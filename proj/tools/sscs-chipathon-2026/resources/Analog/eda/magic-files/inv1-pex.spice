* NGSPICE file created from inv1.ext - technology: gf180mcuD

.subckt inv1 DVDD vin vout DVSS
X0 vout vin DVSS DVSS nfet_03v3 ad=0.5525p pd=3u as=0.425p ps=2.7u w=0.85u l=0.3u
X1 vout vin DVDD DVDD pfet_03v3 ad=1.105p pd=4.7u as=0.85p ps=4.4u w=1.7u l=0.3u
C0 vin DVDD 0.13843f
C1 vout DVDD 0.22837f
C2 vin vout 0.11697f
C3 vout DVSS 0.53819f
C4 vin DVSS 0.65883f
C5 DVDD DVSS 1.15556f
.ends
