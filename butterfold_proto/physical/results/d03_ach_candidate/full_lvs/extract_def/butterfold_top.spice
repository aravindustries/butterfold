* NGSPICE file created from butterfold_top.ext - technology: gf180mcuD

* Black-box entry subcircuit for gf180mcu_fd_sc_mcu9t5v0__dffrnq_1 abstract view
.subckt gf180mcu_fd_sc_mcu9t5v0__dffrnq_1 D RN CLK Q VDD VNW VPW VSS
.ends

* Black-box entry subcircuit for gf180mcu_fd_sc_mcu9t5v0__nand3_1 abstract view
.subckt gf180mcu_fd_sc_mcu9t5v0__nand3_1 A1 A2 A3 ZN VDD VNW VPW VSS
.ends

* Black-box entry subcircuit for gf180mcu_fd_sc_mcu9t5v0__filltie abstract view
.subckt gf180mcu_fd_sc_mcu9t5v0__filltie VDD VSS
.ends

* Black-box entry subcircuit for gf180mcu_fd_sc_mcu9t5v0__endcap abstract view
.subckt gf180mcu_fd_sc_mcu9t5v0__endcap VDD VSS
.ends

* Black-box entry subcircuit for gf180mcu_fd_sc_mcu9t5v0__clkinv_1 abstract view
.subckt gf180mcu_fd_sc_mcu9t5v0__clkinv_1 I ZN VDD VNW VPW VSS
.ends

* Black-box entry subcircuit for gf180mcu_fd_sc_mcu9t5v0__dffq_1 abstract view
.subckt gf180mcu_fd_sc_mcu9t5v0__dffq_1 D CLK Q VDD VNW VPW VSS
.ends

* Black-box entry subcircuit for gf180mcu_fd_sc_mcu9t5v0__nor4_1 abstract view
.subckt gf180mcu_fd_sc_mcu9t5v0__nor4_1 A1 A2 A3 A4 ZN VDD VNW VPW VSS
.ends

* Black-box entry subcircuit for gf180mcu_fd_sc_mcu9t5v0__nand2_1 abstract view
.subckt gf180mcu_fd_sc_mcu9t5v0__nand2_1 A1 A2 ZN VDD VNW VPW VSS
.ends

* Black-box entry subcircuit for gf180mcu_fd_sc_mcu9t5v0__mux2_1 abstract view
.subckt gf180mcu_fd_sc_mcu9t5v0__mux2_1 I0 I1 S Z VDD VNW VPW VSS
.ends

* Black-box entry subcircuit for gf180mcu_fd_sc_mcu9t5v0__nor3_1 abstract view
.subckt gf180mcu_fd_sc_mcu9t5v0__nor3_1 A1 A2 A3 ZN VDD VNW VPW VSS
.ends

* Black-box entry subcircuit for gf180mcu_fd_sc_mcu9t5v0__nor2_1 abstract view
.subckt gf180mcu_fd_sc_mcu9t5v0__nor2_1 A1 A2 ZN VDD VNW VPW VSS
.ends

* Black-box entry subcircuit for gf180mcu_fd_sc_mcu9t5v0__oai22_4 abstract view
.subckt gf180mcu_fd_sc_mcu9t5v0__oai22_4 A1 A2 B1 B2 ZN VDD VNW VPW VSS
.ends

* Black-box entry subcircuit for gf180mcu_fd_sc_mcu9t5v0__aoi22_1 abstract view
.subckt gf180mcu_fd_sc_mcu9t5v0__aoi22_1 A1 A2 B1 B2 ZN VDD VNW VPW VSS
.ends

* Black-box entry subcircuit for gf180mcu_fd_sc_mcu9t5v0__xnor2_1 abstract view
.subckt gf180mcu_fd_sc_mcu9t5v0__xnor2_1 A1 A2 ZN VDD VNW VPW VSS
.ends

* Black-box entry subcircuit for gf180mcu_fd_sc_mcu9t5v0__aoi21_1 abstract view
.subckt gf180mcu_fd_sc_mcu9t5v0__aoi21_1 A1 A2 B ZN VDD VNW VPW VSS
.ends

* Black-box entry subcircuit for gf180mcu_fd_sc_mcu9t5v0__oai21_1 abstract view
.subckt gf180mcu_fd_sc_mcu9t5v0__oai21_1 A1 A2 B ZN VDD VNW VPW VSS
.ends

* Black-box entry subcircuit for gf180mcu_fd_sc_mcu9t5v0__mux2_4 abstract view
.subckt gf180mcu_fd_sc_mcu9t5v0__mux2_4 I0 I1 S Z VDD VNW VPW VSS
.ends

* Black-box entry subcircuit for gf180mcu_fd_sc_mcu9t5v0__nand3_4 abstract view
.subckt gf180mcu_fd_sc_mcu9t5v0__nand3_4 A1 A2 A3 ZN VDD VNW VPW VSS
.ends

* Black-box entry subcircuit for gf180mcu_fd_sc_mcu9t5v0__oai31_1 abstract view
.subckt gf180mcu_fd_sc_mcu9t5v0__oai31_1 A1 A2 A3 B ZN VDD VNW VPW VSS
.ends

* Black-box entry subcircuit for gf180mcu_fd_sc_mcu9t5v0__dffrnq_4 abstract view
.subckt gf180mcu_fd_sc_mcu9t5v0__dffrnq_4 D RN CLK Q VDD VNW VPW VSS
.ends

* Black-box entry subcircuit for gf180mcu_fd_sc_mcu9t5v0__nand4_1 abstract view
.subckt gf180mcu_fd_sc_mcu9t5v0__nand4_1 A1 A2 A3 A4 ZN VDD VNW VPW VSS
.ends

* Black-box entry subcircuit for gf180mcu_fd_sc_mcu9t5v0__oai211_1 abstract view
.subckt gf180mcu_fd_sc_mcu9t5v0__oai211_1 A1 A2 B C ZN VDD VNW VPW VSS
.ends

* Black-box entry subcircuit for gf180mcu_fd_sc_mcu9t5v0__or2_1 abstract view
.subckt gf180mcu_fd_sc_mcu9t5v0__or2_1 A1 A2 Z VDD VNW VPW VSS
.ends

* Black-box entry subcircuit for gf180mcu_fd_sc_mcu9t5v0__dffq_4 abstract view
.subckt gf180mcu_fd_sc_mcu9t5v0__dffq_4 D CLK Q VDD VNW VPW VSS
.ends

* Black-box entry subcircuit for gf180mcu_fd_sc_mcu9t5v0__xor2_1 abstract view
.subckt gf180mcu_fd_sc_mcu9t5v0__xor2_1 A1 A2 Z VDD VNW VPW VSS
.ends

* Black-box entry subcircuit for gf180mcu_fd_sc_mcu9t5v0__oai21_4 abstract view
.subckt gf180mcu_fd_sc_mcu9t5v0__oai21_4 A1 A2 B ZN VDD VNW VPW VSS
.ends

* Black-box entry subcircuit for gf180mcu_fd_sc_mcu9t5v0__clkbuf_8 abstract view
.subckt gf180mcu_fd_sc_mcu9t5v0__clkbuf_8 I Z VDD VNW VPW VSS
.ends

* Black-box entry subcircuit for gf180mcu_fd_sc_mcu9t5v0__oai211_2 abstract view
.subckt gf180mcu_fd_sc_mcu9t5v0__oai211_2 A1 A2 B C ZN VDD VNW VPW VSS
.ends

* Black-box entry subcircuit for gf180mcu_fd_sc_mcu9t5v0__aoi21_4 abstract view
.subckt gf180mcu_fd_sc_mcu9t5v0__aoi21_4 A1 A2 B ZN VDD VNW VPW VSS
.ends

* Black-box entry subcircuit for gf180mcu_fd_sc_mcu9t5v0__aoi21_2 abstract view
.subckt gf180mcu_fd_sc_mcu9t5v0__aoi21_2 A1 A2 B ZN VDD VNW VPW VSS
.ends

* Black-box entry subcircuit for gf180mcu_fd_sc_mcu9t5v0__or3_1 abstract view
.subckt gf180mcu_fd_sc_mcu9t5v0__or3_1 A1 A2 A3 Z VDD VNW VPW VSS
.ends

* Black-box entry subcircuit for gf180mcu_fd_sc_mcu9t5v0__and3_1 abstract view
.subckt gf180mcu_fd_sc_mcu9t5v0__and3_1 A1 A2 A3 Z VDD VNW VPW VSS
.ends

* Black-box entry subcircuit for gf180mcu_fd_sc_mcu9t5v0__xor3_1 abstract view
.subckt gf180mcu_fd_sc_mcu9t5v0__xor3_1 A1 A2 A3 Z VDD VNW VPW VSS
.ends

* Black-box entry subcircuit for gf180mcu_fd_sc_mcu9t5v0__and2_1 abstract view
.subckt gf180mcu_fd_sc_mcu9t5v0__and2_1 A1 A2 Z VDD VNW VPW VSS
.ends

* Black-box entry subcircuit for gf180mcu_fd_sc_mcu9t5v0__aoi221_1 abstract view
.subckt gf180mcu_fd_sc_mcu9t5v0__aoi221_1 A1 A2 B1 B2 C ZN VDD VNW VPW VSS
.ends

* Black-box entry subcircuit for gf180mcu_fd_sc_mcu9t5v0__nor2_2 abstract view
.subckt gf180mcu_fd_sc_mcu9t5v0__nor2_2 A1 A2 ZN VDD VNW VPW VSS
.ends

* Black-box entry subcircuit for gf180mcu_fd_sc_mcu9t5v0__clkbuf_4 abstract view
.subckt gf180mcu_fd_sc_mcu9t5v0__clkbuf_4 I Z VDD VNW VPW VSS
.ends

* Black-box entry subcircuit for gf180mcu_fd_sc_mcu9t5v0__buf_4 abstract view
.subckt gf180mcu_fd_sc_mcu9t5v0__buf_4 I Z VDD VNW VPW VSS
.ends

* Black-box entry subcircuit for gf180mcu_fd_sc_mcu9t5v0__clkbuf_16 abstract view
.subckt gf180mcu_fd_sc_mcu9t5v0__clkbuf_16 I Z VDD VNW VPW VSS
.ends

* Black-box entry subcircuit for gf180mcu_fd_sc_mcu9t5v0__buf_8 abstract view
.subckt gf180mcu_fd_sc_mcu9t5v0__buf_8 I Z VDD VNW VPW VSS
.ends

* Black-box entry subcircuit for gf180mcu_fd_sc_mcu9t5v0__nand2_2 abstract view
.subckt gf180mcu_fd_sc_mcu9t5v0__nand2_2 A1 A2 ZN VDD VNW VPW VSS
.ends

* Black-box entry subcircuit for gf180mcu_fd_sc_mcu9t5v0__oai21_2 abstract view
.subckt gf180mcu_fd_sc_mcu9t5v0__oai21_2 A1 A2 B ZN VDD VNW VPW VSS
.ends

* Black-box entry subcircuit for gf180mcu_fd_sc_mcu9t5v0__nand3_2 abstract view
.subckt gf180mcu_fd_sc_mcu9t5v0__nand3_2 A1 A2 A3 ZN VDD VNW VPW VSS
.ends

* Black-box entry subcircuit for gf180mcu_fd_sc_mcu9t5v0__aoi211_1 abstract view
.subckt gf180mcu_fd_sc_mcu9t5v0__aoi211_1 A1 A2 B C ZN VDD VNW VPW VSS
.ends

* Black-box entry subcircuit for gf180mcu_fd_sc_mcu9t5v0__antenna abstract view
.subckt gf180mcu_fd_sc_mcu9t5v0__antenna I VDD VNW VPW VSS
.ends

* Black-box entry subcircuit for gf180mcu_fd_sc_mcu9t5v0__inv_2 abstract view
.subckt gf180mcu_fd_sc_mcu9t5v0__inv_2 I ZN VDD VNW VPW VSS
.ends

* Black-box entry subcircuit for gf180mcu_fd_sc_mcu9t5v0__mux4_1 abstract view
.subckt gf180mcu_fd_sc_mcu9t5v0__mux4_1 I0 I1 I2 I3 S0 S1 Z VDD VNW VPW VSS
.ends

* Black-box entry subcircuit for gf180mcu_fd_sc_mcu9t5v0__nand2_4 abstract view
.subckt gf180mcu_fd_sc_mcu9t5v0__nand2_4 A1 A2 ZN VDD VNW VPW VSS
.ends

* Black-box entry subcircuit for gf180mcu_fd_sc_mcu9t5v0__oai221_1 abstract view
.subckt gf180mcu_fd_sc_mcu9t5v0__oai221_1 A1 A2 B1 B2 C ZN VDD VNW VPW VSS
.ends

* Black-box entry subcircuit for gf180mcu_fd_sc_mcu9t5v0__oai22_1 abstract view
.subckt gf180mcu_fd_sc_mcu9t5v0__oai22_1 A1 A2 B1 B2 ZN VDD VNW VPW VSS
.ends

* Black-box entry subcircuit for gf180mcu_fd_sc_mcu9t5v0__aoi222_1 abstract view
.subckt gf180mcu_fd_sc_mcu9t5v0__aoi222_1 A1 A2 B1 B2 C1 C2 ZN VDD VNW VPW VSS
.ends

* Black-box entry subcircuit for gf180mcu_fd_sc_mcu9t5v0__and3_4 abstract view
.subckt gf180mcu_fd_sc_mcu9t5v0__and3_4 A1 A2 A3 Z VDD VNW VPW VSS
.ends

* Black-box entry subcircuit for gf180mcu_fd_sc_mcu9t5v0__nor3_2 abstract view
.subckt gf180mcu_fd_sc_mcu9t5v0__nor3_2 A1 A2 A3 ZN VDD VNW VPW VSS
.ends

* Black-box entry subcircuit for gf180mcu_fd_sc_mcu9t5v0__oai31_4 abstract view
.subckt gf180mcu_fd_sc_mcu9t5v0__oai31_4 A1 A2 A3 B ZN VDD VNW VPW VSS
.ends

* Black-box entry subcircuit for gf180mcu_fd_sc_mcu9t5v0__inv_4 abstract view
.subckt gf180mcu_fd_sc_mcu9t5v0__inv_4 I ZN VDD VNW VPW VSS
.ends

* Black-box entry subcircuit for gf180mcu_fd_sc_mcu9t5v0__oai32_1 abstract view
.subckt gf180mcu_fd_sc_mcu9t5v0__oai32_1 A1 A2 A3 B1 B2 ZN VDD VNW VPW VSS
.ends

* Black-box entry subcircuit for gf180mcu_fd_sc_mcu9t5v0__oai222_1 abstract view
.subckt gf180mcu_fd_sc_mcu9t5v0__oai222_1 A1 A2 B1 B2 C1 C2 ZN VDD VNW VPW VSS
.ends

* Black-box entry subcircuit for gf180mcu_fd_sc_mcu9t5v0__xnor3_1 abstract view
.subckt gf180mcu_fd_sc_mcu9t5v0__xnor3_1 A1 A2 A3 ZN VDD VNW VPW VSS
.ends

* Black-box entry subcircuit for gf180mcu_fd_sc_mcu9t5v0__dlyd_1 abstract view
.subckt gf180mcu_fd_sc_mcu9t5v0__dlyd_1 I Z VDD VNW VPW VSS
.ends

* Black-box entry subcircuit for gf180mcu_fd_sc_mcu9t5v0__aoi22_2 abstract view
.subckt gf180mcu_fd_sc_mcu9t5v0__aoi22_2 A1 A2 B1 B2 ZN VDD VNW VPW VSS
.ends

* Black-box entry subcircuit for gf180mcu_fd_sc_mcu9t5v0__oai32_4 abstract view
.subckt gf180mcu_fd_sc_mcu9t5v0__oai32_4 A1 A2 A3 B1 B2 ZN VDD VNW VPW VSS
.ends

* Black-box entry subcircuit for gf180mcu_fd_sc_mcu9t5v0__dffsnq_1 abstract view
.subckt gf180mcu_fd_sc_mcu9t5v0__dffsnq_1 D SETN CLK Q VDD VNW VPW VSS
.ends

* Black-box entry subcircuit for gf180mcu_fd_sc_mcu9t5v0__aoi22_4 abstract view
.subckt gf180mcu_fd_sc_mcu9t5v0__aoi22_4 A1 A2 B1 B2 ZN VDD VNW VPW VSS
.ends

* Black-box entry subcircuit for gf180mcu_fd_sc_mcu9t5v0__dffrnq_2 abstract view
.subckt gf180mcu_fd_sc_mcu9t5v0__dffrnq_2 D RN CLK Q VDD VNW VPW VSS
.ends

* Black-box entry subcircuit for gf180mcu_fd_sc_mcu9t5v0__or3_4 abstract view
.subckt gf180mcu_fd_sc_mcu9t5v0__or3_4 A1 A2 A3 Z VDD VNW VPW VSS
.ends

* Black-box entry subcircuit for gf180mcu_fd_sc_mcu9t5v0__clkinv_4 abstract view
.subckt gf180mcu_fd_sc_mcu9t5v0__clkinv_4 I ZN VDD VNW VPW VSS
.ends

* Black-box entry subcircuit for gf180mcu_fd_sc_mcu9t5v0__inv_3 abstract view
.subckt gf180mcu_fd_sc_mcu9t5v0__inv_3 I ZN VDD VNW VPW VSS
.ends

* Black-box entry subcircuit for gf180mcu_fd_sc_mcu9t5v0__clkbuf_3 abstract view
.subckt gf180mcu_fd_sc_mcu9t5v0__clkbuf_3 I Z VDD VNW VPW VSS
.ends

* Black-box entry subcircuit for gf180mcu_fd_sc_mcu9t5v0__oai211_4 abstract view
.subckt gf180mcu_fd_sc_mcu9t5v0__oai211_4 A1 A2 B C ZN VDD VNW VPW VSS
.ends

* Black-box entry subcircuit for gf180mcu_fd_sc_mcu9t5v0__oai32_2 abstract view
.subckt gf180mcu_fd_sc_mcu9t5v0__oai32_2 A1 A2 A3 B1 B2 ZN VDD VNW VPW VSS
.ends

* Black-box entry subcircuit for gf180mcu_fd_sc_mcu9t5v0__aoi221_2 abstract view
.subckt gf180mcu_fd_sc_mcu9t5v0__aoi221_2 A1 A2 B1 B2 C ZN VDD VNW VPW VSS
.ends

* Black-box entry subcircuit for gf180mcu_fd_sc_mcu9t5v0__and4_1 abstract view
.subckt gf180mcu_fd_sc_mcu9t5v0__and4_1 A1 A2 A3 A4 Z VDD VNW VPW VSS
.ends

* Black-box entry subcircuit for gf180mcu_fd_sc_mcu9t5v0__clkinv_8 abstract view
.subckt gf180mcu_fd_sc_mcu9t5v0__clkinv_8 I ZN VDD VNW VPW VSS
.ends

* Black-box entry subcircuit for gf180mcu_fd_sc_mcu9t5v0__aoi221_4 abstract view
.subckt gf180mcu_fd_sc_mcu9t5v0__aoi221_4 A1 A2 B1 B2 C ZN VDD VNW VPW VSS
.ends

* Black-box entry subcircuit for gf180mcu_fd_sc_mcu9t5v0__and2_4 abstract view
.subckt gf180mcu_fd_sc_mcu9t5v0__and2_4 A1 A2 Z VDD VNW VPW VSS
.ends

* Black-box entry subcircuit for gf180mcu_fd_sc_mcu9t5v0__nor2_4 abstract view
.subckt gf180mcu_fd_sc_mcu9t5v0__nor2_4 A1 A2 ZN VDD VNW VPW VSS
.ends

* Black-box entry subcircuit for gf180mcu_fd_sc_mcu9t5v0__nor3_4 abstract view
.subckt gf180mcu_fd_sc_mcu9t5v0__nor3_4 A1 A2 A3 ZN VDD VNW VPW VSS
.ends

* Black-box entry subcircuit for gf180mcu_fd_sc_mcu9t5v0__clkinv_16 abstract view
.subckt gf180mcu_fd_sc_mcu9t5v0__clkinv_16 I ZN VDD VNW VPW VSS
.ends

* Black-box entry subcircuit for gf180mcu_fd_sc_mcu9t5v0__and2_2 abstract view
.subckt gf180mcu_fd_sc_mcu9t5v0__and2_2 A1 A2 Z VDD VNW VPW VSS
.ends

* Black-box entry subcircuit for gf180mcu_fd_sc_mcu9t5v0__or4_1 abstract view
.subckt gf180mcu_fd_sc_mcu9t5v0__or4_1 A1 A2 A3 A4 Z VDD VNW VPW VSS
.ends

* Black-box entry subcircuit for gf180mcu_fd_sc_mcu9t5v0__clkinv_12 abstract view
.subckt gf180mcu_fd_sc_mcu9t5v0__clkinv_12 I ZN VDD VNW VPW VSS
.ends

* Black-box entry subcircuit for gf180mcu_fd_sc_mcu9t5v0__or2_4 abstract view
.subckt gf180mcu_fd_sc_mcu9t5v0__or2_4 A1 A2 Z VDD VNW VPW VSS
.ends

* Black-box entry subcircuit for gf180mcu_fd_sc_mcu9t5v0__and3_2 abstract view
.subckt gf180mcu_fd_sc_mcu9t5v0__and3_2 A1 A2 A3 Z VDD VNW VPW VSS
.ends

* Black-box entry subcircuit for gf180mcu_fd_sc_mcu9t5v0__oai31_2 abstract view
.subckt gf180mcu_fd_sc_mcu9t5v0__oai31_2 A1 A2 A3 B ZN VDD VNW VPW VSS
.ends

* Black-box entry subcircuit for gf180mcu_fd_sc_mcu9t5v0__inv_1 abstract view
.subckt gf180mcu_fd_sc_mcu9t5v0__inv_1 I ZN VDD VNW VPW VSS
.ends

* Black-box entry subcircuit for gf180mcu_fd_sc_mcu9t5v0__buf_12 abstract view
.subckt gf180mcu_fd_sc_mcu9t5v0__buf_12 I Z VDD VNW VPW VSS
.ends

* Black-box entry subcircuit for gf180mcu_fd_sc_mcu9t5v0__inv_8 abstract view
.subckt gf180mcu_fd_sc_mcu9t5v0__inv_8 I ZN VDD VNW VPW VSS
.ends

* Black-box entry subcircuit for gf180mcu_fd_sc_mcu9t5v0__aoi211_4 abstract view
.subckt gf180mcu_fd_sc_mcu9t5v0__aoi211_4 A1 A2 B C ZN VDD VNW VPW VSS
.ends

* Black-box entry subcircuit for gf180mcu_fd_sc_mcu9t5v0__clkbuf_2 abstract view
.subckt gf180mcu_fd_sc_mcu9t5v0__clkbuf_2 I Z VDD VNW VPW VSS
.ends

* Black-box entry subcircuit for gf180mcu_fd_sc_mcu9t5v0__buf_2 abstract view
.subckt gf180mcu_fd_sc_mcu9t5v0__buf_2 I Z VDD VNW VPW VSS
.ends

* Black-box entry subcircuit for gf180mcu_fd_sc_mcu9t5v0__oai221_4 abstract view
.subckt gf180mcu_fd_sc_mcu9t5v0__oai221_4 A1 A2 B1 B2 C ZN VDD VNW VPW VSS
.ends

* Black-box entry subcircuit for gf180mcu_fd_sc_mcu9t5v0__inv_20 abstract view
.subckt gf180mcu_fd_sc_mcu9t5v0__inv_20 I ZN VDD VNW VPW VSS
.ends

* Black-box entry subcircuit for gf180mcu_fd_ip_sram__sram256x8m8wm1 abstract view
.subckt gf180mcu_fd_ip_sram__sram256x8m8wm1 A[7] A[6] A[5] A[4] A[3] A[2] A[1] A[0]
+ CEN CLK D[7] D[6] D[5] D[4] D[3] D[2] D[1] D[0] GWEN Q[7] Q[6] Q[5] Q[4] Q[3] Q[2]
+ Q[1] Q[0] VDD VSS WEN[7] WEN[6] WEN[5] WEN[4] WEN[3] WEN[2] WEN[1] WEN[0]
.ends

* Black-box entry subcircuit for gf180mcu_fd_sc_mcu9t5v0__and4_4 abstract view
.subckt gf180mcu_fd_sc_mcu9t5v0__and4_4 A1 A2 A3 A4 Z VDD VNW VPW VSS
.ends

* Black-box entry subcircuit for gf180mcu_fd_sc_mcu9t5v0__nand4_4 abstract view
.subckt gf180mcu_fd_sc_mcu9t5v0__nand4_4 A1 A2 A3 A4 ZN VDD VNW VPW VSS
.ends

* Black-box entry subcircuit for gf180mcu_fd_sc_mcu9t5v0__buf_3 abstract view
.subckt gf180mcu_fd_sc_mcu9t5v0__buf_3 I Z VDD VNW VPW VSS
.ends

* Black-box entry subcircuit for gf180mcu_fd_sc_mcu9t5v0__xnor2_2 abstract view
.subckt gf180mcu_fd_sc_mcu9t5v0__xnor2_2 A1 A2 ZN VDD VNW VPW VSS
.ends

* Black-box entry subcircuit for gf180mcu_fd_sc_mcu9t5v0__oai22_2 abstract view
.subckt gf180mcu_fd_sc_mcu9t5v0__oai22_2 A1 A2 B1 B2 ZN VDD VNW VPW VSS
.ends

* Black-box entry subcircuit for gf180mcu_fd_sc_mcu9t5v0__oai33_1 abstract view
.subckt gf180mcu_fd_sc_mcu9t5v0__oai33_1 A1 A2 A3 B1 B2 B3 ZN VDD VNW VPW VSS
.ends

* Black-box entry subcircuit for gf180mcu_fd_sc_mcu9t5v0__oai222_4 abstract view
.subckt gf180mcu_fd_sc_mcu9t5v0__oai222_4 A1 A2 B1 B2 C1 C2 ZN VDD VNW VPW VSS
.ends

* Black-box entry subcircuit for gf180mcu_fd_sc_mcu9t5v0__clkbuf_1 abstract view
.subckt gf180mcu_fd_sc_mcu9t5v0__clkbuf_1 I Z VDD VNW VPW VSS
.ends

* Black-box entry subcircuit for gf180mcu_fd_sc_mcu9t5v0__aoi211_2 abstract view
.subckt gf180mcu_fd_sc_mcu9t5v0__aoi211_2 A1 A2 B C ZN VDD VNW VPW VSS
.ends

* Black-box entry subcircuit for gf180mcu_fd_sc_mcu9t5v0__or2_2 abstract view
.subckt gf180mcu_fd_sc_mcu9t5v0__or2_2 A1 A2 Z VDD VNW VPW VSS
.ends

* Black-box entry subcircuit for gf180mcu_fd_sc_mcu9t5v0__dlyb_4 abstract view
.subckt gf180mcu_fd_sc_mcu9t5v0__dlyb_4 I Z VDD VNW VPW VSS
.ends

* Black-box entry subcircuit for gf180mcu_fd_sc_mcu9t5v0__dlya_4 abstract view
.subckt gf180mcu_fd_sc_mcu9t5v0__dlya_4 I Z VDD VNW VPW VSS
.ends

* Black-box entry subcircuit for gf180mcu_fd_sc_mcu9t5v0__xnor2_4 abstract view
.subckt gf180mcu_fd_sc_mcu9t5v0__xnor2_4 A1 A2 ZN VDD VNW VPW VSS
.ends

* Black-box entry subcircuit for gf180mcu_fd_sc_mcu9t5v0__clkbuf_12 abstract view
.subckt gf180mcu_fd_sc_mcu9t5v0__clkbuf_12 I Z VDD VNW VPW VSS
.ends

* Black-box entry subcircuit for gf180mcu_fd_sc_mcu9t5v0__nor4_4 abstract view
.subckt gf180mcu_fd_sc_mcu9t5v0__nor4_4 A1 A2 A3 A4 ZN VDD VNW VPW VSS
.ends

* Black-box entry subcircuit for gf180mcu_fd_sc_mcu9t5v0__mux2_2 abstract view
.subckt gf180mcu_fd_sc_mcu9t5v0__mux2_2 I0 I1 S Z VDD VNW VPW VSS
.ends

* Black-box entry subcircuit for gf180mcu_fd_sc_mcu9t5v0__xor2_2 abstract view
.subckt gf180mcu_fd_sc_mcu9t5v0__xor2_2 A1 A2 Z VDD VNW VPW VSS
.ends

* Black-box entry subcircuit for gf180mcu_fd_sc_mcu9t5v0__oai221_2 abstract view
.subckt gf180mcu_fd_sc_mcu9t5v0__oai221_2 A1 A2 B1 B2 C ZN VDD VNW VPW VSS
.ends

.subckt butterfold_top VSS clk din[0] din[1] din[2] din[3] din[4] din[5] din[6] din[7]
+ din_ready_o din_valid_i dout[0] dout[1] dout[2] dout[3] dout[4] dout[5] dout[6]
+ dout[7] dout_valid_o rst_n
X_18869_ _18869_/D _20021_/RN clkload40/I _18869_/Q VSS VSS VSS VSS gf180mcu_fd_sc_mcu9t5v0__dffrnq_1
X_09671_ _20032_/Q _20008_/Q wire216/I _09673_/A1 VSS _09671_/VNW VSS VSS gf180mcu_fd_sc_mcu9t5v0__nand3_1
XTAP_TAPCELL_ROW_11_1272 VSS VSS gf180mcu_fd_sc_mcu9t5v0__filltie
XTAP_TAPCELL_ROW_11_1283 VSS VSS gf180mcu_fd_sc_mcu9t5v0__filltie
XTAP_TAPCELL_ROW_11_1294 VSS VSS gf180mcu_fd_sc_mcu9t5v0__filltie
XPHY_EDGE_ROW_207_1_Left_530 VSS VSS gf180mcu_fd_sc_mcu9t5v0__endcap
XTAP_TAPCELL_ROW_24_1633 VSS VSS gf180mcu_fd_sc_mcu9t5v0__filltie
XTAP_TAPCELL_ROW_24_1644 VSS VSS gf180mcu_fd_sc_mcu9t5v0__filltie
XTAP_TAPCELL_ROW_24_1655 VSS VSS gf180mcu_fd_sc_mcu9t5v0__filltie
X_09105_ _19292_/Q _13891_/B2 VSS VSS VSS VSS gf180mcu_fd_sc_mcu9t5v0__clkinv_1
XTAP_TAPCELL_ROW_20_1519 VSS VSS gf180mcu_fd_sc_mcu9t5v0__filltie
XTAP_TAPCELL_ROW_303_7415 VSS VSS gf180mcu_fd_sc_mcu9t5v0__filltie
XTAP_TAPCELL_ROW_303_7404 VSS VSS gf180mcu_fd_sc_mcu9t5v0__filltie
X_20127_ _20127_/D clkload60/I _20127_/Q VSS VSS VSS VSS gf180mcu_fd_sc_mcu9t5v0__dffq_1
X_09938_ _09938_/A1 _09938_/A2 _09938_/A3 _09938_/A4 _09939_/C VSS VSS VSS VSS gf180mcu_fd_sc_mcu9t5v0__nor4_1
X_20058_ _20058_/D _20058_/RN clkload53/I _20058_/Q VSS VSS VSS VSS gf180mcu_fd_sc_mcu9t5v0__dffrnq_1
X_09869_ _09869_/I _09873_/A2 VSS VSS VSS VSS gf180mcu_fd_sc_mcu9t5v0__clkinv_1
X_11900_ _11909_/A1 _11909_/A2 _11901_/A2 VSS VSS VSS VSS gf180mcu_fd_sc_mcu9t5v0__nand2_1
X_12880_ _19739_/Q _19804_/Q _13244_/B _12880_/Z VSS VSS VSS VSS gf180mcu_fd_sc_mcu9t5v0__mux2_1
XTAP_TAPCELL_ROW_289_7009 VSS VSS gf180mcu_fd_sc_mcu9t5v0__filltie
X_11831_ _11988_/B _11832_/A2 _11832_/B _11835_/A1 VSS VSS VSS VSS gf180mcu_fd_sc_mcu9t5v0__nor3_1
X_14550_ _19169_/Q _19135_/Q _14752_/C VSS _14550_/VNW VSS VSS gf180mcu_fd_sc_mcu9t5v0__nor2_1
X_11762_ _11762_/A1 _11762_/A2 _11761_/Z _12261_/B _11807_/A2 VSS VSS VSS VSS gf180mcu_fd_sc_mcu9t5v0__oai22_4
X_13501_ _19261_/Q _13304_/B _13504_/B VSS VSS VSS VSS gf180mcu_fd_sc_mcu9t5v0__nand2_1
X_11693_ _11693_/A1 _11693_/A2 _11693_/B1 _11693_/B2 _11696_/A2 VSS _11695_/VNW VSS
+ VSS gf180mcu_fd_sc_mcu9t5v0__aoi22_1
X_14481_ _19161_/Q _19127_/Q _14716_/B VSS _14720_/VNW VSS VSS gf180mcu_fd_sc_mcu9t5v0__xnor2_1
X_10713_ _10713_/I0 _10712_/Z _18852_/Q _10713_/Z VSS VSS VSS VSS gf180mcu_fd_sc_mcu9t5v0__mux2_1
X_16220_ _16167_/B _19270_/Q _16785_/S _16220_/Z VSS VSS VSS VSS gf180mcu_fd_sc_mcu9t5v0__mux2_1
X_10644_ _20075_/Q _17407_/C _10645_/B VSS VSS VSS VSS gf180mcu_fd_sc_mcu9t5v0__nand2_1
X_13432_ _12948_/S _13448_/A2 _13432_/A3 _13438_/B1 VSS VSS VSS VSS gf180mcu_fd_sc_mcu9t5v0__nand3_1
XTAP_TAPCELL_ROW_98_3681 VSS VSS gf180mcu_fd_sc_mcu9t5v0__filltie
XTAP_TAPCELL_ROW_98_3670 VSS VSS gf180mcu_fd_sc_mcu9t5v0__filltie
X_16151_ _16668_/A1 _16686_/A3 _16151_/B _16154_/A1 VSS VSS VSS VSS gf180mcu_fd_sc_mcu9t5v0__aoi21_1
X_10575_ _10654_/A2 _10575_/A2 _10575_/A3 _10576_/B VSS _10576_/VNW VSS VSS gf180mcu_fd_sc_mcu9t5v0__nand3_1
X_13363_ _13378_/A2 _19808_/Q _13403_/A1 VSS _13363_/VNW VSS VSS gf180mcu_fd_sc_mcu9t5v0__nor2_1
XTAP_TAPCELL_ROW_94_3556 VSS VSS gf180mcu_fd_sc_mcu9t5v0__filltie
XTAP_TAPCELL_ROW_265_6363 VSS VSS gf180mcu_fd_sc_mcu9t5v0__filltie
XTAP_TAPCELL_ROW_265_6352 VSS VSS gf180mcu_fd_sc_mcu9t5v0__filltie
XTAP_TAPCELL_ROW_94_3578 VSS VSS gf180mcu_fd_sc_mcu9t5v0__filltie
XTAP_TAPCELL_ROW_94_3567 VSS VSS gf180mcu_fd_sc_mcu9t5v0__filltie
X_12314_ _18921_/Q _12314_/A2 _12333_/A2 VSS _12314_/VNW VSS VSS gf180mcu_fd_sc_mcu9t5v0__xnor2_1
X_15102_ _19395_/Q _19314_/Q _15105_/A2 VSS VSS VSS VSS gf180mcu_fd_sc_mcu9t5v0__nor2_1
XTAP_TAPCELL_ROW_261_6249 VSS VSS gf180mcu_fd_sc_mcu9t5v0__filltie
X_16082_ _16750_/A1 _16674_/A2 _16177_/C _16084_/A2 VSS _16092_/VNW VSS VSS gf180mcu_fd_sc_mcu9t5v0__aoi21_1
XTAP_TAPCELL_ROW_261_6238 VSS VSS gf180mcu_fd_sc_mcu9t5v0__filltie
X_13294_ _13294_/A1 _13295_/A2 _13595_/A1 VSS VSS VSS VSS gf180mcu_fd_sc_mcu9t5v0__nand2_1
X_12245_ _18467_/Q _12345_/A2 _12299_/S _12246_/B2 VSS VSS VSS VSS gf180mcu_fd_sc_mcu9t5v0__aoi21_1
X_19910_ _19910_/D _20038_/RN clkload41/I _19910_/Q VSS VSS VSS VSS gf180mcu_fd_sc_mcu9t5v0__dffrnq_1
X_15033_ _19635_/Q _19386_/Q _20039_/Q _19635_/D VSS VSS VSS VSS gf180mcu_fd_sc_mcu9t5v0__mux2_1
XTAP_TAPCELL_ROW_278_6713 VSS VSS gf180mcu_fd_sc_mcu9t5v0__filltie
X_12176_ _18368_/Q _18352_/Q _12315_/S _12176_/Z VSS VSS VSS VSS gf180mcu_fd_sc_mcu9t5v0__mux2_1
XTAP_TAPCELL_ROW_278_6702 VSS VSS gf180mcu_fd_sc_mcu9t5v0__filltie
X_19841_ _19841_/D _20033_/RN clkload56/I _19841_/Q VSS VSS VSS VSS gf180mcu_fd_sc_mcu9t5v0__dffrnq_1
XTAP_TAPCELL_ROW_278_6724 VSS VSS gf180mcu_fd_sc_mcu9t5v0__filltie
X_11127_ _18267_/Q _11403_/S _11520_/B _11129_/A2 VSS VSS VSS VSS gf180mcu_fd_sc_mcu9t5v0__oai21_1
X_16984_ _18483_/Q _16983_/Z _16990_/S _18483_/D VSS VSS VSS VSS gf180mcu_fd_sc_mcu9t5v0__mux2_4
XPHY_EDGE_ROW_149_3_Right_264 VSS VSS gf180mcu_fd_sc_mcu9t5v0__endcap
X_19772_ _19772_/D _20028_/RN clkload26/I _19772_/Q VSS VSS VSS VSS gf180mcu_fd_sc_mcu9t5v0__dffrnq_1
XTAP_TAPCELL_ROW_259_6189 VSS VSS gf180mcu_fd_sc_mcu9t5v0__filltie
X_15935_ _15936_/B _15936_/C _15985_/B1 _15986_/C VSS VSS VSS VSS gf180mcu_fd_sc_mcu9t5v0__nand3_4
X_18723_ _18723_/D clkload47/I _18723_/Q VSS VSS VSS VSS gf180mcu_fd_sc_mcu9t5v0__dffq_1
X_11058_ _18028_/I0 _19059_/Q _11067_/S _19059_/D VSS VSS VSS VSS gf180mcu_fd_sc_mcu9t5v0__mux2_1
X_15866_ _20075_/Q _19243_/Q _15927_/S _20075_/D VSS VSS VSS VSS gf180mcu_fd_sc_mcu9t5v0__mux2_1
X_10009_ _10009_/A1 _10009_/A2 _10011_/C VSS _10011_/VNW VSS VSS gf180mcu_fd_sc_mcu9t5v0__nand2_1
X_18654_ _18654_/D _20058_/RN clkload47/I _18654_/Q VSS VSS VSS VSS gf180mcu_fd_sc_mcu9t5v0__dffrnq_1
XTAP_TAPCELL_ROW_8_1193 VSS VSS gf180mcu_fd_sc_mcu9t5v0__filltie
X_17605_ input4/Z _18668_/Q _17609_/S _18668_/D VSS VSS VSS VSS gf180mcu_fd_sc_mcu9t5v0__mux2_1
X_14817_ _19403_/Q _19340_/Q _14821_/B VSS _14817_/VNW VSS VSS gf180mcu_fd_sc_mcu9t5v0__nand2_1
X_18585_ _18585_/D _20021_/RN clkload28/I _18585_/Q VSS VSS VSS VSS gf180mcu_fd_sc_mcu9t5v0__dffrnq_1
X_17536_ _17541_/A2 _17536_/A2 _17689_/A1 VSS _17536_/VNW VSS VSS gf180mcu_fd_sc_mcu9t5v0__nand2_1
X_15797_ _18032_/I0 _19967_/Q _15802_/S _19967_/D VSS VSS VSS VSS gf180mcu_fd_sc_mcu9t5v0__mux2_1
XTAP_TAPCELL_ROW_4_1079 VSS VSS gf180mcu_fd_sc_mcu9t5v0__filltie
X_14748_ _14748_/A1 _14752_/A2 _14749_/A2 VSS _14748_/VNW VSS VSS gf180mcu_fd_sc_mcu9t5v0__xnor2_1
XTAP_TAPCELL_ROW_250_5953 VSS VSS gf180mcu_fd_sc_mcu9t5v0__filltie
XTAP_TAPCELL_ROW_250_5942 VSS VSS gf180mcu_fd_sc_mcu9t5v0__filltie
X_14679_ _14766_/A2 _14683_/C _14679_/A3 _14679_/B _19531_/D VSS VSS VSS VSS gf180mcu_fd_sc_mcu9t5v0__oai31_1
X_17467_ wire198/I _11540_/C _18580_/Q _17468_/A2 VSS VSS VSS VSS gf180mcu_fd_sc_mcu9t5v0__aoi21_1
X_16418_ _19233_/Q _16142_/C _16955_/S _16418_/Z VSS VSS VSS VSS gf180mcu_fd_sc_mcu9t5v0__mux2_1
X_17398_ _09261_/I _17398_/A2 _17398_/A3 _17398_/B _17403_/A1 VSS VSS VSS VSS gf180mcu_fd_sc_mcu9t5v0__oai31_1
X_19206_ _19206_/D _20038_/RN clkload43/I _19206_/Q VSS VSS VSS VSS gf180mcu_fd_sc_mcu9t5v0__dffrnq_1
X_16349_ _19234_/Q _16147_/C _16895_/S _16349_/Z VSS VSS VSS VSS gf180mcu_fd_sc_mcu9t5v0__mux2_1
X_19137_ _19137_/D _20033_/RN clkload30/I _19137_/Q VSS VSS VSS VSS gf180mcu_fd_sc_mcu9t5v0__dffrnq_4
XTAP_TAPCELL_ROW_248_5882 VSS VSS gf180mcu_fd_sc_mcu9t5v0__filltie
X_19068_ _19068_/D _20028_/RN clkload36/I _19068_/Q VSS VSS VSS VSS gf180mcu_fd_sc_mcu9t5v0__dffrnq_1
XTAP_TAPCELL_ROW_248_5893 VSS VSS gf180mcu_fd_sc_mcu9t5v0__filltie
X_18019_ _18035_/I0 _18904_/Q _18021_/S _18904_/D VSS VSS VSS VSS gf180mcu_fd_sc_mcu9t5v0__mux2_1
XTAP_TAPCELL_ROW_244_5779 VSS VSS gf180mcu_fd_sc_mcu9t5v0__filltie
XTAP_TAPCELL_ROW_244_5768 VSS VSS gf180mcu_fd_sc_mcu9t5v0__filltie
X_09723_ wire300/Z wire301/Z _09634_/Z _15747_/A2 VSS _09723_/VNW VSS VSS gf180mcu_fd_sc_mcu9t5v0__nand3_1
XTAP_TAPCELL_ROW_13_1334 VSS VSS gf180mcu_fd_sc_mcu9t5v0__filltie
XTAP_TAPCELL_ROW_13_1345 VSS VSS gf180mcu_fd_sc_mcu9t5v0__filltie
X_09654_ _19915_/Q _15691_/B _09652_/I _09654_/A4 _09670_/A2 VSS VSS VSS VSS gf180mcu_fd_sc_mcu9t5v0__nand4_1
X_09585_ _20040_/Q _09609_/A3 _09587_/A3 VSS VSS VSS VSS gf180mcu_fd_sc_mcu9t5v0__nor2_1
XTAP_TAPCELL_ROW_26_1706 VSS VSS gf180mcu_fd_sc_mcu9t5v0__filltie
X_10360_ _17161_/C _10360_/A2 _10360_/A3 _10361_/C VSS VSS VSS VSS gf180mcu_fd_sc_mcu9t5v0__nand3_1
X_10291_ _17198_/A1 _10291_/A2 _10291_/B _10543_/C _10300_/C VSS VSS VSS VSS gf180mcu_fd_sc_mcu9t5v0__oai211_1
X_12030_ _19124_/Q _12311_/B _12031_/A2 VSS _12030_/VNW VSS VSS gf180mcu_fd_sc_mcu9t5v0__nand2_1
X_13981_ _13982_/A2 _13979_/Z _13981_/Z VSS VSS VSS VSS gf180mcu_fd_sc_mcu9t5v0__or2_1
XTAP_TAPCELL_ROW_87_3371 VSS VSS gf180mcu_fd_sc_mcu9t5v0__filltie
X_15720_ _15720_/A1 _15704_/Z _19922_/Q _15725_/B2 VSS _15720_/VNW VSS VSS gf180mcu_fd_sc_mcu9t5v0__oai21_1
X_12932_ _12924_/Z _12932_/A2 _12932_/B _12934_/A3 VSS _12932_/VNW VSS VSS gf180mcu_fd_sc_mcu9t5v0__aoi21_1
XTAP_TAPCELL_ROW_87_3382 VSS VSS gf180mcu_fd_sc_mcu9t5v0__filltie
XTAP_TAPCELL_ROW_254_6064 VSS VSS gf180mcu_fd_sc_mcu9t5v0__filltie
XTAP_TAPCELL_ROW_254_6053 VSS VSS gf180mcu_fd_sc_mcu9t5v0__filltie
XTAP_TAPCELL_ROW_254_6042 VSS VSS gf180mcu_fd_sc_mcu9t5v0__filltie
X_15651_ _15651_/A1 _15652_/A2 _19902_/D VSS _15651_/VNW VSS VSS gf180mcu_fd_sc_mcu9t5v0__nand2_1
XTAP_TAPCELL_ROW_83_3268 VSS VSS gf180mcu_fd_sc_mcu9t5v0__filltie
XTAP_TAPCELL_ROW_83_3257 VSS VSS gf180mcu_fd_sc_mcu9t5v0__filltie
XPHY_EDGE_ROW_100_Left_424 VSS VSS gf180mcu_fd_sc_mcu9t5v0__endcap
X_14602_ _19181_/Q _19480_/Q _14715_/S _19480_/D VSS VSS VSS VSS gf180mcu_fd_sc_mcu9t5v0__mux2_1
X_12863_ _19769_/Q _12862_/Z _12870_/B VSS _13271_/VNW VSS VSS gf180mcu_fd_sc_mcu9t5v0__nand2_1
X_18370_ _18370_/D _18370_/CLK _18370_/Q VSS VSS VSS VSS gf180mcu_fd_sc_mcu9t5v0__dffq_4
X_15582_ _20042_/D _15582_/A2 _15597_/B1 VSS _15582_/VNW VSS VSS gf180mcu_fd_sc_mcu9t5v0__nand2_1
X_12794_ _19726_/Q _19791_/Q _12948_/S _12794_/Z VSS VSS VSS VSS gf180mcu_fd_sc_mcu9t5v0__mux2_1
X_11814_ _18896_/Q _18897_/Q _11814_/A3 _11838_/A2 VSS _11814_/VNW VSS VSS gf180mcu_fd_sc_mcu9t5v0__nor3_1
X_17321_ _17260_/S _18532_/Q _17323_/A3 VSS VSS VSS VSS gf180mcu_fd_sc_mcu9t5v0__nor2_1
X_11745_ _18895_/Q _11746_/A2 _12147_/S _11746_/B VSS _11746_/VNW VSS VSS gf180mcu_fd_sc_mcu9t5v0__aoi21_1
X_14533_ _19167_/Q _19133_/Q _14741_/A1 VSS VSS VSS VSS gf180mcu_fd_sc_mcu9t5v0__nand2_1
X_17252_ _18545_/Q _17394_/A2 _17271_/B VSS VSS VSS VSS gf180mcu_fd_sc_mcu9t5v0__nand2_1
XTAP_TAPCELL_ROW_267_6425 VSS VSS gf180mcu_fd_sc_mcu9t5v0__filltie
XTAP_TAPCELL_ROW_267_6414 VSS VSS gf180mcu_fd_sc_mcu9t5v0__filltie
XTAP_TAPCELL_ROW_267_6403 VSS VSS gf180mcu_fd_sc_mcu9t5v0__filltie
XTAP_TAPCELL_ROW_96_3629 VSS VSS gf180mcu_fd_sc_mcu9t5v0__filltie
X_14464_ _19159_/Q _19125_/Q _14464_/Z VSS VSS VSS VSS gf180mcu_fd_sc_mcu9t5v0__xor2_1
XTAP_TAPCELL_ROW_96_3618 VSS VSS gf180mcu_fd_sc_mcu9t5v0__filltie
X_16203_ _16202_/Z _18186_/Q _16764_/S _18186_/D VSS _16203_/VNW VSS VSS gf180mcu_fd_sc_mcu9t5v0__mux2_1
X_13415_ _13415_/A1 _19776_/Q _13433_/A2 VSS VSS VSS VSS gf180mcu_fd_sc_mcu9t5v0__nor2_1
X_11676_ _12645_/C _12646_/A2 _11676_/B _12706_/A3 VSS _11676_/VNW VSS VSS gf180mcu_fd_sc_mcu9t5v0__oai21_1
X_17183_ _19860_/Q _17161_/C _17183_/B _17185_/A3 VSS VSS VSS VSS gf180mcu_fd_sc_mcu9t5v0__oai21_1
X_10627_ _10654_/A2 _10627_/A2 _10627_/A3 _10628_/B VSS VSS VSS VSS gf180mcu_fd_sc_mcu9t5v0__nand3_1
X_14395_ _14395_/A1 _14395_/A2 _19449_/D VSS VSS VSS VSS gf180mcu_fd_sc_mcu9t5v0__nand2_1
X_16134_ _16134_/A1 _16134_/A2 _16134_/B _16135_/I1 VSS VSS VSS VSS gf180mcu_fd_sc_mcu9t5v0__oai21_4
X_10558_ _17404_/S _18277_/Q _10560_/A3 VSS VSS VSS VSS gf180mcu_fd_sc_mcu9t5v0__nor2_1
XPHY_EDGE_ROW_157_2_Left_669 VSS VSS gf180mcu_fd_sc_mcu9t5v0__endcap
X_13346_ _13347_/A1 _13345_/B _13352_/A2 VSS _13346_/VNW VSS VSS gf180mcu_fd_sc_mcu9t5v0__xnor2_1
X_16065_ _19269_/Q _15996_/B _16066_/B VSS VSS VSS VSS gf180mcu_fd_sc_mcu9t5v0__nand2_1
X_13277_ _13257_/Z _13278_/A2 _13585_/B _13297_/A2 VSS _13278_/VNW VSS VSS gf180mcu_fd_sc_mcu9t5v0__oai21_1
X_10489_ _18162_/Q _17406_/A2 _17405_/A2 _18178_/Q _10490_/B VSS VSS VSS VSS gf180mcu_fd_sc_mcu9t5v0__aoi22_1
X_12228_ wire208/I _12228_/A2 _12232_/B1 VSS _17964_/VNW VSS VSS gf180mcu_fd_sc_mcu9t5v0__nand2_1
XTAP_TAPCELL_ROW_72_2950 VSS VSS gf180mcu_fd_sc_mcu9t5v0__filltie
X_15016_ _19434_/Q _19435_/Q _19377_/Q _15017_/A4 VSS VSS VSS VSS gf180mcu_fd_sc_mcu9t5v0__oai21_1
XTAP_TAPCELL_ROW_141_3_8016 VSS VSS gf180mcu_fd_sc_mcu9t5v0__filltie
XTAP_TAPCELL_ROW_72_2972 VSS VSS gf180mcu_fd_sc_mcu9t5v0__filltie
XTAP_TAPCELL_ROW_72_2961 VSS VSS gf180mcu_fd_sc_mcu9t5v0__filltie
X_12159_ _18463_/Q _12181_/A2 _12159_/B _12160_/B2 VSS VSS VSS VSS gf180mcu_fd_sc_mcu9t5v0__aoi21_1
X_19824_ _19824_/D _20144_/RN clkload58/I _19824_/Q VSS VSS VSS VSS gf180mcu_fd_sc_mcu9t5v0__dffrnq_1
X_16967_ _19246_/Q _16584_/B _16991_/S _16967_/Z VSS VSS VSS VSS gf180mcu_fd_sc_mcu9t5v0__mux2_1
X_19755_ _19755_/D _20139_/RN _19806_/CLK _19755_/Q VSS VSS VSS VSS gf180mcu_fd_sc_mcu9t5v0__dffrnq_1
X_15918_ _20127_/Q _19248_/Q _15920_/S _20127_/D VSS VSS VSS VSS gf180mcu_fd_sc_mcu9t5v0__mux2_1
X_18706_ _18706_/D clkload48/I _18706_/Q VSS VSS VSS VSS gf180mcu_fd_sc_mcu9t5v0__dffq_1
Xclkbuf_leaf_54_clk_regs clkload2/I clkload41/I VSS VSS VSS VSS gf180mcu_fd_sc_mcu9t5v0__clkbuf_8
X_16898_ _16897_/Z _18441_/Q _16910_/S _18441_/D VSS VSS VSS VSS gf180mcu_fd_sc_mcu9t5v0__mux2_1
X_19686_ _19686_/D _20070_/RN clkload15/I _19686_/Q VSS VSS VSS VSS gf180mcu_fd_sc_mcu9t5v0__dffrnq_1
X_15849_ _20141_/Q _09758_/B _17529_/S VSS VSS VSS VSS gf180mcu_fd_sc_mcu9t5v0__nand2_1
X_18637_ _18637_/D _20041_/RN clkload48/I _18637_/Q VSS VSS VSS VSS gf180mcu_fd_sc_mcu9t5v0__dffrnq_1
XTAP_TAPCELL_ROW_237_5594 VSS VSS gf180mcu_fd_sc_mcu9t5v0__filltie
XTAP_TAPCELL_ROW_237_5583 VSS VSS gf180mcu_fd_sc_mcu9t5v0__filltie
X_09370_ _18489_/Q _12492_/A1 VSS VSS VSS VSS gf180mcu_fd_sc_mcu9t5v0__clkinv_1
X_18568_ _18568_/D _20068_/RN clkload54/I _18568_/Q VSS VSS VSS VSS gf180mcu_fd_sc_mcu9t5v0__dffrnq_4
XTAP_TAPCELL_ROW_66_2787 VSS VSS gf180mcu_fd_sc_mcu9t5v0__filltie
XTAP_TAPCELL_ROW_66_2798 VSS VSS gf180mcu_fd_sc_mcu9t5v0__filltie
X_17519_ input6/Z _18624_/Q _17521_/S _18624_/D VSS VSS VSS VSS gf180mcu_fd_sc_mcu9t5v0__mux2_1
X_18499_ _18499_/D clkload76/I _18499_/Q VSS VSS VSS VSS gf180mcu_fd_sc_mcu9t5v0__dffq_1
XTAP_TAPCELL_ROW_233_5469 VSS VSS gf180mcu_fd_sc_mcu9t5v0__filltie
XTAP_TAPCELL_ROW_19_1510 VSS VSS gf180mcu_fd_sc_mcu9t5v0__filltie
XTAP_TAPCELL_ROW_321_7890 VSS VSS gf180mcu_fd_sc_mcu9t5v0__filltie
XTAP_TAPCELL_ROW_15_1407 VSS VSS gf180mcu_fd_sc_mcu9t5v0__filltie
X_09706_ _17599_/A1 _17601_/A1 _17532_/A2 VSS VSS VSS VSS gf180mcu_fd_sc_mcu9t5v0__nand2_1
X_09637_ _15946_/A3 _09637_/A2 _19996_/Q input9/Z _15820_/B1 VSS _15837_/VNW VSS VSS
+ gf180mcu_fd_sc_mcu9t5v0__oai211_2
X_09568_ _10693_/B _09575_/B VSS VSS VSS VSS gf180mcu_fd_sc_mcu9t5v0__clkinv_1
X_11530_ _11530_/A1 _11530_/A2 _19104_/D VSS _11542_/VNW VSS VSS gf180mcu_fd_sc_mcu9t5v0__nand2_1
X_09499_ _19174_/Q _14730_/S _09511_/B _12622_/A1 VSS VSS VSS VSS gf180mcu_fd_sc_mcu9t5v0__aoi21_4
XTAP_TAPCELL_ROW_216_4999 VSS VSS gf180mcu_fd_sc_mcu9t5v0__filltie
XTAP_TAPCELL_ROW_134_4677 VSS VSS gf180mcu_fd_sc_mcu9t5v0__filltie
XTAP_TAPCELL_ROW_134_4666 VSS VSS gf180mcu_fd_sc_mcu9t5v0__filltie
XTAP_TAPCELL_ROW_134_4655 VSS VSS gf180mcu_fd_sc_mcu9t5v0__filltie
X_11461_ _11461_/A1 _11461_/A2 _11788_/B _11462_/B2 VSS VSS VSS VSS gf180mcu_fd_sc_mcu9t5v0__aoi21_2
X_11392_ wire283/I _11392_/A2 _11392_/B _11394_/B2 VSS VSS VSS VSS gf180mcu_fd_sc_mcu9t5v0__aoi21_1
X_10412_ _20084_/Q _17408_/B _10413_/A3 VSS VSS VSS VSS gf180mcu_fd_sc_mcu9t5v0__nand2_1
XTAP_TAPCELL_ROW_76_3083 VSS VSS gf180mcu_fd_sc_mcu9t5v0__filltie
X_13200_ _16434_/A1 _13497_/B _13200_/B1 _13200_/B2 _19241_/D VSS VSS VSS VSS gf180mcu_fd_sc_mcu9t5v0__aoi22_1
XTAP_TAPCELL_ROW_76_3072 VSS VSS gf180mcu_fd_sc_mcu9t5v0__filltie
X_14180_ _14365_/I0 _19335_/Q _14266_/S _19335_/D VSS VSS VSS VSS gf180mcu_fd_sc_mcu9t5v0__mux2_1
XTAP_TAPCELL_ROW_76_3061 VSS VSS gf180mcu_fd_sc_mcu9t5v0__filltie
X_10343_ _17260_/S _18269_/Q _10345_/A3 VSS VSS VSS VSS gf180mcu_fd_sc_mcu9t5v0__nor2_1
X_13131_ _19760_/Q _13131_/A2 _13151_/A2 VSS VSS VSS VSS gf180mcu_fd_sc_mcu9t5v0__nor2_1
X_10274_ _20094_/Q _17304_/C wire168/I _10274_/C _10276_/A2 VSS VSS VSS VSS gf180mcu_fd_sc_mcu9t5v0__oai211_1
X_13062_ _13184_/A1 _13082_/A2 _13061_/Z _13062_/Z VSS _13529_/VNW VSS VSS gf180mcu_fd_sc_mcu9t5v0__or3_1
XTAP_TAPCELL_ROW_89_3422 VSS VSS gf180mcu_fd_sc_mcu9t5v0__filltie
XPHY_EDGE_ROW_296_Left_619 VSS VSS gf180mcu_fd_sc_mcu9t5v0__endcap
X_12013_ _18361_/Q _12046_/S _12015_/A2 VSS VSS VSS VSS gf180mcu_fd_sc_mcu9t5v0__nor2_1
X_17870_ _09416_/C _17885_/S _17870_/A3 _17879_/A2 VSS _17870_/VNW VSS VSS gf180mcu_fd_sc_mcu9t5v0__nand3_1
XTAP_TAPCELL_ROW_89_3433 VSS VSS gf180mcu_fd_sc_mcu9t5v0__filltie
XTAP_TAPCELL_ROW_256_6115 VSS VSS gf180mcu_fd_sc_mcu9t5v0__filltie
X_16821_ _19289_/Q _16829_/A2 _16823_/A1 VSS VSS VSS VSS gf180mcu_fd_sc_mcu9t5v0__nand2_1
XTAP_TAPCELL_ROW_256_6104 VSS VSS gf180mcu_fd_sc_mcu9t5v0__filltie
XTAP_TAPCELL_ROW_85_3319 VSS VSS gf180mcu_fd_sc_mcu9t5v0__filltie
XTAP_TAPCELL_ROW_85_3308 VSS VSS gf180mcu_fd_sc_mcu9t5v0__filltie
X_16752_ _16752_/A1 _16752_/A2 _16752_/B _16753_/I1 VSS _16752_/VNW VSS VSS gf180mcu_fd_sc_mcu9t5v0__oai21_4
X_19540_ _19540_/D _20052_/RN clkload16/I _19540_/Q VSS VSS VSS VSS gf180mcu_fd_sc_mcu9t5v0__dffrnq_1
X_15703_ _15705_/B _15703_/A2 _15703_/A3 _15703_/Z VSS VSS VSS VSS gf180mcu_fd_sc_mcu9t5v0__and3_1
X_13964_ _13995_/A1 _14003_/A1 _13964_/Z VSS _13966_/VNW VSS VSS gf180mcu_fd_sc_mcu9t5v0__xor2_1
XTAP_TAPCELL_ROW_5_1130 VSS VSS gf180mcu_fd_sc_mcu9t5v0__filltie
X_16683_ _19277_/Q _16695_/B _16684_/C VSS VSS VSS VSS gf180mcu_fd_sc_mcu9t5v0__nor2_1
X_12915_ _19776_/Q _12914_/Z _12930_/A1 VSS VSS VSS VSS gf180mcu_fd_sc_mcu9t5v0__nand2_1
X_13895_ _13855_/Z _13887_/I _13895_/A3 _13895_/Z VSS VSS VSS VSS gf180mcu_fd_sc_mcu9t5v0__xor3_1
XTAP_TAPCELL_ROW_1_1005 VSS VSS gf180mcu_fd_sc_mcu9t5v0__filltie
X_19471_ _19471_/D _20047_/RN clkload29/I _19471_/Q VSS VSS VSS VSS gf180mcu_fd_sc_mcu9t5v0__dffrnq_1
X_18422_ _18422_/D clkload77/I _18422_/Q VSS VSS VSS VSS gf180mcu_fd_sc_mcu9t5v0__dffq_1
X_15634_ _15634_/A1 _15636_/A2 _15634_/Z VSS VSS VSS VSS gf180mcu_fd_sc_mcu9t5v0__and2_1
X_12846_ _19766_/Q _12846_/A2 _12847_/I0 VSS _13248_/VNW VSS VSS gf180mcu_fd_sc_mcu9t5v0__xnor2_1
XTAP_TAPCELL_ROW_1_1016 VSS VSS gf180mcu_fd_sc_mcu9t5v0__filltie
X_18353_ _18353_/D clkload74/I _18353_/Q VSS VSS VSS VSS gf180mcu_fd_sc_mcu9t5v0__dffq_1
X_15565_ _19875_/Q _15561_/Z _15566_/A3 VSS _15566_/VNW VSS VSS gf180mcu_fd_sc_mcu9t5v0__nor2_1
X_17304_ _19828_/Q _17304_/A2 _17304_/B _17304_/C _17306_/B1 VSS VSS VSS VSS gf180mcu_fd_sc_mcu9t5v0__oai211_1
X_12777_ _12776_/Z _19201_/Q _13320_/B _19201_/D VSS VSS VSS VSS gf180mcu_fd_sc_mcu9t5v0__mux2_1
XTAP_TAPCELL_ROW_61_2651 VSS VSS gf180mcu_fd_sc_mcu9t5v0__filltie
XTAP_TAPCELL_ROW_61_2662 VSS VSS gf180mcu_fd_sc_mcu9t5v0__filltie
X_14516_ _14517_/A1 _14735_/A1 _14518_/A1 VSS VSS VSS VSS gf180mcu_fd_sc_mcu9t5v0__nor2_1
XTAP_TAPCELL_ROW_61_2673 VSS VSS gf180mcu_fd_sc_mcu9t5v0__filltie
X_15496_ _19835_/Q input5/Z _15502_/S _15496_/Z VSS _15497_/VNW VSS VSS gf180mcu_fd_sc_mcu9t5v0__mux2_1
X_18284_ _18284_/D clkload59/I _18284_/Q VSS VSS VSS VSS gf180mcu_fd_sc_mcu9t5v0__dffq_1
X_11728_ _11748_/A1 _11748_/A2 _12164_/B _11738_/A1 VSS VSS VSS VSS gf180mcu_fd_sc_mcu9t5v0__oai21_1
X_17235_ _18416_/Q _17282_/A2 _17282_/B1 _18432_/Q _17235_/C _17243_/A2 VSS _17235_/VNW
+ VSS VSS gf180mcu_fd_sc_mcu9t5v0__aoi221_1
XPHY_EDGE_ROW_104_Right_104 VSS VSS gf180mcu_fd_sc_mcu9t5v0__endcap
X_11659_ _11659_/A1 _11659_/A2 _11633_/B _11659_/B2 _11660_/B1 VSS _11659_/VNW VSS
+ VSS gf180mcu_fd_sc_mcu9t5v0__aoi22_1
X_14447_ _14447_/A1 _14766_/A2 _14447_/B1 _14447_/B2 _19454_/D VSS _14447_/VNW VSS
+ VSS gf180mcu_fd_sc_mcu9t5v0__aoi22_1
X_17166_ _17195_/A1 _18381_/Q _17169_/A2 VSS _17167_/VNW VSS VSS gf180mcu_fd_sc_mcu9t5v0__nor2_1
X_14378_ _14378_/A1 _14378_/A2 _19443_/D VSS _14378_/VNW VSS VSS gf180mcu_fd_sc_mcu9t5v0__nand2_1
X_16117_ _16700_/A2 _16714_/A3 _16695_/B _16117_/C _16119_/B VSS VSS VSS VSS gf180mcu_fd_sc_mcu9t5v0__oai211_1
X_13329_ _19740_/Q _13331_/A2 _13330_/I VSS _13329_/VNW VSS VSS gf180mcu_fd_sc_mcu9t5v0__nand2_1
X_17097_ _18537_/Q _17420_/S _17098_/B VSS VSS VSS VSS gf180mcu_fd_sc_mcu9t5v0__nand2_1
XTAP_TAPCELL_ROW_70_2909 VSS VSS gf180mcu_fd_sc_mcu9t5v0__filltie
X_16048_ _19267_/Q _15996_/B _16054_/B VSS _16048_/VNW VSS VSS gf180mcu_fd_sc_mcu9t5v0__nand2_1
XTAP_TAPCELL_ROW_241_5705 VSS VSS gf180mcu_fd_sc_mcu9t5v0__filltie
XTAP_TAPCELL_ROW_226_5284 VSS VSS gf180mcu_fd_sc_mcu9t5v0__filltie
XTAP_TAPCELL_ROW_226_5273 VSS VSS gf180mcu_fd_sc_mcu9t5v0__filltie
XTAP_TAPCELL_ROW_55_2488 VSS VSS gf180mcu_fd_sc_mcu9t5v0__filltie
XTAP_TAPCELL_ROW_55_2499 VSS VSS gf180mcu_fd_sc_mcu9t5v0__filltie
XTAP_TAPCELL_ROW_226_5295 VSS VSS gf180mcu_fd_sc_mcu9t5v0__filltie
X_19807_ _19807_/D _20063_/RN clkload36/I _19807_/Q VSS VSS VSS VSS gf180mcu_fd_sc_mcu9t5v0__dffrnq_1
X_17999_ _18885_/Q _18032_/I0 _18004_/S _18885_/D VSS VSS VSS VSS gf180mcu_fd_sc_mcu9t5v0__mux2_1
XTAP_TAPCELL_ROW_239_5656 VSS VSS gf180mcu_fd_sc_mcu9t5v0__filltie
XTAP_TAPCELL_ROW_239_5645 VSS VSS gf180mcu_fd_sc_mcu9t5v0__filltie
XTAP_TAPCELL_ROW_239_5634 VSS VSS gf180mcu_fd_sc_mcu9t5v0__filltie
X_19738_ _19738_/D _20058_/RN clkload22/I _19738_/Q VSS VSS VSS VSS gf180mcu_fd_sc_mcu9t5v0__dffrnq_1
XTAP_TAPCELL_ROW_68_2849 VSS VSS gf180mcu_fd_sc_mcu9t5v0__filltie
X_19669_ _19669_/D _20053_/RN clkload23/I _19669_/Q VSS VSS VSS VSS gf180mcu_fd_sc_mcu9t5v0__dffrnq_1
X_09422_ _18566_/Q _17435_/A1 _10064_/S VSS VSS VSS VSS gf180mcu_fd_sc_mcu9t5v0__nor2_2
XPHY_EDGE_ROW_142_3_Left_800 VSS VSS gf180mcu_fd_sc_mcu9t5v0__endcap
XPHY_EDGE_ROW_149_1_Left_472 VSS VSS gf180mcu_fd_sc_mcu9t5v0__endcap
X_09353_ _19891_/Q _15620_/B VSS VSS VSS VSS gf180mcu_fd_sc_mcu9t5v0__clkinv_1
XTAP_TAPCELL_ROW_310_7591 VSS VSS gf180mcu_fd_sc_mcu9t5v0__filltie
X_09284_ _20035_/Q _09880_/A2 VSS VSS VSS VSS gf180mcu_fd_sc_mcu9t5v0__clkinv_1
XPHY_EDGE_ROW_204_3_Left_862 VSS VSS gf180mcu_fd_sc_mcu9t5v0__endcap
XTAP_TAPCELL_ROW_211_4863 VSS VSS gf180mcu_fd_sc_mcu9t5v0__filltie
XTAP_TAPCELL_ROW_323_7963 VSS VSS gf180mcu_fd_sc_mcu9t5v0__filltie
XTAP_TAPCELL_ROW_323_7952 VSS VSS gf180mcu_fd_sc_mcu9t5v0__filltie
XTAP_TAPCELL_ROW_323_7941 VSS VSS gf180mcu_fd_sc_mcu9t5v0__filltie
XTAP_TAPCELL_ROW_211_4885 VSS VSS gf180mcu_fd_sc_mcu9t5v0__filltie
XTAP_TAPCELL_ROW_211_4874 VSS VSS gf180mcu_fd_sc_mcu9t5v0__filltie
XTAP_TAPCELL_ROW_323_7996 VSS VSS gf180mcu_fd_sc_mcu9t5v0__filltie
XTAP_TAPCELL_ROW_323_7985 VSS VSS gf180mcu_fd_sc_mcu9t5v0__filltie
XTAP_TAPCELL_ROW_323_7974 VSS VSS gf180mcu_fd_sc_mcu9t5v0__filltie
XTAP_TAPCELL_ROW_209_4781 VSS VSS gf180mcu_fd_sc_mcu9t5v0__filltie
XTAP_TAPCELL_ROW_209_4792 VSS VSS gf180mcu_fd_sc_mcu9t5v0__filltie
XPHY_EDGE_ROW_137_3_Left_795 VSS VSS gf180mcu_fd_sc_mcu9t5v0__endcap
XTAP_TAPCELL_ROW_127_4481 VSS VSS gf180mcu_fd_sc_mcu9t5v0__filltie
XTAP_TAPCELL_ROW_127_4470 VSS VSS gf180mcu_fd_sc_mcu9t5v0__filltie
XTAP_TAPCELL_ROW_123_4356 VSS VSS gf180mcu_fd_sc_mcu9t5v0__filltie
XTAP_TAPCELL_ROW_317_7789 VSS VSS gf180mcu_fd_sc_mcu9t5v0__filltie
XTAP_TAPCELL_ROW_317_7778 VSS VSS gf180mcu_fd_sc_mcu9t5v0__filltie
XTAP_TAPCELL_ROW_123_4378 VSS VSS gf180mcu_fd_sc_mcu9t5v0__filltie
XTAP_TAPCELL_ROW_123_4367 VSS VSS gf180mcu_fd_sc_mcu9t5v0__filltie
XPHY_EDGE_ROW_255_Right_182 VSS VSS gf180mcu_fd_sc_mcu9t5v0__endcap
X_10961_ _18923_/Q _18932_/Q _18044_/B _10963_/A2 VSS VSS VSS VSS gf180mcu_fd_sc_mcu9t5v0__oai21_1
X_13680_ _19451_/Q _13733_/A2 _14286_/A2 _19442_/Q _13681_/A2 VSS VSS VSS VSS gf180mcu_fd_sc_mcu9t5v0__aoi22_1
X_12700_ _12722_/A1 _12699_/Z _12700_/B _19185_/D VSS VSS VSS VSS gf180mcu_fd_sc_mcu9t5v0__oai21_1
X_10892_ _16436_/A1 _18147_/S _10892_/B _10893_/I0 VSS VSS VSS VSS gf180mcu_fd_sc_mcu9t5v0__oai21_1
X_12631_ _12631_/I0 _19175_/Q _12655_/S _19175_/D VSS VSS VSS VSS gf180mcu_fd_sc_mcu9t5v0__mux2_1
X_15350_ _19746_/Q _15350_/I1 _15364_/S _19746_/D VSS VSS VSS VSS gf180mcu_fd_sc_mcu9t5v0__mux2_1
XTAP_TAPCELL_ROW_78_3134 VSS VSS gf180mcu_fd_sc_mcu9t5v0__filltie
X_12562_ wire175/Z wire122/Z _12618_/B _12564_/A3 VSS VSS VSS VSS gf180mcu_fd_sc_mcu9t5v0__aoi21_1
XTAP_TAPCELL_ROW_78_3123 VSS VSS gf180mcu_fd_sc_mcu9t5v0__filltie
Xwire122 wire122/I wire122/Z VSS VSS VSS VSS gf180mcu_fd_sc_mcu9t5v0__clkbuf_4
X_11513_ wire136/Z _11508_/Z _11513_/B wire283/Z _11514_/A2 VSS VSS VSS VSS gf180mcu_fd_sc_mcu9t5v0__oai211_1
X_12493_ _18441_/Q _12501_/A2 _12541_/B _12493_/C _12494_/B VSS _12493_/VNW VSS VSS
+ gf180mcu_fd_sc_mcu9t5v0__oai211_1
X_15281_ _19633_/Q _19610_/Q _19632_/Q _19609_/Q _15283_/A2 VSS VSS VSS VSS gf180mcu_fd_sc_mcu9t5v0__aoi22_1
XTAP_TAPCELL_ROW_74_3009 VSS VSS gf180mcu_fd_sc_mcu9t5v0__filltie
X_14301_ _14214_/Z _19374_/Q _14304_/S _19374_/D VSS _15274_/VNW VSS VSS gf180mcu_fd_sc_mcu9t5v0__mux2_1
X_17020_ _18501_/Q _17019_/Z _17020_/S _18501_/D VSS _17020_/VNW VSS VSS gf180mcu_fd_sc_mcu9t5v0__mux2_4
X_11444_ _18401_/Q _11524_/S _11445_/C VSS VSS VSS VSS gf180mcu_fd_sc_mcu9t5v0__or2_1
Xwire166 wire166/I wire166/Z VSS wire166/VNW VSS VSS gf180mcu_fd_sc_mcu9t5v0__buf_4
X_14232_ _14190_/I _14242_/A2 _14241_/A2 VSS _14253_/VNW VSS VSS gf180mcu_fd_sc_mcu9t5v0__xnor2_1
Xwire199 wire199/I wire199/Z VSS wire199/VNW VSS VSS gf180mcu_fd_sc_mcu9t5v0__buf_4
XTAP_TAPCELL_ROW_281_6797 VSS VSS gf180mcu_fd_sc_mcu9t5v0__filltie
X_11375_ _11429_/B _11374_/Z _11375_/B _11379_/A2 VSS VSS VSS VSS gf180mcu_fd_sc_mcu9t5v0__oai21_1
XTAP_TAPCELL_ROW_281_6786 VSS VSS gf180mcu_fd_sc_mcu9t5v0__filltie
X_14163_ _19322_/Q _14162_/Z _19192_/D _19322_/D VSS VSS VSS VSS gf180mcu_fd_sc_mcu9t5v0__mux2_1
X_18971_ _18971_/D _20059_/RN _20132_/CLK _18971_/Q VSS VSS VSS VSS gf180mcu_fd_sc_mcu9t5v0__dffrnq_1
X_10326_ _10326_/A1 _10326_/A2 _10326_/B1 _10326_/B2 _10327_/A2 VSS VSS VSS VSS gf180mcu_fd_sc_mcu9t5v0__aoi22_1
X_13114_ _13116_/A1 _19793_/Q _13115_/I VSS _13115_/VNW VSS VSS gf180mcu_fd_sc_mcu9t5v0__nand2_1
X_14094_ _14070_/I _14103_/A2 _14096_/A2 VSS VSS VSS VSS gf180mcu_fd_sc_mcu9t5v0__xnor2_1
X_10257_ _18955_/Q wire165/Z _10652_/B1 _18971_/Q _10258_/A3 VSS _10451_/VNW VSS VSS
+ gf180mcu_fd_sc_mcu9t5v0__aoi22_1
Xload_slew116 _10809_/B _10655_/B VSS VSS VSS VSS gf180mcu_fd_sc_mcu9t5v0__clkbuf_8
Xload_slew127 _18102_/B _18148_/S VSS VSS VSS VSS gf180mcu_fd_sc_mcu9t5v0__clkbuf_16
X_13045_ _19723_/Q _13046_/A2 _13065_/A2 VSS VSS VSS VSS gf180mcu_fd_sc_mcu9t5v0__nand2_1
X_17922_ _17968_/A1 _17922_/A2 _17923_/I VSS VSS VSS VSS gf180mcu_fd_sc_mcu9t5v0__nand2_1
Xload_slew149 _11429_/B _11469_/B VSS VSS VSS VSS gf180mcu_fd_sc_mcu9t5v0__buf_8
XTAP_TAPCELL_ROW_50_2352 VSS VSS gf180mcu_fd_sc_mcu9t5v0__filltie
Xeco14_skew_7 clkload82/I _18518_/CLK VSS VSS VSS VSS gf180mcu_fd_sc_mcu9t5v0__clkbuf_16
X_17853_ _18825_/Q _17850_/Z _17853_/Z VSS VSS VSS VSS gf180mcu_fd_sc_mcu9t5v0__and2_1
X_10188_ _10189_/S _14267_/A2 _14322_/S VSS VSS VSS VSS gf180mcu_fd_sc_mcu9t5v0__nand2_2
XTAP_TAPCELL_ROW_50_2363 VSS VSS gf180mcu_fd_sc_mcu9t5v0__filltie
X_16804_ _18399_/Q _16804_/I1 _16818_/S _18399_/D VSS VSS VSS VSS gf180mcu_fd_sc_mcu9t5v0__mux2_4
X_17784_ _18766_/Q _17782_/B _17784_/Z VSS _17784_/VNW VSS VSS gf180mcu_fd_sc_mcu9t5v0__and2_1
X_14996_ _14996_/A1 _14994_/Z _14997_/A2 VSS VSS VSS VSS gf180mcu_fd_sc_mcu9t5v0__xnor2_1
X_16735_ _16750_/A1 _16750_/A2 _16672_/B _16735_/B2 _16736_/A3 VSS _16745_/VNW VSS
+ VSS gf180mcu_fd_sc_mcu9t5v0__aoi22_1
Xload_slew41 _16302_/ZN _16864_/S VSS VSS VSS VSS gf180mcu_fd_sc_mcu9t5v0__clkbuf_16
XTAP_TAPCELL_ROW_136_3_8000 VSS VSS gf180mcu_fd_sc_mcu9t5v0__filltie
XTAP_TAPCELL_ROW_106_3897 VSS VSS gf180mcu_fd_sc_mcu9t5v0__filltie
X_13947_ _13948_/A1 _13948_/A2 _13950_/A2 VSS VSS VSS VSS gf180mcu_fd_sc_mcu9t5v0__nand2_1
X_19523_ _19523_/D _20035_/RN clkload28/I _19523_/Q VSS VSS VSS VSS gf180mcu_fd_sc_mcu9t5v0__dffrnq_1
XTAP_TAPCELL_ROW_106_3886 VSS VSS gf180mcu_fd_sc_mcu9t5v0__filltie
X_16666_ _16666_/A1 _16672_/A2 _16672_/B _16668_/B VSS VSS VSS VSS gf180mcu_fd_sc_mcu9t5v0__oai21_2
Xload_slew52 _16897_/S _16925_/S VSS VSS VSS VSS gf180mcu_fd_sc_mcu9t5v0__buf_8
Xload_slew63 _17673_/S _17742_/S VSS VSS VSS VSS gf180mcu_fd_sc_mcu9t5v0__clkbuf_8
XTAP_TAPCELL_ROW_63_2702 VSS VSS gf180mcu_fd_sc_mcu9t5v0__filltie
X_19454_ _19454_/D _20030_/RN _19798_/CLK _19454_/Q VSS VSS VSS VSS gf180mcu_fd_sc_mcu9t5v0__dffrnq_1
XTAP_TAPCELL_ROW_63_2713 VSS VSS gf180mcu_fd_sc_mcu9t5v0__filltie
XTAP_TAPCELL_ROW_63_2724 VSS VSS gf180mcu_fd_sc_mcu9t5v0__filltie
X_18405_ _18405_/D clkload78/I _18405_/Q VSS VSS VSS VSS gf180mcu_fd_sc_mcu9t5v0__dffq_1
X_15617_ _15617_/A1 _15617_/A2 _15677_/B _19890_/D VSS VSS VSS VSS gf180mcu_fd_sc_mcu9t5v0__oai21_1
X_13878_ _13879_/A1 _13879_/A2 _13909_/A1 VSS VSS VSS VSS gf180mcu_fd_sc_mcu9t5v0__nand2_1
XTAP_TAPCELL_ROW_48_2292 VSS VSS gf180mcu_fd_sc_mcu9t5v0__filltie
XTAP_TAPCELL_ROW_230_5406 VSS VSS gf180mcu_fd_sc_mcu9t5v0__filltie
X_16597_ input5/Z _18782_/Q _16597_/S _16597_/Z VSS VSS VSS VSS gf180mcu_fd_sc_mcu9t5v0__mux2_1
X_12829_ _19763_/Q _12828_/Z _12836_/A2 VSS VSS VSS VSS gf180mcu_fd_sc_mcu9t5v0__nor2_1
X_19385_ _19385_/D _20025_/RN _19633_/CLK _19385_/Q VSS VSS VSS VSS gf180mcu_fd_sc_mcu9t5v0__dffrnq_1
X_18336_ _18336_/D clkload75/I _18336_/Q VSS VSS VSS VSS gf180mcu_fd_sc_mcu9t5v0__dffq_1
X_15548_ _19866_/Q _19873_/Q _15551_/S _19866_/D VSS VSS VSS VSS gf180mcu_fd_sc_mcu9t5v0__mux2_1
XTAP_TAPCELL_ROW_44_2189 VSS VSS gf180mcu_fd_sc_mcu9t5v0__filltie
X_18267_ _18267_/D clkload61/I _18267_/Q VSS VSS VSS VSS gf180mcu_fd_sc_mcu9t5v0__dffq_1
X_15479_ _15544_/S _15479_/A2 _15552_/B VSS VSS VSS VSS gf180mcu_fd_sc_mcu9t5v0__nand2_1
X_17218_ _19828_/Q _17218_/A2 _17219_/C VSS VSS VSS VSS gf180mcu_fd_sc_mcu9t5v0__nand2_1
X_18198_ _18198_/D clkload82/I _18198_/Q VSS VSS VSS VSS gf180mcu_fd_sc_mcu9t5v0__dffq_1
XTAP_TAPCELL_ROW_228_5335 VSS VSS gf180mcu_fd_sc_mcu9t5v0__filltie
XTAP_TAPCELL_ROW_57_2539 VSS VSS gf180mcu_fd_sc_mcu9t5v0__filltie
X_17149_ _18492_/Q _17380_/B1 _17155_/B1 VSS _17149_/VNW VSS VSS gf180mcu_fd_sc_mcu9t5v0__nand2_1
XTAP_TAPCELL_ROW_228_5346 VSS VSS gf180mcu_fd_sc_mcu9t5v0__filltie
X_09971_ _10180_/B1 _09971_/A2 _09971_/A3 _09975_/B VSS _09971_/VNW VSS VSS gf180mcu_fd_sc_mcu9t5v0__nand3_1
X_20091_ _20091_/D clkload76/I _20091_/Q VSS VSS VSS VSS gf180mcu_fd_sc_mcu9t5v0__dffq_1
XTAP_TAPCELL_ROW_291_7071 VSS VSS gf180mcu_fd_sc_mcu9t5v0__filltie
XTAP_TAPCELL_ROW_291_7060 VSS VSS gf180mcu_fd_sc_mcu9t5v0__filltie
XTAP_TAPCELL_ROW_33_1882 VSS VSS gf180mcu_fd_sc_mcu9t5v0__filltie
XTAP_TAPCELL_ROW_33_1893 VSS VSS gf180mcu_fd_sc_mcu9t5v0__filltie
XTAP_TAPCELL_ROW_291_7082 VSS VSS gf180mcu_fd_sc_mcu9t5v0__filltie
XTAP_TAPCELL_ROW_312_7642 VSS VSS gf180mcu_fd_sc_mcu9t5v0__filltie
XTAP_TAPCELL_ROW_312_7664 VSS VSS gf180mcu_fd_sc_mcu9t5v0__filltie
XTAP_TAPCELL_ROW_312_7653 VSS VSS gf180mcu_fd_sc_mcu9t5v0__filltie
X_09405_ _20054_/Q _19997_/Q wire216/I _15802_/S VSS VSS VSS VSS gf180mcu_fd_sc_mcu9t5v0__nand3_2
X_09336_ _19210_/Q _18132_/A1 VSS VSS VSS VSS gf180mcu_fd_sc_mcu9t5v0__clkinv_1
XTAP_TAPCELL_ROW_213_4925 VSS VSS gf180mcu_fd_sc_mcu9t5v0__filltie
XTAP_TAPCELL_ROW_213_4936 VSS VSS gf180mcu_fd_sc_mcu9t5v0__filltie
X_09267_ _20048_/Q _10201_/A1 VSS VSS VSS VSS gf180mcu_fd_sc_mcu9t5v0__clkinv_1
XTAP_TAPCELL_ROW_116_4171 VSS VSS gf180mcu_fd_sc_mcu9t5v0__filltie
XTAP_TAPCELL_ROW_116_4160 VSS VSS gf180mcu_fd_sc_mcu9t5v0__filltie
XTAP_TAPCELL_ROW_116_4182 VSS VSS gf180mcu_fd_sc_mcu9t5v0__filltie
XTAP_TAPCELL_ROW_112_4068 VSS VSS gf180mcu_fd_sc_mcu9t5v0__filltie
XTAP_TAPCELL_ROW_112_4057 VSS VSS gf180mcu_fd_sc_mcu9t5v0__filltie
X_09198_ _19170_/Q _14567_/A1 VSS VSS VSS VSS gf180mcu_fd_sc_mcu9t5v0__clkinv_1
XTAP_TAPCELL_ROW_306_7479 VSS VSS gf180mcu_fd_sc_mcu9t5v0__filltie
X_11160_ _11526_/B _11160_/A2 _11160_/A3 _11164_/B1 VSS VSS VSS VSS gf180mcu_fd_sc_mcu9t5v0__nand3_1
XTAP_TAPCELL_ROW_298_7258 VSS VSS gf180mcu_fd_sc_mcu9t5v0__filltie
XTAP_TAPCELL_ROW_129_4543 VSS VSS gf180mcu_fd_sc_mcu9t5v0__filltie
XTAP_TAPCELL_ROW_129_4532 VSS VSS gf180mcu_fd_sc_mcu9t5v0__filltie
XTAP_TAPCELL_ROW_129_4521 VSS VSS gf180mcu_fd_sc_mcu9t5v0__filltie
XTAP_TAPCELL_ROW_298_7269 VSS VSS gf180mcu_fd_sc_mcu9t5v0__filltie
X_11091_ _18568_/Q _09395_/I _11091_/B wire283/I VSS VSS VSS VSS gf180mcu_fd_sc_mcu9t5v0__aoi21_2
XTAP_TAPCELL_ROW_142_3_8021 VSS VSS gf180mcu_fd_sc_mcu9t5v0__filltie
XTAP_TAPCELL_ROW_125_4407 VSS VSS gf180mcu_fd_sc_mcu9t5v0__filltie
X_10111_ _10180_/B1 _10111_/A2 _10111_/A3 _10114_/A1 VSS _10111_/VNW VSS VSS gf180mcu_fd_sc_mcu9t5v0__nand3_1
X_10042_ _10133_/B1 _10042_/A2 _10042_/B _10042_/C _10044_/B1 VSS VSS VSS VSS gf180mcu_fd_sc_mcu9t5v0__aoi211_1
XTAP_TAPCELL_ROW_125_4429 VSS VSS gf180mcu_fd_sc_mcu9t5v0__filltie
XTAP_TAPCELL_ROW_125_4418 VSS VSS gf180mcu_fd_sc_mcu9t5v0__filltie
X_14850_ _19579_/Q _14850_/I1 _15163_/S _19579_/D VSS VSS VSS VSS gf180mcu_fd_sc_mcu9t5v0__mux2_1
X_13801_ _13795_/Z _13829_/A2 _13831_/A1 VSS VSS VSS VSS gf180mcu_fd_sc_mcu9t5v0__nand2_1
X_14781_ _19567_/Q _14780_/Z _20039_/D _19567_/D VSS VSS VSS VSS gf180mcu_fd_sc_mcu9t5v0__mux2_1
X_11993_ _18232_/Q _12340_/S _11997_/A1 VSS _11993_/VNW VSS VSS gf180mcu_fd_sc_mcu9t5v0__nand2_1
X_16520_ _16519_/Z _18316_/Q _17034_/S _18316_/D VSS VSS VSS VSS gf180mcu_fd_sc_mcu9t5v0__mux2_1
XPHY_EDGE_ROW_166_2_Left_678 VSS VSS gf180mcu_fd_sc_mcu9t5v0__endcap
X_13732_ _14120_/A1 _14166_/B _13731_/Z _14143_/B2 _13732_/C _19298_/D VSS VSS VSS
+ VSS gf180mcu_fd_sc_mcu9t5v0__aoi221_1
X_10944_ _10944_/A1 _10944_/A2 _10986_/A1 VSS _10944_/VNW VSS VSS gf180mcu_fd_sc_mcu9t5v0__xnor2_1
XTAP_TAPCELL_ROW_101_3750 VSS VSS gf180mcu_fd_sc_mcu9t5v0__filltie
XTAP_TAPCELL_ROW_270_6498 VSS VSS gf180mcu_fd_sc_mcu9t5v0__filltie
X_10875_ _19240_/Q _19234_/Q _18117_/S _10875_/Z VSS VSS VSS VSS gf180mcu_fd_sc_mcu9t5v0__mux2_1
X_16451_ _19231_/Q _16131_/B _16971_/S _16451_/Z VSS VSS VSS VSS gf180mcu_fd_sc_mcu9t5v0__mux2_1
XTAP_TAPCELL_ROW_270_6487 VSS VSS gf180mcu_fd_sc_mcu9t5v0__filltie
XTAP_TAPCELL_ROW_101_3772 VSS VSS gf180mcu_fd_sc_mcu9t5v0__filltie
XTAP_TAPCELL_ROW_101_3761 VSS VSS gf180mcu_fd_sc_mcu9t5v0__filltie
X_13663_ _13663_/A1 _13663_/A2 _13670_/A2 VSS _14373_/VNW VSS VSS gf180mcu_fd_sc_mcu9t5v0__nand2_1
X_16382_ _16381_/Z _18254_/Q _16926_/S _18254_/D VSS VSS VSS VSS gf180mcu_fd_sc_mcu9t5v0__mux2_4
X_12614_ _18408_/Q wire163/Z _12617_/A3 VSS _12614_/VNW VSS VSS gf180mcu_fd_sc_mcu9t5v0__nor2_1
X_19170_ _19170_/D _20066_/RN clkload31/I _19170_/Q VSS VSS VSS VSS gf180mcu_fd_sc_mcu9t5v0__dffrnq_1
X_13594_ _13595_/A1 _13595_/A3 _13594_/B _13599_/A2 VSS VSS VSS VSS gf180mcu_fd_sc_mcu9t5v0__aoi21_1
X_15402_ _19687_/Q _19787_/Q _15430_/S _19787_/D VSS VSS VSS VSS gf180mcu_fd_sc_mcu9t5v0__mux2_1
XTAP_TAPCELL_ROW_287_6973 VSS VSS gf180mcu_fd_sc_mcu9t5v0__filltie
XTAP_TAPCELL_ROW_287_6962 VSS VSS gf180mcu_fd_sc_mcu9t5v0__filltie
XTAP_TAPCELL_ROW_287_6951 VSS VSS gf180mcu_fd_sc_mcu9t5v0__filltie
X_18121_ _19211_/Q _18147_/S _18132_/B VSS _18128_/VNW VSS VSS gf180mcu_fd_sc_mcu9t5v0__nand2_1
X_12545_ wire213/I _12620_/A1 _12545_/A3 _12545_/B _19164_/D VSS _12545_/VNW VSS VSS
+ gf180mcu_fd_sc_mcu9t5v0__oai31_1
X_15333_ _19743_/Q _15417_/S _15334_/B VSS VSS VSS VSS gf180mcu_fd_sc_mcu9t5v0__nand2_1
XTAP_TAPCELL_ROW_283_6848 VSS VSS gf180mcu_fd_sc_mcu9t5v0__filltie
X_18052_ _18053_/A1 _18057_/A3 _18079_/A2 VSS VSS VSS VSS gf180mcu_fd_sc_mcu9t5v0__nor2_1
XTAP_TAPCELL_ROW_283_6859 VSS VSS gf180mcu_fd_sc_mcu9t5v0__filltie
X_17003_ _19248_/Q _16599_/B _17003_/S _17003_/Z VSS VSS VSS VSS gf180mcu_fd_sc_mcu9t5v0__mux2_1
X_12476_ _19155_/Q _12355_/I _12477_/B VSS _12476_/VNW VSS VSS gf180mcu_fd_sc_mcu9t5v0__nand2_1
X_15264_ _15266_/A1 _19579_/Q _15268_/B VSS VSS VSS VSS gf180mcu_fd_sc_mcu9t5v0__nand2_1
X_11427_ _18448_/Q _11519_/A2 _11429_/A1 VSS VSS VSS VSS gf180mcu_fd_sc_mcu9t5v0__nor2_1
XANTENNA_5 output12/I VSS VSS VSS VSS gf180mcu_fd_sc_mcu9t5v0__antenna
X_14215_ _14214_/Z _19338_/Q _14266_/S _19338_/D VSS VSS VSS VSS gf180mcu_fd_sc_mcu9t5v0__mux2_1
X_15195_ _15204_/B1 _15204_/B2 _15197_/A2 VSS _15198_/VNW VSS VSS gf180mcu_fd_sc_mcu9t5v0__xnor2_1
X_11358_ _11428_/B _11358_/A2 _11358_/A3 _11359_/C VSS VSS VSS VSS gf180mcu_fd_sc_mcu9t5v0__nand3_1
X_14146_ _19475_/Q _19483_/Q _14165_/S _14146_/Z VSS VSS VSS VSS gf180mcu_fd_sc_mcu9t5v0__mux2_1
XTAP_TAPCELL_ROW_52_2403 VSS VSS gf180mcu_fd_sc_mcu9t5v0__filltie
X_10309_ _18941_/Q wire166/Z _10311_/A2 VSS _10309_/VNW VSS VSS gf180mcu_fd_sc_mcu9t5v0__nand2_1
XTAP_TAPCELL_ROW_223_5210 VSS VSS gf180mcu_fd_sc_mcu9t5v0__filltie
XTAP_TAPCELL_ROW_52_2414 VSS VSS gf180mcu_fd_sc_mcu9t5v0__filltie
XTAP_TAPCELL_ROW_52_2425 VSS VSS gf180mcu_fd_sc_mcu9t5v0__filltie
X_11289_ _18294_/Q _11509_/A2 _11510_/B _11291_/A2 VSS VSS VSS VSS gf180mcu_fd_sc_mcu9t5v0__oai21_1
X_18954_ _18954_/D _20042_/RN clkload70/I _18954_/Q VSS VSS VSS VSS gf180mcu_fd_sc_mcu9t5v0__dffrnq_1
X_14077_ _14079_/A2 _14111_/A1 _14077_/Z VSS _14106_/VNW VSS VSS gf180mcu_fd_sc_mcu9t5v0__and2_1
X_18885_ _18885_/D _20037_/RN clkload40/I _18885_/Q VSS VSS VSS VSS gf180mcu_fd_sc_mcu9t5v0__dffrnq_1
X_17905_ _17926_/A1 _17905_/A2 _17905_/B _18839_/D VSS VSS VSS VSS gf180mcu_fd_sc_mcu9t5v0__aoi21_1
X_13028_ _13028_/A1 _13028_/A2 _13028_/B _13044_/A2 VSS VSS VSS VSS gf180mcu_fd_sc_mcu9t5v0__aoi21_1
XTAP_TAPCELL_ROW_108_3948 VSS VSS gf180mcu_fd_sc_mcu9t5v0__filltie
XTAP_TAPCELL_ROW_108_3959 VSS VSS gf180mcu_fd_sc_mcu9t5v0__filltie
X_17836_ _19043_/Q _18813_/Q _17844_/S _18813_/D VSS _17836_/VNW VSS VSS gf180mcu_fd_sc_mcu9t5v0__mux2_1
X_17767_ _17767_/A1 _17779_/A2 _17767_/B _17779_/C _18758_/D VSS _17767_/VNW VSS VSS
+ gf180mcu_fd_sc_mcu9t5v0__aoi211_1
X_19506_ _19506_/D _20018_/RN clkload22/I _19506_/Q VSS VSS VSS VSS gf180mcu_fd_sc_mcu9t5v0__dffrnq_1
X_14979_ _19618_/Q _14979_/I1 _20039_/D _19618_/D VSS VSS VSS VSS gf180mcu_fd_sc_mcu9t5v0__mux2_1
XTAP_TAPCELL_ROW_217_5047 VSS VSS gf180mcu_fd_sc_mcu9t5v0__filltie
X_16718_ _18370_/Q _16747_/A2 _16741_/A1 _16722_/B VSS VSS VSS VSS gf180mcu_fd_sc_mcu9t5v0__nand3_1
XTAP_TAPCELL_ROW_217_5036 VSS VSS gf180mcu_fd_sc_mcu9t5v0__filltie
X_17698_ _17698_/I _18726_/D VSS VSS VSS VSS gf180mcu_fd_sc_mcu9t5v0__clkinv_1
XTAP_TAPCELL_ROW_217_5025 VSS VSS gf180mcu_fd_sc_mcu9t5v0__filltie
X_16649_ _18356_/Q _16649_/I1 _16670_/S _18356_/D VSS VSS VSS VSS gf180mcu_fd_sc_mcu9t5v0__mux2_1
X_19437_ _19437_/D _20141_/RN clkload9/I _19437_/Q VSS VSS VSS VSS gf180mcu_fd_sc_mcu9t5v0__dffrnq_1
X_19368_ _19368_/D _20072_/RN clkload21/I _19368_/Q VSS VSS VSS VSS gf180mcu_fd_sc_mcu9t5v0__dffrnq_1
X_18319_ _18319_/D _20132_/CLK _18319_/Q VSS VSS VSS VSS gf180mcu_fd_sc_mcu9t5v0__dffq_1
X_09121_ _19754_/Q _13025_/A2 VSS VSS VSS VSS gf180mcu_fd_sc_mcu9t5v0__clkinv_1
X_19299_ _19299_/D _20067_/RN clkload14/I _19299_/Q VSS VSS VSS VSS gf180mcu_fd_sc_mcu9t5v0__dffrnq_1
XTAP_TAPCELL_ROW_22_1583 VSS VSS gf180mcu_fd_sc_mcu9t5v0__filltie
XTAP_TAPCELL_ROW_22_1594 VSS VSS gf180mcu_fd_sc_mcu9t5v0__filltie
XTAP_TAPCELL_ROW_301_7354 VSS VSS gf180mcu_fd_sc_mcu9t5v0__filltie
Xmax_cap274 max_cap40/I _16854_/S VSS VSS VSS VSS gf180mcu_fd_sc_mcu9t5v0__clkbuf_16
XTAP_TAPCELL_ROW_301_7343 VSS VSS gf180mcu_fd_sc_mcu9t5v0__filltie
X_20143_ _20143_/D _20143_/RN clkload50/I _20143_/Q VSS VSS VSS VSS gf180mcu_fd_sc_mcu9t5v0__dffrnq_1
XTAP_TAPCELL_ROW_293_7122 VSS VSS gf180mcu_fd_sc_mcu9t5v0__filltie
Xclkbuf_leaf_9_clk_regs clkload0/I clkload25/I VSS VSS VSS VSS gf180mcu_fd_sc_mcu9t5v0__clkbuf_8
XTAP_TAPCELL_ROW_35_1933 VSS VSS gf180mcu_fd_sc_mcu9t5v0__filltie
XTAP_TAPCELL_ROW_35_1944 VSS VSS gf180mcu_fd_sc_mcu9t5v0__filltie
X_09954_ _10179_/A1 _18805_/Q _09956_/A2 VSS VSS VSS VSS gf180mcu_fd_sc_mcu9t5v0__nand2_1
XTAP_TAPCELL_ROW_293_7133 VSS VSS gf180mcu_fd_sc_mcu9t5v0__filltie
X_20074_ _20074_/D clkload76/I _20074_/Q VSS VSS VSS VSS gf180mcu_fd_sc_mcu9t5v0__dffq_1
X_09885_ _09885_/I _09885_/ZN VSS _09885_/VNW VSS VSS gf180mcu_fd_sc_mcu9t5v0__clkinv_1
XTAP_TAPCELL_ROW_35_1955 VSS VSS gf180mcu_fd_sc_mcu9t5v0__filltie
XTAP_TAPCELL_ROW_314_7704 VSS VSS gf180mcu_fd_sc_mcu9t5v0__filltie
XTAP_TAPCELL_ROW_314_7715 VSS VSS gf180mcu_fd_sc_mcu9t5v0__filltie
XTAP_TAPCELL_ROW_118_4222 VSS VSS gf180mcu_fd_sc_mcu9t5v0__filltie
X_10660_ _10660_/A1 _10660_/A2 _10662_/I0 VSS VSS VSS VSS gf180mcu_fd_sc_mcu9t5v0__nand2_1
XTAP_TAPCELL_ROW_118_4233 VSS VSS gf180mcu_fd_sc_mcu9t5v0__filltie
X_09319_ _19238_/Q _16428_/A1 VSS VSS VSS VSS gf180mcu_fd_sc_mcu9t5v0__inv_2
XTAP_TAPCELL_ROW_114_4119 VSS VSS gf180mcu_fd_sc_mcu9t5v0__filltie
XTAP_TAPCELL_ROW_114_4108 VSS VSS gf180mcu_fd_sc_mcu9t5v0__filltie
X_10591_ _10459_/C _10591_/A2 _10591_/A3 _10591_/B _10592_/C1 VSS VSS VSS VSS gf180mcu_fd_sc_mcu9t5v0__oai31_1
X_12330_ _11988_/B _12330_/A2 _12329_/B _12331_/A2 VSS VSS VSS VSS gf180mcu_fd_sc_mcu9t5v0__nor3_1
X_12261_ _18388_/Q _12322_/B _12261_/B _12270_/A2 VSS VSS VSS VSS gf180mcu_fd_sc_mcu9t5v0__aoi21_1
X_11212_ _11212_/A1 _11212_/A2 _11788_/B _11213_/B2 VSS _11212_/VNW VSS VSS gf180mcu_fd_sc_mcu9t5v0__aoi21_2
XTAP_TAPCELL_ROW_263_6291 VSS VSS gf180mcu_fd_sc_mcu9t5v0__filltie
X_14000_ _19318_/Q _19300_/Q _14006_/A2 VSS VSS VSS VSS gf180mcu_fd_sc_mcu9t5v0__nand2_1
X_12192_ _12192_/A1 _12192_/A2 _12235_/B _12217_/A2 VSS VSS VSS VSS gf180mcu_fd_sc_mcu9t5v0__aoi21_1
X_11143_ _18332_/Q _18316_/Q _18300_/Q _18284_/Q _11403_/S _11098_/B _11143_/Z VSS
+ VSS VSS VSS gf180mcu_fd_sc_mcu9t5v0__mux4_1
X_15951_ _20068_/Q _18788_/Q _16619_/S _15951_/Z VSS _15952_/VNW VSS VSS gf180mcu_fd_sc_mcu9t5v0__mux2_4
Xu_transform_scheduler_core.u_fft_scratch_sram.u_hi.u_cen_driver _20018_/RN _09885_/ZN
+ u_transform_scheduler_core.u_fft_scratch_sram.u_hi.u_sram/CEN VSS _11281_/VNW VSS
+ VSS gf180mcu_fd_sc_mcu9t5v0__nand2_4
X_11074_ _11075_/A1 _11075_/A2 _11320_/C VSS VSS VSS VSS gf180mcu_fd_sc_mcu9t5v0__and2_1
XTAP_TAPCELL_ROW_276_6663 VSS VSS gf180mcu_fd_sc_mcu9t5v0__filltie
X_18670_ _18670_/D _20138_/RN _20129_/CLK _18670_/Q VSS VSS VSS VSS gf180mcu_fd_sc_mcu9t5v0__dffrnq_1
XTAP_TAPCELL_ROW_276_6652 VSS VSS gf180mcu_fd_sc_mcu9t5v0__filltie
X_15882_ _20091_/Q _19241_/Q _15912_/S _20091_/D VSS VSS VSS VSS gf180mcu_fd_sc_mcu9t5v0__mux2_1
X_10025_ _10059_/A1 _10059_/A2 _10027_/C VSS VSS VSS VSS gf180mcu_fd_sc_mcu9t5v0__nand2_1
X_14902_ _19417_/Q _19358_/Q _14907_/B VSS VSS VSS VSS gf180mcu_fd_sc_mcu9t5v0__nand2_1
XTAP_TAPCELL_ROW_276_6674 VSS VSS gf180mcu_fd_sc_mcu9t5v0__filltie
X_17621_ _17621_/A1 _17621_/A2 _18682_/D VSS _17621_/VNW VSS VSS gf180mcu_fd_sc_mcu9t5v0__nor2_1
XTAP_TAPCELL_ROW_272_6549 VSS VSS gf180mcu_fd_sc_mcu9t5v0__filltie
XTAP_TAPCELL_ROW_272_6538 VSS VSS gf180mcu_fd_sc_mcu9t5v0__filltie
XTAP_TAPCELL_ROW_103_3823 VSS VSS gf180mcu_fd_sc_mcu9t5v0__filltie
XTAP_TAPCELL_ROW_103_3812 VSS VSS gf180mcu_fd_sc_mcu9t5v0__filltie
X_14833_ _14833_/I _14837_/A2 VSS VSS VSS VSS gf180mcu_fd_sc_mcu9t5v0__clkinv_1
X_11976_ _18263_/Q _12340_/S _11978_/B1 VSS _11976_/VNW VSS VSS gf180mcu_fd_sc_mcu9t5v0__nand2_1
X_17552_ input6/Z _17546_/Z _17554_/A1 VSS VSS VSS VSS gf180mcu_fd_sc_mcu9t5v0__nand2_1
X_14764_ _14764_/A1 _14764_/A2 _14764_/B _14767_/A2 VSS _14764_/VNW VSS VSS gf180mcu_fd_sc_mcu9t5v0__oai21_1
X_16503_ _19240_/Q _16177_/C _17025_/S _16503_/Z VSS VSS VSS VSS gf180mcu_fd_sc_mcu9t5v0__mux2_1
X_17483_ _18588_/Q _19229_/Q _17504_/S _18588_/D VSS VSS VSS VSS gf180mcu_fd_sc_mcu9t5v0__mux2_1
X_10927_ _18932_/Q _19003_/Q _18148_/S _19003_/D VSS VSS VSS VSS gf180mcu_fd_sc_mcu9t5v0__mux2_1
X_13715_ _19445_/Q _14286_/A2 _13656_/Z _19471_/Q _13715_/C _13717_/A2 VSS _15145_/VNW
+ VSS VSS gf180mcu_fd_sc_mcu9t5v0__aoi221_1
X_14695_ _19153_/Q _19119_/Q _14696_/B VSS _14695_/VNW VSS VSS gf180mcu_fd_sc_mcu9t5v0__and2_1
X_16434_ _16434_/A1 _16809_/S _16434_/B _16435_/I0 VSS VSS VSS VSS gf180mcu_fd_sc_mcu9t5v0__oai21_4
X_13646_ _13043_/I _13644_/Z _13646_/A3 _13646_/B _19291_/D VSS VSS VSS VSS gf180mcu_fd_sc_mcu9t5v0__oai31_1
X_19222_ _19222_/D _20054_/RN clkload37/I _19222_/Q VSS VSS VSS VSS gf180mcu_fd_sc_mcu9t5v0__dffrnq_1
XTAP_TAPCELL_ROW_41_2104 VSS VSS gf180mcu_fd_sc_mcu9t5v0__filltie
XTAP_TAPCELL_ROW_41_2115 VSS VSS gf180mcu_fd_sc_mcu9t5v0__filltie
X_10858_ _16658_/A1 _18147_/S _10860_/B _10859_/I0 VSS _10859_/VNW VSS VSS gf180mcu_fd_sc_mcu9t5v0__oai21_1
Xclkbuf_leaf_79_clk_regs clkbuf_3_0_0_clk_regs/Z clkload14/I VSS _14120_/VNW VSS VSS
+ gf180mcu_fd_sc_mcu9t5v0__clkbuf_8
X_16365_ _19242_/Q _16187_/C _16865_/S _16365_/Z VSS VSS VSS VSS gf180mcu_fd_sc_mcu9t5v0__mux2_1
X_10789_ _10693_/B _10789_/A2 _10789_/A3 _10792_/A1 VSS VSS VSS VSS gf180mcu_fd_sc_mcu9t5v0__nand3_1
X_13577_ _19734_/Q _13577_/A2 _13576_/B _13577_/Z VSS _13577_/VNW VSS VSS gf180mcu_fd_sc_mcu9t5v0__and3_1
X_19153_ _19153_/D _20049_/RN _19798_/CLK _19153_/Q VSS VSS VSS VSS gf180mcu_fd_sc_mcu9t5v0__dffrnq_1
X_16296_ _18216_/Q _16296_/I1 _16824_/S _18216_/D VSS VSS VSS VSS gf180mcu_fd_sc_mcu9t5v0__mux2_4
X_18104_ _18103_/Z _18939_/Q _18152_/S _18939_/D VSS VSS VSS VSS gf180mcu_fd_sc_mcu9t5v0__mux2_1
X_19084_ _19084_/D _20044_/RN clkload41/I _19084_/Q VSS VSS VSS VSS gf180mcu_fd_sc_mcu9t5v0__dffrnq_1
X_12528_ _19162_/Q _12620_/A1 _12529_/B VSS VSS VSS VSS gf180mcu_fd_sc_mcu9t5v0__nand2_1
X_15316_ _19640_/Q _19617_/Q _15320_/B _15316_/Z VSS VSS VSS VSS gf180mcu_fd_sc_mcu9t5v0__xor3_1
X_12459_ wire175/Z _12459_/A2 _12618_/B _12461_/A3 VSS _12475_/VNW VSS VSS gf180mcu_fd_sc_mcu9t5v0__aoi21_1
X_15247_ _19598_/Q _15247_/A2 _15247_/B1 _15247_/B2 _15247_/C _15249_/A3 VSS _15247_/VNW
+ VSS VSS gf180mcu_fd_sc_mcu9t5v0__oai221_1
X_18035_ _18035_/I0 _18920_/Q _18037_/S _18920_/D VSS _18035_/VNW VSS VSS gf180mcu_fd_sc_mcu9t5v0__mux2_1
XTAP_TAPCELL_ROW_39_2044 VSS VSS gf180mcu_fd_sc_mcu9t5v0__filltie
XTAP_TAPCELL_ROW_39_2055 VSS VSS gf180mcu_fd_sc_mcu9t5v0__filltie
XTAP_TAPCELL_ROW_39_2066 VSS VSS gf180mcu_fd_sc_mcu9t5v0__filltie
X_15178_ _15179_/A1 _19565_/Q _15192_/B VSS VSS VSS VSS gf180mcu_fd_sc_mcu9t5v0__nand2_1
XPHY_EDGE_ROW_158_1_Left_481 VSS VSS gf180mcu_fd_sc_mcu9t5v0__endcap
X_19986_ _19986_/D _20050_/RN clkload46/I _19986_/Q VSS VSS VSS VSS gf180mcu_fd_sc_mcu9t5v0__dffrnq_1
X_14129_ _14129_/A1 _14127_/Z _14185_/A2 VSS _14185_/VNW VSS VSS gf180mcu_fd_sc_mcu9t5v0__xnor2_1
X_18937_ _18937_/D _20025_/RN clkload39/I _18937_/Q VSS VSS VSS VSS gf180mcu_fd_sc_mcu9t5v0__dffrnq_1
X_09670_ _15705_/B _09670_/A2 _15680_/A1 _09676_/B _19999_/D VSS VSS VSS VSS gf180mcu_fd_sc_mcu9t5v0__oai22_1
XTAP_TAPCELL_ROW_140_2_8012 VSS VSS gf180mcu_fd_sc_mcu9t5v0__filltie
X_18868_ _18868_/D _20020_/RN clkload40/I _18868_/Q VSS VSS VSS VSS gf180mcu_fd_sc_mcu9t5v0__dffrnq_1
X_17819_ _19026_/Q _18796_/Q _17844_/S _18796_/D VSS VSS VSS VSS gf180mcu_fd_sc_mcu9t5v0__mux2_1
X_18799_ _18799_/D _20143_/RN clkload36/I _18799_/Q VSS VSS VSS VSS gf180mcu_fd_sc_mcu9t5v0__dffrnq_1
XTAP_TAPCELL_ROW_11_1273 VSS VSS gf180mcu_fd_sc_mcu9t5v0__filltie
XTAP_TAPCELL_ROW_11_1284 VSS VSS gf180mcu_fd_sc_mcu9t5v0__filltie
XTAP_TAPCELL_ROW_11_1295 VSS VSS gf180mcu_fd_sc_mcu9t5v0__filltie
XTAP_TAPCELL_ROW_24_1634 VSS VSS gf180mcu_fd_sc_mcu9t5v0__filltie
XTAP_TAPCELL_ROW_24_1645 VSS VSS gf180mcu_fd_sc_mcu9t5v0__filltie
XTAP_TAPCELL_ROW_24_1656 VSS VSS gf180mcu_fd_sc_mcu9t5v0__filltie
X_09104_ _19913_/Q _09450_/A1 VSS _09104_/VNW VSS VSS gf180mcu_fd_sc_mcu9t5v0__clkinv_1
XTAP_TAPCELL_ROW_303_7416 VSS VSS gf180mcu_fd_sc_mcu9t5v0__filltie
XTAP_TAPCELL_ROW_303_7405 VSS VSS gf180mcu_fd_sc_mcu9t5v0__filltie
XTAP_TAPCELL_ROW_168_1_4754 VSS VSS gf180mcu_fd_sc_mcu9t5v0__filltie
X_20126_ _20126_/D clkload57/I _20126_/Q VSS VSS VSS VSS gf180mcu_fd_sc_mcu9t5v0__dffq_1
X_09937_ _09937_/A1 _09937_/A2 _09981_/B _09938_/A4 VSS _18103_/VNW VSS VSS gf180mcu_fd_sc_mcu9t5v0__aoi21_1
X_20057_ _20057_/D _20057_/RN clkload53/I _20057_/Q VSS VSS VSS VSS gf180mcu_fd_sc_mcu9t5v0__dffrnq_1
X_09868_ _19902_/Q _15649_/A1 _09869_/I VSS _15649_/VNW VSS VSS gf180mcu_fd_sc_mcu9t5v0__nor2_1
X_09799_ _18838_/Q _11585_/A2 _17912_/A2 VSS VSS VSS VSS gf180mcu_fd_sc_mcu9t5v0__nor2_1
X_11830_ _12261_/B _11818_/Z _11830_/B _11832_/B VSS VSS VSS VSS gf180mcu_fd_sc_mcu9t5v0__oai21_1
X_11761_ _18189_/Q _11750_/Z _12159_/B _11761_/Z VSS VSS VSS VSS gf180mcu_fd_sc_mcu9t5v0__mux2_4
X_10712_ _10689_/I _10712_/A2 _10712_/Z VSS VSS VSS VSS gf180mcu_fd_sc_mcu9t5v0__xor2_1
X_13500_ _13500_/A1 _12955_/Z wire277/Z _13500_/B _19260_/D VSS VSS VSS VSS gf180mcu_fd_sc_mcu9t5v0__oai31_1
X_11692_ _18282_/Q _12046_/S _12208_/C _11693_/B1 VSS _11692_/VNW VSS VSS gf180mcu_fd_sc_mcu9t5v0__aoi21_1
XTAP_TAPCELL_ROW_140_1_4740 VSS VSS gf180mcu_fd_sc_mcu9t5v0__filltie
X_14480_ _19160_/Q _14480_/A2 _14483_/A2 VSS _14480_/VNW VSS VSS gf180mcu_fd_sc_mcu9t5v0__nor2_1
X_10643_ _10643_/A1 _10643_/A2 _10643_/B1 _10643_/B2 _10643_/C1 _10543_/C _10645_/A2
+ VSS VSS VSS VSS gf180mcu_fd_sc_mcu9t5v0__aoi222_1
X_13431_ _13431_/A1 _13429_/I _13432_/A3 VSS VSS VSS VSS gf180mcu_fd_sc_mcu9t5v0__nand2_1
XTAP_TAPCELL_ROW_98_3682 VSS VSS gf180mcu_fd_sc_mcu9t5v0__filltie
XTAP_TAPCELL_ROW_98_3671 VSS VSS gf180mcu_fd_sc_mcu9t5v0__filltie
X_16150_ _18175_/Q _16150_/I1 _16707_/S _18175_/D VSS VSS VSS VSS gf180mcu_fd_sc_mcu9t5v0__mux2_4
X_10574_ _18967_/Q wire165/Z _10652_/B1 _18983_/Q _10575_/A3 VSS _10574_/VNW VSS VSS
+ gf180mcu_fd_sc_mcu9t5v0__aoi22_1
X_13362_ _16709_/A1 _13419_/B _13362_/B1 _13362_/B2 _19251_/D VSS _13362_/VNW VSS
+ VSS gf180mcu_fd_sc_mcu9t5v0__aoi22_1
XTAP_TAPCELL_ROW_94_3557 VSS VSS gf180mcu_fd_sc_mcu9t5v0__filltie
XTAP_TAPCELL_ROW_265_6364 VSS VSS gf180mcu_fd_sc_mcu9t5v0__filltie
X_16081_ _18128_/A1 _16672_/A2 _16098_/B _16177_/C VSS VSS VSS VSS gf180mcu_fd_sc_mcu9t5v0__oai21_4
XTAP_TAPCELL_ROW_265_6353 VSS VSS gf180mcu_fd_sc_mcu9t5v0__filltie
XTAP_TAPCELL_ROW_94_3579 VSS VSS gf180mcu_fd_sc_mcu9t5v0__filltie
XTAP_TAPCELL_ROW_94_3568 VSS VSS gf180mcu_fd_sc_mcu9t5v0__filltie
X_12313_ _18920_/Q _12336_/A3 _12336_/B _12314_/A2 VSS _12314_/VNW VSS VSS gf180mcu_fd_sc_mcu9t5v0__oai21_1
X_15101_ _19395_/Q _19314_/Q _15105_/B VSS VSS VSS VSS gf180mcu_fd_sc_mcu9t5v0__nand2_1
XTAP_TAPCELL_ROW_261_6239 VSS VSS gf180mcu_fd_sc_mcu9t5v0__filltie
X_15032_ _19634_/Q _19385_/Q _20039_/Q _19634_/D VSS VSS VSS VSS gf180mcu_fd_sc_mcu9t5v0__mux2_1
X_13293_ _13293_/I _13313_/A1 VSS VSS VSS VSS gf180mcu_fd_sc_mcu9t5v0__clkinv_1
X_12244_ _18451_/Q _12340_/S _12246_/B1 VSS VSS VSS VSS gf180mcu_fd_sc_mcu9t5v0__nand2_1
XTAP_TAPCELL_ROW_278_6714 VSS VSS gf180mcu_fd_sc_mcu9t5v0__filltie
XTAP_TAPCELL_ROW_278_6703 VSS VSS gf180mcu_fd_sc_mcu9t5v0__filltie
X_12175_ _12237_/B _12195_/A1 _12187_/A1 VSS VSS VSS VSS gf180mcu_fd_sc_mcu9t5v0__nand2_1
X_19840_ _19840_/D _09246_/I clkload56/I _19840_/Q VSS VSS VSS VSS gf180mcu_fd_sc_mcu9t5v0__dffrnq_1
XTAP_TAPCELL_ROW_278_6725 VSS VSS gf180mcu_fd_sc_mcu9t5v0__filltie
X_11126_ _18251_/Q _11385_/A2 _11129_/A1 VSS _11126_/VNW VSS VSS gf180mcu_fd_sc_mcu9t5v0__nor2_1
X_19771_ _19771_/D _19963_/RN _20054_/CLK _19771_/Q VSS VSS VSS VSS gf180mcu_fd_sc_mcu9t5v0__dffrnq_1
X_16983_ _19254_/Q _16641_/B _16991_/S _16983_/Z VSS _17295_/VNW VSS VSS gf180mcu_fd_sc_mcu9t5v0__mux2_1
X_18722_ _18722_/D clkload48/I _18722_/Q VSS VSS VSS VSS gf180mcu_fd_sc_mcu9t5v0__dffq_1
X_15934_ _15934_/I _15985_/B1 VSS VSS VSS VSS gf180mcu_fd_sc_mcu9t5v0__clkinv_1
X_11057_ _18027_/I0 _19058_/Q _11067_/S _19058_/D VSS VSS VSS VSS gf180mcu_fd_sc_mcu9t5v0__mux2_1
X_10008_ _18997_/Q wire285/Z _10168_/B1 _18949_/Q _10009_/A2 VSS VSS VSS VSS gf180mcu_fd_sc_mcu9t5v0__aoi22_1
X_15865_ _16196_/A1 _17481_/A2 _15865_/ZN VSS VSS VSS VSS gf180mcu_fd_sc_mcu9t5v0__nor2_2
X_18653_ _18653_/D _20057_/RN clkload47/I _18653_/Q VSS VSS VSS VSS gf180mcu_fd_sc_mcu9t5v0__dffrnq_1
X_17604_ wire300/Z _18667_/Q _17609_/S _18667_/D VSS VSS VSS VSS gf180mcu_fd_sc_mcu9t5v0__mux2_1
X_14816_ _19402_/Q _19339_/Q _14816_/B _14821_/A1 VSS _15229_/VNW VSS VSS gf180mcu_fd_sc_mcu9t5v0__aoi21_1
XTAP_TAPCELL_ROW_8_1194 VSS VSS gf180mcu_fd_sc_mcu9t5v0__filltie
X_18584_ _18584_/D _20020_/RN clkload28/I _18584_/Q VSS VSS VSS VSS gf180mcu_fd_sc_mcu9t5v0__dffrnq_1
X_17535_ wire300/Z _17601_/A1 _18664_/Q _17536_/A2 VSS _17536_/VNW VSS VSS gf180mcu_fd_sc_mcu9t5v0__aoi21_1
X_15796_ _18031_/I0 _19966_/Q _15802_/S _19966_/D VSS VSS VSS VSS gf180mcu_fd_sc_mcu9t5v0__mux2_1
X_11959_ _12237_/B _11960_/A2 _11960_/B _11959_/Z VSS _18133_/VNW VSS VSS gf180mcu_fd_sc_mcu9t5v0__and3_4
X_14747_ _14540_/Z _14747_/A2 _14747_/B _14752_/A2 VSS VSS VSS VSS gf180mcu_fd_sc_mcu9t5v0__aoi21_1
XTAP_TAPCELL_ROW_250_5954 VSS VSS gf180mcu_fd_sc_mcu9t5v0__filltie
XTAP_TAPCELL_ROW_250_5943 VSS VSS gf180mcu_fd_sc_mcu9t5v0__filltie
XTAP_TAPCELL_ROW_250_5932 VSS VSS gf180mcu_fd_sc_mcu9t5v0__filltie
X_14678_ _19531_/Q _14624_/S _14679_/B VSS VSS VSS VSS gf180mcu_fd_sc_mcu9t5v0__nand2_1
X_17466_ _09517_/I _17466_/A2 _18579_/D VSS VSS VSS VSS gf180mcu_fd_sc_mcu9t5v0__nor2_1
X_16417_ _16416_/Z _18269_/Q _16940_/S _18269_/D VSS VSS VSS VSS gf180mcu_fd_sc_mcu9t5v0__mux2_1
X_17397_ _18488_/Q _17406_/A2 _17405_/A2 _18504_/Q _19827_/Q _17398_/B VSS _17397_/VNW
+ VSS VSS gf180mcu_fd_sc_mcu9t5v0__aoi221_1
X_19205_ _19205_/D _20037_/RN _19680_/CLK _19205_/Q VSS VSS VSS VSS gf180mcu_fd_sc_mcu9t5v0__dffrnq_1
X_13629_ _13630_/B _13630_/A1 _13630_/A2 _13632_/A1 VSS VSS VSS VSS gf180mcu_fd_sc_mcu9t5v0__nor3_1
X_16348_ _18238_/Q _16347_/Z _16882_/S _18238_/D VSS VSS VSS VSS gf180mcu_fd_sc_mcu9t5v0__mux2_4
X_19136_ _19136_/D _09246_/I clkload31/I _19136_/Q VSS VSS VSS VSS gf180mcu_fd_sc_mcu9t5v0__dffrnq_1
X_16279_ _16279_/A1 _16430_/B _16280_/I1 VSS VSS VSS VSS gf180mcu_fd_sc_mcu9t5v0__nand2_1
XTAP_TAPCELL_ROW_248_5883 VSS VSS gf180mcu_fd_sc_mcu9t5v0__filltie
X_19067_ _19067_/D _19963_/RN clkload32/I _19067_/Q VSS VSS VSS VSS gf180mcu_fd_sc_mcu9t5v0__dffrnq_1
XTAP_TAPCELL_ROW_248_5894 VSS VSS gf180mcu_fd_sc_mcu9t5v0__filltie
X_18018_ _18034_/I0 _18903_/Q _18021_/S _18903_/D VSS _18021_/VNW VSS VSS gf180mcu_fd_sc_mcu9t5v0__mux2_1
XTAP_TAPCELL_ROW_244_5769 VSS VSS gf180mcu_fd_sc_mcu9t5v0__filltie
X_09722_ _09722_/I _20022_/D VSS VSS VSS VSS gf180mcu_fd_sc_mcu9t5v0__clkinv_1
X_19969_ _19969_/D _20033_/RN clkload44/I _19969_/Q VSS VSS VSS VSS gf180mcu_fd_sc_mcu9t5v0__dffrnq_1
XTAP_TAPCELL_ROW_17_1460 VSS VSS gf180mcu_fd_sc_mcu9t5v0__filltie
XTAP_TAPCELL_ROW_13_1335 VSS VSS gf180mcu_fd_sc_mcu9t5v0__filltie
XTAP_TAPCELL_ROW_13_1346 VSS VSS gf180mcu_fd_sc_mcu9t5v0__filltie
X_09653_ _19923_/Q _19916_/Q _09654_/A4 VSS _09653_/VNW VSS VSS gf180mcu_fd_sc_mcu9t5v0__nor2_1
X_09584_ _18682_/Q _20070_/Q _18684_/Q _09609_/A3 VSS _09584_/VNW VSS VSS gf180mcu_fd_sc_mcu9t5v0__nor3_1
XPHY_EDGE_ROW_118_Right_118 VSS VSS gf180mcu_fd_sc_mcu9t5v0__endcap
XTAP_TAPCELL_ROW_26_1707 VSS VSS gf180mcu_fd_sc_mcu9t5v0__filltie
X_10290_ _18155_/Q _17322_/A2 _17255_/B1 _18171_/Q _10291_/B VSS VSS VSS VSS gf180mcu_fd_sc_mcu9t5v0__aoi22_1
XPHY_EDGE_ROW_175_2_Left_687 VSS VSS gf180mcu_fd_sc_mcu9t5v0__endcap
X_20109_ _20109_/D _20129_/CLK _20109_/Q VSS VSS VSS VSS gf180mcu_fd_sc_mcu9t5v0__dffq_1
X_13980_ _13982_/A2 _13979_/Z _13988_/B VSS _13988_/VNW VSS VSS gf180mcu_fd_sc_mcu9t5v0__and2_1
XTAP_TAPCELL_ROW_87_3383 VSS VSS gf180mcu_fd_sc_mcu9t5v0__filltie
X_12931_ _12924_/Z _12932_/B _12932_/A2 _12935_/B VSS _12931_/VNW VSS VSS gf180mcu_fd_sc_mcu9t5v0__and3_1
XTAP_TAPCELL_ROW_87_3372 VSS VSS gf180mcu_fd_sc_mcu9t5v0__filltie
XTAP_TAPCELL_ROW_254_6054 VSS VSS gf180mcu_fd_sc_mcu9t5v0__filltie
XTAP_TAPCELL_ROW_254_6043 VSS VSS gf180mcu_fd_sc_mcu9t5v0__filltie
X_15650_ _09869_/I _10192_/I _15672_/B _15652_/A2 VSS _15651_/VNW VSS VSS gf180mcu_fd_sc_mcu9t5v0__aoi21_1
XTAP_TAPCELL_ROW_83_3269 VSS VSS gf180mcu_fd_sc_mcu9t5v0__filltie
XTAP_TAPCELL_ROW_83_3258 VSS VSS gf180mcu_fd_sc_mcu9t5v0__filltie
X_12862_ _19737_/Q _19802_/Q _13244_/B _12862_/Z VSS VSS VSS VSS gf180mcu_fd_sc_mcu9t5v0__mux2_1
XTAP_TAPCELL_ROW_254_6065 VSS VSS gf180mcu_fd_sc_mcu9t5v0__filltie
X_14601_ _19180_/Q _19479_/Q _14715_/S _19479_/D VSS VSS VSS VSS gf180mcu_fd_sc_mcu9t5v0__mux2_1
X_11813_ _11966_/B _11813_/A2 _11813_/A3 _11813_/B _19113_/D VSS VSS VSS VSS gf180mcu_fd_sc_mcu9t5v0__oai31_1
X_15581_ _15581_/A1 _15581_/A2 _15581_/B _15582_/A2 VSS VSS VSS VSS gf180mcu_fd_sc_mcu9t5v0__oai21_1
X_12793_ _12788_/Z _12793_/A2 _12793_/Z VSS VSS VSS VSS gf180mcu_fd_sc_mcu9t5v0__or2_1
X_17320_ _17378_/A1 _18516_/Q _17323_/A2 VSS VSS VSS VSS gf180mcu_fd_sc_mcu9t5v0__nor2_1
X_11744_ _12235_/B _11768_/A2 _11746_/A2 VSS _11768_/VNW VSS VSS gf180mcu_fd_sc_mcu9t5v0__nor2_1
X_14532_ _19167_/Q _19133_/Q _14741_/B VSS _14542_/VNW VSS VSS gf180mcu_fd_sc_mcu9t5v0__nor2_1
X_17251_ _17251_/A1 _17250_/Z _17251_/B _18544_/D VSS VSS VSS VSS gf180mcu_fd_sc_mcu9t5v0__oai21_4
XTAP_TAPCELL_ROW_267_6426 VSS VSS gf180mcu_fd_sc_mcu9t5v0__filltie
XTAP_TAPCELL_ROW_267_6415 VSS VSS gf180mcu_fd_sc_mcu9t5v0__filltie
XTAP_TAPCELL_ROW_267_6404 VSS VSS gf180mcu_fd_sc_mcu9t5v0__filltie
X_11675_ _12671_/B2 _11675_/A2 _11675_/B _11675_/C _12646_/A2 VSS _12653_/VNW VSS
+ VSS gf180mcu_fd_sc_mcu9t5v0__oai211_1
X_14463_ _19159_/Q _19125_/Q _14465_/B VSS VSS VSS VSS gf180mcu_fd_sc_mcu9t5v0__xnor2_1
XTAP_TAPCELL_ROW_96_3619 VSS VSS gf180mcu_fd_sc_mcu9t5v0__filltie
X_17182_ _17161_/C _17182_/A2 _17182_/A3 _17183_/B VSS VSS VSS VSS gf180mcu_fd_sc_mcu9t5v0__nand3_1
X_10626_ _18969_/Q wire165/Z _10652_/B1 _18985_/Q _10627_/A3 VSS _10628_/VNW VSS VSS
+ gf180mcu_fd_sc_mcu9t5v0__aoi22_1
X_16202_ _16009_/B _19261_/Q _16763_/S _16202_/Z VSS VSS VSS VSS gf180mcu_fd_sc_mcu9t5v0__mux2_1
XTAP_TAPCELL_ROW_148_3_8041 VSS VSS gf180mcu_fd_sc_mcu9t5v0__filltie
X_13414_ _13415_/A1 _19776_/Q _13433_/B VSS VSS VSS VSS gf180mcu_fd_sc_mcu9t5v0__nand2_1
X_16133_ _19263_/Q _16730_/C _16134_/B VSS VSS VSS VSS gf180mcu_fd_sc_mcu9t5v0__nand2_1
X_14394_ _19116_/Q wire199/Z _14704_/S _14394_/C _14395_/A2 VSS VSS VSS VSS gf180mcu_fd_sc_mcu9t5v0__oai211_1
X_10557_ _17358_/A1 _18261_/Q _10560_/A2 VSS VSS VSS VSS gf180mcu_fd_sc_mcu9t5v0__nor2_1
X_13345_ _13345_/A1 _13603_/A2 _13345_/B _13366_/A2 VSS VSS VSS VSS gf180mcu_fd_sc_mcu9t5v0__oai21_1
X_10488_ _17260_/S _18210_/Q _10490_/A3 VSS VSS VSS VSS gf180mcu_fd_sc_mcu9t5v0__nor2_1
X_16064_ _16668_/A1 _16668_/A2 _16162_/B _16066_/A3 VSS VSS VSS VSS gf180mcu_fd_sc_mcu9t5v0__aoi21_4
X_13276_ _13281_/A1 _13276_/A2 _13585_/B VSS VSS VSS VSS gf180mcu_fd_sc_mcu9t5v0__xnor2_1
X_12227_ _12227_/A1 _12226_/Z _12228_/A2 VSS VSS VSS VSS gf180mcu_fd_sc_mcu9t5v0__xnor2_1
XTAP_TAPCELL_ROW_72_2951 VSS VSS gf180mcu_fd_sc_mcu9t5v0__filltie
X_15015_ _15015_/A1 _15008_/B _15012_/Z _15017_/A3 VSS _15015_/VNW VSS VSS gf180mcu_fd_sc_mcu9t5v0__nand3_1
X_19823_ _19823_/D _20143_/RN clkload58/I _19823_/Q VSS VSS VSS VSS gf180mcu_fd_sc_mcu9t5v0__dffrnq_1
XPHY_EDGE_ROW_269_Right_196 VSS VSS gf180mcu_fd_sc_mcu9t5v0__endcap
XTAP_TAPCELL_ROW_141_3_8017 VSS VSS gf180mcu_fd_sc_mcu9t5v0__filltie
XTAP_TAPCELL_ROW_72_2973 VSS VSS gf180mcu_fd_sc_mcu9t5v0__filltie
XTAP_TAPCELL_ROW_72_2962 VSS VSS gf180mcu_fd_sc_mcu9t5v0__filltie
X_12158_ _18447_/Q _12315_/S _12160_/B1 VSS VSS VSS VSS gf180mcu_fd_sc_mcu9t5v0__nand2_1
X_12089_ _18428_/Q _12203_/A2 _12093_/A1 VSS _12090_/VNW VSS VSS gf180mcu_fd_sc_mcu9t5v0__nand2_1
X_16966_ _18474_/Q _16965_/Z _16972_/S _18474_/D VSS VSS VSS VSS gf180mcu_fd_sc_mcu9t5v0__mux2_1
X_11109_ _18282_/Q _11403_/S _11115_/B1 VSS _17098_/VNW VSS VSS gf180mcu_fd_sc_mcu9t5v0__nand2_1
X_19754_ _19754_/D _20138_/RN clkload26/I _19754_/Q VSS VSS VSS VSS gf180mcu_fd_sc_mcu9t5v0__dffrnq_1
X_15917_ _20126_/Q _19247_/Q _15920_/S _20126_/D VSS VSS VSS VSS gf180mcu_fd_sc_mcu9t5v0__mux2_1
X_18705_ _18705_/D clkload48/I _18705_/Q VSS VSS VSS VSS gf180mcu_fd_sc_mcu9t5v0__dffq_1
X_19685_ _19685_/D _20069_/RN clkload15/I _19685_/Q VSS VSS VSS VSS gf180mcu_fd_sc_mcu9t5v0__dffrnq_1
X_16897_ _17059_/I1 _19244_/Q _16897_/S _16897_/Z VSS VSS VSS VSS gf180mcu_fd_sc_mcu9t5v0__mux2_1
X_18636_ _18636_/D _20040_/RN clkload48/I _18636_/Q VSS VSS VSS VSS gf180mcu_fd_sc_mcu9t5v0__dffrnq_1
X_15848_ _17597_/S _15848_/A2 _20140_/D VSS _15848_/VNW VSS VSS gf180mcu_fd_sc_mcu9t5v0__nand2_1
Xclkbuf_leaf_23_clk_regs clkload4/I clkload61/I VSS VSS VSS VSS gf180mcu_fd_sc_mcu9t5v0__clkbuf_8
X_15779_ _19973_/Q _19949_/Q _15786_/S _19949_/D VSS VSS VSS VSS gf180mcu_fd_sc_mcu9t5v0__mux2_1
XTAP_TAPCELL_ROW_237_5595 VSS VSS gf180mcu_fd_sc_mcu9t5v0__filltie
XTAP_TAPCELL_ROW_237_5584 VSS VSS gf180mcu_fd_sc_mcu9t5v0__filltie
X_18567_ _18567_/D _20067_/RN clkload54/I _18567_/Q VSS VSS VSS VSS gf180mcu_fd_sc_mcu9t5v0__dffrnq_4
XTAP_TAPCELL_ROW_66_2788 VSS VSS gf180mcu_fd_sc_mcu9t5v0__filltie
XTAP_TAPCELL_ROW_66_2799 VSS VSS gf180mcu_fd_sc_mcu9t5v0__filltie
X_18498_ _18498_/D _20132_/CLK _18498_/Q VSS VSS VSS VSS gf180mcu_fd_sc_mcu9t5v0__dffq_1
X_17518_ input5/Z _18623_/Q _17521_/S _18623_/D VSS VSS VSS VSS gf180mcu_fd_sc_mcu9t5v0__mux2_1
X_17449_ _17461_/A1 _11540_/C _18571_/Q _17450_/A2 VSS VSS VSS VSS gf180mcu_fd_sc_mcu9t5v0__aoi21_1
X_19119_ _19119_/D _20143_/RN clkload30/I _19119_/Q VSS VSS VSS VSS gf180mcu_fd_sc_mcu9t5v0__dffrnq_4
XPHY_EDGE_ROW_12_Right_12 VSS VSS gf180mcu_fd_sc_mcu9t5v0__endcap
XTAP_TAPCELL_ROW_19_1500 VSS VSS gf180mcu_fd_sc_mcu9t5v0__filltie
XTAP_TAPCELL_ROW_19_1511 VSS VSS gf180mcu_fd_sc_mcu9t5v0__filltie
XTAP_TAPCELL_ROW_321_7891 VSS VSS gf180mcu_fd_sc_mcu9t5v0__filltie
XPHY_EDGE_ROW_236_Right_163 VSS VSS gf180mcu_fd_sc_mcu9t5v0__endcap
XTAP_TAPCELL_ROW_15_1408 VSS VSS gf180mcu_fd_sc_mcu9t5v0__filltie
X_09705_ _17599_/A1 _17601_/A1 _09705_/Z VSS _09738_/VNW VSS VSS gf180mcu_fd_sc_mcu9t5v0__and2_1
X_09636_ _09703_/A3 _09634_/Z _09675_/B VSS _09703_/VNW VSS VSS gf180mcu_fd_sc_mcu9t5v0__nor2_1
XTAP_TAPCELL_ROW_154_3_8062 VSS VSS gf180mcu_fd_sc_mcu9t5v0__filltie
XPHY_EDGE_ROW_21_Right_21 VSS VSS gf180mcu_fd_sc_mcu9t5v0__endcap
X_09567_ _10659_/C _09878_/A1 _09416_/B _10693_/B VSS VSS VSS VSS gf180mcu_fd_sc_mcu9t5v0__nor3_2
X_09498_ _19174_/Q _14730_/S _17960_/A1 VSS _09498_/VNW VSS VSS gf180mcu_fd_sc_mcu9t5v0__nand2_1
XTAP_TAPCELL_ROW_134_4667 VSS VSS gf180mcu_fd_sc_mcu9t5v0__filltie
XTAP_TAPCELL_ROW_134_4656 VSS VSS gf180mcu_fd_sc_mcu9t5v0__filltie
X_11460_ wire136/Z _11455_/Z _11460_/B _11526_/B _11461_/A2 VSS VSS VSS VSS gf180mcu_fd_sc_mcu9t5v0__oai211_1
XTAP_TAPCELL_ROW_134_4678 VSS VSS gf180mcu_fd_sc_mcu9t5v0__filltie
X_11391_ _18566_/Q _18365_/Q _11428_/B _11390_/Z wire283/I _11392_/B VSS VSS VSS VSS
+ gf180mcu_fd_sc_mcu9t5v0__aoi221_1
X_10411_ _20099_/Q _17304_/C wire168/Z _10411_/C _10413_/A2 VSS VSS VSS VSS gf180mcu_fd_sc_mcu9t5v0__oai211_1
XTAP_TAPCELL_ROW_76_3084 VSS VSS gf180mcu_fd_sc_mcu9t5v0__filltie
XTAP_TAPCELL_ROW_76_3073 VSS VSS gf180mcu_fd_sc_mcu9t5v0__filltie
XPHY_EDGE_ROW_30_Right_30 VSS VSS gf180mcu_fd_sc_mcu9t5v0__endcap
XTAP_TAPCELL_ROW_76_3062 VSS VSS gf180mcu_fd_sc_mcu9t5v0__filltie
X_10342_ _17378_/A1 _18253_/Q _10345_/A2 VSS VSS VSS VSS gf180mcu_fd_sc_mcu9t5v0__nor2_1
X_13130_ _19760_/Q _13131_/A2 _13151_/B VSS _13130_/VNW VSS VSS gf180mcu_fd_sc_mcu9t5v0__nand2_1
X_13061_ _13061_/A1 _13061_/A2 _13525_/B _13061_/Z VSS VSS VSS VSS gf180mcu_fd_sc_mcu9t5v0__and3_1
X_10273_ _17275_/C _10273_/A2 _10273_/B _17304_/C _10274_/C VSS _17091_/VNW VSS VSS
+ gf180mcu_fd_sc_mcu9t5v0__oai211_1
X_12012_ _17960_/A3 _12311_/B _19123_/D VSS _12012_/VNW VSS VSS gf180mcu_fd_sc_mcu9t5v0__nand2_1
XTAP_TAPCELL_ROW_89_3434 VSS VSS gf180mcu_fd_sc_mcu9t5v0__filltie
XTAP_TAPCELL_ROW_89_3423 VSS VSS gf180mcu_fd_sc_mcu9t5v0__filltie
X_16820_ _18405_/Q _16819_/Z _16828_/S _18405_/D VSS _16820_/VNW VSS VSS gf180mcu_fd_sc_mcu9t5v0__mux2_1
XTAP_TAPCELL_ROW_256_6105 VSS VSS gf180mcu_fd_sc_mcu9t5v0__filltie
XTAP_TAPCELL_ROW_85_3309 VSS VSS gf180mcu_fd_sc_mcu9t5v0__filltie
X_16751_ _19259_/Q _16751_/A2 _16751_/A3 _16751_/B _16752_/A2 VSS VSS VSS VSS gf180mcu_fd_sc_mcu9t5v0__oai31_4
XTAP_TAPCELL_ROW_256_6116 VSS VSS gf180mcu_fd_sc_mcu9t5v0__filltie
X_15702_ _15702_/I0 _19917_/Q _15726_/S _19917_/D VSS VSS VSS VSS gf180mcu_fd_sc_mcu9t5v0__mux2_1
X_13963_ _19319_/Q _19298_/Q _14003_/A1 VSS _13963_/VNW VSS VSS gf180mcu_fd_sc_mcu9t5v0__nand2_1
XTAP_TAPCELL_ROW_5_1120 VSS VSS gf180mcu_fd_sc_mcu9t5v0__filltie
XTAP_TAPCELL_ROW_5_1131 VSS VSS gf180mcu_fd_sc_mcu9t5v0__filltie
X_16682_ _19245_/Q _16730_/C _16684_/B1 VSS _16697_/VNW VSS VSS gf180mcu_fd_sc_mcu9t5v0__nor2_1
X_12914_ _19744_/Q _19809_/Q _12948_/S _12914_/Z VSS VSS VSS VSS gf180mcu_fd_sc_mcu9t5v0__mux2_1
X_13894_ _13855_/Z _13895_/A3 _13921_/A2 VSS _13942_/VNW VSS VSS gf180mcu_fd_sc_mcu9t5v0__nor2_1
XTAP_TAPCELL_ROW_1_1006 VSS VSS gf180mcu_fd_sc_mcu9t5v0__filltie
X_19470_ _19470_/D _20046_/RN clkload32/I _19470_/Q VSS VSS VSS VSS gf180mcu_fd_sc_mcu9t5v0__dffrnq_1
X_18421_ _18421_/D clkload79/I _18421_/Q VSS VSS VSS VSS gf180mcu_fd_sc_mcu9t5v0__dffq_1
X_15633_ _15633_/A1 _10192_/I _15636_/A2 VSS _15633_/VNW VSS VSS gf180mcu_fd_sc_mcu9t5v0__nand2_1
X_12845_ _13229_/A2 _12846_/A2 _12845_/Z VSS _12845_/VNW VSS VSS gf180mcu_fd_sc_mcu9t5v0__or2_1
XTAP_TAPCELL_ROW_1_1017 VSS VSS gf180mcu_fd_sc_mcu9t5v0__filltie
X_18352_ _18352_/D _20132_/CLK _18352_/Q VSS VSS VSS VSS gf180mcu_fd_sc_mcu9t5v0__dffq_1
X_15564_ _19875_/Q _15561_/Z _15564_/Z VSS _15566_/VNW VSS VSS gf180mcu_fd_sc_mcu9t5v0__and2_1
X_12776_ _12776_/A1 _12776_/A2 _12776_/Z VSS _12776_/VNW VSS VSS gf180mcu_fd_sc_mcu9t5v0__xor2_1
X_17303_ _10459_/C _17303_/A2 _17303_/A3 _17303_/B _17304_/B VSS VSS VSS VSS gf180mcu_fd_sc_mcu9t5v0__oai31_1
XPHY_EDGE_ROW_167_1_Left_490 VSS VSS gf180mcu_fd_sc_mcu9t5v0__endcap
X_11727_ _18894_/Q _11725_/Z _11727_/B _11742_/B1 VSS _18009_/VNW VSS VSS gf180mcu_fd_sc_mcu9t5v0__oai21_1
XTAP_TAPCELL_ROW_61_2652 VSS VSS gf180mcu_fd_sc_mcu9t5v0__filltie
XTAP_TAPCELL_ROW_61_2663 VSS VSS gf180mcu_fd_sc_mcu9t5v0__filltie
X_14515_ _19165_/Q _19131_/Q _14735_/A1 VSS VSS VSS VSS gf180mcu_fd_sc_mcu9t5v0__xnor2_1
X_18283_ _18283_/D clkload60/I _18283_/Q VSS VSS VSS VSS gf180mcu_fd_sc_mcu9t5v0__dffq_1
X_15495_ _17422_/S _15494_/Z _19834_/D VSS _15495_/VNW VSS VSS gf180mcu_fd_sc_mcu9t5v0__and2_1
X_17234_ _17234_/A1 _17234_/A2 _19826_/Q _17235_/C VSS VSS VSS VSS gf180mcu_fd_sc_mcu9t5v0__aoi21_1
X_11658_ _11654_/C _12632_/A1 _11659_/B2 VSS VSS VSS VSS gf180mcu_fd_sc_mcu9t5v0__nand2_1
X_14446_ _19121_/Q _14590_/B _14624_/S _14447_/B2 VSS VSS VSS VSS gf180mcu_fd_sc_mcu9t5v0__aoi21_1
X_17165_ input5/Z _10648_/C _10821_/B _17182_/A2 VSS VSS VSS VSS gf180mcu_fd_sc_mcu9t5v0__nand3_1
X_10609_ _10459_/C _10609_/A2 _10609_/A3 _10609_/B _10618_/A2 VSS VSS VSS VSS gf180mcu_fd_sc_mcu9t5v0__oai31_1
X_14377_ _19443_/Q _14715_/S _14378_/A2 VSS _14377_/VNW VSS VSS gf180mcu_fd_sc_mcu9t5v0__nand2_1
X_11589_ _11589_/A1 _11586_/Z _11589_/B _12665_/B VSS VSS VSS VSS gf180mcu_fd_sc_mcu9t5v0__oai21_1
XTAP_TAPCELL_ROW_245_5820 VSS VSS gf180mcu_fd_sc_mcu9t5v0__filltie
X_16116_ _19228_/Q _16695_/B _16119_/A2 VSS VSS VSS VSS gf180mcu_fd_sc_mcu9t5v0__nand2_1
X_13328_ _13603_/A2 _13327_/Z _13331_/A2 VSS VSS VSS VSS gf180mcu_fd_sc_mcu9t5v0__nor2_1
X_17096_ _19856_/Q _10724_/C _17096_/B _17098_/A3 VSS VSS VSS VSS gf180mcu_fd_sc_mcu9t5v0__oai21_1
XTAP_TAPCELL_ROW_59_2592 VSS VSS gf180mcu_fd_sc_mcu9t5v0__filltie
XTAP_TAPCELL_ROW_241_5706 VSS VSS gf180mcu_fd_sc_mcu9t5v0__filltie
X_16047_ _18159_/Q _16047_/I1 _16047_/S _18159_/D VSS VSS VSS VSS gf180mcu_fd_sc_mcu9t5v0__mux2_4
XTAP_TAPCELL_ROW_226_5274 VSS VSS gf180mcu_fd_sc_mcu9t5v0__filltie
XPHY_EDGE_ROW_186_1_Left_509 VSS VSS gf180mcu_fd_sc_mcu9t5v0__endcap
X_13259_ _19736_/Q _13259_/A2 _13580_/B VSS _13266_/VNW VSS VSS gf180mcu_fd_sc_mcu9t5v0__xnor2_1
XTAP_TAPCELL_ROW_55_2489 VSS VSS gf180mcu_fd_sc_mcu9t5v0__filltie
XTAP_TAPCELL_ROW_226_5296 VSS VSS gf180mcu_fd_sc_mcu9t5v0__filltie
XTAP_TAPCELL_ROW_226_5285 VSS VSS gf180mcu_fd_sc_mcu9t5v0__filltie
XTAP_TAPCELL_ROW_160_3_8083 VSS VSS gf180mcu_fd_sc_mcu9t5v0__filltie
X_19806_ _19806_/D _20062_/RN _19806_/CLK _19806_/Q VSS VSS VSS VSS gf180mcu_fd_sc_mcu9t5v0__dffrnq_1
X_17998_ _18884_/Q _18031_/I0 _18004_/S _18884_/D VSS VSS VSS VSS gf180mcu_fd_sc_mcu9t5v0__mux2_1
X_19737_ _19737_/D _20057_/RN clkload23/I _19737_/Q VSS VSS VSS VSS gf180mcu_fd_sc_mcu9t5v0__dffrnq_1
X_16949_ _19253_/Q _16634_/B _16949_/S _16949_/Z VSS VSS VSS VSS gf180mcu_fd_sc_mcu9t5v0__mux2_1
XTAP_TAPCELL_ROW_239_5646 VSS VSS gf180mcu_fd_sc_mcu9t5v0__filltie
XTAP_TAPCELL_ROW_239_5635 VSS VSS gf180mcu_fd_sc_mcu9t5v0__filltie
XTAP_TAPCELL_ROW_68_2839 VSS VSS gf180mcu_fd_sc_mcu9t5v0__filltie
X_19668_ _19668_/D _20052_/RN clkload23/I _19668_/Q VSS VSS VSS VSS gf180mcu_fd_sc_mcu9t5v0__dffrnq_1
X_09421_ _18564_/Q _18565_/Q _17435_/A1 VSS _11330_/VNW VSS VSS gf180mcu_fd_sc_mcu9t5v0__nand2_1
X_18619_ _18619_/D _20023_/RN clkload48/I _18619_/Q VSS VSS VSS VSS gf180mcu_fd_sc_mcu9t5v0__dffrnq_1
X_19599_ _19599_/D _20047_/RN clkload17/I _19599_/Q VSS VSS VSS VSS gf180mcu_fd_sc_mcu9t5v0__dffrnq_1
X_09352_ _19888_/Q _15618_/A1 VSS VSS VSS VSS gf180mcu_fd_sc_mcu9t5v0__clkinv_1
XTAP_TAPCELL_ROW_310_7592 VSS VSS gf180mcu_fd_sc_mcu9t5v0__filltie
X_09283_ _20024_/Q _09837_/A1 VSS VSS VSS VSS gf180mcu_fd_sc_mcu9t5v0__clkinv_1
XPHY_EDGE_ROW_305_Right_232 VSS VSS gf180mcu_fd_sc_mcu9t5v0__endcap
XTAP_TAPCELL_ROW_211_4864 VSS VSS gf180mcu_fd_sc_mcu9t5v0__filltie
XTAP_TAPCELL_ROW_323_7964 VSS VSS gf180mcu_fd_sc_mcu9t5v0__filltie
XTAP_TAPCELL_ROW_323_7953 VSS VSS gf180mcu_fd_sc_mcu9t5v0__filltie
XTAP_TAPCELL_ROW_323_7942 VSS VSS gf180mcu_fd_sc_mcu9t5v0__filltie
XTAP_TAPCELL_ROW_211_4886 VSS VSS gf180mcu_fd_sc_mcu9t5v0__filltie
XTAP_TAPCELL_ROW_211_4875 VSS VSS gf180mcu_fd_sc_mcu9t5v0__filltie
XTAP_TAPCELL_ROW_323_7986 VSS VSS gf180mcu_fd_sc_mcu9t5v0__filltie
XTAP_TAPCELL_ROW_323_7975 VSS VSS gf180mcu_fd_sc_mcu9t5v0__filltie
Xclkload80 clkload80/I clkload80/ZN VSS _11865_/VNW VSS VSS gf180mcu_fd_sc_mcu9t5v0__inv_4
XTAP_TAPCELL_ROW_209_4782 VSS VSS gf180mcu_fd_sc_mcu9t5v0__filltie
XTAP_TAPCELL_ROW_296_7197 VSS VSS gf180mcu_fd_sc_mcu9t5v0__filltie
XTAP_TAPCELL_ROW_209_4793 VSS VSS gf180mcu_fd_sc_mcu9t5v0__filltie
XTAP_TAPCELL_ROW_127_4482 VSS VSS gf180mcu_fd_sc_mcu9t5v0__filltie
XTAP_TAPCELL_ROW_127_4471 VSS VSS gf180mcu_fd_sc_mcu9t5v0__filltie
XTAP_TAPCELL_ROW_317_7779 VSS VSS gf180mcu_fd_sc_mcu9t5v0__filltie
XTAP_TAPCELL_ROW_123_4368 VSS VSS gf180mcu_fd_sc_mcu9t5v0__filltie
XTAP_TAPCELL_ROW_123_4357 VSS VSS gf180mcu_fd_sc_mcu9t5v0__filltie
X_10960_ _18102_/B _11005_/C _10960_/B _19010_/D VSS VSS VSS VSS gf180mcu_fd_sc_mcu9t5v0__oai21_1
X_10891_ _10891_/I0 _18984_/Q _18148_/S _18984_/D VSS VSS VSS VSS gf180mcu_fd_sc_mcu9t5v0__mux2_1
X_09619_ _10063_/C _19913_/Q _09416_/C _09619_/A4 _15827_/A2 VSS _09619_/VNW VSS VSS
+ gf180mcu_fd_sc_mcu9t5v0__nand4_1
X_12630_ _12720_/S _12630_/A2 _12685_/B _12630_/C _12631_/I0 VSS VSS VSS VSS gf180mcu_fd_sc_mcu9t5v0__aoi211_1
X_12561_ wire146/Z _12561_/A2 _12561_/A3 _12561_/B1 _12561_/B2 wire122/I VSS VSS VSS
+ VSS gf180mcu_fd_sc_mcu9t5v0__oai32_1
XTAP_TAPCELL_ROW_78_3135 VSS VSS gf180mcu_fd_sc_mcu9t5v0__filltie
XTAP_TAPCELL_ROW_78_3124 VSS VSS gf180mcu_fd_sc_mcu9t5v0__filltie
Xwire123 wire123/I wire123/Z VSS wire123/VNW VSS VSS gf180mcu_fd_sc_mcu9t5v0__clkbuf_4
X_11512_ _11512_/A1 _11512_/A2 _11512_/B wire136/Z _11513_/B VSS _11512_/VNW VSS VSS
+ gf180mcu_fd_sc_mcu9t5v0__oai211_1
X_12492_ _12492_/A1 _12501_/A2 _12493_/C VSS VSS VSS VSS gf180mcu_fd_sc_mcu9t5v0__nand2_1
X_15280_ _19632_/Q _19609_/Q _19631_/Q _19608_/Q _15280_/C1 _15280_/C2 _15283_/A1
+ VSS _15280_/VNW VSS VSS gf180mcu_fd_sc_mcu9t5v0__oai222_1
X_14300_ _14367_/I0 _19373_/Q _14304_/S _19373_/D VSS _14300_/VNW VSS VSS gf180mcu_fd_sc_mcu9t5v0__mux2_1
X_11443_ _11521_/B _11441_/Z _11443_/B _11447_/A2 VSS VSS VSS VSS gf180mcu_fd_sc_mcu9t5v0__oai21_1
XPHY_EDGE_ROW_205_2_Left_717 VSS VSS gf180mcu_fd_sc_mcu9t5v0__endcap
X_14231_ _14231_/A1 _14229_/Z _14242_/A2 VSS _14231_/VNW VSS VSS gf180mcu_fd_sc_mcu9t5v0__xnor2_1
X_14162_ _19181_/Q _14161_/Z _14715_/S _14162_/Z VSS VSS VSS VSS gf180mcu_fd_sc_mcu9t5v0__mux2_1
X_11374_ _18524_/Q _18508_/Q _18492_/Q _18476_/Q _11403_/S _11098_/B _11374_/Z VSS
+ VSS VSS VSS gf180mcu_fd_sc_mcu9t5v0__mux4_1
XTAP_TAPCELL_ROW_281_6787 VSS VSS gf180mcu_fd_sc_mcu9t5v0__filltie
X_13113_ _13132_/A1 _13132_/A2 _13117_/A3 VSS VSS VSS VSS gf180mcu_fd_sc_mcu9t5v0__nor2_1
XTAP_TAPCELL_ROW_281_6798 VSS VSS gf180mcu_fd_sc_mcu9t5v0__filltie
X_18970_ _18970_/D _20058_/RN clkload68/I _18970_/Q VSS VSS VSS VSS gf180mcu_fd_sc_mcu9t5v0__dffrnq_1
X_10325_ _19826_/Q _10325_/A2 _10325_/A3 _10325_/B _10327_/A1 VSS VSS VSS VSS gf180mcu_fd_sc_mcu9t5v0__oai31_1
X_14093_ _14074_/I _14093_/A2 _14103_/A2 VSS _14093_/VNW VSS VSS gf180mcu_fd_sc_mcu9t5v0__xnor2_1
X_10256_ _17878_/A1 _10657_/C _10652_/B1 VSS VSS VSS VSS gf180mcu_fd_sc_mcu9t5v0__nor2_2
X_17921_ _18845_/Q _17968_/A1 _17925_/A2 VSS _17926_/VNW VSS VSS gf180mcu_fd_sc_mcu9t5v0__nand2_1
X_13044_ _13044_/A1 _13044_/A2 _13044_/Z VSS _13044_/VNW VSS VSS gf180mcu_fd_sc_mcu9t5v0__or2_1
X_17852_ _18825_/Q _17850_/Z _17854_/A2 VSS VSS VSS VSS gf180mcu_fd_sc_mcu9t5v0__nor2_1
X_16803_ _16803_/A1 _16943_/B _16804_/I1 VSS VSS VSS VSS gf180mcu_fd_sc_mcu9t5v0__nand2_1
XTAP_TAPCELL_ROW_221_5160 VSS VSS gf180mcu_fd_sc_mcu9t5v0__filltie
X_10187_ _20038_/Q _10187_/A2 _14267_/A2 VSS VSS VSS VSS gf180mcu_fd_sc_mcu9t5v0__nor2_1
XTAP_TAPCELL_ROW_50_2353 VSS VSS gf180mcu_fd_sc_mcu9t5v0__filltie
XTAP_TAPCELL_ROW_50_2364 VSS VSS gf180mcu_fd_sc_mcu9t5v0__filltie
Xeco14_skew_8 clkload74/I _18320_/CLK VSS VSS VSS VSS gf180mcu_fd_sc_mcu9t5v0__clkbuf_16
X_17783_ _18766_/Q _17782_/B _17785_/A2 VSS VSS VSS VSS gf180mcu_fd_sc_mcu9t5v0__nor2_1
X_14995_ _14996_/A1 _14994_/Z _15003_/A1 VSS _14995_/VNW VSS VSS gf180mcu_fd_sc_mcu9t5v0__nand2_1
X_16734_ _16734_/A1 _16751_/A2 _16751_/A3 _16736_/A2 VSS VSS VSS VSS gf180mcu_fd_sc_mcu9t5v0__nor3_1
X_13946_ _13908_/I _13944_/Z _13948_/A2 VSS _15237_/VNW VSS VSS gf180mcu_fd_sc_mcu9t5v0__xnor2_1
X_19522_ _19522_/D _20034_/RN clkload16/I _19522_/Q VSS VSS VSS VSS gf180mcu_fd_sc_mcu9t5v0__dffrnq_1
XTAP_TAPCELL_ROW_106_3887 VSS VSS gf180mcu_fd_sc_mcu9t5v0__filltie
Xload_slew53 _16897_/S _16927_/S VSS VSS VSS VSS gf180mcu_fd_sc_mcu9t5v0__clkbuf_8
X_16665_ _19226_/Q _16665_/A2 _16745_/B2 VSS VSS VSS VSS gf180mcu_fd_sc_mcu9t5v0__nand2_1
XTAP_TAPCELL_ROW_234_5510 VSS VSS gf180mcu_fd_sc_mcu9t5v0__filltie
XTAP_TAPCELL_ROW_136_3_8001 VSS VSS gf180mcu_fd_sc_mcu9t5v0__filltie
XTAP_TAPCELL_ROW_106_3898 VSS VSS gf180mcu_fd_sc_mcu9t5v0__filltie
XTAP_TAPCELL_ROW_63_2703 VSS VSS gf180mcu_fd_sc_mcu9t5v0__filltie
X_19453_ _19453_/D _20029_/RN clkload30/I _19453_/Q VSS VSS VSS VSS gf180mcu_fd_sc_mcu9t5v0__dffrnq_1
XTAP_TAPCELL_ROW_63_2714 VSS VSS gf180mcu_fd_sc_mcu9t5v0__filltie
X_18404_ _18404_/D clkload75/I _18404_/Q VSS VSS VSS VSS gf180mcu_fd_sc_mcu9t5v0__dffq_4
X_15616_ _19889_/Q _15616_/A2 _19890_/Q _15617_/A2 VSS VSS VSS VSS gf180mcu_fd_sc_mcu9t5v0__aoi21_1
X_13877_ _14245_/A1 _13876_/Z _13879_/A2 VSS VSS VSS VSS gf180mcu_fd_sc_mcu9t5v0__xnor2_1
XTAP_TAPCELL_ROW_48_2293 VSS VSS gf180mcu_fd_sc_mcu9t5v0__filltie
XTAP_TAPCELL_ROW_63_2725 VSS VSS gf180mcu_fd_sc_mcu9t5v0__filltie
X_16596_ _19280_/Q _15996_/B _16601_/B VSS VSS VSS VSS gf180mcu_fd_sc_mcu9t5v0__nand2_1
XTAP_TAPCELL_ROW_230_5407 VSS VSS gf180mcu_fd_sc_mcu9t5v0__filltie
X_12828_ _19731_/Q _19796_/Q _12948_/S _12828_/Z VSS _13171_/VNW VSS VSS gf180mcu_fd_sc_mcu9t5v0__mux2_1
X_19384_ _19384_/D _19960_/RN _19633_/CLK _19384_/Q VSS VSS VSS VSS gf180mcu_fd_sc_mcu9t5v0__dffrnq_1
X_15547_ _19865_/Q _19872_/Q _15551_/S _19865_/D VSS VSS VSS VSS gf180mcu_fd_sc_mcu9t5v0__mux2_1
X_18335_ _18335_/D _20132_/CLK _18335_/Q VSS VSS VSS VSS gf180mcu_fd_sc_mcu9t5v0__dffq_1
XTAP_TAPCELL_ROW_44_2179 VSS VSS gf180mcu_fd_sc_mcu9t5v0__filltie
X_12759_ _19199_/Q _13304_/B _12760_/B VSS _12958_/VNW VSS VSS gf180mcu_fd_sc_mcu9t5v0__nand2_1
X_15478_ _15478_/I _15479_/A2 VSS _15478_/VNW VSS VSS gf180mcu_fd_sc_mcu9t5v0__clkinv_1
X_18266_ _18266_/D clkload64/I _18266_/Q VSS VSS VSS VSS gf180mcu_fd_sc_mcu9t5v0__dffq_1
X_17217_ _18351_/Q _17282_/A2 _17218_/A2 VSS VSS VSS VSS gf180mcu_fd_sc_mcu9t5v0__nand2_1
X_14429_ _19154_/Q _19120_/Q _14699_/A1 VSS VSS VSS VSS gf180mcu_fd_sc_mcu9t5v0__nand2_1
X_18197_ _18197_/D clkload68/I _18197_/Q VSS VSS VSS VSS gf180mcu_fd_sc_mcu9t5v0__dffq_1
X_17148_ _18524_/Q _18508_/Q _17260_/S _17148_/Z VSS VSS VSS VSS gf180mcu_fd_sc_mcu9t5v0__mux2_1
XTAP_TAPCELL_ROW_228_5347 VSS VSS gf180mcu_fd_sc_mcu9t5v0__filltie
XTAP_TAPCELL_ROW_228_5336 VSS VSS gf180mcu_fd_sc_mcu9t5v0__filltie
X_17079_ _18345_/Q _17282_/A2 _17282_/B1 _18361_/Q _17080_/B VSS VSS VSS VSS gf180mcu_fd_sc_mcu9t5v0__aoi22_1
X_09970_ _18792_/Q _10154_/A2 _10154_/B _09971_/A3 VSS VSS VSS VSS gf180mcu_fd_sc_mcu9t5v0__oai21_1
X_20090_ _20090_/D clkload76/I _20090_/Q VSS VSS VSS VSS gf180mcu_fd_sc_mcu9t5v0__dffq_1
XTAP_TAPCELL_ROW_291_7061 VSS VSS gf180mcu_fd_sc_mcu9t5v0__filltie
XTAP_TAPCELL_ROW_33_1883 VSS VSS gf180mcu_fd_sc_mcu9t5v0__filltie
XTAP_TAPCELL_ROW_291_7083 VSS VSS gf180mcu_fd_sc_mcu9t5v0__filltie
XTAP_TAPCELL_ROW_291_7072 VSS VSS gf180mcu_fd_sc_mcu9t5v0__filltie
XTAP_TAPCELL_ROW_33_1894 VSS VSS gf180mcu_fd_sc_mcu9t5v0__filltie
XTAP_TAPCELL_ROW_312_7643 VSS VSS gf180mcu_fd_sc_mcu9t5v0__filltie
XPHY_EDGE_ROW_69_Left_393 VSS VSS gf180mcu_fd_sc_mcu9t5v0__endcap
XTAP_TAPCELL_ROW_312_7654 VSS VSS gf180mcu_fd_sc_mcu9t5v0__filltie
X_09404_ _20002_/Q _20032_/Q wire216/I _20009_/D VSS VSS VSS VSS gf180mcu_fd_sc_mcu9t5v0__and3_1
XPHY_EDGE_ROW_184_2_Left_696 VSS VSS gf180mcu_fd_sc_mcu9t5v0__endcap
X_09335_ _19242_/Q _16436_/A1 VSS VSS VSS VSS gf180mcu_fd_sc_mcu9t5v0__clkinv_1
XTAP_TAPCELL_ROW_213_4915 VSS VSS gf180mcu_fd_sc_mcu9t5v0__filltie
XTAP_TAPCELL_ROW_213_4937 VSS VSS gf180mcu_fd_sc_mcu9t5v0__filltie
XTAP_TAPCELL_ROW_213_4926 VSS VSS gf180mcu_fd_sc_mcu9t5v0__filltie
X_09266_ _19898_/Q _15640_/A1 VSS VSS VSS VSS gf180mcu_fd_sc_mcu9t5v0__clkinv_1
XTAP_TAPCELL_ROW_116_4161 VSS VSS gf180mcu_fd_sc_mcu9t5v0__filltie
XTAP_TAPCELL_ROW_116_4183 VSS VSS gf180mcu_fd_sc_mcu9t5v0__filltie
XTAP_TAPCELL_ROW_116_4172 VSS VSS gf180mcu_fd_sc_mcu9t5v0__filltie
XTAP_TAPCELL_ROW_112_4069 VSS VSS gf180mcu_fd_sc_mcu9t5v0__filltie
XTAP_TAPCELL_ROW_112_4058 VSS VSS gf180mcu_fd_sc_mcu9t5v0__filltie
X_09197_ _19169_/Q _14560_/A1 VSS _14560_/VNW VSS VSS gf180mcu_fd_sc_mcu9t5v0__clkinv_1
Xclkbuf_3_7_0_clk_regs clkbuf_0_clk_regs/Z clkload6/I VSS VSS VSS VSS gf180mcu_fd_sc_mcu9t5v0__clkbuf_8
XTAP_TAPCELL_ROW_298_7259 VSS VSS gf180mcu_fd_sc_mcu9t5v0__filltie
XTAP_TAPCELL_ROW_129_4533 VSS VSS gf180mcu_fd_sc_mcu9t5v0__filltie
XTAP_TAPCELL_ROW_129_4522 VSS VSS gf180mcu_fd_sc_mcu9t5v0__filltie
X_11090_ _15939_/B _11094_/B wire163/I _11359_/B VSS VSS VSS VSS gf180mcu_fd_sc_mcu9t5v0__aoi21_1
XTAP_TAPCELL_ROW_142_3_8022 VSS VSS gf180mcu_fd_sc_mcu9t5v0__filltie
XTAP_TAPCELL_ROW_125_4408 VSS VSS gf180mcu_fd_sc_mcu9t5v0__filltie
X_10110_ _18796_/Q _10154_/A2 _10154_/B _10111_/A3 VSS VSS VSS VSS gf180mcu_fd_sc_mcu9t5v0__oai21_1
X_10041_ _20072_/Q _10041_/A2 _10041_/A3 _10041_/A4 _10042_/C VSS _12213_/VNW VSS
+ VSS gf180mcu_fd_sc_mcu9t5v0__nand4_1
XTAP_TAPCELL_ROW_125_4419 VSS VSS gf180mcu_fd_sc_mcu9t5v0__filltie
X_11992_ _18280_/Q _12345_/A2 _11999_/A3 VSS _12001_/VNW VSS VSS gf180mcu_fd_sc_mcu9t5v0__nand2_1
X_13800_ _13843_/A1 _13800_/A2 _13823_/B2 _13829_/A2 VSS _13800_/VNW VSS VSS gf180mcu_fd_sc_mcu9t5v0__xnor3_1
X_14780_ _19396_/Q _19333_/Q _14780_/Z VSS VSS VSS VSS gf180mcu_fd_sc_mcu9t5v0__xor2_1
X_10943_ _10944_/A1 _10944_/A2 _10947_/B VSS _10943_/VNW VSS VSS gf180mcu_fd_sc_mcu9t5v0__nor2_1
X_13731_ _13731_/A1 _13731_/A2 _13731_/Z VSS VSS VSS VSS gf180mcu_fd_sc_mcu9t5v0__and2_1
XTAP_TAPCELL_ROW_101_3751 VSS VSS gf180mcu_fd_sc_mcu9t5v0__filltie
X_16450_ _18283_/Q _16449_/Z _16972_/S _18283_/D VSS VSS VSS VSS gf180mcu_fd_sc_mcu9t5v0__mux2_1
XTAP_TAPCELL_ROW_270_6499 VSS VSS gf180mcu_fd_sc_mcu9t5v0__filltie
X_10874_ _10873_/Z _18976_/Q _18152_/S _18976_/D VSS VSS VSS VSS gf180mcu_fd_sc_mcu9t5v0__mux2_1
XTAP_TAPCELL_ROW_270_6488 VSS VSS gf180mcu_fd_sc_mcu9t5v0__filltie
XTAP_TAPCELL_ROW_101_3773 VSS VSS gf180mcu_fd_sc_mcu9t5v0__filltie
XTAP_TAPCELL_ROW_101_3762 VSS VSS gf180mcu_fd_sc_mcu9t5v0__filltie
X_13662_ _19441_/Q _14286_/A2 _13745_/B1 _19458_/Q _13656_/Z _19467_/Q _13663_/A2
+ VSS _14373_/VNW VSS VSS gf180mcu_fd_sc_mcu9t5v0__aoi222_1
XTAP_TAPCELL_ROW_0_990 VSS VSS gf180mcu_fd_sc_mcu9t5v0__filltie
X_16381_ _16142_/C _19233_/Q _16925_/S _16381_/Z VSS VSS VSS VSS gf180mcu_fd_sc_mcu9t5v0__mux2_1
X_12613_ _18360_/Q _12613_/A2 _12617_/A2 VSS _12614_/VNW VSS VSS gf180mcu_fd_sc_mcu9t5v0__nor2_1
X_15401_ _19686_/Q _19786_/Q _15417_/S _19786_/D VSS VSS VSS VSS gf180mcu_fd_sc_mcu9t5v0__mux2_1
X_13593_ _19281_/Q _13320_/B _13596_/B VSS VSS VSS VSS gf180mcu_fd_sc_mcu9t5v0__nand2_1
XTAP_TAPCELL_ROW_287_6974 VSS VSS gf180mcu_fd_sc_mcu9t5v0__filltie
XTAP_TAPCELL_ROW_287_6963 VSS VSS gf180mcu_fd_sc_mcu9t5v0__filltie
XTAP_TAPCELL_ROW_287_6952 VSS VSS gf180mcu_fd_sc_mcu9t5v0__filltie
X_18120_ _18119_/Z _18947_/Q _18152_/S _18947_/D VSS VSS VSS VSS gf180mcu_fd_sc_mcu9t5v0__mux2_1
X_12544_ _19164_/Q _12620_/A1 _12545_/B VSS _12545_/VNW VSS VSS gf180mcu_fd_sc_mcu9t5v0__nand2_1
X_15332_ _15332_/A1 _15332_/A2 _15341_/C VSS VSS VSS VSS gf180mcu_fd_sc_mcu9t5v0__nor2_1
X_18051_ _18102_/B _18053_/A2 _18079_/A1 VSS _18068_/VNW VSS VSS gf180mcu_fd_sc_mcu9t5v0__nor2_1
X_17002_ _18492_/Q _17001_/Z _17006_/S _18492_/D VSS VSS VSS VSS gf180mcu_fd_sc_mcu9t5v0__mux2_1
XTAP_TAPCELL_ROW_283_6849 VSS VSS gf180mcu_fd_sc_mcu9t5v0__filltie
X_12475_ wire175/Z _12475_/A2 _12618_/B _12477_/A3 VSS _12475_/VNW VSS VSS gf180mcu_fd_sc_mcu9t5v0__aoi21_1
X_15263_ _15263_/A1 _19578_/Q _15263_/B _15268_/A1 VSS VSS VSS VSS gf180mcu_fd_sc_mcu9t5v0__aoi21_1
X_11426_ _18432_/Q _11485_/C _11429_/C VSS VSS VSS VSS gf180mcu_fd_sc_mcu9t5v0__nand2_1
XANTENNA_6 output12/I VSS VSS VSS VSS gf180mcu_fd_sc_mcu9t5v0__antenna
X_14214_ _14216_/A1 _14216_/A2 _14214_/Z VSS VSS VSS VSS gf180mcu_fd_sc_mcu9t5v0__xor2_1
X_15194_ _19589_/Q _19566_/Q _15204_/B2 VSS _15198_/VNW VSS VSS gf180mcu_fd_sc_mcu9t5v0__xnor2_1
X_11357_ _18395_/Q _11519_/A2 _11358_/A3 VSS _12119_/VNW VSS VSS gf180mcu_fd_sc_mcu9t5v0__nand2_1
X_14145_ _19176_/Q _14546_/S _14148_/B1 VSS VSS VSS VSS gf180mcu_fd_sc_mcu9t5v0__nand2_1
XTAP_TAPCELL_ROW_52_2404 VSS VSS gf180mcu_fd_sc_mcu9t5v0__filltie
XTAP_TAPCELL_ROW_223_5211 VSS VSS gf180mcu_fd_sc_mcu9t5v0__filltie
XTAP_TAPCELL_ROW_223_5200 VSS VSS gf180mcu_fd_sc_mcu9t5v0__filltie
X_18953_ _18953_/D _20041_/RN clkload70/I _18953_/Q VSS VSS VSS VSS gf180mcu_fd_sc_mcu9t5v0__dffrnq_1
X_10308_ _18539_/Q wire81/Z wire282/Z _10314_/A2 VSS _10308_/VNW VSS VSS gf180mcu_fd_sc_mcu9t5v0__aoi21_1
X_14076_ _19319_/Q _19301_/Q _14111_/A1 VSS VSS VSS VSS gf180mcu_fd_sc_mcu9t5v0__nand2_1
XTAP_TAPCELL_ROW_52_2415 VSS VSS gf180mcu_fd_sc_mcu9t5v0__filltie
XTAP_TAPCELL_ROW_52_2426 VSS VSS gf180mcu_fd_sc_mcu9t5v0__filltie
X_11288_ _18310_/Q _11534_/S _11291_/A1 VSS _11290_/VNW VSS VSS gf180mcu_fd_sc_mcu9t5v0__nor2_1
X_17904_ _17907_/B _17887_/I _17905_/A2 VSS VSS VSS VSS gf180mcu_fd_sc_mcu9t5v0__nand2_1
X_13027_ _13028_/A1 _13028_/A2 _13028_/B _13030_/A1 VSS _13030_/VNW VSS VSS gf180mcu_fd_sc_mcu9t5v0__nand3_1
X_10239_ _10516_/C _17380_/B1 _17159_/B VSS VSS VSS VSS gf180mcu_fd_sc_mcu9t5v0__and2_1
X_18884_ _18884_/D _20036_/RN clkload44/I _18884_/Q VSS VSS VSS VSS gf180mcu_fd_sc_mcu9t5v0__dffrnq_1
XTAP_TAPCELL_ROW_108_3949 VSS VSS gf180mcu_fd_sc_mcu9t5v0__filltie
X_17835_ _19042_/Q _18812_/Q _17844_/S _18812_/D VSS VSS VSS VSS gf180mcu_fd_sc_mcu9t5v0__mux2_1
X_17766_ _18758_/Q _17779_/A2 _17767_/B VSS _17767_/VNW VSS VSS gf180mcu_fd_sc_mcu9t5v0__nor2_1
X_16717_ _16722_/A1 _16717_/A2 _16717_/A3 _16717_/B _18369_/D VSS VSS VSS VSS gf180mcu_fd_sc_mcu9t5v0__oai31_4
X_19505_ _19505_/D _20145_/RN clkload41/I _19505_/Q VSS VSS VSS VSS gf180mcu_fd_sc_mcu9t5v0__dffrnq_1
X_14978_ _19429_/Q _19374_/Q _14981_/A1 _14979_/I1 VSS VSS VSS VSS gf180mcu_fd_sc_mcu9t5v0__xnor3_1
XTAP_TAPCELL_ROW_217_5048 VSS VSS gf180mcu_fd_sc_mcu9t5v0__filltie
XTAP_TAPCELL_ROW_217_5037 VSS VSS gf180mcu_fd_sc_mcu9t5v0__filltie
X_17697_ _18726_/Q _17681_/S _17743_/B _18650_/Q _17697_/C _17698_/I VSS VSS VSS VSS
+ gf180mcu_fd_sc_mcu9t5v0__aoi221_1
XTAP_TAPCELL_ROW_217_5026 VSS VSS gf180mcu_fd_sc_mcu9t5v0__filltie
X_13929_ _19321_/Q _19295_/Q _13967_/A1 VSS _13930_/VNW VSS VSS gf180mcu_fd_sc_mcu9t5v0__nand2_1
X_16648_ _15996_/B _16648_/A2 _16648_/A3 _16648_/B _16649_/I1 VSS _17351_/VNW VSS
+ VSS gf180mcu_fd_sc_mcu9t5v0__oai31_1
X_19436_ _19436_/D _20140_/RN clkload9/I _19436_/Q VSS VSS VSS VSS gf180mcu_fd_sc_mcu9t5v0__dffrnq_1
X_16579_ _18346_/Q _16579_/I1 _16602_/S _18346_/D VSS VSS VSS VSS gf180mcu_fd_sc_mcu9t5v0__mux2_4
X_19367_ _19367_/D _20071_/RN _19633_/CLK _19367_/Q VSS VSS VSS VSS gf180mcu_fd_sc_mcu9t5v0__dffrnq_1
X_18318_ _18318_/D _18513_/CLK _18318_/Q VSS VSS VSS VSS gf180mcu_fd_sc_mcu9t5v0__dffq_4
X_09120_ _19787_/Q _12994_/A2 VSS VSS VSS VSS gf180mcu_fd_sc_mcu9t5v0__clkinv_1
XTAP_TAPCELL_ROW_147_3_8037 VSS VSS gf180mcu_fd_sc_mcu9t5v0__filltie
X_19298_ _19298_/D _20066_/RN clkload14/I _19298_/Q VSS VSS VSS VSS gf180mcu_fd_sc_mcu9t5v0__dffrnq_1
X_18249_ _18249_/D clkload63/I _18249_/Q VSS VSS VSS VSS gf180mcu_fd_sc_mcu9t5v0__dffq_1
XPHY_EDGE_ROW_6_Right_6 VSS VSS gf180mcu_fd_sc_mcu9t5v0__endcap
Xmax_cap220 _17399_/A1 _17378_/A1 VSS VSS VSS VSS gf180mcu_fd_sc_mcu9t5v0__clkbuf_8
XTAP_TAPCELL_ROW_22_1584 VSS VSS gf180mcu_fd_sc_mcu9t5v0__filltie
XTAP_TAPCELL_ROW_22_1595 VSS VSS gf180mcu_fd_sc_mcu9t5v0__filltie
XTAP_TAPCELL_ROW_301_7355 VSS VSS gf180mcu_fd_sc_mcu9t5v0__filltie
XTAP_TAPCELL_ROW_301_7344 VSS VSS gf180mcu_fd_sc_mcu9t5v0__filltie
Xmax_cap275 max_cap20/I _17069_/S VSS VSS VSS VSS gf180mcu_fd_sc_mcu9t5v0__buf_4
X_20142_ _20142_/D _20142_/RN clkload48/I _20142_/Q VSS VSS VSS VSS gf180mcu_fd_sc_mcu9t5v0__dffrnq_1
XTAP_TAPCELL_ROW_35_1934 VSS VSS gf180mcu_fd_sc_mcu9t5v0__filltie
XTAP_TAPCELL_ROW_35_1945 VSS VSS gf180mcu_fd_sc_mcu9t5v0__filltie
X_09953_ _18799_/Q _18800_/Q _18798_/Q _09956_/A1 VSS _09961_/VNW VSS VSS gf180mcu_fd_sc_mcu9t5v0__nand3_1
XTAP_TAPCELL_ROW_293_7134 VSS VSS gf180mcu_fd_sc_mcu9t5v0__filltie
XTAP_TAPCELL_ROW_293_7123 VSS VSS gf180mcu_fd_sc_mcu9t5v0__filltie
X_20073_ _20073_/D _20073_/RN clkload49/I _20073_/Q VSS VSS VSS VSS gf180mcu_fd_sc_mcu9t5v0__dffrnq_1
X_09884_ _10445_/A2 _10718_/C _10661_/A2 _09885_/I VSS VSS VSS VSS gf180mcu_fd_sc_mcu9t5v0__and3_1
XTAP_TAPCELL_ROW_35_1956 VSS VSS gf180mcu_fd_sc_mcu9t5v0__filltie
XTAP_TAPCELL_ROW_314_7716 VSS VSS gf180mcu_fd_sc_mcu9t5v0__filltie
XTAP_TAPCELL_ROW_314_7705 VSS VSS gf180mcu_fd_sc_mcu9t5v0__filltie
XPHY_EDGE_ROW_77_Left_401 VSS VSS gf180mcu_fd_sc_mcu9t5v0__endcap
XTAP_TAPCELL_ROW_118_4234 VSS VSS gf180mcu_fd_sc_mcu9t5v0__filltie
XTAP_TAPCELL_ROW_118_4223 VSS VSS gf180mcu_fd_sc_mcu9t5v0__filltie
X_09318_ _19204_/Q _16057_/A1 VSS _09318_/VNW VSS VSS gf180mcu_fd_sc_mcu9t5v0__clkinv_1
XTAP_TAPCELL_ROW_114_4109 VSS VSS gf180mcu_fd_sc_mcu9t5v0__filltie
X_10590_ _18230_/Q _17406_/A2 _17405_/A2 _18246_/Q _10591_/B VSS VSS VSS VSS gf180mcu_fd_sc_mcu9t5v0__aoi22_1
XPHY_EDGE_ROW_86_Left_410 VSS VSS gf180mcu_fd_sc_mcu9t5v0__endcap
X_09249_ _18767_/Q _17755_/A1 VSS _17755_/VNW VSS VSS gf180mcu_fd_sc_mcu9t5v0__clkinv_1
X_12260_ _12324_/B _12259_/Z _12270_/A1 VSS VSS VSS VSS gf180mcu_fd_sc_mcu9t5v0__nand2_1
X_11211_ _11485_/C _11206_/Z _11211_/B _11526_/B _11212_/A2 VSS _11823_/VNW VSS VSS
+ gf180mcu_fd_sc_mcu9t5v0__oai211_1
X_12191_ _14514_/A2 _12333_/B _12191_/B1 _12191_/B2 _19131_/D VSS VSS VSS VSS gf180mcu_fd_sc_mcu9t5v0__oai22_1
X_11142_ _11142_/A1 _11142_/A2 _11429_/B _11142_/C _11144_/B VSS VSS VSS VSS gf180mcu_fd_sc_mcu9t5v0__oai211_1
XTAP_TAPCELL_ROW_263_6292 VSS VSS gf180mcu_fd_sc_mcu9t5v0__filltie
Xoutput10 output10/I din_ready_o VSS VSS VSS VSS gf180mcu_fd_sc_mcu9t5v0__dlyd_1
X_15950_ _16301_/A1 _16443_/A2 _16442_/A1 VSS VSS VSS VSS gf180mcu_fd_sc_mcu9t5v0__nand2_4
X_11073_ _18579_/Q _12689_/A2 _12028_/A1 _18570_/Q _12689_/C _11075_/A2 VSS _17447_/VNW
+ VSS VSS gf180mcu_fd_sc_mcu9t5v0__oai221_1
X_15881_ _20090_/Q _19240_/Q _15912_/S _20090_/D VSS VSS VSS VSS gf180mcu_fd_sc_mcu9t5v0__mux2_1
XTAP_TAPCELL_ROW_276_6653 VSS VSS gf180mcu_fd_sc_mcu9t5v0__filltie
X_10024_ _19247_/Q wire297/Z wire285/I _19255_/Q _10059_/A2 VSS VSS VSS VSS gf180mcu_fd_sc_mcu9t5v0__aoi22_1
X_14901_ _19416_/Q _19357_/Q _14901_/B _14907_/A1 VSS VSS VSS VSS gf180mcu_fd_sc_mcu9t5v0__aoi21_1
XTAP_TAPCELL_ROW_276_6664 VSS VSS gf180mcu_fd_sc_mcu9t5v0__filltie
X_17620_ _18682_/Q _09726_/B _20052_/Q _17621_/A2 VSS _17620_/VNW VSS VSS gf180mcu_fd_sc_mcu9t5v0__aoi21_1
X_14832_ _19404_/Q _19405_/Q _19341_/Q _14833_/I VSS VSS VSS VSS gf180mcu_fd_sc_mcu9t5v0__oai21_1
XTAP_TAPCELL_ROW_103_3802 VSS VSS gf180mcu_fd_sc_mcu9t5v0__filltie
XTAP_TAPCELL_ROW_272_6539 VSS VSS gf180mcu_fd_sc_mcu9t5v0__filltie
XTAP_TAPCELL_ROW_103_3824 VSS VSS gf180mcu_fd_sc_mcu9t5v0__filltie
XTAP_TAPCELL_ROW_103_3813 VSS VSS gf180mcu_fd_sc_mcu9t5v0__filltie
X_11975_ _18231_/Q _12340_/S _12347_/C _11978_/A2 VSS VSS VSS VSS gf180mcu_fd_sc_mcu9t5v0__aoi21_1
X_17551_ _17581_/I1 _18639_/Q _17571_/S _18639_/D VSS _17551_/VNW VSS VSS gf180mcu_fd_sc_mcu9t5v0__mux2_1
XTAP_TAPCELL_ROW_153_3_8058 VSS VSS gf180mcu_fd_sc_mcu9t5v0__filltie
X_14763_ _14764_/A1 _14764_/A2 _14763_/Z VSS _14764_/VNW VSS VSS gf180mcu_fd_sc_mcu9t5v0__and2_1
X_16502_ _18308_/Q _16501_/Z _17026_/S _18308_/D VSS VSS VSS VSS gf180mcu_fd_sc_mcu9t5v0__mux2_1
X_10926_ _19259_/Q _19002_/Q _18152_/S _19002_/D VSS VSS VSS VSS gf180mcu_fd_sc_mcu9t5v0__mux2_1
X_17482_ _18587_/Q _19228_/Q _17504_/S _18587_/D VSS VSS VSS VSS gf180mcu_fd_sc_mcu9t5v0__mux2_1
X_13714_ _13714_/I _13715_/C VSS VSS VSS VSS gf180mcu_fd_sc_mcu9t5v0__clkinv_1
X_14694_ _19535_/Q _14694_/I1 _14704_/S _19535_/D VSS VSS VSS VSS gf180mcu_fd_sc_mcu9t5v0__mux2_1
XTAP_TAPCELL_ROW_45_2230 VSS VSS gf180mcu_fd_sc_mcu9t5v0__filltie
X_10857_ _10857_/I0 _18967_/Q _18148_/S _18967_/D VSS VSS VSS VSS gf180mcu_fd_sc_mcu9t5v0__mux2_1
X_16433_ _16433_/I0 _18277_/Q _16958_/S _18277_/D VSS _16433_/VNW VSS VSS gf180mcu_fd_sc_mcu9t5v0__mux2_4
X_13645_ _13645_/A1 _13645_/A2 _13645_/B _13646_/A3 VSS VSS VSS VSS gf180mcu_fd_sc_mcu9t5v0__aoi21_1
X_19221_ _19221_/D _20053_/RN clkload37/I _19221_/Q VSS VSS VSS VSS gf180mcu_fd_sc_mcu9t5v0__dffrnq_1
XTAP_TAPCELL_ROW_41_2105 VSS VSS gf180mcu_fd_sc_mcu9t5v0__filltie
XTAP_TAPCELL_ROW_41_2116 VSS VSS gf180mcu_fd_sc_mcu9t5v0__filltie
Xeco7_buf_15981 _15981_/ZN _16107_/A1 VSS VSS VSS VSS gf180mcu_fd_sc_mcu9t5v0__clkbuf_16
XPHY_EDGE_ROW_195_1_Left_518 VSS VSS gf180mcu_fd_sc_mcu9t5v0__endcap
X_19152_ _19152_/D _20048_/RN _19798_/CLK _19152_/Q VSS VSS VSS VSS gf180mcu_fd_sc_mcu9t5v0__dffrnq_1
X_16364_ _18246_/Q _16363_/Z _16892_/S _18246_/D VSS VSS VSS VSS gf180mcu_fd_sc_mcu9t5v0__mux2_4
X_18103_ _19196_/Q _19202_/Q _18151_/S _18103_/Z VSS _18103_/VNW VSS VSS gf180mcu_fd_sc_mcu9t5v0__mux2_1
X_10788_ _10715_/C _10788_/A2 _10788_/A3 _10806_/B _10789_/A3 VSS VSS VSS VSS gf180mcu_fd_sc_mcu9t5v0__oai31_1
X_13576_ _19734_/Q _13577_/A2 _13576_/B _13581_/A3 VSS _13581_/VNW VSS VSS gf180mcu_fd_sc_mcu9t5v0__aoi21_1
XPHY_EDGE_ROW_59_Right_59 VSS VSS gf180mcu_fd_sc_mcu9t5v0__endcap
X_16295_ _16295_/A1 _16438_/B _16296_/I1 VSS VSS VSS VSS gf180mcu_fd_sc_mcu9t5v0__nand2_4
XPHY_EDGE_ROW_229_Left_552 VSS VSS gf180mcu_fd_sc_mcu9t5v0__endcap
X_12527_ _18743_/Q _12527_/A2 _12543_/B1 _12527_/B2 _12529_/A3 VSS VSS VSS VSS gf180mcu_fd_sc_mcu9t5v0__aoi22_2
X_19083_ _19083_/D _20043_/RN clkload42/I _19083_/Q VSS VSS VSS VSS gf180mcu_fd_sc_mcu9t5v0__dffrnq_1
X_15315_ _19640_/Q _19617_/Q _15324_/A1 VSS VSS VSS VSS gf180mcu_fd_sc_mcu9t5v0__nor2_1
X_12458_ _12616_/B _12458_/A2 _12458_/A3 _12458_/B1 _12458_/B2 _12459_/A2 VSS VSS
+ VSS VSS gf180mcu_fd_sc_mcu9t5v0__oai32_4
X_15246_ _19599_/Q _19576_/Q _15248_/B VSS VSS VSS VSS gf180mcu_fd_sc_mcu9t5v0__xnor2_1
X_18034_ _18034_/I0 _18919_/Q _18037_/S _18919_/D VSS VSS VSS VSS gf180mcu_fd_sc_mcu9t5v0__mux2_1
Xclkbuf_leaf_48_clk_regs clkload5/I clkload70/I VSS VSS VSS VSS gf180mcu_fd_sc_mcu9t5v0__clkbuf_8
X_11409_ _11423_/A1 _11409_/A2 _11409_/A3 _11409_/B _19095_/D VSS _14633_/VNW VSS
+ VSS gf180mcu_fd_sc_mcu9t5v0__oai31_1
XTAP_TAPCELL_ROW_39_2045 VSS VSS gf180mcu_fd_sc_mcu9t5v0__filltie
XTAP_TAPCELL_ROW_39_2056 VSS VSS gf180mcu_fd_sc_mcu9t5v0__filltie
XTAP_TAPCELL_ROW_39_2067 VSS VSS gf180mcu_fd_sc_mcu9t5v0__filltie
X_12389_ _18205_/Q _12582_/A2 _12392_/A3 VSS VSS VSS VSS gf180mcu_fd_sc_mcu9t5v0__nor2_1
X_15177_ _19557_/Q _19717_/Q _15417_/S _19717_/D VSS _15177_/VNW VSS VSS gf180mcu_fd_sc_mcu9t5v0__mux2_1
X_19985_ _19985_/D _20049_/RN clkload45/I _19985_/Q VSS VSS VSS VSS gf180mcu_fd_sc_mcu9t5v0__dffrnq_1
X_14128_ _14129_/A1 _14127_/Z _14185_/B VSS VSS VSS VSS gf180mcu_fd_sc_mcu9t5v0__nand2_1
X_18936_ _18936_/D _19960_/RN clkload40/I _18936_/Q VSS VSS VSS VSS gf180mcu_fd_sc_mcu9t5v0__dffrnq_1
X_14059_ _14061_/A2 _14061_/A3 _14068_/B VSS _14183_/VNW VSS VSS gf180mcu_fd_sc_mcu9t5v0__and2_1
XPHY_EDGE_ROW_238_Left_561 VSS VSS gf180mcu_fd_sc_mcu9t5v0__endcap
XPHY_EDGE_ROW_68_Right_68 VSS VSS gf180mcu_fd_sc_mcu9t5v0__endcap
X_18867_ _18867_/D _20019_/RN _19680_/CLK _18867_/Q VSS VSS VSS VSS gf180mcu_fd_sc_mcu9t5v0__dffrnq_1
X_17818_ _19025_/Q _18795_/Q _17844_/S _18795_/D VSS _17840_/VNW VSS VSS gf180mcu_fd_sc_mcu9t5v0__mux2_1
XTAP_TAPCELL_ROW_30_1820 VSS VSS gf180mcu_fd_sc_mcu9t5v0__filltie
X_18798_ _18798_/D _20142_/RN clkload32/I _18798_/Q VSS VSS VSS VSS gf180mcu_fd_sc_mcu9t5v0__dffrnq_1
XTAP_TAPCELL_ROW_202_1_4771 VSS VSS gf180mcu_fd_sc_mcu9t5v0__filltie
X_17749_ _20036_/RN _18690_/Q _17749_/A3 _09517_/I _17753_/S VSS _17749_/VNW VSS VSS
+ gf180mcu_fd_sc_mcu9t5v0__nand4_1
XTAP_TAPCELL_ROW_11_1274 VSS VSS gf180mcu_fd_sc_mcu9t5v0__filltie
XTAP_TAPCELL_ROW_11_1285 VSS VSS gf180mcu_fd_sc_mcu9t5v0__filltie
XTAP_TAPCELL_ROW_11_1296 VSS VSS gf180mcu_fd_sc_mcu9t5v0__filltie
X_19419_ _19419_/D _20059_/RN clkload8/I _19419_/Q VSS VSS VSS VSS gf180mcu_fd_sc_mcu9t5v0__dffrnq_1
XPHY_EDGE_ROW_77_Right_77 VSS VSS gf180mcu_fd_sc_mcu9t5v0__endcap
XTAP_TAPCELL_ROW_28_1760 VSS VSS gf180mcu_fd_sc_mcu9t5v0__filltie
X_09103_ _19818_/Q _15450_/A2 VSS VSS VSS VSS gf180mcu_fd_sc_mcu9t5v0__clkinv_1
XPHY_EDGE_ROW_247_Left_570 VSS VSS gf180mcu_fd_sc_mcu9t5v0__endcap
XTAP_TAPCELL_ROW_24_1635 VSS VSS gf180mcu_fd_sc_mcu9t5v0__filltie
XTAP_TAPCELL_ROW_24_1646 VSS VSS gf180mcu_fd_sc_mcu9t5v0__filltie
XTAP_TAPCELL_ROW_307_7520 VSS VSS gf180mcu_fd_sc_mcu9t5v0__filltie
XTAP_TAPCELL_ROW_303_7406 VSS VSS gf180mcu_fd_sc_mcu9t5v0__filltie
X_20125_ _20125_/D clkload60/I _20125_/Q VSS VSS VSS VSS gf180mcu_fd_sc_mcu9t5v0__dffq_1
X_09936_ _19228_/Q _09998_/C _10169_/B1 _19236_/Q _10168_/B1 _19204_/Q _09937_/A2
+ VSS _10117_/VNW VSS VSS gf180mcu_fd_sc_mcu9t5v0__aoi222_1
XPHY_EDGE_ROW_86_Right_86 VSS VSS gf180mcu_fd_sc_mcu9t5v0__endcap
X_20056_ wire175/I _19992_/RN clkload53/I _20056_/Q VSS VSS VSS VSS gf180mcu_fd_sc_mcu9t5v0__dffsnq_1
X_09867_ _15639_/A1 _09867_/A2 _15649_/A1 VSS _15643_/VNW VSS VSS gf180mcu_fd_sc_mcu9t5v0__nand2_1
X_09798_ _18842_/Q _10732_/A1 _09798_/Z VSS VSS VSS VSS gf180mcu_fd_sc_mcu9t5v0__xor2_1
X_11760_ _12261_/B _11760_/A2 _11762_/A2 VSS VSS VSS VSS gf180mcu_fd_sc_mcu9t5v0__nand2_1
XPHY_EDGE_ROW_95_Right_95 VSS VSS gf180mcu_fd_sc_mcu9t5v0__endcap
X_10711_ _10689_/I _10712_/A2 _10734_/A2 VSS VSS VSS VSS gf180mcu_fd_sc_mcu9t5v0__nor2_1
XTAP_TAPCELL_ROW_81_3197 VSS VSS gf180mcu_fd_sc_mcu9t5v0__filltie
X_11691_ _18234_/Q _12181_/A2 _12116_/C _11693_/A2 VSS VSS VSS VSS gf180mcu_fd_sc_mcu9t5v0__aoi21_1
X_10642_ _10459_/C _10642_/A2 _10642_/A3 _10642_/B _10643_/B1 VSS _11317_/VNW VSS
+ VSS gf180mcu_fd_sc_mcu9t5v0__oai31_1
X_13430_ _13430_/A1 _13430_/A2 _13625_/B _13448_/A2 VSS VSS VSS VSS gf180mcu_fd_sc_mcu9t5v0__oai21_1
XTAP_TAPCELL_ROW_98_3683 VSS VSS gf180mcu_fd_sc_mcu9t5v0__filltie
XTAP_TAPCELL_ROW_98_3672 VSS VSS gf180mcu_fd_sc_mcu9t5v0__filltie
X_10573_ _18951_/Q wire166/Z _10575_/A2 VSS VSS VSS VSS gf180mcu_fd_sc_mcu9t5v0__nand2_1
XPHY_EDGE_ROW_147_2_Left_659 VSS VSS gf180mcu_fd_sc_mcu9t5v0__endcap
X_13361_ _13497_/A1 _13361_/A2 _13419_/B _13362_/B2 VSS _13361_/VNW VSS VSS gf180mcu_fd_sc_mcu9t5v0__aoi21_1
XTAP_TAPCELL_ROW_265_6365 VSS VSS gf180mcu_fd_sc_mcu9t5v0__filltie
X_16080_ _19272_/Q _16675_/A1 _16084_/B VSS VSS VSS VSS gf180mcu_fd_sc_mcu9t5v0__nand2_1
XTAP_TAPCELL_ROW_265_6354 VSS VSS gf180mcu_fd_sc_mcu9t5v0__filltie
XTAP_TAPCELL_ROW_94_3569 VSS VSS gf180mcu_fd_sc_mcu9t5v0__filltie
X_12312_ _12312_/A1 _12311_/B _12312_/B1 _12312_/B2 _19137_/D VSS VSS VSS VSS gf180mcu_fd_sc_mcu9t5v0__aoi22_4
XTAP_TAPCELL_ROW_94_3558 VSS VSS gf180mcu_fd_sc_mcu9t5v0__filltie
X_15100_ _19395_/Q _19313_/Q _15100_/B _15100_/C _15105_/A1 VSS VSS VSS VSS gf180mcu_fd_sc_mcu9t5v0__aoi211_1
X_13292_ _19738_/Q _13295_/A2 _13293_/I VSS _13292_/VNW VSS VSS gf180mcu_fd_sc_mcu9t5v0__nand2_1
X_12243_ _18419_/Q _12340_/S _12347_/C _12246_/A2 VSS VSS VSS VSS gf180mcu_fd_sc_mcu9t5v0__aoi21_1
X_15031_ _19633_/Q _19384_/Q _20039_/Q _19633_/D VSS VSS VSS VSS gf180mcu_fd_sc_mcu9t5v0__mux2_1
XTAP_TAPCELL_ROW_278_6704 VSS VSS gf180mcu_fd_sc_mcu9t5v0__filltie
X_12174_ _12192_/A1 _12174_/A2 _12190_/A2 VSS VSS VSS VSS gf180mcu_fd_sc_mcu9t5v0__xnor2_1
XPHY_EDGE_ROW_296_Right_223 VSS VSS gf180mcu_fd_sc_mcu9t5v0__endcap
XTAP_TAPCELL_ROW_278_6726 VSS VSS gf180mcu_fd_sc_mcu9t5v0__filltie
XTAP_TAPCELL_ROW_278_6715 VSS VSS gf180mcu_fd_sc_mcu9t5v0__filltie
X_11125_ _18235_/Q _11098_/B _11129_/C VSS _16342_/VNW VSS VSS gf180mcu_fd_sc_mcu9t5v0__nand2_1
X_16982_ _18482_/Q _16981_/Z _16990_/S _18482_/D VSS VSS VSS VSS gf180mcu_fd_sc_mcu9t5v0__mux2_4
X_19770_ _19770_/D _20026_/RN clkload27/I _19770_/Q VSS VSS VSS VSS gf180mcu_fd_sc_mcu9t5v0__dffrnq_1
X_15933_ _20058_/Q _15933_/A2 _15934_/I VSS VSS VSS VSS gf180mcu_fd_sc_mcu9t5v0__nand2_1
X_18721_ _18721_/D clkload48/I _18721_/Q VSS VSS VSS VSS gf180mcu_fd_sc_mcu9t5v0__dffq_1
X_11056_ _18026_/I0 _19057_/Q _11067_/S _19057_/D VSS _11056_/VNW VSS VSS gf180mcu_fd_sc_mcu9t5v0__mux2_1
X_10007_ _18965_/Q _09898_/C _10172_/A2 _18941_/Q _10009_/A1 VSS VSS VSS VSS gf180mcu_fd_sc_mcu9t5v0__aoi22_1
X_15864_ _10064_/S _16198_/A2 _17481_/A2 VSS VSS VSS VSS gf180mcu_fd_sc_mcu9t5v0__nand2_1
X_18652_ _18652_/D _19992_/RN clkload54/I _18652_/Q VSS VSS VSS VSS gf180mcu_fd_sc_mcu9t5v0__dffrnq_1
X_17603_ wire301/Z _18666_/Q _17609_/S _18666_/D VSS VSS VSS VSS gf180mcu_fd_sc_mcu9t5v0__mux2_1
X_15795_ _18030_/I0 _19965_/Q _15802_/S _19965_/D VSS VSS VSS VSS gf180mcu_fd_sc_mcu9t5v0__mux2_1
X_14815_ _19573_/Q _14814_/Z _14900_/S _19573_/D VSS VSS VSS VSS gf180mcu_fd_sc_mcu9t5v0__mux2_1
XTAP_TAPCELL_ROW_8_1195 VSS VSS gf180mcu_fd_sc_mcu9t5v0__filltie
X_18583_ _18583_/D _20019_/RN clkload28/I _18583_/Q VSS VSS VSS VSS gf180mcu_fd_sc_mcu9t5v0__dffrnq_1
X_17534_ _17769_/A1 _17767_/A1 _17765_/A1 _17541_/A2 VSS VSS VSS VSS gf180mcu_fd_sc_mcu9t5v0__nand3_1
X_14746_ _19168_/Q _19134_/Q _14747_/B VSS VSS VSS VSS gf180mcu_fd_sc_mcu9t5v0__and2_1
X_11958_ _11958_/A1 _11958_/A2 _11960_/B VSS VSS VSS VSS gf180mcu_fd_sc_mcu9t5v0__nand2_1
Xeco15_sk1_0 clkload64/I eco15_sk2_0/I VSS VSS VSS VSS gf180mcu_fd_sc_mcu9t5v0__clkbuf_16
X_11889_ _18307_/Q _12315_/S _12320_/C _11892_/A2 VSS VSS VSS VSS gf180mcu_fd_sc_mcu9t5v0__oai21_1
XTAP_TAPCELL_ROW_250_5955 VSS VSS gf180mcu_fd_sc_mcu9t5v0__filltie
X_10909_ _19251_/Q _19257_/Q _18151_/S _10909_/Z VSS VSS VSS VSS gf180mcu_fd_sc_mcu9t5v0__mux2_1
XTAP_TAPCELL_ROW_250_5944 VSS VSS gf180mcu_fd_sc_mcu9t5v0__filltie
XTAP_TAPCELL_ROW_250_5933 VSS VSS gf180mcu_fd_sc_mcu9t5v0__filltie
X_19204_ _19204_/D _20036_/RN _19680_/CLK _19204_/Q VSS VSS VSS VSS gf180mcu_fd_sc_mcu9t5v0__dffrnq_1
X_14677_ _13749_/Z _14677_/A2 _14679_/A3 VSS _14677_/VNW VSS VSS gf180mcu_fd_sc_mcu9t5v0__nor2_1
X_17465_ wire198/I _11320_/C _18579_/Q _17466_/A2 VSS VSS VSS VSS gf180mcu_fd_sc_mcu9t5v0__aoi21_1
X_16416_ _19232_/Q _16137_/C _16955_/S _16416_/Z VSS VSS VSS VSS gf180mcu_fd_sc_mcu9t5v0__mux2_1
X_17396_ _17404_/S _18536_/Q _17398_/A3 VSS _17397_/VNW VSS VSS gf180mcu_fd_sc_mcu9t5v0__nor2_1
X_13628_ _19745_/Q _13426_/I _13630_/A2 VSS VSS VSS VSS gf180mcu_fd_sc_mcu9t5v0__nor2_1
X_16347_ _19233_/Q _16142_/C _16881_/S _16347_/Z VSS VSS VSS VSS gf180mcu_fd_sc_mcu9t5v0__mux2_4
X_13559_ _19273_/Q _13419_/B _13562_/B VSS _13559_/VNW VSS VSS gf180mcu_fd_sc_mcu9t5v0__nand2_1
X_19135_ _19135_/D _20031_/RN clkload37/I _19135_/Q VSS VSS VSS VSS gf180mcu_fd_sc_mcu9t5v0__dffrnq_1
XPHY_EDGE_ROW_217_Right_144 VSS VSS gf180mcu_fd_sc_mcu9t5v0__endcap
X_19066_ _19066_/D _20026_/RN clkload32/I _19066_/Q VSS VSS VSS VSS gf180mcu_fd_sc_mcu9t5v0__dffrnq_1
X_16278_ _16172_/C _16809_/S _16430_/B VSS wire281/VNW VSS VSS gf180mcu_fd_sc_mcu9t5v0__nand2_1
X_18017_ _18033_/I0 _18902_/Q _18021_/S _18902_/D VSS VSS VSS VSS gf180mcu_fd_sc_mcu9t5v0__mux2_1
XTAP_TAPCELL_ROW_248_5895 VSS VSS gf180mcu_fd_sc_mcu9t5v0__filltie
XTAP_TAPCELL_ROW_248_5884 VSS VSS gf180mcu_fd_sc_mcu9t5v0__filltie
X_15229_ _15229_/A1 _15229_/A2 _15229_/A3 _15229_/B _15237_/A1 VSS _15229_/VNW VSS
+ VSS gf180mcu_fd_sc_mcu9t5v0__oai31_1
X_09721_ _20022_/Q _15850_/A2 _09721_/B _09722_/I VSS _10308_/VNW VSS VSS gf180mcu_fd_sc_mcu9t5v0__aoi21_1
X_19968_ _19968_/D _09246_/I clkload46/I _19968_/Q VSS VSS VSS VSS gf180mcu_fd_sc_mcu9t5v0__dffrnq_1
XTAP_TAPCELL_ROW_17_1450 VSS VSS gf180mcu_fd_sc_mcu9t5v0__filltie
XTAP_TAPCELL_ROW_17_1461 VSS VSS gf180mcu_fd_sc_mcu9t5v0__filltie
X_19899_ _19899_/D _19963_/RN clkload40/I _19899_/Q VSS VSS VSS VSS gf180mcu_fd_sc_mcu9t5v0__dffrnq_1
XTAP_TAPCELL_ROW_13_1336 VSS VSS gf180mcu_fd_sc_mcu9t5v0__filltie
X_18919_ _18919_/D _20071_/RN clkload31/I _18919_/Q VSS VSS VSS VSS gf180mcu_fd_sc_mcu9t5v0__dffrnq_1
X_09652_ _09652_/I _15721_/A3 VSS _15693_/VNW VSS VSS gf180mcu_fd_sc_mcu9t5v0__clkinv_1
XTAP_TAPCELL_ROW_13_1347 VSS VSS gf180mcu_fd_sc_mcu9t5v0__filltie
X_09583_ _18578_/Q _18685_/Q _19195_/Q _09609_/A2 VSS _09583_/VNW VSS VSS gf180mcu_fd_sc_mcu9t5v0__nor3_1
XTAP_TAPCELL_ROW_288_7000 VSS VSS gf180mcu_fd_sc_mcu9t5v0__filltie
XTAP_TAPCELL_ROW_26_1708 VSS VSS gf180mcu_fd_sc_mcu9t5v0__filltie
XTAP_TAPCELL_ROW_136_2_7998 VSS VSS gf180mcu_fd_sc_mcu9t5v0__filltie
X_20108_ _20108_/D clkload59/I _20108_/Q VSS VSS VSS VSS gf180mcu_fd_sc_mcu9t5v0__dffq_1
X_09919_ _09916_/B _17426_/A1 _10016_/B VSS VSS VSS VSS gf180mcu_fd_sc_mcu9t5v0__nor2_1
XTAP_TAPCELL_ROW_87_3362 VSS VSS gf180mcu_fd_sc_mcu9t5v0__filltie
XTAP_TAPCELL_ROW_87_3384 VSS VSS gf180mcu_fd_sc_mcu9t5v0__filltie
X_12930_ _12930_/A1 _12930_/A2 _12930_/A3 _12932_/A2 VSS VSS VSS VSS gf180mcu_fd_sc_mcu9t5v0__nand3_1
XTAP_TAPCELL_ROW_87_3373 VSS VSS gf180mcu_fd_sc_mcu9t5v0__filltie
X_20039_ _20039_/D _20039_/RN clkload20/I _20039_/Q VSS VSS VSS VSS gf180mcu_fd_sc_mcu9t5v0__dffrnq_2
XTAP_TAPCELL_ROW_254_6055 VSS VSS gf180mcu_fd_sc_mcu9t5v0__filltie
XTAP_TAPCELL_ROW_254_6044 VSS VSS gf180mcu_fd_sc_mcu9t5v0__filltie
X_12861_ _12861_/A1 _12861_/A2 _12861_/B _12870_/A1 VSS _12861_/VNW VSS VSS gf180mcu_fd_sc_mcu9t5v0__aoi21_1
XTAP_TAPCELL_ROW_83_3259 VSS VSS gf180mcu_fd_sc_mcu9t5v0__filltie
XPHY_EDGE_ROW_319_Right_246 VSS VSS gf180mcu_fd_sc_mcu9t5v0__endcap
XTAP_TAPCELL_ROW_254_6066 VSS VSS gf180mcu_fd_sc_mcu9t5v0__filltie
XTAP_TAPCELL_ROW_168_3_8111 VSS VSS gf180mcu_fd_sc_mcu9t5v0__filltie
X_14600_ _19179_/Q _19478_/Q _14715_/S _19478_/D VSS _14600_/VNW VSS VSS gf180mcu_fd_sc_mcu9t5v0__mux2_1
X_11812_ _19113_/Q _11966_/B _11813_/B VSS _11814_/VNW VSS VSS gf180mcu_fd_sc_mcu9t5v0__nand2_1
X_15580_ _18036_/I0 _18034_/I0 _18035_/I0 _18032_/I0 _15581_/A2 VSS VSS VSS VSS gf180mcu_fd_sc_mcu9t5v0__nand4_1
X_12792_ _12792_/I0 _19203_/Q _13320_/B _19203_/D VSS VSS VSS VSS gf180mcu_fd_sc_mcu9t5v0__mux2_1
XPHY_EDGE_ROW_14_Left_338 VSS VSS gf180mcu_fd_sc_mcu9t5v0__endcap
XTAP_TAPCELL_ROW_3_1070 VSS VSS gf180mcu_fd_sc_mcu9t5v0__filltie
X_11743_ _18894_/Q _11724_/Z _11768_/A2 VSS VSS VSS VSS gf180mcu_fd_sc_mcu9t5v0__nor2_1
X_14531_ _14531_/A1 _14738_/A1 _14531_/B _14542_/B VSS VSS VSS VSS gf180mcu_fd_sc_mcu9t5v0__oai21_1
X_17250_ _20030_/Q _17394_/A2 _17250_/A3 _17250_/Z VSS VSS VSS VSS gf180mcu_fd_sc_mcu9t5v0__or3_4
XTAP_TAPCELL_ROW_267_6416 VSS VSS gf180mcu_fd_sc_mcu9t5v0__filltie
XTAP_TAPCELL_ROW_267_6405 VSS VSS gf180mcu_fd_sc_mcu9t5v0__filltie
X_11674_ _11674_/A1 _11672_/Z _12664_/C _12632_/C _11675_/C VSS VSS VSS VSS gf180mcu_fd_sc_mcu9t5v0__oai211_1
X_14462_ _14462_/A1 _19125_/Q _14474_/A1 VSS _14473_/VNW VSS VSS gf180mcu_fd_sc_mcu9t5v0__nand2_1
XTAP_TAPCELL_ROW_96_3609 VSS VSS gf180mcu_fd_sc_mcu9t5v0__filltie
X_17181_ _18607_/Q _17409_/B _17225_/B _17181_/C _17182_/A3 VSS _17181_/VNW VSS VSS
+ gf180mcu_fd_sc_mcu9t5v0__oai211_1
X_16201_ _16200_/Z _18185_/Q _16764_/S _18185_/D VSS VSS VSS VSS gf180mcu_fd_sc_mcu9t5v0__mux2_1
XPHY_EDGE_ROW_261_Right_188 VSS VSS gf180mcu_fd_sc_mcu9t5v0__endcap
X_10625_ _18953_/Q wire166/Z _10627_/A2 VSS VSS VSS VSS gf180mcu_fd_sc_mcu9t5v0__nand2_1
XTAP_TAPCELL_ROW_148_3_8042 VSS VSS gf180mcu_fd_sc_mcu9t5v0__filltie
X_13413_ _13413_/A1 _13413_/A2 _13420_/B1 VSS _13413_/VNW VSS VSS gf180mcu_fd_sc_mcu9t5v0__nand2_1
X_16132_ _19231_/Q _16700_/A2 _16714_/A3 _16695_/B _16134_/A2 VSS VSS VSS VSS gf180mcu_fd_sc_mcu9t5v0__oai31_1
X_14393_ wire199/Z _14392_/Z _14394_/C VSS VSS VSS VSS gf180mcu_fd_sc_mcu9t5v0__nand2_1
X_10556_ _10459_/C _10556_/A2 _10556_/A3 _10556_/B _10565_/A2 VSS VSS VSS VSS gf180mcu_fd_sc_mcu9t5v0__oai31_1
X_13344_ _19773_/Q _19807_/Q _13345_/B VSS VSS VSS VSS gf180mcu_fd_sc_mcu9t5v0__xnor2_1
X_10487_ _17399_/A1 _18194_/Q _10490_/A2 VSS _16073_/VNW VSS VSS gf180mcu_fd_sc_mcu9t5v0__nor2_1
X_16063_ _18122_/A1 _16672_/A2 _16098_/B _16162_/B VSS VSS VSS VSS gf180mcu_fd_sc_mcu9t5v0__oai21_4
X_13275_ _13281_/A1 _13276_/A2 _13275_/Z VSS _13275_/VNW VSS VSS gf180mcu_fd_sc_mcu9t5v0__and2_1
X_12226_ _12221_/Z _12225_/Z _12348_/C _12226_/Z VSS VSS VSS VSS gf180mcu_fd_sc_mcu9t5v0__mux2_1
XPHY_EDGE_ROW_23_Left_347 VSS VSS gf180mcu_fd_sc_mcu9t5v0__endcap
X_15014_ _19624_/Q _15013_/Z _15163_/S _19624_/D VSS VSS VSS VSS gf180mcu_fd_sc_mcu9t5v0__mux2_1
X_12157_ _18415_/Q _12315_/S _12322_/B _12160_/A2 VSS _12157_/VNW VSS VSS gf180mcu_fd_sc_mcu9t5v0__aoi21_1
X_19822_ _19822_/D _20142_/RN clkload57/I _19822_/Q VSS VSS VSS VSS gf180mcu_fd_sc_mcu9t5v0__dffrnq_1
XTAP_TAPCELL_ROW_72_2974 VSS VSS gf180mcu_fd_sc_mcu9t5v0__filltie
XTAP_TAPCELL_ROW_72_2963 VSS VSS gf180mcu_fd_sc_mcu9t5v0__filltie
XTAP_TAPCELL_ROW_72_2952 VSS VSS gf180mcu_fd_sc_mcu9t5v0__filltie
XTAP_TAPCELL_ROW_141_3_8018 VSS VSS gf180mcu_fd_sc_mcu9t5v0__filltie
X_11108_ _11321_/A2 _11108_/A2 _11108_/A3 _11108_/B _19073_/D VSS VSS VSS VSS gf180mcu_fd_sc_mcu9t5v0__oai31_1
X_12088_ _12088_/A1 _12088_/A2 _12094_/A2 VSS _12088_/VNW VSS VSS gf180mcu_fd_sc_mcu9t5v0__nor2_1
X_16965_ _19245_/Q _16576_/B _16971_/S _16965_/Z VSS VSS VSS VSS gf180mcu_fd_sc_mcu9t5v0__mux2_1
X_19753_ _19753_/D _20073_/RN clkload28/I _19753_/Q VSS VSS VSS VSS gf180mcu_fd_sc_mcu9t5v0__dffrnq_1
X_16896_ _18440_/Q _16895_/Z wire37/Z _18440_/D VSS VSS VSS VSS gf180mcu_fd_sc_mcu9t5v0__mux2_1
X_15916_ _20125_/Q _19246_/Q _15920_/S _20125_/D VSS VSS VSS VSS gf180mcu_fd_sc_mcu9t5v0__mux2_1
X_18704_ _18704_/D clkload52/I _18704_/Q VSS VSS VSS VSS gf180mcu_fd_sc_mcu9t5v0__dffq_1
X_19684_ _19684_/D _20068_/RN clkload16/I _19684_/Q VSS VSS VSS VSS gf180mcu_fd_sc_mcu9t5v0__dffrnq_1
X_11039_ _18025_/I0 _19040_/Q wire174/Z _19040_/D VSS VSS VSS VSS gf180mcu_fd_sc_mcu9t5v0__mux2_1
X_15847_ _20140_/Q _15850_/A2 _15848_/A2 VSS _15847_/VNW VSS VSS gf180mcu_fd_sc_mcu9t5v0__nand2_1
X_18635_ _18635_/D _20039_/RN clkload53/I _18635_/Q VSS VSS VSS VSS gf180mcu_fd_sc_mcu9t5v0__dffrnq_1
XPHY_EDGE_ROW_139_1_Left_462 VSS VSS gf180mcu_fd_sc_mcu9t5v0__endcap
XPHY_EDGE_ROW_32_Left_356 VSS VSS gf180mcu_fd_sc_mcu9t5v0__endcap
XTAP_TAPCELL_ROW_237_5596 VSS VSS gf180mcu_fd_sc_mcu9t5v0__filltie
X_15778_ input8/Z _19948_/Q _15786_/S _19948_/D VSS _15809_/VNW VSS VSS gf180mcu_fd_sc_mcu9t5v0__mux2_1
XTAP_TAPCELL_ROW_237_5585 VSS VSS gf180mcu_fd_sc_mcu9t5v0__filltie
X_18566_ _18566_/D _20066_/RN clkload53/I _18566_/Q VSS VSS VSS VSS gf180mcu_fd_sc_mcu9t5v0__dffrnq_4
XTAP_TAPCELL_ROW_66_2789 VSS VSS gf180mcu_fd_sc_mcu9t5v0__filltie
X_18497_ _18497_/D _18497_/CLK _18497_/Q VSS VSS VSS VSS gf180mcu_fd_sc_mcu9t5v0__dffq_4
X_17517_ input4/Z _18622_/Q _17521_/S _18622_/D VSS VSS VSS VSS gf180mcu_fd_sc_mcu9t5v0__mux2_1
X_14729_ _14731_/A1 _14731_/A2 _14729_/Z VSS VSS VSS VSS gf180mcu_fd_sc_mcu9t5v0__xor2_1
X_17448_ _17462_/A1 _17448_/A2 _18570_/D VSS VSS VSS VSS gf180mcu_fd_sc_mcu9t5v0__nor2_1
Xclkbuf_leaf_63_clk_regs clkload1/I clkload34/I VSS _17836_/VNW VSS VSS gf180mcu_fd_sc_mcu9t5v0__clkbuf_8
X_17379_ _17260_/S _18471_/Q _17381_/A3 VSS _17379_/VNW VSS VSS gf180mcu_fd_sc_mcu9t5v0__nor2_1
X_19118_ _19118_/D _20142_/RN clkload30/I _19118_/Q VSS VSS VSS VSS gf180mcu_fd_sc_mcu9t5v0__dffrnq_4
XPHY_EDGE_ROW_41_Left_365 VSS VSS gf180mcu_fd_sc_mcu9t5v0__endcap
X_19049_ _19049_/D _20073_/RN clkload34/I _19049_/Q VSS VSS VSS VSS gf180mcu_fd_sc_mcu9t5v0__dffrnq_1
XTAP_TAPCELL_ROW_19_1501 VSS VSS gf180mcu_fd_sc_mcu9t5v0__filltie
XTAP_TAPCELL_ROW_19_1512 VSS VSS gf180mcu_fd_sc_mcu9t5v0__filltie
XTAP_TAPCELL_ROW_321_7892 VSS VSS gf180mcu_fd_sc_mcu9t5v0__filltie
XTAP_TAPCELL_ROW_174_3_8132 VSS VSS gf180mcu_fd_sc_mcu9t5v0__filltie
X_09704_ _09704_/A1 _20049_/Q _17421_/S _20023_/D VSS VSS VSS VSS gf180mcu_fd_sc_mcu9t5v0__oai21_1
X_09635_ _17771_/A1 _09635_/A2 _09735_/B VSS _09635_/VNW VSS VSS gf180mcu_fd_sc_mcu9t5v0__nand2_1
XPHY_EDGE_ROW_50_Left_374 VSS VSS gf180mcu_fd_sc_mcu9t5v0__endcap
XTAP_TAPCELL_ROW_154_3_8063 VSS VSS gf180mcu_fd_sc_mcu9t5v0__filltie
X_09566_ _19019_/Q _17869_/A1 _11018_/A1 VSS _09770_/VNW VSS VSS gf180mcu_fd_sc_mcu9t5v0__nand2_1
X_09497_ _19069_/Q _14475_/B _09497_/B _09497_/ZN VSS VSS VSS VSS gf180mcu_fd_sc_mcu9t5v0__aoi21_4
XTAP_TAPCELL_ROW_156_1_4748 VSS VSS gf180mcu_fd_sc_mcu9t5v0__filltie
XTAP_TAPCELL_ROW_134_4668 VSS VSS gf180mcu_fd_sc_mcu9t5v0__filltie
XTAP_TAPCELL_ROW_134_4657 VSS VSS gf180mcu_fd_sc_mcu9t5v0__filltie
X_10410_ _17406_/C _10410_/A2 _10410_/B _17304_/C _10411_/C VSS _16607_/VNW VSS VSS
+ gf180mcu_fd_sc_mcu9t5v0__oai211_1
XTAP_TAPCELL_ROW_134_4679 VSS VSS gf180mcu_fd_sc_mcu9t5v0__filltie
X_11390_ _18397_/Q _18381_/Q _11524_/S _11390_/Z VSS VSS VSS VSS gf180mcu_fd_sc_mcu9t5v0__mux2_1
XTAP_TAPCELL_ROW_76_3074 VSS VSS gf180mcu_fd_sc_mcu9t5v0__filltie
XTAP_TAPCELL_ROW_76_3063 VSS VSS gf180mcu_fd_sc_mcu9t5v0__filltie
X_10341_ _10648_/C _18669_/Q _10821_/B _10360_/A2 VSS VSS VSS VSS gf180mcu_fd_sc_mcu9t5v0__nand3_1
XTAP_TAPCELL_ROW_76_3085 VSS VSS gf180mcu_fd_sc_mcu9t5v0__filltie
X_10272_ _17243_/A1 _10272_/A2 _10272_/B1 _19828_/Q _10273_/B VSS VSS VSS VSS gf180mcu_fd_sc_mcu9t5v0__aoi22_1
X_13060_ _13061_/A1 _13061_/A2 _13525_/B _13082_/A2 VSS _13529_/VNW VSS VSS gf180mcu_fd_sc_mcu9t5v0__aoi21_1
X_12011_ _12311_/B _12333_/B VSS _12311_/VNW VSS VSS gf180mcu_fd_sc_mcu9t5v0__clkinv_1
XTAP_TAPCELL_ROW_89_3435 VSS VSS gf180mcu_fd_sc_mcu9t5v0__filltie
XTAP_TAPCELL_ROW_89_3424 VSS VSS gf180mcu_fd_sc_mcu9t5v0__filltie
XTAP_TAPCELL_ROW_256_6106 VSS VSS gf180mcu_fd_sc_mcu9t5v0__filltie
X_16750_ _16750_/A1 _16750_/A2 _16750_/B _16752_/A1 VSS VSS VSS VSS gf180mcu_fd_sc_mcu9t5v0__aoi21_4
XTAP_TAPCELL_ROW_256_6117 VSS VSS gf180mcu_fd_sc_mcu9t5v0__filltie
X_13962_ _19320_/Q _19298_/Q _14006_/A1 VSS _13963_/VNW VSS VSS gf180mcu_fd_sc_mcu9t5v0__nand2_1
Xclone228 wire108/I _10187_/A2 _09473_/B _14766_/A2 VSS _11029_/VNW VSS VSS gf180mcu_fd_sc_mcu9t5v0__oai21_2
X_15701_ _15705_/B _15701_/A2 _15701_/B1 _15700_/Z _15702_/I0 VSS VSS VSS VSS gf180mcu_fd_sc_mcu9t5v0__aoi22_1
X_12913_ _12913_/I0 _19221_/Q _13320_/B _19221_/D VSS _12913_/VNW VSS VSS gf180mcu_fd_sc_mcu9t5v0__mux2_1
XTAP_TAPCELL_ROW_5_1110 VSS VSS gf180mcu_fd_sc_mcu9t5v0__filltie
XTAP_TAPCELL_ROW_5_1121 VSS VSS gf180mcu_fd_sc_mcu9t5v0__filltie
XTAP_TAPCELL_ROW_5_1132 VSS VSS gf180mcu_fd_sc_mcu9t5v0__filltie
X_18420_ _18420_/D clkload75/I _18420_/Q VSS VSS VSS VSS gf180mcu_fd_sc_mcu9t5v0__dffq_1
X_16681_ _16722_/A1 _16681_/A2 _16681_/A3 _16681_/B _18361_/D VSS VSS VSS VSS gf180mcu_fd_sc_mcu9t5v0__oai31_4
X_13893_ _13855_/Z _13895_/A3 _13921_/B VSS VSS VSS VSS gf180mcu_fd_sc_mcu9t5v0__nand2_1
X_15632_ _19895_/Q _10201_/B _19896_/Q _15634_/A1 VSS _15633_/VNW VSS VSS gf180mcu_fd_sc_mcu9t5v0__oai21_1
XTAP_TAPCELL_ROW_1_1007 VSS VSS gf180mcu_fd_sc_mcu9t5v0__filltie
XTAP_TAPCELL_ROW_1_1018 VSS VSS gf180mcu_fd_sc_mcu9t5v0__filltie
X_12844_ _19783_/Q _12734_/Z _12844_/B _12846_/A2 VSS _12844_/VNW VSS VSS gf180mcu_fd_sc_mcu9t5v0__oai21_1
X_15563_ _15566_/A1 _15561_/Z _15563_/A3 _19874_/D VSS VSS VSS VSS gf180mcu_fd_sc_mcu9t5v0__nor3_1
X_18351_ _18351_/D _20099_/CLK _18351_/Q VSS VSS VSS VSS gf180mcu_fd_sc_mcu9t5v0__dffq_1
X_12775_ _12783_/A1 _12781_/B _12776_/A2 VSS _12776_/VNW VSS VSS gf180mcu_fd_sc_mcu9t5v0__nor2_1
X_17302_ _18355_/Q _17406_/A2 _17405_/A2 _18371_/Q _17406_/C _17303_/B VSS VSS VSS
+ VSS gf180mcu_fd_sc_mcu9t5v0__aoi221_1
X_18282_ _18282_/D clkload52/I _18282_/Q VSS VSS VSS VSS gf180mcu_fd_sc_mcu9t5v0__dffq_1
X_11726_ _18894_/Q _11725_/Z _12147_/S _11727_/B VSS VSS VSS VSS gf180mcu_fd_sc_mcu9t5v0__aoi21_1
XTAP_TAPCELL_ROW_61_2653 VSS VSS gf180mcu_fd_sc_mcu9t5v0__filltie
XTAP_TAPCELL_ROW_61_2664 VSS VSS gf180mcu_fd_sc_mcu9t5v0__filltie
X_14514_ _19165_/Q _14514_/A2 _14522_/A1 VSS _14514_/VNW VSS VSS gf180mcu_fd_sc_mcu9t5v0__nor2_1
X_17233_ _17404_/S _18448_/Q _17234_/A2 VSS VSS VSS VSS gf180mcu_fd_sc_mcu9t5v0__nand2_1
X_15494_ _19834_/Q input4/Z _15502_/S _15494_/Z VSS VSS VSS VSS gf180mcu_fd_sc_mcu9t5v0__mux2_1
XTAP_TAPCELL_ROW_232_5460 VSS VSS gf180mcu_fd_sc_mcu9t5v0__filltie
XTAP_TAPCELL_ROW_180_3_8153 VSS VSS gf180mcu_fd_sc_mcu9t5v0__filltie
X_11657_ _12664_/C _12672_/A2 _11660_/A2 VSS VSS VSS VSS gf180mcu_fd_sc_mcu9t5v0__nand2_1
X_14445_ wire199/Z _14443_/Z _14448_/B _14447_/B1 VSS _14447_/VNW VSS VSS gf180mcu_fd_sc_mcu9t5v0__nand3_1
X_17164_ _20030_/Q _17394_/A2 _17164_/A3 _17164_/B _18540_/D VSS _17164_/VNW VSS VSS
+ gf180mcu_fd_sc_mcu9t5v0__oai31_1
X_10608_ _18231_/Q _17406_/A2 _17405_/A2 _18247_/Q _10609_/B VSS VSS VSS VSS gf180mcu_fd_sc_mcu9t5v0__aoi22_1
X_14376_ _13682_/C _14376_/A2 _19442_/D VSS VSS VSS VSS gf180mcu_fd_sc_mcu9t5v0__nor2_1
X_11588_ _18845_/Q _17912_/A2 _11611_/B _11588_/B2 _12664_/C VSS _11612_/VNW VSS VSS
+ gf180mcu_fd_sc_mcu9t5v0__aoi22_2
X_16115_ _16747_/A2 _16747_/A3 _16115_/ZN VSS _17026_/VNW VSS VSS gf180mcu_fd_sc_mcu9t5v0__nand2_4
X_10539_ _10539_/A1 _10539_/A2 _10539_/B1 _10539_/B2 _10544_/A2 VSS VSS VSS VSS gf180mcu_fd_sc_mcu9t5v0__aoi22_1
XTAP_TAPCELL_ROW_245_5821 VSS VSS gf180mcu_fd_sc_mcu9t5v0__filltie
XTAP_TAPCELL_ROW_245_5810 VSS VSS gf180mcu_fd_sc_mcu9t5v0__filltie
X_17095_ _10724_/C _17095_/A2 _17095_/A3 _17096_/B VSS _17095_/VNW VSS VSS gf180mcu_fd_sc_mcu9t5v0__nand3_1
X_13327_ _13327_/A1 _13326_/B _13327_/A3 _13327_/Z VSS _13327_/VNW VSS VSS gf180mcu_fd_sc_mcu9t5v0__and3_1
X_16046_ _16675_/A1 _16046_/A2 _16046_/A3 _16046_/B _16047_/I1 VSS VSS VSS VSS gf180mcu_fd_sc_mcu9t5v0__oai31_4
XTAP_TAPCELL_ROW_59_2593 VSS VSS gf180mcu_fd_sc_mcu9t5v0__filltie
XTAP_TAPCELL_ROW_241_5707 VSS VSS gf180mcu_fd_sc_mcu9t5v0__filltie
XTAP_TAPCELL_ROW_226_5275 VSS VSS gf180mcu_fd_sc_mcu9t5v0__filltie
X_13258_ _13280_/A1 _13259_/A2 _13586_/A1 VSS _13258_/VNW VSS VSS gf180mcu_fd_sc_mcu9t5v0__nand2_1
X_12209_ _12209_/A1 _12209_/A2 _12210_/A2 VSS _12209_/VNW VSS VSS gf180mcu_fd_sc_mcu9t5v0__nand2_1
XTAP_TAPCELL_ROW_226_5297 VSS VSS gf180mcu_fd_sc_mcu9t5v0__filltie
XTAP_TAPCELL_ROW_226_5286 VSS VSS gf180mcu_fd_sc_mcu9t5v0__filltie
XTAP_TAPCELL_ROW_160_3_8084 VSS VSS gf180mcu_fd_sc_mcu9t5v0__filltie
X_13189_ _13198_/A2 _19797_/Q _13203_/A1 _13564_/A2 VSS VSS VSS VSS gf180mcu_fd_sc_mcu9t5v0__xnor3_1
X_17997_ _18883_/Q _18030_/I0 _17997_/S _18883_/D VSS _17997_/VNW VSS VSS gf180mcu_fd_sc_mcu9t5v0__mux2_1
X_19805_ _19805_/D _20061_/RN clkload27/I _19805_/Q VSS VSS VSS VSS gf180mcu_fd_sc_mcu9t5v0__dffrnq_1
X_16948_ _16947_/Z _18465_/Q _16960_/S _18465_/D VSS VSS VSS VSS gf180mcu_fd_sc_mcu9t5v0__mux2_1
X_19736_ _19736_/D _19992_/RN clkload20/I _19736_/Q VSS VSS VSS VSS gf180mcu_fd_sc_mcu9t5v0__dffrnq_1
XTAP_TAPCELL_ROW_239_5647 VSS VSS gf180mcu_fd_sc_mcu9t5v0__filltie
XTAP_TAPCELL_ROW_239_5636 VSS VSS gf180mcu_fd_sc_mcu9t5v0__filltie
X_16879_ _19251_/Q _16622_/B _16881_/S _16879_/Z VSS VSS VSS VSS gf180mcu_fd_sc_mcu9t5v0__mux2_4
X_19667_ _19667_/D _20051_/RN clkload23/I _19667_/Q VSS VSS VSS VSS gf180mcu_fd_sc_mcu9t5v0__dffrnq_1
X_18618_ _18618_/D clkload76/I _18618_/Q VSS VSS VSS VSS gf180mcu_fd_sc_mcu9t5v0__dffq_1
X_09420_ _11558_/C _18564_/Q _17434_/A1 VSS VSS VSS VSS gf180mcu_fd_sc_mcu9t5v0__nand2_1
X_19598_ _19598_/D _20046_/RN clkload17/I _19598_/Q VSS VSS VSS VSS gf180mcu_fd_sc_mcu9t5v0__dffrnq_1
X_18549_ _18549_/D _20049_/RN clkload75/I _18549_/Q VSS VSS VSS VSS gf180mcu_fd_sc_mcu9t5v0__dffrnq_4
X_09351_ _18831_/Q _17878_/A1 VSS VSS VSS VSS gf180mcu_fd_sc_mcu9t5v0__clkinv_4
XTAP_TAPCELL_ROW_310_7582 VSS VSS gf180mcu_fd_sc_mcu9t5v0__filltie
X_09282_ _20014_/Q _09755_/A1 VSS VSS VSS VSS gf180mcu_fd_sc_mcu9t5v0__clkinv_1
XTAP_TAPCELL_ROW_310_7593 VSS VSS gf180mcu_fd_sc_mcu9t5v0__filltie
XTAP_TAPCELL_ROW_215_4990 VSS VSS gf180mcu_fd_sc_mcu9t5v0__filltie
XTAP_TAPCELL_ROW_323_7954 VSS VSS gf180mcu_fd_sc_mcu9t5v0__filltie
XTAP_TAPCELL_ROW_323_7943 VSS VSS gf180mcu_fd_sc_mcu9t5v0__filltie
XTAP_TAPCELL_ROW_211_4876 VSS VSS gf180mcu_fd_sc_mcu9t5v0__filltie
XTAP_TAPCELL_ROW_211_4865 VSS VSS gf180mcu_fd_sc_mcu9t5v0__filltie
XTAP_TAPCELL_ROW_146_2_8033 VSS VSS gf180mcu_fd_sc_mcu9t5v0__filltie
XTAP_TAPCELL_ROW_323_7987 VSS VSS gf180mcu_fd_sc_mcu9t5v0__filltie
XTAP_TAPCELL_ROW_323_7976 VSS VSS gf180mcu_fd_sc_mcu9t5v0__filltie
XTAP_TAPCELL_ROW_323_7965 VSS VSS gf180mcu_fd_sc_mcu9t5v0__filltie
Xclkload70 clkload70/I clkload70/ZN VSS _10920_/VNW VSS VSS gf180mcu_fd_sc_mcu9t5v0__inv_3
Xclkload81 clkload81/I clkload81/ZN VSS VSS VSS VSS gf180mcu_fd_sc_mcu9t5v0__inv_3
XTAP_TAPCELL_ROW_296_7198 VSS VSS gf180mcu_fd_sc_mcu9t5v0__filltie
XTAP_TAPCELL_ROW_209_4794 VSS VSS gf180mcu_fd_sc_mcu9t5v0__filltie
XTAP_TAPCELL_ROW_209_4783 VSS VSS gf180mcu_fd_sc_mcu9t5v0__filltie
XTAP_TAPCELL_ROW_127_4472 VSS VSS gf180mcu_fd_sc_mcu9t5v0__filltie
XTAP_TAPCELL_ROW_127_4483 VSS VSS gf180mcu_fd_sc_mcu9t5v0__filltie
XTAP_TAPCELL_ROW_123_4369 VSS VSS gf180mcu_fd_sc_mcu9t5v0__filltie
XTAP_TAPCELL_ROW_123_4358 VSS VSS gf180mcu_fd_sc_mcu9t5v0__filltie
XPHY_EDGE_ROW_156_2_Left_668 VSS VSS gf180mcu_fd_sc_mcu9t5v0__endcap
X_10890_ _16434_/A1 _18147_/S _10892_/B _10891_/I0 VSS VSS VSS VSS gf180mcu_fd_sc_mcu9t5v0__oai21_1
X_09618_ _09618_/I _09619_/A4 VSS VSS VSS VSS gf180mcu_fd_sc_mcu9t5v0__clkinv_1
X_09549_ _09662_/S _15691_/B VSS VSS VSS VSS gf180mcu_fd_sc_mcu9t5v0__clkinv_1
X_12560_ _18497_/Q _12608_/A2 wire146/Z _12561_/B2 VSS VSS VSS VSS gf180mcu_fd_sc_mcu9t5v0__oai21_1
XTAP_TAPCELL_ROW_78_3125 VSS VSS gf180mcu_fd_sc_mcu9t5v0__filltie
XTAP_TAPCELL_ROW_78_3114 VSS VSS gf180mcu_fd_sc_mcu9t5v0__filltie
X_11511_ _18438_/Q _11469_/B _11512_/B VSS _16891_/VNW VSS VSS gf180mcu_fd_sc_mcu9t5v0__nand2_1
X_12491_ _18393_/Q wire163/I _12494_/A3 VSS _12493_/VNW VSS VSS gf180mcu_fd_sc_mcu9t5v0__nor2_1
XTAP_TAPCELL_ROW_78_3136 VSS VSS gf180mcu_fd_sc_mcu9t5v0__filltie
X_11442_ _11442_/A1 _11442_/A2 _11521_/B _11442_/C _11443_/B VSS VSS VSS VSS gf180mcu_fd_sc_mcu9t5v0__oai211_1
Xwire124 wire124/I wire124/Z VSS VSS VSS VSS gf180mcu_fd_sc_mcu9t5v0__clkbuf_3
Xwire146 wire146/I wire146/Z VSS VSS VSS VSS gf180mcu_fd_sc_mcu9t5v0__clkbuf_8
X_14230_ _14231_/A1 _14229_/Z _14242_/B VSS _14231_/VNW VSS VSS gf180mcu_fd_sc_mcu9t5v0__nand2_1
X_11373_ _11373_/A1 _11373_/A2 _11429_/B _11373_/C _11375_/B VSS _11373_/VNW VSS VSS
+ gf180mcu_fd_sc_mcu9t5v0__oai211_1
Xwire168 wire168/I wire168/Z VSS VSS VSS VSS gf180mcu_fd_sc_mcu9t5v0__clkbuf_8
X_14161_ _19480_/Q _19488_/Q _14165_/S _14161_/Z VSS VSS VSS VSS gf180mcu_fd_sc_mcu9t5v0__mux2_1
XTAP_TAPCELL_ROW_281_6788 VSS VSS gf180mcu_fd_sc_mcu9t5v0__filltie
X_10324_ _18156_/Q _17282_/A2 _17282_/B1 _18172_/Q _17406_/C _10325_/B VSS VSS VSS
+ VSS gf180mcu_fd_sc_mcu9t5v0__aoi221_1
XPHY_EDGE_ROW_140_2_Right_871 VSS VSS gf180mcu_fd_sc_mcu9t5v0__endcap
X_13112_ _16424_/A1 _13419_/B _13105_/Z _13112_/B2 _19236_/D VSS VSS VSS VSS gf180mcu_fd_sc_mcu9t5v0__aoi22_1
XTAP_TAPCELL_ROW_281_6799 VSS VSS gf180mcu_fd_sc_mcu9t5v0__filltie
X_14092_ _14092_/A1 _14093_/A2 _14104_/B VSS _14092_/VNW VSS VSS gf180mcu_fd_sc_mcu9t5v0__nor2_1
X_10255_ _10657_/C _10804_/A2 _10654_/A2 VSS VSS VSS VSS gf180mcu_fd_sc_mcu9t5v0__nand2_2
X_13043_ _13043_/I _13615_/B VSS _13043_/VNW VSS VSS gf180mcu_fd_sc_mcu9t5v0__clkinv_1
X_17920_ _18844_/Q _17894_/I _18844_/D VSS VSS VSS VSS gf180mcu_fd_sc_mcu9t5v0__and2_1
X_17851_ _17851_/A1 _17868_/A2 _17850_/Z _17864_/A1 _17851_/B2 _18824_/D VSS VSS VSS
+ VSS gf180mcu_fd_sc_mcu9t5v0__oai32_1
X_10186_ _10187_/A2 _10189_/S _14323_/A2 _20037_/D VSS VSS VSS VSS gf180mcu_fd_sc_mcu9t5v0__nor3_1
X_16802_ _16949_/S _16614_/B _16943_/B VSS _16802_/VNW VSS VSS gf180mcu_fd_sc_mcu9t5v0__nand2_1
XTAP_TAPCELL_ROW_221_5161 VSS VSS gf180mcu_fd_sc_mcu9t5v0__filltie
XTAP_TAPCELL_ROW_221_5150 VSS VSS gf180mcu_fd_sc_mcu9t5v0__filltie
XTAP_TAPCELL_ROW_50_2354 VSS VSS gf180mcu_fd_sc_mcu9t5v0__filltie
XTAP_TAPCELL_ROW_50_2365 VSS VSS gf180mcu_fd_sc_mcu9t5v0__filltie
Xeco14_skew_9 clkload69/I _18279_/CLK VSS VSS VSS VSS gf180mcu_fd_sc_mcu9t5v0__clkbuf_16
X_17782_ _17781_/B _17807_/S _17782_/B _18765_/D VSS VSS VSS VSS gf180mcu_fd_sc_mcu9t5v0__aoi21_1
X_14994_ _19432_/Q _19377_/Q _14994_/Z VSS VSS VSS VSS gf180mcu_fd_sc_mcu9t5v0__xor2_1
X_16733_ _19288_/Q _16751_/B _16736_/B VSS _16733_/VNW VSS VSS gf180mcu_fd_sc_mcu9t5v0__or2_1
X_19521_ _19521_/D _20033_/RN _19680_/CLK _19521_/Q VSS VSS VSS VSS gf180mcu_fd_sc_mcu9t5v0__dffrnq_1
X_13945_ _13945_/A1 _13944_/Z _13950_/A1 VSS VSS VSS VSS gf180mcu_fd_sc_mcu9t5v0__nand2_1
XTAP_TAPCELL_ROW_106_3888 VSS VSS gf180mcu_fd_sc_mcu9t5v0__filltie
X_16664_ _19290_/Q _15996_/B _16669_/B VSS VSS VSS VSS gf180mcu_fd_sc_mcu9t5v0__nand2_1
XTAP_TAPCELL_ROW_234_5500 VSS VSS gf180mcu_fd_sc_mcu9t5v0__filltie
XTAP_TAPCELL_ROW_106_3899 VSS VSS gf180mcu_fd_sc_mcu9t5v0__filltie
X_13876_ _13876_/A1 _13876_/A2 _13876_/Z VSS _13876_/VNW VSS VSS gf180mcu_fd_sc_mcu9t5v0__xor2_1
XTAP_TAPCELL_ROW_63_2704 VSS VSS gf180mcu_fd_sc_mcu9t5v0__filltie
X_19452_ _19452_/D _20028_/RN clkload30/I _19452_/Q VSS VSS VSS VSS gf180mcu_fd_sc_mcu9t5v0__dffrnq_1
XTAP_TAPCELL_ROW_63_2715 VSS VSS gf180mcu_fd_sc_mcu9t5v0__filltie
X_18403_ _18403_/D clkload67/I _18403_/Q VSS VSS VSS VSS gf180mcu_fd_sc_mcu9t5v0__dffq_1
XTAP_TAPCELL_ROW_234_5511 VSS VSS gf180mcu_fd_sc_mcu9t5v0__filltie
X_15615_ _15611_/I _15620_/A2 _15617_/A1 VSS VSS VSS VSS gf180mcu_fd_sc_mcu9t5v0__nor2_1
X_12827_ _19762_/Q _12820_/Z _12827_/B _12836_/A1 VSS _12831_/VNW VSS VSS gf180mcu_fd_sc_mcu9t5v0__aoi21_1
XTAP_TAPCELL_ROW_48_2294 VSS VSS gf180mcu_fd_sc_mcu9t5v0__filltie
XTAP_TAPCELL_ROW_63_2726 VSS VSS gf180mcu_fd_sc_mcu9t5v0__filltie
X_19383_ _19383_/D _20023_/RN _19633_/CLK _19383_/Q VSS VSS VSS VSS gf180mcu_fd_sc_mcu9t5v0__dffrnq_1
X_18334_ _18334_/D clkload73/I _18334_/Q VSS VSS VSS VSS gf180mcu_fd_sc_mcu9t5v0__dffq_1
X_16595_ _18348_/Q _16595_/I1 _16602_/S _18348_/D VSS VSS VSS VSS gf180mcu_fd_sc_mcu9t5v0__mux2_4
XTAP_TAPCELL_ROW_230_5408 VSS VSS gf180mcu_fd_sc_mcu9t5v0__filltie
XTAP_TAPCELL_ROW_219_5090 VSS VSS gf180mcu_fd_sc_mcu9t5v0__filltie
XTAP_TAPCELL_ROW_152_2_8054 VSS VSS gf180mcu_fd_sc_mcu9t5v0__filltie
XPHY_EDGE_ROW_106_Left_430 VSS VSS gf180mcu_fd_sc_mcu9t5v0__endcap
X_15546_ _19864_/Q _19871_/Q _15551_/S _19864_/D VSS _15546_/VNW VSS VSS gf180mcu_fd_sc_mcu9t5v0__mux2_1
X_12758_ _12762_/A1 _12762_/A2 _12758_/Z VSS VSS VSS VSS gf180mcu_fd_sc_mcu9t5v0__and2_1
X_11709_ _18187_/Q _12090_/B _12153_/B _11718_/A2 VSS VSS VSS VSS gf180mcu_fd_sc_mcu9t5v0__aoi21_1
X_15477_ _19872_/Q _19871_/Q _19873_/Q _15477_/A4 _15478_/I VSS _15546_/VNW VSS VSS
+ gf180mcu_fd_sc_mcu9t5v0__nand4_1
X_18265_ _18265_/D clkload64/I _18265_/Q VSS VSS VSS VSS gf180mcu_fd_sc_mcu9t5v0__dffq_1
XPHY_EDGE_ROW_210_Left_533 VSS VSS gf180mcu_fd_sc_mcu9t5v0__endcap
X_12689_ _18586_/Q _12689_/A2 _12618_/B _18577_/Q _12689_/C _12690_/A2 VSS VSS VSS
+ VSS gf180mcu_fd_sc_mcu9t5v0__oai221_1
X_18196_ _18196_/D clkload82/I _18196_/Q VSS VSS VSS VSS gf180mcu_fd_sc_mcu9t5v0__dffq_1
X_17216_ _18399_/Q _18383_/Q _17404_/S _17216_/Z VSS VSS VSS VSS gf180mcu_fd_sc_mcu9t5v0__mux2_1
X_14428_ _14419_/I _14428_/A2 _14428_/B _14442_/A1 VSS _14428_/VNW VSS VSS gf180mcu_fd_sc_mcu9t5v0__aoi21_1
X_17147_ _18412_/Q _17380_/A2 _17380_/B1 _18428_/Q _17278_/C _17155_/A2 VSS _17147_/VNW
+ VSS VSS gf180mcu_fd_sc_mcu9t5v0__aoi221_1
XTAP_TAPCELL_ROW_228_5348 VSS VSS gf180mcu_fd_sc_mcu9t5v0__filltie
XTAP_TAPCELL_ROW_228_5337 VSS VSS gf180mcu_fd_sc_mcu9t5v0__filltie
X_14359_ _14359_/I0 _19429_/Q _14367_/S _19429_/D VSS _14359_/VNW VSS VSS gf180mcu_fd_sc_mcu9t5v0__mux2_1
X_17078_ _19825_/Q _18393_/Q _17080_/A3 VSS VSS VSS VSS gf180mcu_fd_sc_mcu9t5v0__nor2_1
X_16029_ _19200_/Q _16028_/Z _16598_/S _16137_/C VSS VSS VSS VSS gf180mcu_fd_sc_mcu9t5v0__mux2_4
XTAP_TAPCELL_ROW_291_7062 VSS VSS gf180mcu_fd_sc_mcu9t5v0__filltie
XTAP_TAPCELL_ROW_33_1884 VSS VSS gf180mcu_fd_sc_mcu9t5v0__filltie
XTAP_TAPCELL_ROW_291_7084 VSS VSS gf180mcu_fd_sc_mcu9t5v0__filltie
XTAP_TAPCELL_ROW_291_7073 VSS VSS gf180mcu_fd_sc_mcu9t5v0__filltie
XTAP_TAPCELL_ROW_33_1895 VSS VSS gf180mcu_fd_sc_mcu9t5v0__filltie
X_19719_ _19719_/D _20039_/RN clkload20/I _19719_/Q VSS VSS VSS VSS gf180mcu_fd_sc_mcu9t5v0__dffrnq_1
XTAP_TAPCELL_ROW_312_7655 VSS VSS gf180mcu_fd_sc_mcu9t5v0__filltie
XTAP_TAPCELL_ROW_312_7644 VSS VSS gf180mcu_fd_sc_mcu9t5v0__filltie
X_09403_ wire216/I _09413_/A2 _09658_/A2 VSS _10037_/VNW VSS VSS gf180mcu_fd_sc_mcu9t5v0__nand2_1
X_09334_ _19234_/Q _16420_/A1 VSS VSS VSS VSS gf180mcu_fd_sc_mcu9t5v0__clkinv_1
XTAP_TAPCELL_ROW_213_4916 VSS VSS gf180mcu_fd_sc_mcu9t5v0__filltie
XPHY_EDGE_ROW_179_2_Right_910 VSS VSS gf180mcu_fd_sc_mcu9t5v0__endcap
XTAP_TAPCELL_ROW_135_4730 VSS VSS gf180mcu_fd_sc_mcu9t5v0__filltie
XTAP_TAPCELL_ROW_213_4938 VSS VSS gf180mcu_fd_sc_mcu9t5v0__filltie
XTAP_TAPCELL_ROW_213_4927 VSS VSS gf180mcu_fd_sc_mcu9t5v0__filltie
X_09265_ _19894_/Q _15629_/A1 VSS _09265_/VNW VSS VSS gf180mcu_fd_sc_mcu9t5v0__clkinv_1
XTAP_TAPCELL_ROW_116_4162 VSS VSS gf180mcu_fd_sc_mcu9t5v0__filltie
XTAP_TAPCELL_ROW_116_4184 VSS VSS gf180mcu_fd_sc_mcu9t5v0__filltie
XTAP_TAPCELL_ROW_116_4173 VSS VSS gf180mcu_fd_sc_mcu9t5v0__filltie
X_09196_ _19168_/Q _14539_/A1 VSS _14742_/VNW VSS VSS gf180mcu_fd_sc_mcu9t5v0__clkinv_1
XTAP_TAPCELL_ROW_73_3000 VSS VSS gf180mcu_fd_sc_mcu9t5v0__filltie
XTAP_TAPCELL_ROW_112_4059 VSS VSS gf180mcu_fd_sc_mcu9t5v0__filltie
XTAP_TAPCELL_ROW_129_4534 VSS VSS gf180mcu_fd_sc_mcu9t5v0__filltie
XTAP_TAPCELL_ROW_129_4523 VSS VSS gf180mcu_fd_sc_mcu9t5v0__filltie
X_10040_ _19270_/Q _10166_/A2 _10040_/B1 _10138_/B1 _10041_/A4 VSS _10040_/VNW VSS
+ VSS gf180mcu_fd_sc_mcu9t5v0__aoi22_1
XTAP_TAPCELL_ROW_125_4409 VSS VSS gf180mcu_fd_sc_mcu9t5v0__filltie
X_11991_ _18264_/Q _12340_/S _11999_/A2 VSS VSS VSS VSS gf180mcu_fd_sc_mcu9t5v0__nand2_1
XTAP_TAPCELL_ROW_274_6592 VSS VSS gf180mcu_fd_sc_mcu9t5v0__filltie
X_10942_ _18928_/Q _18935_/Q _10942_/B _10944_/A2 VSS _10943_/VNW VSS VSS gf180mcu_fd_sc_mcu9t5v0__aoi21_1
X_13730_ _19455_/Q _13733_/A2 _14286_/A2 _19446_/Q _13731_/A2 VSS _13730_/VNW VSS
+ VSS gf180mcu_fd_sc_mcu9t5v0__aoi22_1
X_10873_ _19239_/Q _19233_/Q _18117_/S _10873_/Z VSS VSS VSS VSS gf180mcu_fd_sc_mcu9t5v0__mux2_1
XTAP_TAPCELL_ROW_270_6489 VSS VSS gf180mcu_fd_sc_mcu9t5v0__filltie
XTAP_TAPCELL_ROW_101_3763 VSS VSS gf180mcu_fd_sc_mcu9t5v0__filltie
X_13661_ _19450_/Q _13733_/A2 _13663_/A1 VSS _13661_/VNW VSS VSS gf180mcu_fd_sc_mcu9t5v0__nand2_1
X_15400_ _19685_/Q _19785_/Q _15417_/S _19785_/D VSS VSS VSS VSS gf180mcu_fd_sc_mcu9t5v0__mux2_1
XTAP_TAPCELL_ROW_0_980 VSS VSS gf180mcu_fd_sc_mcu9t5v0__filltie
XTAP_TAPCELL_ROW_0_991 VSS VSS gf180mcu_fd_sc_mcu9t5v0__filltie
XTAP_TAPCELL_ROW_101_3752 VSS VSS gf180mcu_fd_sc_mcu9t5v0__filltie
X_16380_ _16379_/Z _18253_/Q _16928_/S _18253_/D VSS VSS VSS VSS gf180mcu_fd_sc_mcu9t5v0__mux2_1
X_12612_ _12620_/A1 _12620_/A2 _12612_/A3 _12612_/B _19172_/D VSS _12612_/VNW VSS
+ VSS gf180mcu_fd_sc_mcu9t5v0__oai31_1
X_13592_ wire277/Z _13591_/Z _13592_/B _19280_/D VSS VSS VSS VSS gf180mcu_fd_sc_mcu9t5v0__oai21_1
XTAP_TAPCELL_ROW_287_6964 VSS VSS gf180mcu_fd_sc_mcu9t5v0__filltie
XTAP_TAPCELL_ROW_287_6953 VSS VSS gf180mcu_fd_sc_mcu9t5v0__filltie
X_12543_ _18745_/Q wire198/Z _12543_/B1 _12543_/B2 _12545_/A3 VSS VSS VSS VSS gf180mcu_fd_sc_mcu9t5v0__aoi22_4
X_15331_ _15332_/A1 _15332_/A2 _15331_/Z VSS VSS VSS VSS gf180mcu_fd_sc_mcu9t5v0__and2_1
XTAP_TAPCELL_ROW_287_6975 VSS VSS gf180mcu_fd_sc_mcu9t5v0__filltie
X_18050_ _18078_/A1 _18048_/Z _18050_/B _18057_/A3 VSS VSS VSS VSS gf180mcu_fd_sc_mcu9t5v0__oai21_1
X_15262_ _15417_/S _15262_/A2 _15263_/B _15262_/B _19731_/D VSS VSS VSS VSS gf180mcu_fd_sc_mcu9t5v0__oai31_1
X_17001_ _19247_/Q _16592_/B _17003_/S _17001_/Z VSS VSS VSS VSS gf180mcu_fd_sc_mcu9t5v0__mux2_1
X_12474_ _12616_/B _12474_/A2 _12474_/A3 _12474_/B1 _12474_/B2 _12475_/A2 VSS VSS
+ VSS VSS gf180mcu_fd_sc_mcu9t5v0__oai32_4
X_14213_ _14213_/A1 _14213_/A2 _14216_/A2 VSS VSS VSS VSS gf180mcu_fd_sc_mcu9t5v0__xnor2_1
XANTENNA_7 _10034_/A2 VSS VSS VSS VSS gf180mcu_fd_sc_mcu9t5v0__antenna
X_11425_ _12028_/C _11425_/A2 _11488_/B VSS VSS VSS VSS gf180mcu_fd_sc_mcu9t5v0__nand2_1
X_15193_ _19589_/Q _15193_/A2 _15204_/C VSS VSS VSS VSS gf180mcu_fd_sc_mcu9t5v0__nor2_1
XTAP_TAPCELL_ROW_56_2530 VSS VSS gf180mcu_fd_sc_mcu9t5v0__filltie
X_11356_ _18379_/Q _11524_/S _11358_/A2 VSS _17127_/VNW VSS VSS gf180mcu_fd_sc_mcu9t5v0__nand2_1
XPHY_EDGE_ROW_141_2_Right_872 VSS VSS gf180mcu_fd_sc_mcu9t5v0__endcap
XPHY_EDGE_ROW_148_1_Left_471 VSS VSS gf180mcu_fd_sc_mcu9t5v0__endcap
X_14144_ _14144_/A1 _14144_/A2 _19316_/D VSS VSS VSS VSS gf180mcu_fd_sc_mcu9t5v0__nand2_1
XTAP_TAPCELL_ROW_223_5212 VSS VSS gf180mcu_fd_sc_mcu9t5v0__filltie
XTAP_TAPCELL_ROW_223_5201 VSS VSS gf180mcu_fd_sc_mcu9t5v0__filltie
X_18952_ _18952_/D _20040_/RN clkload70/I _18952_/Q VSS VSS VSS VSS gf180mcu_fd_sc_mcu9t5v0__dffrnq_1
X_10307_ _19850_/Q _10724_/C _10416_/B _10307_/C _10314_/A1 VSS VSS VSS VSS gf180mcu_fd_sc_mcu9t5v0__oai211_4
X_14075_ _14075_/A1 _14075_/A2 _14104_/A1 VSS _14075_/VNW VSS VSS gf180mcu_fd_sc_mcu9t5v0__nand2_1
XTAP_TAPCELL_ROW_52_2405 VSS VSS gf180mcu_fd_sc_mcu9t5v0__filltie
XTAP_TAPCELL_ROW_52_2416 VSS VSS gf180mcu_fd_sc_mcu9t5v0__filltie
X_11287_ _18342_/Q _18326_/Q _18278_/Q _18262_/Q _11534_/S _11469_/B _11287_/Z VSS
+ VSS VSS VSS gf180mcu_fd_sc_mcu9t5v0__mux4_1
X_17903_ _17903_/A1 _17926_/A1 _18839_/Q _17905_/B VSS _17903_/VNW VSS VSS gf180mcu_fd_sc_mcu9t5v0__aoi21_1
X_13026_ _19722_/Q _19754_/Q _13028_/B VSS VSS VSS VSS gf180mcu_fd_sc_mcu9t5v0__xor2_1
X_10238_ _20093_/Q _17304_/C _10238_/B wire168/I _10242_/A1 VSS VSS VSS VSS gf180mcu_fd_sc_mcu9t5v0__oai211_1
X_18883_ _18883_/D _20035_/RN clkload46/I _18883_/Q VSS VSS VSS VSS gf180mcu_fd_sc_mcu9t5v0__dffrnq_1
XTAP_TAPCELL_ROW_108_3939 VSS VSS gf180mcu_fd_sc_mcu9t5v0__filltie
XPHY_EDGE_ROW_203_3_Left_861 VSS VSS gf180mcu_fd_sc_mcu9t5v0__endcap
X_10169_ _19002_/Q wire285/Z _10169_/B1 _18986_/Q _10170_/A2 VSS VSS VSS VSS gf180mcu_fd_sc_mcu9t5v0__aoi22_1
X_17834_ _19041_/Q _18811_/Q _17844_/S _18811_/D VSS VSS VSS VSS gf180mcu_fd_sc_mcu9t5v0__mux2_1
X_17765_ _17765_/A1 _17779_/A2 _17765_/B _17779_/C _18757_/D VSS VSS VSS VSS gf180mcu_fd_sc_mcu9t5v0__aoi211_1
X_14977_ _19429_/Q _19374_/Q _14981_/A2 VSS _14977_/VNW VSS VSS gf180mcu_fd_sc_mcu9t5v0__nand2_1
X_16716_ _19284_/Q _16695_/B _16717_/A3 VSS VSS VSS VSS gf180mcu_fd_sc_mcu9t5v0__nor2_1
X_19504_ _19504_/D _20144_/RN clkload41/I _19504_/Q VSS VSS VSS VSS gf180mcu_fd_sc_mcu9t5v0__dffrnq_1
X_13928_ _13928_/A1 _13928_/A2 _13928_/B _13936_/A1 VSS _13928_/VNW VSS VSS gf180mcu_fd_sc_mcu9t5v0__oai21_1
XTAP_TAPCELL_ROW_217_5038 VSS VSS gf180mcu_fd_sc_mcu9t5v0__filltie
X_17696_ _18664_/Q _17696_/A2 _17681_/S _17697_/C VSS VSS VSS VSS gf180mcu_fd_sc_mcu9t5v0__nor3_1
XTAP_TAPCELL_ROW_217_5027 VSS VSS gf180mcu_fd_sc_mcu9t5v0__filltie
XTAP_TAPCELL_ROW_167_3_8107 VSS VSS gf180mcu_fd_sc_mcu9t5v0__filltie
X_16647_ _16668_/A1 _16668_/A2 _16647_/B _16648_/A3 VSS VSS VSS VSS gf180mcu_fd_sc_mcu9t5v0__aoi21_1
XTAP_TAPCELL_ROW_217_5049 VSS VSS gf180mcu_fd_sc_mcu9t5v0__filltie
X_13859_ _13861_/A1 _13858_/Z _13872_/B VSS VSS VSS VSS gf180mcu_fd_sc_mcu9t5v0__or2_1
X_19435_ _19435_/D _20139_/RN clkload9/I _19435_/Q VSS VSS VSS VSS gf180mcu_fd_sc_mcu9t5v0__dffrnq_1
X_16578_ _15996_/B _16578_/A2 _16578_/A3 _16578_/B _16579_/I1 VSS VSS VSS VSS gf180mcu_fd_sc_mcu9t5v0__oai31_1
X_19366_ _19366_/D _20070_/RN _19633_/CLK _19366_/Q VSS VSS VSS VSS gf180mcu_fd_sc_mcu9t5v0__dffrnq_1
X_18317_ _18317_/D _18513_/CLK _18317_/Q VSS VSS VSS VSS gf180mcu_fd_sc_mcu9t5v0__dffq_4
X_15529_ _15566_/A1 _15529_/A2 _19847_/D VSS VSS VSS VSS gf180mcu_fd_sc_mcu9t5v0__nor2_1
XPHY_EDGE_ROW_136_3_Left_794 VSS VSS gf180mcu_fd_sc_mcu9t5v0__endcap
X_19297_ _19297_/D _20065_/RN clkload15/I _19297_/Q VSS VSS VSS VSS gf180mcu_fd_sc_mcu9t5v0__dffrnq_1
X_18248_ _18248_/D clkload81/I _18248_/Q VSS VSS VSS VSS gf180mcu_fd_sc_mcu9t5v0__dffq_1
XTAP_TAPCELL_ROW_147_3_8038 VSS VSS gf180mcu_fd_sc_mcu9t5v0__filltie
X_18179_ _18179_/D clkload78/I _18179_/Q VSS VSS VSS VSS gf180mcu_fd_sc_mcu9t5v0__dffq_4
Xmax_cap210 _12548_/A1 _12028_/C VSS VSS VSS VSS gf180mcu_fd_sc_mcu9t5v0__clkbuf_8
XTAP_TAPCELL_ROW_22_1574 VSS VSS gf180mcu_fd_sc_mcu9t5v0__filltie
XTAP_TAPCELL_ROW_22_1585 VSS VSS gf180mcu_fd_sc_mcu9t5v0__filltie
XTAP_TAPCELL_ROW_22_1596 VSS VSS gf180mcu_fd_sc_mcu9t5v0__filltie
XTAP_TAPCELL_ROW_305_7470 VSS VSS gf180mcu_fd_sc_mcu9t5v0__filltie
XTAP_TAPCELL_ROW_301_7356 VSS VSS gf180mcu_fd_sc_mcu9t5v0__filltie
XTAP_TAPCELL_ROW_301_7345 VSS VSS gf180mcu_fd_sc_mcu9t5v0__filltie
X_20141_ _20141_/D _20141_/RN clkload48/I _20141_/Q VSS VSS VSS VSS gf180mcu_fd_sc_mcu9t5v0__dffrnq_1
X_09952_ _20028_/Q _18806_/Q _10179_/B VSS VSS VSS VSS gf180mcu_fd_sc_mcu9t5v0__or2_1
XTAP_TAPCELL_ROW_35_1935 VSS VSS gf180mcu_fd_sc_mcu9t5v0__filltie
XTAP_TAPCELL_ROW_318_7820 VSS VSS gf180mcu_fd_sc_mcu9t5v0__filltie
XTAP_TAPCELL_ROW_293_7135 VSS VSS gf180mcu_fd_sc_mcu9t5v0__filltie
XTAP_TAPCELL_ROW_293_7124 VSS VSS gf180mcu_fd_sc_mcu9t5v0__filltie
X_20072_ _20072_/D _20072_/RN clkload65/I _20072_/Q VSS VSS VSS VSS gf180mcu_fd_sc_mcu9t5v0__dffrnq_1
X_09883_ _20034_/Q _20035_/Q _10661_/A2 VSS _09883_/VNW VSS VSS gf180mcu_fd_sc_mcu9t5v0__nor2_1
XTAP_TAPCELL_ROW_35_1946 VSS VSS gf180mcu_fd_sc_mcu9t5v0__filltie
XTAP_TAPCELL_ROW_35_1957 VSS VSS gf180mcu_fd_sc_mcu9t5v0__filltie
XTAP_TAPCELL_ROW_314_7717 VSS VSS gf180mcu_fd_sc_mcu9t5v0__filltie
XTAP_TAPCELL_ROW_314_7706 VSS VSS gf180mcu_fd_sc_mcu9t5v0__filltie
Xeco7_buf_16105 _16105_/ZN _16747_/A2 VSS VSS VSS VSS gf180mcu_fd_sc_mcu9t5v0__clkbuf_16
XPHY_EDGE_ROW_306_Left_629 VSS VSS gf180mcu_fd_sc_mcu9t5v0__endcap
XTAP_TAPCELL_ROW_118_4235 VSS VSS gf180mcu_fd_sc_mcu9t5v0__filltie
XTAP_TAPCELL_ROW_118_4224 VSS VSS gf180mcu_fd_sc_mcu9t5v0__filltie
X_09317_ _19205_/Q _18122_/A1 VSS VSS VSS VSS gf180mcu_fd_sc_mcu9t5v0__clkinv_1
XPHY_EDGE_ROW_277_Right_204 VSS VSS gf180mcu_fd_sc_mcu9t5v0__endcap
X_09248_ _18765_/Q _17781_/B VSS _17784_/VNW VSS VSS gf180mcu_fd_sc_mcu9t5v0__clkinv_1
X_09179_ _19151_/Q _14397_/A1 VSS VSS VSS VSS gf180mcu_fd_sc_mcu9t5v0__clkinv_1
X_11210_ _11210_/A1 _11210_/A2 _11210_/B _11485_/C _11211_/B VSS _11829_/VNW VSS VSS
+ gf180mcu_fd_sc_mcu9t5v0__oai211_1
X_12190_ _12548_/A1 _12190_/A2 _12333_/B _12191_/B2 VSS VSS VSS VSS gf180mcu_fd_sc_mcu9t5v0__oai21_1
Xoutput11 output11/I dout[0] VSS VSS VSS VSS gf180mcu_fd_sc_mcu9t5v0__dlyd_1
XPHY_EDGE_ROW_315_Left_638 VSS VSS gf180mcu_fd_sc_mcu9t5v0__endcap
X_11141_ _18268_/Q _11403_/S _11428_/B _11142_/A2 VSS _17112_/VNW VSS VSS gf180mcu_fd_sc_mcu9t5v0__oai21_1
XTAP_TAPCELL_ROW_263_6293 VSS VSS gf180mcu_fd_sc_mcu9t5v0__filltie
XPHY_EDGE_ROW_140_1_Right_724 VSS VSS gf180mcu_fd_sc_mcu9t5v0__endcap
XTAP_TAPCELL_ROW_173_3_8128 VSS VSS gf180mcu_fd_sc_mcu9t5v0__filltie
X_11072_ _19071_/Q _12694_/A1 _11072_/S _19071_/D VSS VSS VSS VSS gf180mcu_fd_sc_mcu9t5v0__mux2_1
X_15880_ _20089_/Q _19239_/Q _15912_/S _20089_/D VSS VSS VSS VSS gf180mcu_fd_sc_mcu9t5v0__mux2_1
XTAP_TAPCELL_ROW_276_6654 VSS VSS gf180mcu_fd_sc_mcu9t5v0__filltie
X_10023_ _19223_/Q _09898_/C wire172/Z _19215_/Q _10059_/A1 VSS VSS VSS VSS gf180mcu_fd_sc_mcu9t5v0__aoi22_1
X_14900_ _19596_/Q _14899_/Z _14900_/S _19596_/D VSS VSS VSS VSS gf180mcu_fd_sc_mcu9t5v0__mux2_1
XTAP_TAPCELL_ROW_276_6665 VSS VSS gf180mcu_fd_sc_mcu9t5v0__filltie
X_14831_ _14827_/B _14828_/Z _14831_/Z VSS VSS VSS VSS gf180mcu_fd_sc_mcu9t5v0__and2_1
X_17550_ _17693_/A1 _17735_/A1 _17581_/I1 VSS VSS VSS VSS gf180mcu_fd_sc_mcu9t5v0__nand2_1
XTAP_TAPCELL_ROW_103_3825 VSS VSS gf180mcu_fd_sc_mcu9t5v0__filltie
XTAP_TAPCELL_ROW_103_3814 VSS VSS gf180mcu_fd_sc_mcu9t5v0__filltie
XTAP_TAPCELL_ROW_103_3803 VSS VSS gf180mcu_fd_sc_mcu9t5v0__filltie
X_16501_ _19239_/Q _16172_/C _17025_/S _16501_/Z VSS VSS VSS VSS gf180mcu_fd_sc_mcu9t5v0__mux2_1
X_11974_ _18199_/Q _11971_/Z _12299_/S _11974_/Z VSS VSS VSS VSS gf180mcu_fd_sc_mcu9t5v0__mux2_1
XTAP_TAPCELL_ROW_153_3_8059 VSS VSS gf180mcu_fd_sc_mcu9t5v0__filltie
X_14762_ _14762_/A1 _14762_/A2 _14762_/B _14764_/A2 VSS _14762_/VNW VSS VSS gf180mcu_fd_sc_mcu9t5v0__aoi21_1
X_10925_ _10925_/I0 _19001_/Q _18148_/S _19001_/D VSS VSS VSS VSS gf180mcu_fd_sc_mcu9t5v0__mux2_1
X_17481_ _17481_/A1 _17481_/A2 _17511_/S VSS VSS VSS VSS gf180mcu_fd_sc_mcu9t5v0__nor2_2
X_13713_ _19454_/Q _13733_/A2 _13745_/B1 _19462_/Q _13714_/I VSS VSS VSS VSS gf180mcu_fd_sc_mcu9t5v0__aoi22_1
XTAP_TAPCELL_ROW_45_2220 VSS VSS gf180mcu_fd_sc_mcu9t5v0__filltie
X_14693_ _14419_/I _14696_/A2 _14694_/I1 VSS _14693_/VNW VSS VSS gf180mcu_fd_sc_mcu9t5v0__xnor2_1
XTAP_TAPCELL_ROW_45_2231 VSS VSS gf180mcu_fd_sc_mcu9t5v0__filltie
X_10856_ _16652_/A1 _18147_/S _10860_/B _10857_/I0 VSS VSS VSS VSS gf180mcu_fd_sc_mcu9t5v0__oai21_1
X_16432_ _16432_/A1 _16809_/S _16432_/B _16433_/I0 VSS _16432_/VNW VSS VSS gf180mcu_fd_sc_mcu9t5v0__oai21_4
X_13644_ _13645_/A1 _13645_/B _13645_/A2 _13644_/Z VSS VSS VSS VSS gf180mcu_fd_sc_mcu9t5v0__and3_1
X_19220_ _19220_/D _20052_/RN clkload36/I _19220_/Q VSS VSS VSS VSS gf180mcu_fd_sc_mcu9t5v0__dffrnq_1
XTAP_TAPCELL_ROW_41_2106 VSS VSS gf180mcu_fd_sc_mcu9t5v0__filltie
XTAP_TAPCELL_ROW_41_2117 VSS VSS gf180mcu_fd_sc_mcu9t5v0__filltie
X_16363_ _19241_/Q _16182_/B _16895_/S _16363_/Z VSS VSS VSS VSS gf180mcu_fd_sc_mcu9t5v0__mux2_1
X_19151_ _19151_/D _20047_/RN _19798_/CLK _19151_/Q VSS VSS VSS VSS gf180mcu_fd_sc_mcu9t5v0__dffrnq_1
X_10787_ _19008_/Q _18831_/Q _10788_/A3 VSS VSS VSS VSS gf180mcu_fd_sc_mcu9t5v0__nor2_1
X_18102_ _18102_/A1 _18102_/A2 _18102_/B _18938_/D VSS VSS VSS VSS gf180mcu_fd_sc_mcu9t5v0__oai21_1
X_13575_ _19277_/Q _13304_/B _13578_/B VSS _13582_/VNW VSS VSS gf180mcu_fd_sc_mcu9t5v0__nand2_1
X_15314_ _15314_/A1 _15314_/A2 _15314_/B _15320_/B VSS VSS VSS VSS gf180mcu_fd_sc_mcu9t5v0__oai21_1
X_12526_ _12541_/B _12526_/A2 _12526_/A3 _12526_/B1 _12526_/B2 _12527_/B2 VSS VSS
+ VSS VSS gf180mcu_fd_sc_mcu9t5v0__oai32_2
X_16294_ _16099_/B _16809_/S _16438_/B VSS VSS VSS VSS gf180mcu_fd_sc_mcu9t5v0__nand2_4
X_19082_ _19082_/D _20042_/RN clkload42/I _19082_/Q VSS VSS VSS VSS gf180mcu_fd_sc_mcu9t5v0__dffrnq_1
X_12457_ _18309_/Q _12616_/A2 _12616_/B _12458_/B2 VSS VSS VSS VSS gf180mcu_fd_sc_mcu9t5v0__oai21_1
X_15245_ _19728_/Q _15245_/I1 _15364_/S _19728_/D VSS VSS VSS VSS gf180mcu_fd_sc_mcu9t5v0__mux2_1
X_18033_ _18033_/I0 _18918_/Q _18037_/S _18918_/D VSS VSS VSS VSS gf180mcu_fd_sc_mcu9t5v0__mux2_1
X_11408_ _18708_/Q wire198/Z wire208/Z _11408_/B2 wire213/Z _11409_/A3 VSS VSS VSS
+ VSS gf180mcu_fd_sc_mcu9t5v0__aoi221_2
XTAP_TAPCELL_ROW_39_2046 VSS VSS gf180mcu_fd_sc_mcu9t5v0__filltie
XTAP_TAPCELL_ROW_39_2057 VSS VSS gf180mcu_fd_sc_mcu9t5v0__filltie
XTAP_TAPCELL_ROW_39_2068 VSS VSS gf180mcu_fd_sc_mcu9t5v0__filltie
X_15176_ _19556_/Q _19716_/Q _15417_/S _19716_/D VSS VSS VSS VSS gf180mcu_fd_sc_mcu9t5v0__mux2_1
X_12388_ _18157_/Q _12382_/S _12392_/A2 VSS VSS VSS VSS gf180mcu_fd_sc_mcu9t5v0__nor2_1
X_14127_ _14115_/Z _14127_/A2 _14127_/Z VSS _14127_/VNW VSS VSS gf180mcu_fd_sc_mcu9t5v0__xor2_1
X_11339_ _18703_/Q _12527_/A2 wire208/Z _11339_/B2 wire213/Z _11340_/A3 VSS VSS VSS
+ VSS gf180mcu_fd_sc_mcu9t5v0__aoi221_2
XPHY_EDGE_ROW_142_2_Right_873 VSS VSS gf180mcu_fd_sc_mcu9t5v0__endcap
X_19984_ _19984_/D _20048_/RN _20054_/CLK _19984_/Q VSS VSS VSS VSS gf180mcu_fd_sc_mcu9t5v0__dffrnq_1
X_18935_ _18935_/D _20023_/RN clkload40/I _18935_/Q VSS VSS VSS VSS gf180mcu_fd_sc_mcu9t5v0__dffrnq_1
X_14058_ _14038_/I _14058_/A2 _14061_/A3 VSS VSS VSS VSS gf180mcu_fd_sc_mcu9t5v0__xnor2_1
Xclkbuf_leaf_17_clk_regs clkload4/I clkload56/I VSS VSS VSS VSS gf180mcu_fd_sc_mcu9t5v0__clkbuf_8
X_18866_ _18866_/D _20018_/RN clkload38/I _18866_/Q VSS VSS VSS VSS gf180mcu_fd_sc_mcu9t5v0__dffrnq_1
X_13009_ _13028_/A2 _13008_/Z _13010_/B1 VSS _13009_/VNW VSS VSS gf180mcu_fd_sc_mcu9t5v0__nand2_1
XTAP_TAPCELL_ROW_30_1810 VSS VSS gf180mcu_fd_sc_mcu9t5v0__filltie
X_17817_ _19024_/Q _18794_/Q _17844_/S _18794_/D VSS _17817_/VNW VSS VSS gf180mcu_fd_sc_mcu9t5v0__mux2_1
XTAP_TAPCELL_ROW_30_1821 VSS VSS gf180mcu_fd_sc_mcu9t5v0__filltie
X_18797_ _18797_/D _20141_/RN clkload34/I _18797_/Q VSS VSS VSS VSS gf180mcu_fd_sc_mcu9t5v0__dffrnq_1
X_17748_ _18750_/Q _18747_/Q _17752_/S _18750_/D VSS VSS VSS VSS gf180mcu_fd_sc_mcu9t5v0__mux2_1
XTAP_TAPCELL_ROW_11_1275 VSS VSS gf180mcu_fd_sc_mcu9t5v0__filltie
X_17679_ _18642_/Q _18718_/Q _17681_/S _18718_/D VSS VSS VSS VSS gf180mcu_fd_sc_mcu9t5v0__mux2_1
XTAP_TAPCELL_ROW_11_1286 VSS VSS gf180mcu_fd_sc_mcu9t5v0__filltie
XTAP_TAPCELL_ROW_11_1297 VSS VSS gf180mcu_fd_sc_mcu9t5v0__filltie
X_19418_ _19418_/D _20058_/RN clkload8/I _19418_/Q VSS VSS VSS VSS gf180mcu_fd_sc_mcu9t5v0__dffrnq_1
XTAP_TAPCELL_ROW_28_1750 VSS VSS gf180mcu_fd_sc_mcu9t5v0__filltie
XTAP_TAPCELL_ROW_28_1761 VSS VSS gf180mcu_fd_sc_mcu9t5v0__filltie
X_09102_ _19817_/Q _15470_/A1 VSS _15466_/VNW VSS VSS gf180mcu_fd_sc_mcu9t5v0__clkinv_1
XTAP_TAPCELL_ROW_24_1636 VSS VSS gf180mcu_fd_sc_mcu9t5v0__filltie
X_19349_ _19349_/D _20053_/RN clkload7/I _19349_/Q VSS VSS VSS VSS gf180mcu_fd_sc_mcu9t5v0__dffrnq_1
XTAP_TAPCELL_ROW_24_1647 VSS VSS gf180mcu_fd_sc_mcu9t5v0__filltie
XTAP_TAPCELL_ROW_307_7521 VSS VSS gf180mcu_fd_sc_mcu9t5v0__filltie
XTAP_TAPCELL_ROW_307_7510 VSS VSS gf180mcu_fd_sc_mcu9t5v0__filltie
XTAP_TAPCELL_ROW_303_7407 VSS VSS gf180mcu_fd_sc_mcu9t5v0__filltie
XTAP_TAPCELL_ROW_299_7300 VSS VSS gf180mcu_fd_sc_mcu9t5v0__filltie
XPHY_EDGE_ROW_165_2_Left_677 VSS VSS gf180mcu_fd_sc_mcu9t5v0__endcap
X_20124_ _20124_/D _20129_/CLK _20124_/Q VSS VSS VSS VSS gf180mcu_fd_sc_mcu9t5v0__dffq_1
X_09935_ _19212_/Q wire172/Z _10172_/A2 _19196_/Q wire285/I _19252_/Q _09937_/A1 VSS
+ _12211_/VNW VSS VSS gf180mcu_fd_sc_mcu9t5v0__aoi222_1
X_20055_ _20055_/D _20055_/RN clkload53/I _20055_/Q VSS VSS VSS VSS gf180mcu_fd_sc_mcu9t5v0__dffrnq_4
X_09866_ _19899_/Q _19900_/Q _19901_/Q _09867_/A2 VSS VSS VSS VSS gf180mcu_fd_sc_mcu9t5v0__nor3_1
Xload_slew290 _11541_/A2 _11423_/A1 VSS VSS VSS VSS gf180mcu_fd_sc_mcu9t5v0__clkbuf_8
X_09797_ _18842_/Q _10732_/A1 _09807_/A1 VSS VSS VSS VSS gf180mcu_fd_sc_mcu9t5v0__nand2_1
XPHY_EDGE_ROW_242_Right_169 VSS VSS gf180mcu_fd_sc_mcu9t5v0__endcap
X_10710_ _17912_/A2 _10713_/I0 _10712_/A2 VSS VSS VSS VSS gf180mcu_fd_sc_mcu9t5v0__xnor2_1
XTAP_TAPCELL_ROW_81_3198 VSS VSS gf180mcu_fd_sc_mcu9t5v0__filltie
X_11690_ _18298_/Q _12181_/A2 _11693_/B2 VSS VSS VSS VSS gf180mcu_fd_sc_mcu9t5v0__nand2_1
X_10641_ _18296_/Q _17406_/A2 _17405_/A2 _18312_/Q _10642_/B VSS VSS VSS VSS gf180mcu_fd_sc_mcu9t5v0__aoi22_1
XTAP_TAPCELL_ROW_98_3673 VSS VSS gf180mcu_fd_sc_mcu9t5v0__filltie
X_10572_ _18549_/Q wire80/Z _10650_/B1 _10572_/B2 _10578_/A2 VSS VSS VSS VSS gf180mcu_fd_sc_mcu9t5v0__aoi22_4
XTAP_TAPCELL_ROW_269_6480 VSS VSS gf180mcu_fd_sc_mcu9t5v0__filltie
XTAP_TAPCELL_ROW_98_3684 VSS VSS gf180mcu_fd_sc_mcu9t5v0__filltie
X_13360_ _13360_/A1 _19773_/Q _13377_/A1 _13361_/A2 VSS VSS VSS VSS gf180mcu_fd_sc_mcu9t5v0__xnor3_1
XTAP_TAPCELL_ROW_265_6366 VSS VSS gf180mcu_fd_sc_mcu9t5v0__filltie
XTAP_TAPCELL_ROW_265_6355 VSS VSS gf180mcu_fd_sc_mcu9t5v0__filltie
X_12311_ wire213/I _12311_/A2 _12311_/B _12312_/B2 VSS _12311_/VNW VSS VSS gf180mcu_fd_sc_mcu9t5v0__aoi21_1
XTAP_TAPCELL_ROW_94_3559 VSS VSS gf180mcu_fd_sc_mcu9t5v0__filltie
X_13291_ _13291_/A1 _13290_/B _13295_/A2 VSS VSS VSS VSS gf180mcu_fd_sc_mcu9t5v0__xnor2_1
X_12242_ _18387_/Q _12238_/Z _12299_/S _12242_/Z VSS VSS VSS VSS gf180mcu_fd_sc_mcu9t5v0__mux2_1
X_15030_ _19632_/Q _19383_/Q _20039_/Q _19632_/D VSS VSS VSS VSS gf180mcu_fd_sc_mcu9t5v0__mux2_1
XTAP_TAPCELL_ROW_278_6705 VSS VSS gf180mcu_fd_sc_mcu9t5v0__filltie
XPHY_EDGE_ROW_141_1_Right_725 VSS VSS gf180mcu_fd_sc_mcu9t5v0__endcap
X_12173_ _12235_/B _12192_/A2 _12174_/A2 VSS VSS VSS VSS gf180mcu_fd_sc_mcu9t5v0__nor2_1
XTAP_TAPCELL_ROW_278_6727 VSS VSS gf180mcu_fd_sc_mcu9t5v0__filltie
XTAP_TAPCELL_ROW_278_6716 VSS VSS gf180mcu_fd_sc_mcu9t5v0__filltie
X_16981_ _19253_/Q _16634_/B _16991_/S _16981_/Z VSS VSS VSS VSS gf180mcu_fd_sc_mcu9t5v0__mux2_1
X_11124_ _19075_/Q _11321_/A2 _11137_/B VSS _11124_/VNW VSS VSS gf180mcu_fd_sc_mcu9t5v0__nand2_1
X_15932_ _15936_/B _15936_/C _15936_/A1 _15967_/C VSS _17428_/VNW VSS VSS gf180mcu_fd_sc_mcu9t5v0__nand3_4
X_18720_ _18720_/D clkload65/I _18720_/Q VSS VSS VSS VSS gf180mcu_fd_sc_mcu9t5v0__dffq_1
X_11055_ _18025_/I0 _19056_/Q _11067_/S _19056_/D VSS VSS VSS VSS gf180mcu_fd_sc_mcu9t5v0__mux2_1
X_10006_ _10063_/C _10006_/A2 _10006_/B1 _10006_/B2 output12/I VSS _10006_/VNW VSS
+ VSS gf180mcu_fd_sc_mcu9t5v0__aoi22_1
X_15863_ _20074_/Q _19243_/Q _15912_/S _20074_/D VSS VSS VSS VSS gf180mcu_fd_sc_mcu9t5v0__mux2_1
X_18651_ _18651_/D _20055_/RN clkload54/I _18651_/Q VSS VSS VSS VSS gf180mcu_fd_sc_mcu9t5v0__dffrnq_1
X_17602_ _09065_/I _18665_/Q _17609_/S _18665_/D VSS VSS VSS VSS gf180mcu_fd_sc_mcu9t5v0__mux2_1
X_15794_ _18029_/I0 _19964_/Q _15802_/S _19964_/D VSS _15794_/VNW VSS VSS gf180mcu_fd_sc_mcu9t5v0__mux2_1
X_14814_ _14814_/A1 _14814_/A2 _14814_/Z VSS VSS VSS VSS gf180mcu_fd_sc_mcu9t5v0__xor2_1
XTAP_TAPCELL_ROW_8_1196 VSS VSS gf180mcu_fd_sc_mcu9t5v0__filltie
X_18582_ _18582_/D _20018_/RN clkload28/I _18582_/Q VSS VSS VSS VSS gf180mcu_fd_sc_mcu9t5v0__dffrnq_1
X_11957_ _12348_/C _11956_/Z _11958_/A2 VSS VSS VSS VSS gf180mcu_fd_sc_mcu9t5v0__nand2_1
X_17533_ _17578_/I1 _18636_/Q _17571_/S _18636_/D VSS VSS VSS VSS gf180mcu_fd_sc_mcu9t5v0__mux2_1
X_14745_ _19550_/Q _14764_/B _14749_/B VSS _14749_/VNW VSS VSS gf180mcu_fd_sc_mcu9t5v0__nor2_1
Xeco15_sk1_1 clkload78/I eco15_sk2_1/I VSS VSS VSS VSS gf180mcu_fd_sc_mcu9t5v0__clkbuf_16
X_10908_ _10907_/Z _18993_/Q _18148_/S _18993_/D VSS _10908_/VNW VSS VSS gf180mcu_fd_sc_mcu9t5v0__mux2_1
X_17464_ _09517_/I _17464_/A2 _18578_/D VSS _17464_/VNW VSS VSS gf180mcu_fd_sc_mcu9t5v0__nor2_1
X_11888_ _18291_/Q _12345_/A2 _11892_/A1 VSS VSS VSS VSS gf180mcu_fd_sc_mcu9t5v0__nor2_1
X_16415_ _16415_/I0 _18268_/Q _16940_/S _18268_/D VSS VSS VSS VSS gf180mcu_fd_sc_mcu9t5v0__mux2_1
XTAP_TAPCELL_ROW_250_5956 VSS VSS gf180mcu_fd_sc_mcu9t5v0__filltie
XTAP_TAPCELL_ROW_250_5945 VSS VSS gf180mcu_fd_sc_mcu9t5v0__filltie
XTAP_TAPCELL_ROW_250_5934 VSS VSS gf180mcu_fd_sc_mcu9t5v0__filltie
X_19203_ _19203_/D _20035_/RN clkload35/I _19203_/Q VSS VSS VSS VSS gf180mcu_fd_sc_mcu9t5v0__dffrnq_1
X_14676_ _13749_/Z _14677_/A2 _14683_/C VSS VSS VSS VSS gf180mcu_fd_sc_mcu9t5v0__and2_1
X_17395_ _17399_/A1 _18520_/Q _17398_/A2 VSS VSS VSS VSS gf180mcu_fd_sc_mcu9t5v0__nor2_1
X_10839_ _17601_/A2 _15703_/A3 _20071_/Q _10840_/A2 VSS VSS VSS VSS gf180mcu_fd_sc_mcu9t5v0__oai21_1
X_13627_ _19288_/Q _13497_/B _13632_/B VSS VSS VSS VSS gf180mcu_fd_sc_mcu9t5v0__nand2_1
X_16346_ _18237_/Q _16345_/Z _16882_/S _18237_/D VSS VSS VSS VSS gf180mcu_fd_sc_mcu9t5v0__mux2_4
X_13558_ _13558_/A1 _13558_/A2 _13558_/B _19272_/D VSS VSS VSS VSS gf180mcu_fd_sc_mcu9t5v0__oai21_1
X_19134_ _19134_/D _20030_/RN clkload36/I _19134_/Q VSS VSS VSS VSS gf180mcu_fd_sc_mcu9t5v0__dffrnq_1
X_16277_ _19271_/Q _16829_/A2 _16279_/A1 VSS VSS VSS VSS gf180mcu_fd_sc_mcu9t5v0__nand2_1
X_12509_ _18443_/Q _12607_/A2 _12541_/B _12509_/C _12510_/B VSS VSS VSS VSS gf180mcu_fd_sc_mcu9t5v0__oai211_1
XPHY_EDGE_ROW_132_Right_132 VSS VSS gf180mcu_fd_sc_mcu9t5v0__endcap
X_19065_ _19065_/D _20025_/RN clkload32/I _19065_/Q VSS VSS VSS VSS gf180mcu_fd_sc_mcu9t5v0__dffrnq_1
X_13489_ _13489_/A1 _13489_/A2 _13489_/B _13491_/A2 VSS _13489_/VNW VSS VSS gf180mcu_fd_sc_mcu9t5v0__oai21_1
X_18016_ _18032_/I0 _18901_/Q _18021_/S _18901_/D VSS VSS VSS VSS gf180mcu_fd_sc_mcu9t5v0__mux2_1
X_15228_ _19725_/Q _15228_/I1 _15364_/S _19725_/D VSS _15228_/VNW VSS VSS gf180mcu_fd_sc_mcu9t5v0__mux2_1
XTAP_TAPCELL_ROW_248_5896 VSS VSS gf180mcu_fd_sc_mcu9t5v0__filltie
XTAP_TAPCELL_ROW_248_5885 VSS VSS gf180mcu_fd_sc_mcu9t5v0__filltie
X_15159_ _19701_/Q _19541_/Q _15163_/S _19701_/D VSS VSS VSS VSS gf180mcu_fd_sc_mcu9t5v0__mux2_1
XPHY_EDGE_ROW_143_2_Right_874 VSS VSS gf180mcu_fd_sc_mcu9t5v0__endcap
X_19967_ _19967_/D _20031_/RN clkload46/I _19967_/Q VSS VSS VSS VSS gf180mcu_fd_sc_mcu9t5v0__dffrnq_1
X_09720_ _09709_/Z _09719_/Z _09721_/B VSS _10720_/VNW VSS VSS gf180mcu_fd_sc_mcu9t5v0__nand2_1
XTAP_TAPCELL_ROW_17_1440 VSS VSS gf180mcu_fd_sc_mcu9t5v0__filltie
XTAP_TAPCELL_ROW_17_1451 VSS VSS gf180mcu_fd_sc_mcu9t5v0__filltie
X_18918_ _18918_/D _20070_/RN clkload32/I _18918_/Q VSS VSS VSS VSS gf180mcu_fd_sc_mcu9t5v0__dffrnq_1
XTAP_TAPCELL_ROW_17_1462 VSS VSS gf180mcu_fd_sc_mcu9t5v0__filltie
X_19898_ _19898_/D _20026_/RN clkload40/I _19898_/Q VSS VSS VSS VSS gf180mcu_fd_sc_mcu9t5v0__dffrnq_1
XTAP_TAPCELL_ROW_13_1337 VSS VSS gf180mcu_fd_sc_mcu9t5v0__filltie
X_09651_ _19917_/Q _19918_/Q _19922_/Q _15720_/A1 _09652_/I VSS VSS VSS VSS gf180mcu_fd_sc_mcu9t5v0__nor4_1
X_18849_ _18849_/D _20065_/RN clkload33/I _18849_/Q VSS VSS VSS VSS gf180mcu_fd_sc_mcu9t5v0__dffrnq_1
XTAP_TAPCELL_ROW_13_1348 VSS VSS gf180mcu_fd_sc_mcu9t5v0__filltie
X_09582_ _17631_/A1 _09889_/A2 _09582_/A3 _09582_/A4 _09582_/Z VSS _09582_/VNW VSS
+ VSS gf180mcu_fd_sc_mcu9t5v0__and4_1
XTAP_TAPCELL_ROW_288_7001 VSS VSS gf180mcu_fd_sc_mcu9t5v0__filltie
Xu_transform_scheduler_core.u_fft_scratch_sram.u_lo.u_gwen_driver u_transform_scheduler_core.u_fft_scratch_sram.u_lo.u_gwen_driver/I
+ u_transform_scheduler_core.u_fft_scratch_sram.u_lo.u_gwen_driver/ZN VSS VSS VSS
+ VSS gf180mcu_fd_sc_mcu9t5v0__clkinv_8
XTAP_TAPCELL_ROW_26_1709 VSS VSS gf180mcu_fd_sc_mcu9t5v0__filltie
XTAP_TAPCELL_ROW_260_6230 VSS VSS gf180mcu_fd_sc_mcu9t5v0__filltie
XPHY_EDGE_ROW_311_Right_238 VSS VSS gf180mcu_fd_sc_mcu9t5v0__endcap
X_20107_ _20107_/D clkload77/I _20107_/Q VSS VSS VSS VSS gf180mcu_fd_sc_mcu9t5v0__dffq_1
X_09918_ _10057_/A2 _09924_/A1 _10138_/B1 VSS _09918_/VNW VSS VSS gf180mcu_fd_sc_mcu9t5v0__nor2_1
X_09849_ _10821_/B _09849_/A2 _09849_/B _10445_/A2 VSS VSS VSS VSS gf180mcu_fd_sc_mcu9t5v0__oai21_4
XTAP_TAPCELL_ROW_258_6170 VSS VSS gf180mcu_fd_sc_mcu9t5v0__filltie
XTAP_TAPCELL_ROW_87_3385 VSS VSS gf180mcu_fd_sc_mcu9t5v0__filltie
XTAP_TAPCELL_ROW_87_3374 VSS VSS gf180mcu_fd_sc_mcu9t5v0__filltie
X_20038_ _20038_/D _20038_/RN clkload15/I _20038_/Q VSS VSS VSS VSS gf180mcu_fd_sc_mcu9t5v0__dffrnq_1
XTAP_TAPCELL_ROW_87_3363 VSS VSS gf180mcu_fd_sc_mcu9t5v0__filltie
XTAP_TAPCELL_ROW_254_6045 VSS VSS gf180mcu_fd_sc_mcu9t5v0__filltie
X_12860_ _13304_/B _12860_/A2 _12860_/B _19214_/D VSS VSS VSS VSS gf180mcu_fd_sc_mcu9t5v0__oai21_1
XTAP_TAPCELL_ROW_254_6067 VSS VSS gf180mcu_fd_sc_mcu9t5v0__filltie
XTAP_TAPCELL_ROW_254_6056 VSS VSS gf180mcu_fd_sc_mcu9t5v0__filltie
X_11811_ _18717_/Q wire198/Z _11811_/B1 _11811_/B2 wire213/Z _11813_/A3 VSS VSS VSS
+ VSS gf180mcu_fd_sc_mcu9t5v0__aoi221_4
XTAP_TAPCELL_ROW_168_3_8112 VSS VSS gf180mcu_fd_sc_mcu9t5v0__filltie
X_12791_ _12791_/A1 _12790_/B _12792_/I0 VSS VSS VSS VSS gf180mcu_fd_sc_mcu9t5v0__xnor2_1
XTAP_TAPCELL_ROW_3_1060 VSS VSS gf180mcu_fd_sc_mcu9t5v0__filltie
XTAP_TAPCELL_ROW_3_1071 VSS VSS gf180mcu_fd_sc_mcu9t5v0__filltie
X_14530_ _14530_/A1 _19132_/Q _14531_/B VSS VSS VSS VSS gf180mcu_fd_sc_mcu9t5v0__nand2_1
XPHY_EDGE_ROW_157_1_Left_480 VSS VSS gf180mcu_fd_sc_mcu9t5v0__endcap
X_11742_ _13698_/A2 _11966_/B _11742_/B1 _11742_/B2 _19110_/D VSS VSS VSS VSS gf180mcu_fd_sc_mcu9t5v0__aoi22_1
XTAP_TAPCELL_ROW_267_6417 VSS VSS gf180mcu_fd_sc_mcu9t5v0__filltie
XTAP_TAPCELL_ROW_267_6406 VSS VSS gf180mcu_fd_sc_mcu9t5v0__filltie
X_11673_ _11674_/A1 _11672_/Z _12653_/A2 VSS _12653_/VNW VSS VSS gf180mcu_fd_sc_mcu9t5v0__nor2_1
X_14461_ _19125_/Q _14475_/B _14469_/A2 VSS _14473_/VNW VSS VSS gf180mcu_fd_sc_mcu9t5v0__nor2_1
X_10624_ _18551_/Q wire80/Z _10650_/B1 _10624_/B2 _10630_/A2 VSS VSS VSS VSS gf180mcu_fd_sc_mcu9t5v0__aoi22_4
X_17180_ _17180_/A1 _17180_/A2 _17180_/B _17409_/B _17181_/C VSS VSS VSS VSS gf180mcu_fd_sc_mcu9t5v0__oai211_1
X_16200_ _16117_/C _19260_/Q _16763_/S _16200_/Z VSS VSS VSS VSS gf180mcu_fd_sc_mcu9t5v0__mux2_1
XTAP_TAPCELL_ROW_148_3_8043 VSS VSS gf180mcu_fd_sc_mcu9t5v0__filltie
X_13412_ _13497_/A1 _13430_/A2 _13413_/A2 VSS _13413_/VNW VSS VSS gf180mcu_fd_sc_mcu9t5v0__nor2_1
X_14392_ _14392_/A1 _14681_/A1 _14392_/Z VSS VSS VSS VSS gf180mcu_fd_sc_mcu9t5v0__xor2_1
X_16131_ _16750_/A1 _16686_/A3 _16131_/B _16134_/A1 VSS VSS VSS VSS gf180mcu_fd_sc_mcu9t5v0__aoi21_4
X_13343_ _19773_/Q _13343_/A2 _13366_/A1 VSS VSS VSS VSS gf180mcu_fd_sc_mcu9t5v0__nand2_1
X_10555_ _18293_/Q _17406_/A2 _17405_/A2 _18309_/Q _10556_/B VSS VSS VSS VSS gf180mcu_fd_sc_mcu9t5v0__aoi22_1
X_10486_ _09261_/I _10486_/A2 _10486_/A3 _10486_/B _10495_/A2 VSS VSS VSS VSS gf180mcu_fd_sc_mcu9t5v0__oai31_1
X_16062_ _19237_/Q _16744_/A2 wire71/Z _16066_/A2 VSS VSS VSS VSS gf180mcu_fd_sc_mcu9t5v0__nor3_1
XPHY_EDGE_ROW_266_Left_589 VSS VSS gf180mcu_fd_sc_mcu9t5v0__endcap
Xrebuffer270 _20041_/Q _09833_/B2 VSS VSS VSS VSS gf180mcu_fd_sc_mcu9t5v0__buf_8
X_13274_ _13274_/I _13297_/A1 VSS _13275_/VNW VSS VSS gf180mcu_fd_sc_mcu9t5v0__clkinv_1
X_12225_ _18514_/Q _12222_/Z _12224_/Z _12223_/Z _12208_/C _12159_/B _12225_/Z VSS
+ VSS VSS VSS gf180mcu_fd_sc_mcu9t5v0__mux4_1
X_15013_ _15013_/A1 _15012_/Z _15013_/Z VSS _15013_/VNW VSS VSS gf180mcu_fd_sc_mcu9t5v0__xor2_1
X_12156_ _18431_/Q _12181_/A2 _12160_/A1 VSS VSS VSS VSS gf180mcu_fd_sc_mcu9t5v0__nand2_1
X_19821_ _19821_/D _20141_/RN clkload58/I _19821_/Q VSS VSS VSS VSS gf180mcu_fd_sc_mcu9t5v0__dffrnq_1
XTAP_TAPCELL_ROW_243_5760 VSS VSS gf180mcu_fd_sc_mcu9t5v0__filltie
XTAP_TAPCELL_ROW_72_2975 VSS VSS gf180mcu_fd_sc_mcu9t5v0__filltie
XTAP_TAPCELL_ROW_72_2964 VSS VSS gf180mcu_fd_sc_mcu9t5v0__filltie
XTAP_TAPCELL_ROW_72_2953 VSS VSS gf180mcu_fd_sc_mcu9t5v0__filltie
XPHY_EDGE_ROW_142_1_Right_726 VSS VSS gf180mcu_fd_sc_mcu9t5v0__endcap
X_11107_ _19073_/Q _11321_/A2 _11108_/B VSS VSS VSS VSS gf180mcu_fd_sc_mcu9t5v0__nand2_1
X_12087_ _18476_/Q _12046_/S _12090_/B _12087_/C _12088_/A2 VSS VSS VSS VSS gf180mcu_fd_sc_mcu9t5v0__aoi211_1
X_16964_ _18473_/Q _16963_/Z _16972_/S _18473_/D VSS VSS VSS VSS gf180mcu_fd_sc_mcu9t5v0__mux2_1
X_19752_ _19752_/D _20072_/RN clkload24/I _19752_/Q VSS VSS VSS VSS gf180mcu_fd_sc_mcu9t5v0__dffrnq_1
X_16895_ _19259_/Q _16750_/B _16895_/S _16895_/Z VSS VSS VSS VSS gf180mcu_fd_sc_mcu9t5v0__mux2_1
X_15915_ _20124_/Q _19245_/Q _15920_/S _20124_/D VSS VSS VSS VSS gf180mcu_fd_sc_mcu9t5v0__mux2_1
X_18703_ _18703_/D clkload48/I _18703_/Q VSS VSS VSS VSS gf180mcu_fd_sc_mcu9t5v0__dffq_1
X_11038_ _18024_/I0 _19039_/Q wire174/Z _19039_/D VSS VSS VSS VSS gf180mcu_fd_sc_mcu9t5v0__mux2_1
X_19683_ _19683_/D _20067_/RN clkload16/I _19683_/Q VSS VSS VSS VSS gf180mcu_fd_sc_mcu9t5v0__dffrnq_1
X_15846_ _20020_/Q _09758_/B _17597_/S VSS VSS VSS VSS gf180mcu_fd_sc_mcu9t5v0__nand2_1
X_18634_ _18634_/D _20038_/RN clkload65/I _18634_/Q VSS VSS VSS VSS gf180mcu_fd_sc_mcu9t5v0__dffrnq_1
XPHY_EDGE_ROW_275_Left_598 VSS VSS gf180mcu_fd_sc_mcu9t5v0__endcap
XTAP_TAPCELL_ROW_237_5586 VSS VSS gf180mcu_fd_sc_mcu9t5v0__filltie
X_18565_ _18565_/D _20065_/RN clkload53/I _18565_/Q VSS VSS VSS VSS gf180mcu_fd_sc_mcu9t5v0__dffrnq_4
X_15777_ input7/Z _19947_/Q _15786_/S _19947_/D VSS VSS VSS VSS gf180mcu_fd_sc_mcu9t5v0__mux2_1
XTAP_TAPCELL_ROW_237_5575 VSS VSS gf180mcu_fd_sc_mcu9t5v0__filltie
X_12989_ _12989_/A1 _12989_/A2 _13507_/B _13003_/A2 VSS VSS VSS VSS gf180mcu_fd_sc_mcu9t5v0__aoi21_1
X_18496_ _18496_/D _18496_/CLK _18496_/Q VSS VSS VSS VSS gf180mcu_fd_sc_mcu9t5v0__dffq_4
XTAP_TAPCELL_ROW_237_5597 VSS VSS gf180mcu_fd_sc_mcu9t5v0__filltie
X_17516_ wire300/Z _18621_/Q _17521_/S _18621_/D VSS _17658_/VNW VSS VSS gf180mcu_fd_sc_mcu9t5v0__mux2_1
X_14728_ _14728_/A1 _14728_/A2 _14728_/B _14731_/A2 VSS VSS VSS VSS gf180mcu_fd_sc_mcu9t5v0__oai21_1
X_14659_ _14715_/S _14660_/B _14657_/Z _14659_/B _19526_/D VSS VSS VSS VSS gf180mcu_fd_sc_mcu9t5v0__oai31_1
X_17447_ _17461_/A1 _11320_/C _18570_/Q _17448_/A2 VSS _17447_/VNW VSS VSS gf180mcu_fd_sc_mcu9t5v0__aoi21_1
X_17378_ _17378_/A1 _18455_/Q _17381_/A2 VSS VSS VSS VSS gf180mcu_fd_sc_mcu9t5v0__nor2_1
XTAP_TAPCELL_ROW_194_3_8202 VSS VSS gf180mcu_fd_sc_mcu9t5v0__filltie
X_19117_ _19117_/D _20141_/RN clkload30/I _19117_/Q VSS VSS VSS VSS gf180mcu_fd_sc_mcu9t5v0__dffrnq_1
X_16329_ _19241_/Q _16182_/B _16833_/S _16329_/Z VSS VSS VSS VSS gf180mcu_fd_sc_mcu9t5v0__mux2_1
X_19048_ _19048_/D _20072_/RN clkload32/I _19048_/Q VSS VSS VSS VSS gf180mcu_fd_sc_mcu9t5v0__dffrnq_1
Xclkbuf_leaf_32_clk_regs clkload5/I clkload67/I VSS VSS VSS VSS gf180mcu_fd_sc_mcu9t5v0__clkbuf_8
XTAP_TAPCELL_ROW_19_1502 VSS VSS gf180mcu_fd_sc_mcu9t5v0__filltie
XTAP_TAPCELL_ROW_19_1513 VSS VSS gf180mcu_fd_sc_mcu9t5v0__filltie
Xeco9_buf_09497 _09497_/ZN _09511_/B VSS VSS VSS VSS gf180mcu_fd_sc_mcu9t5v0__clkbuf_16
XTAP_TAPCELL_ROW_321_7893 VSS VSS gf180mcu_fd_sc_mcu9t5v0__filltie
Xu_transform_scheduler_core.u_fft_scratch_sram.u_lo.g_pin_drive\[5\].u_addr_driver
+ _10770_/ZN u_transform_scheduler_core.u_fft_scratch_sram.u_lo.u_sram/A[5] VSS VSS
+ VSS VSS gf180mcu_fd_sc_mcu9t5v0__buf_8
XTAP_TAPCELL_ROW_174_3_8133 VSS VSS gf180mcu_fd_sc_mcu9t5v0__filltie
XPHY_EDGE_ROW_144_2_Right_875 VSS VSS gf180mcu_fd_sc_mcu9t5v0__endcap
X_09703_ _20013_/Q _15946_/A3 _09703_/A3 _15946_/A4 _17421_/S VSS _09703_/VNW VSS
+ VSS gf180mcu_fd_sc_mcu9t5v0__nand4_1
X_09634_ _17771_/A1 _09635_/A2 _09634_/Z VSS _09634_/VNW VSS VSS gf180mcu_fd_sc_mcu9t5v0__and2_1
XTAP_TAPCELL_ROW_154_3_8064 VSS VSS gf180mcu_fd_sc_mcu9t5v0__filltie
X_09565_ _10157_/B1 _09680_/A1 _09565_/A3 output19/I VSS VSS VSS VSS gf180mcu_fd_sc_mcu9t5v0__nand3_1
XTAP_TAPCELL_ROW_121_4297 VSS VSS gf180mcu_fd_sc_mcu9t5v0__filltie
X_09496_ _19069_/Q _11069_/B _09496_/B _09497_/B VSS VSS VSS VSS gf180mcu_fd_sc_mcu9t5v0__oai21_4
XTAP_TAPCELL_ROW_134_4658 VSS VSS gf180mcu_fd_sc_mcu9t5v0__filltie
XTAP_TAPCELL_ROW_134_4669 VSS VSS gf180mcu_fd_sc_mcu9t5v0__filltie
XTAP_TAPCELL_ROW_76_3075 VSS VSS gf180mcu_fd_sc_mcu9t5v0__filltie
XTAP_TAPCELL_ROW_76_3064 VSS VSS gf180mcu_fd_sc_mcu9t5v0__filltie
X_10340_ _10340_/A1 _10340_/A2 _10340_/B1 _10340_/B2 _10340_/ZN VSS VSS VSS VSS gf180mcu_fd_sc_mcu9t5v0__aoi22_4
XTAP_TAPCELL_ROW_76_3086 VSS VSS gf180mcu_fd_sc_mcu9t5v0__filltie
X_10271_ _19826_/Q _10271_/A2 _10271_/A3 _10271_/B _10272_/B1 VSS VSS VSS VSS gf180mcu_fd_sc_mcu9t5v0__oai31_1
X_12010_ _12010_/A1 _12010_/A2 _12311_/B VSS _12010_/VNW VSS VSS gf180mcu_fd_sc_mcu9t5v0__nand2_2
XTAP_TAPCELL_ROW_89_3436 VSS VSS gf180mcu_fd_sc_mcu9t5v0__filltie
XTAP_TAPCELL_ROW_89_3425 VSS VSS gf180mcu_fd_sc_mcu9t5v0__filltie
XTAP_TAPCELL_ROW_256_6118 VSS VSS gf180mcu_fd_sc_mcu9t5v0__filltie
XTAP_TAPCELL_ROW_256_6107 VSS VSS gf180mcu_fd_sc_mcu9t5v0__filltie
X_13961_ _19318_/Q _19299_/Q _13966_/A1 VSS _13961_/VNW VSS VSS gf180mcu_fd_sc_mcu9t5v0__nand2_1
X_16680_ _19276_/Q _16751_/B _16681_/A3 VSS VSS VSS VSS gf180mcu_fd_sc_mcu9t5v0__nor2_1
X_15700_ _20003_/Q _15699_/Z _15700_/Z VSS VSS VSS VSS gf180mcu_fd_sc_mcu9t5v0__and2_1
X_12912_ _19775_/Q _12918_/A1 _12909_/Z _12913_/I0 VSS VSS VSS VSS gf180mcu_fd_sc_mcu9t5v0__xnor3_1
XTAP_TAPCELL_ROW_5_1111 VSS VSS gf180mcu_fd_sc_mcu9t5v0__filltie
XTAP_TAPCELL_ROW_5_1122 VSS VSS gf180mcu_fd_sc_mcu9t5v0__filltie
X_13892_ _13892_/A1 _13928_/A1 _13892_/A3 _13895_/A3 VSS VSS VSS VSS gf180mcu_fd_sc_mcu9t5v0__xnor3_1
XTAP_TAPCELL_ROW_5_1133 VSS VSS gf180mcu_fd_sc_mcu9t5v0__filltie
X_15631_ _10192_/I _15649_/A2 _19895_/Q _19895_/D VSS VSS VSS VSS gf180mcu_fd_sc_mcu9t5v0__mux2_1
XTAP_TAPCELL_ROW_1_1008 VSS VSS gf180mcu_fd_sc_mcu9t5v0__filltie
XTAP_TAPCELL_ROW_1_1019 VSS VSS gf180mcu_fd_sc_mcu9t5v0__filltie
X_12843_ _12843_/A1 _19716_/Q _12843_/B _12844_/B VSS VSS VSS VSS gf180mcu_fd_sc_mcu9t5v0__oai21_1
X_18350_ _18350_/D clkload62/I _18350_/Q VSS VSS VSS VSS gf180mcu_fd_sc_mcu9t5v0__dffq_1
X_15562_ _19874_/Q _15558_/Z _15563_/A3 VSS VSS VSS VSS gf180mcu_fd_sc_mcu9t5v0__nor2_1
X_12774_ _19755_/Q _12772_/Z _12781_/B VSS VSS VSS VSS gf180mcu_fd_sc_mcu9t5v0__and2_1
X_15493_ _17422_/S _15492_/Z _19833_/D VSS _15493_/VNW VSS VSS gf180mcu_fd_sc_mcu9t5v0__and2_1
X_17301_ _17404_/S _18403_/Q _17303_/A3 VSS VSS VSS VSS gf180mcu_fd_sc_mcu9t5v0__nor2_1
X_18281_ _18281_/D clkload63/I _18281_/Q VSS VSS VSS VSS gf180mcu_fd_sc_mcu9t5v0__dffq_1
X_11725_ _12076_/B _11724_/Z _11725_/Z VSS _11725_/VNW VSS VSS gf180mcu_fd_sc_mcu9t5v0__and2_1
XTAP_TAPCELL_ROW_61_2654 VSS VSS gf180mcu_fd_sc_mcu9t5v0__filltie
X_14513_ _14731_/A1 _14513_/A2 _14513_/A3 _14513_/B _14517_/A1 VSS VSS VSS VSS gf180mcu_fd_sc_mcu9t5v0__oai31_1
X_17232_ _17378_/A1 _18464_/Q _17234_/A1 VSS VSS VSS VSS gf180mcu_fd_sc_mcu9t5v0__nand2_1
XTAP_TAPCELL_ROW_232_5461 VSS VSS gf180mcu_fd_sc_mcu9t5v0__filltie
XTAP_TAPCELL_ROW_232_5450 VSS VSS gf180mcu_fd_sc_mcu9t5v0__filltie
X_14444_ _14439_/Z _14444_/A2 _14448_/B VSS VSS VSS VSS gf180mcu_fd_sc_mcu9t5v0__nand2_1
XTAP_TAPCELL_ROW_61_2665 VSS VSS gf180mcu_fd_sc_mcu9t5v0__filltie
Xu_transform_scheduler_core.u_fft_scratch_sram.u_hi.g_pin_drive\[7\].u_addr_driver
+ _10810_/ZN u_transform_scheduler_core.u_fft_scratch_sram.u_hi.u_sram/A[7] VSS VSS
+ VSS VSS gf180mcu_fd_sc_mcu9t5v0__buf_8
X_11656_ _11656_/A1 _11659_/A1 _11656_/B _12632_/C _11660_/A1 VSS VSS VSS VSS gf180mcu_fd_sc_mcu9t5v0__aoi211_1
X_17163_ _18540_/Q _17394_/A2 _17164_/B VSS VSS VSS VSS gf180mcu_fd_sc_mcu9t5v0__nand2_1
X_10607_ _17404_/S _18279_/Q _10609_/A3 VSS VSS VSS VSS gf180mcu_fd_sc_mcu9t5v0__nor2_1
XTAP_TAPCELL_ROW_180_3_8154 VSS VSS gf180mcu_fd_sc_mcu9t5v0__filltie
X_14375_ _19442_/Q _14546_/S _14376_/A2 VSS VSS VSS VSS gf180mcu_fd_sc_mcu9t5v0__nor2_1
X_11587_ _11589_/A1 _11587_/A2 _11588_/B2 VSS VSS VSS VSS gf180mcu_fd_sc_mcu9t5v0__nor2_1
X_16114_ _16747_/A2 _16747_/A3 _16114_/Z VSS VSS VSS VSS gf180mcu_fd_sc_mcu9t5v0__and2_4
X_10538_ _18228_/Q _17406_/A2 _17405_/A2 _18244_/Q _17401_/C _10539_/B2 VSS VSS VSS
+ VSS gf180mcu_fd_sc_mcu9t5v0__aoi221_1
XTAP_TAPCELL_ROW_245_5811 VSS VSS gf180mcu_fd_sc_mcu9t5v0__filltie
X_17094_ _18603_/Q _17409_/B _17225_/B _17094_/C _17095_/A3 VSS VSS VSS VSS gf180mcu_fd_sc_mcu9t5v0__oai211_1
XTAP_TAPCELL_ROW_245_5800 VSS VSS gf180mcu_fd_sc_mcu9t5v0__filltie
X_13326_ _13327_/A1 _13327_/A3 _13326_/B _13603_/A2 VSS _13326_/VNW VSS VSS gf180mcu_fd_sc_mcu9t5v0__aoi21_1
X_16045_ _19266_/Q _16675_/A1 _16046_/B VSS VSS VSS VSS gf180mcu_fd_sc_mcu9t5v0__nand2_1
X_13257_ _19736_/Q _13259_/A2 _13257_/Z VSS VSS VSS VSS gf180mcu_fd_sc_mcu9t5v0__and2_1
XTAP_TAPCELL_ROW_59_2594 VSS VSS gf180mcu_fd_sc_mcu9t5v0__filltie
X_12208_ _12159_/B _12200_/Z _12208_/B _12208_/C _12209_/A2 VSS _12208_/VNW VSS VSS
+ gf180mcu_fd_sc_mcu9t5v0__oai211_1
X_10469_ _18595_/Q _17306_/C _10469_/B _10648_/C _10470_/A3 VSS _17280_/VNW VSS VSS
+ gf180mcu_fd_sc_mcu9t5v0__aoi211_1
XTAP_TAPCELL_ROW_241_5708 VSS VSS gf180mcu_fd_sc_mcu9t5v0__filltie
XTAP_TAPCELL_ROW_226_5298 VSS VSS gf180mcu_fd_sc_mcu9t5v0__filltie
XTAP_TAPCELL_ROW_226_5287 VSS VSS gf180mcu_fd_sc_mcu9t5v0__filltie
XTAP_TAPCELL_ROW_226_5276 VSS VSS gf180mcu_fd_sc_mcu9t5v0__filltie
XTAP_TAPCELL_ROW_160_3_8085 VSS VSS gf180mcu_fd_sc_mcu9t5v0__filltie
XTAP_TAPCELL_ROW_159_3_8079 VSS VSS gf180mcu_fd_sc_mcu9t5v0__filltie
X_13188_ _13198_/A2 _19797_/Q _13203_/B VSS VSS VSS VSS gf180mcu_fd_sc_mcu9t5v0__nor2_1
X_12139_ _12139_/A1 _12139_/A2 _12322_/B _12141_/A2 VSS VSS VSS VSS gf180mcu_fd_sc_mcu9t5v0__aoi21_1
XPHY_EDGE_ROW_143_1_Right_727 VSS VSS gf180mcu_fd_sc_mcu9t5v0__endcap
X_17996_ _18882_/Q _18029_/I0 _17997_/S _18882_/D VSS _17996_/VNW VSS VSS gf180mcu_fd_sc_mcu9t5v0__mux2_1
X_19804_ _19804_/D _20060_/RN clkload27/I _19804_/Q VSS VSS VSS VSS gf180mcu_fd_sc_mcu9t5v0__dffrnq_1
X_16947_ _19252_/Q _16628_/B _16955_/S _16947_/Z VSS VSS VSS VSS gf180mcu_fd_sc_mcu9t5v0__mux2_1
XPHY_EDGE_ROW_283_Left_606 VSS VSS gf180mcu_fd_sc_mcu9t5v0__endcap
X_19735_ _19735_/D _20055_/RN clkload23/I _19735_/Q VSS VSS VSS VSS gf180mcu_fd_sc_mcu9t5v0__dffrnq_1
XTAP_TAPCELL_ROW_239_5637 VSS VSS gf180mcu_fd_sc_mcu9t5v0__filltie
X_16878_ _18431_/Q _16877_/Z _16882_/S _18431_/D VSS VSS VSS VSS gf180mcu_fd_sc_mcu9t5v0__mux2_4
XTAP_TAPCELL_ROW_239_5648 VSS VSS gf180mcu_fd_sc_mcu9t5v0__filltie
X_19666_ _19666_/D _20050_/RN clkload22/I _19666_/Q VSS VSS VSS VSS gf180mcu_fd_sc_mcu9t5v0__dffrnq_1
X_18617_ _18617_/D clkload75/I _18617_/Q VSS VSS VSS VSS gf180mcu_fd_sc_mcu9t5v0__dffq_1
X_15829_ _15829_/A1 _15834_/B2 _15834_/A2 _15829_/B2 _19993_/D VSS VSS VSS VSS gf180mcu_fd_sc_mcu9t5v0__oai22_1
X_19597_ _19597_/D _20045_/RN clkload17/I _19597_/Q VSS VSS VSS VSS gf180mcu_fd_sc_mcu9t5v0__dffrnq_1
X_18548_ _18548_/D _20048_/RN clkload75/I _18548_/Q VSS VSS VSS VSS gf180mcu_fd_sc_mcu9t5v0__dffrnq_4
XPHY_EDGE_ROW_174_2_Left_686 VSS VSS gf180mcu_fd_sc_mcu9t5v0__endcap
X_09350_ _18830_/Q _17872_/A1 VSS VSS VSS VSS gf180mcu_fd_sc_mcu9t5v0__clkinv_1
XTAP_TAPCELL_ROW_310_7583 VSS VSS gf180mcu_fd_sc_mcu9t5v0__filltie
X_09281_ _20015_/Q _09753_/A1 VSS _15851_/VNW VSS VSS gf180mcu_fd_sc_mcu9t5v0__clkinv_1
XTAP_TAPCELL_ROW_166_2_8103 VSS VSS gf180mcu_fd_sc_mcu9t5v0__filltie
XTAP_TAPCELL_ROW_310_7594 VSS VSS gf180mcu_fd_sc_mcu9t5v0__filltie
X_18479_ _18479_/D clkload72/I _18479_/Q VSS VSS VSS VSS gf180mcu_fd_sc_mcu9t5v0__dffq_1
XPHY_EDGE_ROW_292_Left_615 VSS VSS gf180mcu_fd_sc_mcu9t5v0__endcap
XTAP_TAPCELL_ROW_215_4980 VSS VSS gf180mcu_fd_sc_mcu9t5v0__filltie
XTAP_TAPCELL_ROW_215_4991 VSS VSS gf180mcu_fd_sc_mcu9t5v0__filltie
XTAP_TAPCELL_ROW_323_7955 VSS VSS gf180mcu_fd_sc_mcu9t5v0__filltie
XTAP_TAPCELL_ROW_323_7944 VSS VSS gf180mcu_fd_sc_mcu9t5v0__filltie
XTAP_TAPCELL_ROW_211_4877 VSS VSS gf180mcu_fd_sc_mcu9t5v0__filltie
XTAP_TAPCELL_ROW_211_4866 VSS VSS gf180mcu_fd_sc_mcu9t5v0__filltie
XTAP_TAPCELL_ROW_323_7988 VSS VSS gf180mcu_fd_sc_mcu9t5v0__filltie
XTAP_TAPCELL_ROW_323_7977 VSS VSS gf180mcu_fd_sc_mcu9t5v0__filltie
XTAP_TAPCELL_ROW_323_7966 VSS VSS gf180mcu_fd_sc_mcu9t5v0__filltie
Xclkload60 clkload60/I clkload60/ZN VSS _12090_/VNW VSS VSS gf180mcu_fd_sc_mcu9t5v0__inv_3
Xclkload71 clkload71/I clkload71/ZN VSS VSS VSS VSS gf180mcu_fd_sc_mcu9t5v0__inv_4
Xclkload82 clkload82/I clkload82/ZN VSS VSS VSS VSS gf180mcu_fd_sc_mcu9t5v0__inv_4
XTAP_TAPCELL_ROW_296_7199 VSS VSS gf180mcu_fd_sc_mcu9t5v0__filltie
XTAP_TAPCELL_ROW_209_4795 VSS VSS gf180mcu_fd_sc_mcu9t5v0__filltie
XTAP_TAPCELL_ROW_209_4784 VSS VSS gf180mcu_fd_sc_mcu9t5v0__filltie
XTAP_TAPCELL_ROW_127_4473 VSS VSS gf180mcu_fd_sc_mcu9t5v0__filltie
XTAP_TAPCELL_ROW_127_4462 VSS VSS gf180mcu_fd_sc_mcu9t5v0__filltie
XPHY_EDGE_ROW_145_2_Right_876 VSS VSS gf180mcu_fd_sc_mcu9t5v0__endcap
XTAP_TAPCELL_ROW_127_4484 VSS VSS gf180mcu_fd_sc_mcu9t5v0__filltie
XTAP_TAPCELL_ROW_84_3300 VSS VSS gf180mcu_fd_sc_mcu9t5v0__filltie
XTAP_TAPCELL_ROW_123_4359 VSS VSS gf180mcu_fd_sc_mcu9t5v0__filltie
X_09617_ _09617_/A1 _09617_/A2 _09916_/B _09618_/I VSS _09617_/VNW VSS VSS gf180mcu_fd_sc_mcu9t5v0__aoi21_1
X_09548_ input9/Z output10/I _09662_/S VSS _09548_/VNW VSS VSS gf180mcu_fd_sc_mcu9t5v0__nand2_1
X_11510_ _18502_/Q _11534_/S _11510_/B _11512_/A2 VSS _12302_/VNW VSS VSS gf180mcu_fd_sc_mcu9t5v0__oai21_1
XTAP_TAPCELL_ROW_78_3126 VSS VSS gf180mcu_fd_sc_mcu9t5v0__filltie
X_09479_ _17888_/B _18857_/Q _12147_/S VSS _11070_/VNW VSS VSS gf180mcu_fd_sc_mcu9t5v0__nand2_1
XTAP_TAPCELL_ROW_78_3115 VSS VSS gf180mcu_fd_sc_mcu9t5v0__filltie
X_12490_ _18345_/Q _12382_/S _12494_/A2 VSS _17086_/VNW VSS VSS gf180mcu_fd_sc_mcu9t5v0__nor2_1
XTAP_TAPCELL_ROW_78_3137 VSS VSS gf180mcu_fd_sc_mcu9t5v0__filltie
X_11441_ _18529_/Q _18513_/Q _18497_/Q _18481_/Q _11524_/S _11176_/C _11441_/Z VSS
+ VSS VSS VSS gf180mcu_fd_sc_mcu9t5v0__mux4_1
Xwire125 wire125/I wire125/Z VSS VSS VSS VSS gf180mcu_fd_sc_mcu9t5v0__clkbuf_4
Xwire136 wire136/I wire136/Z VSS VSS VSS VSS gf180mcu_fd_sc_mcu9t5v0__clkbuf_8
X_11372_ _18460_/Q _11403_/S _11520_/B _11373_/A2 VSS _11373_/VNW VSS VSS gf180mcu_fd_sc_mcu9t5v0__oai21_1
X_14160_ _19321_/Q _14159_/Z _19192_/D _19321_/D VSS VSS VSS VSS gf180mcu_fd_sc_mcu9t5v0__mux2_1
X_10323_ _19825_/Q _18204_/Q _10325_/A3 VSS _17102_/VNW VSS VSS gf180mcu_fd_sc_mcu9t5v0__nor2_1
X_13111_ _13184_/A1 _13111_/A2 _13419_/B _13112_/B2 VSS VSS VSS VSS gf180mcu_fd_sc_mcu9t5v0__aoi21_1
XTAP_TAPCELL_ROW_281_6789 VSS VSS gf180mcu_fd_sc_mcu9t5v0__filltie
X_14091_ _14104_/A1 _14090_/Z _14093_/A2 VSS _14093_/VNW VSS VSS gf180mcu_fd_sc_mcu9t5v0__xnor2_1
X_10254_ _17872_/A1 _10804_/A2 wire165/I VSS VSS VSS VSS gf180mcu_fd_sc_mcu9t5v0__nor2_1
X_13042_ _19194_/Q _09453_/I _13244_/B wire277/I VSS _13042_/VNW VSS VSS gf180mcu_fd_sc_mcu9t5v0__nand3_1
X_17850_ _18824_/Q _18823_/Q _17850_/Z VSS VSS VSS VSS gf180mcu_fd_sc_mcu9t5v0__and2_1
X_10185_ _14353_/A1 _20037_/Q _14338_/A2 VSS _10185_/VNW VSS VSS gf180mcu_fd_sc_mcu9t5v0__nor2_1
XTAP_TAPCELL_ROW_54_2480 VSS VSS gf180mcu_fd_sc_mcu9t5v0__filltie
X_16801_ _19282_/Q _16932_/A2 _16803_/A1 VSS _16801_/VNW VSS VSS gf180mcu_fd_sc_mcu9t5v0__nand2_1
XTAP_TAPCELL_ROW_221_5151 VSS VSS gf180mcu_fd_sc_mcu9t5v0__filltie
XTAP_TAPCELL_ROW_221_5140 VSS VSS gf180mcu_fd_sc_mcu9t5v0__filltie
XTAP_TAPCELL_ROW_50_2344 VSS VSS gf180mcu_fd_sc_mcu9t5v0__filltie
XTAP_TAPCELL_ROW_50_2355 VSS VSS gf180mcu_fd_sc_mcu9t5v0__filltie
XTAP_TAPCELL_ROW_50_2366 VSS VSS gf180mcu_fd_sc_mcu9t5v0__filltie
X_17781_ _17758_/Z _17781_/A2 _17781_/B _17782_/B VSS VSS VSS VSS gf180mcu_fd_sc_mcu9t5v0__aoi21_1
XTAP_TAPCELL_ROW_172_2_8124 VSS VSS gf180mcu_fd_sc_mcu9t5v0__filltie
X_19520_ _19520_/D _09246_/I _19680_/CLK _19520_/Q VSS VSS VSS VSS gf180mcu_fd_sc_mcu9t5v0__dffrnq_1
X_14993_ _19432_/Q _19377_/Q _15017_/A1 VSS _14993_/VNW VSS VSS gf180mcu_fd_sc_mcu9t5v0__nand2_1
X_16732_ _16114_/Z _16732_/A2 _16732_/A3 _16732_/B _18372_/D VSS VSS VSS VSS gf180mcu_fd_sc_mcu9t5v0__oai31_1
X_13944_ _13944_/A1 _13942_/Z _13944_/Z VSS VSS VSS VSS gf180mcu_fd_sc_mcu9t5v0__xor2_1
XTAP_TAPCELL_ROW_67_2830 VSS VSS gf180mcu_fd_sc_mcu9t5v0__filltie
Xload_slew55 _16865_/S _16895_/S VSS VSS VSS VSS gf180mcu_fd_sc_mcu9t5v0__clkbuf_16
X_16663_ _18358_/Q _16663_/I1 _16676_/S _18358_/D VSS VSS VSS VSS gf180mcu_fd_sc_mcu9t5v0__mux2_1
Xload_slew66 _17420_/S _17394_/A2 VSS VSS VSS VSS gf180mcu_fd_sc_mcu9t5v0__clkbuf_8
XTAP_TAPCELL_ROW_234_5501 VSS VSS gf180mcu_fd_sc_mcu9t5v0__filltie
X_13875_ _13876_/A1 _13876_/A2 _13911_/B VSS _13876_/VNW VSS VSS gf180mcu_fd_sc_mcu9t5v0__nor2_1
XTAP_TAPCELL_ROW_63_2705 VSS VSS gf180mcu_fd_sc_mcu9t5v0__filltie
X_19451_ _19451_/D _19963_/RN clkload30/I _19451_/Q VSS VSS VSS VSS gf180mcu_fd_sc_mcu9t5v0__dffrnq_1
XTAP_TAPCELL_ROW_106_3889 VSS VSS gf180mcu_fd_sc_mcu9t5v0__filltie
X_18402_ _18402_/D _20132_/CLK _18402_/Q VSS VSS VSS VSS gf180mcu_fd_sc_mcu9t5v0__dffq_4
XTAP_TAPCELL_ROW_234_5512 VSS VSS gf180mcu_fd_sc_mcu9t5v0__filltie
XTAP_TAPCELL_ROW_219_5080 VSS VSS gf180mcu_fd_sc_mcu9t5v0__filltie
X_15614_ _19889_/Q _19890_/Q _15620_/A2 VSS VSS VSS VSS gf180mcu_fd_sc_mcu9t5v0__nand2_1
X_12826_ _13419_/B _12827_/B _12826_/A3 _12826_/B _19208_/D VSS _12826_/VNW VSS VSS
+ gf180mcu_fd_sc_mcu9t5v0__oai31_1
XTAP_TAPCELL_ROW_48_2295 VSS VSS gf180mcu_fd_sc_mcu9t5v0__filltie
X_19382_ _19382_/D _20022_/RN _19633_/CLK _19382_/Q VSS VSS VSS VSS gf180mcu_fd_sc_mcu9t5v0__dffrnq_1
XTAP_TAPCELL_ROW_63_2716 VSS VSS gf180mcu_fd_sc_mcu9t5v0__filltie
XTAP_TAPCELL_ROW_63_2727 VSS VSS gf180mcu_fd_sc_mcu9t5v0__filltie
X_18333_ _18333_/D clkload73/I _18333_/Q VSS VSS VSS VSS gf180mcu_fd_sc_mcu9t5v0__dffq_1
X_16594_ _15996_/B _16594_/A2 _16594_/A3 _16594_/B _16595_/I1 VSS _16594_/VNW VSS
+ VSS gf180mcu_fd_sc_mcu9t5v0__oai31_1
XTAP_TAPCELL_ROW_219_5091 VSS VSS gf180mcu_fd_sc_mcu9t5v0__filltie
X_15545_ _19863_/Q input8/Z _15551_/S _19863_/D VSS VSS VSS VSS gf180mcu_fd_sc_mcu9t5v0__mux2_1
XTAP_TAPCELL_ROW_230_5409 VSS VSS gf180mcu_fd_sc_mcu9t5v0__filltie
X_12757_ _12762_/A1 _12762_/A2 _12761_/B VSS _12761_/VNW VSS VSS gf180mcu_fd_sc_mcu9t5v0__nor2_1
X_11708_ _12092_/B _11707_/Z _11718_/A1 VSS VSS VSS VSS gf180mcu_fd_sc_mcu9t5v0__nand2_1
X_15476_ _19877_/Q _15476_/A2 _15477_/A4 VSS VSS VSS VSS gf180mcu_fd_sc_mcu9t5v0__nor2_1
X_18264_ _18264_/D clkload81/I _18264_/Q VSS VSS VSS VSS gf180mcu_fd_sc_mcu9t5v0__dffq_1
X_12688_ _12655_/S _12688_/A2 _12688_/A3 _12688_/B _19182_/D VSS VSS VSS VSS gf180mcu_fd_sc_mcu9t5v0__oai31_1
X_18195_ _18195_/D clkload79/I _18195_/Q VSS VSS VSS VSS gf180mcu_fd_sc_mcu9t5v0__dffq_1
X_17215_ _18415_/Q _17282_/A2 _17213_/Z _10514_/B _17278_/C _17220_/B2 VSS VSS VSS
+ VSS gf180mcu_fd_sc_mcu9t5v0__aoi221_1
X_11639_ _11656_/A1 _11639_/A2 _12635_/B VSS VSS VSS VSS gf180mcu_fd_sc_mcu9t5v0__or2_1
X_14427_ _19453_/Q _14766_/A2 _14435_/A1 VSS VSS VSS VSS gf180mcu_fd_sc_mcu9t5v0__nand2_1
X_17146_ _10514_/B _17145_/Z _17155_/A1 VSS _17146_/VNW VSS VSS gf180mcu_fd_sc_mcu9t5v0__nand2_1
X_14358_ _13807_/Z _19428_/Q _14367_/S _19428_/D VSS VSS VSS VSS gf180mcu_fd_sc_mcu9t5v0__mux2_1
XTAP_TAPCELL_ROW_228_5349 VSS VSS gf180mcu_fd_sc_mcu9t5v0__filltie
XTAP_TAPCELL_ROW_228_5338 VSS VSS gf180mcu_fd_sc_mcu9t5v0__filltie
XTAP_TAPCELL_ROW_228_5327 VSS VSS gf180mcu_fd_sc_mcu9t5v0__filltie
X_13309_ _13309_/I _13322_/A2 VSS VSS VSS VSS gf180mcu_fd_sc_mcu9t5v0__clkinv_1
X_17077_ _17195_/A1 _18377_/Q _17080_/A2 VSS VSS VSS VSS gf180mcu_fd_sc_mcu9t5v0__nor2_1
X_14289_ _13772_/Z _19362_/Q _14304_/S _19362_/D VSS VSS VSS VSS gf180mcu_fd_sc_mcu9t5v0__mux2_1
X_16028_ _18677_/Q _18774_/Q _16597_/S _16028_/Z VSS _16028_/VNW VSS VSS gf180mcu_fd_sc_mcu9t5v0__mux2_1
XPHY_EDGE_ROW_144_1_Right_728 VSS VSS gf180mcu_fd_sc_mcu9t5v0__endcap
X_17979_ _18866_/Q _18029_/I0 wire128/Z _18866_/D VSS VSS VSS VSS gf180mcu_fd_sc_mcu9t5v0__mux2_1
XTAP_TAPCELL_ROW_291_7085 VSS VSS gf180mcu_fd_sc_mcu9t5v0__filltie
XTAP_TAPCELL_ROW_291_7074 VSS VSS gf180mcu_fd_sc_mcu9t5v0__filltie
XTAP_TAPCELL_ROW_291_7063 VSS VSS gf180mcu_fd_sc_mcu9t5v0__filltie
XTAP_TAPCELL_ROW_33_1885 VSS VSS gf180mcu_fd_sc_mcu9t5v0__filltie
XTAP_TAPCELL_ROW_33_1896 VSS VSS gf180mcu_fd_sc_mcu9t5v0__filltie
X_19718_ _19718_/D _20038_/RN clkload23/I _19718_/Q VSS VSS VSS VSS gf180mcu_fd_sc_mcu9t5v0__dffrnq_1
XTAP_TAPCELL_ROW_316_7770 VSS VSS gf180mcu_fd_sc_mcu9t5v0__filltie
X_19649_ _19649_/D _20033_/RN clkload9/I _19649_/Q VSS VSS VSS VSS gf180mcu_fd_sc_mcu9t5v0__dffrnq_1
XTAP_TAPCELL_ROW_312_7656 VSS VSS gf180mcu_fd_sc_mcu9t5v0__filltie
XTAP_TAPCELL_ROW_312_7645 VSS VSS gf180mcu_fd_sc_mcu9t5v0__filltie
X_09402_ _20032_/Q _09863_/A2 _09863_/B VSS _09402_/VNW VSS VSS gf180mcu_fd_sc_mcu9t5v0__nand2_1
X_09333_ _19883_/Q _15595_/A1 VSS VSS VSS VSS gf180mcu_fd_sc_mcu9t5v0__clkinv_1
XTAP_TAPCELL_ROW_135_4731 VSS VSS gf180mcu_fd_sc_mcu9t5v0__filltie
XTAP_TAPCELL_ROW_135_4720 VSS VSS gf180mcu_fd_sc_mcu9t5v0__filltie
XTAP_TAPCELL_ROW_213_4939 VSS VSS gf180mcu_fd_sc_mcu9t5v0__filltie
XTAP_TAPCELL_ROW_213_4928 VSS VSS gf180mcu_fd_sc_mcu9t5v0__filltie
X_09264_ _19870_/Q _15552_/A1 VSS VSS VSS VSS gf180mcu_fd_sc_mcu9t5v0__clkinv_1
XTAP_TAPCELL_ROW_213_4917 VSS VSS gf180mcu_fd_sc_mcu9t5v0__filltie
XTAP_TAPCELL_ROW_116_4185 VSS VSS gf180mcu_fd_sc_mcu9t5v0__filltie
XTAP_TAPCELL_ROW_116_4174 VSS VSS gf180mcu_fd_sc_mcu9t5v0__filltie
XTAP_TAPCELL_ROW_116_4163 VSS VSS gf180mcu_fd_sc_mcu9t5v0__filltie
X_09195_ _19167_/Q _14542_/A1 VSS VSS VSS VSS gf180mcu_fd_sc_mcu9t5v0__clkinv_1
XTAP_TAPCELL_ROW_73_3001 VSS VSS gf180mcu_fd_sc_mcu9t5v0__filltie
XTAP_TAPCELL_ROW_112_4049 VSS VSS gf180mcu_fd_sc_mcu9t5v0__filltie
XTAP_TAPCELL_ROW_129_4524 VSS VSS gf180mcu_fd_sc_mcu9t5v0__filltie
XTAP_TAPCELL_ROW_129_4535 VSS VSS gf180mcu_fd_sc_mcu9t5v0__filltie
XPHY_EDGE_ROW_146_2_Right_877 VSS VSS gf180mcu_fd_sc_mcu9t5v0__endcap
X_11990_ _18200_/Q _11989_/Z _12299_/S _11990_/Z VSS _16829_/VNW VSS VSS gf180mcu_fd_sc_mcu9t5v0__mux2_1
XTAP_TAPCELL_ROW_274_6593 VSS VSS gf180mcu_fd_sc_mcu9t5v0__filltie
X_10941_ _10941_/I _10942_/B VSS _10969_/VNW VSS VSS gf180mcu_fd_sc_mcu9t5v0__clkinv_1
X_13660_ _14372_/A1 _13660_/A2 _19292_/D VSS _13661_/VNW VSS VSS gf180mcu_fd_sc_mcu9t5v0__nand2_1
X_10872_ _10871_/Z _18975_/Q _18152_/S _18975_/D VSS _10872_/VNW VSS VSS gf180mcu_fd_sc_mcu9t5v0__mux2_1
XPHY_EDGE_ROW_185_1_Left_508 VSS VSS gf180mcu_fd_sc_mcu9t5v0__endcap
XTAP_TAPCELL_ROW_101_3764 VSS VSS gf180mcu_fd_sc_mcu9t5v0__filltie
X_12611_ _19172_/Q _12620_/A1 _12612_/B VSS VSS VSS VSS gf180mcu_fd_sc_mcu9t5v0__nand2_1
XTAP_TAPCELL_ROW_0_970 VSS VSS gf180mcu_fd_sc_mcu9t5v0__filltie
XTAP_TAPCELL_ROW_0_981 VSS VSS gf180mcu_fd_sc_mcu9t5v0__filltie
XTAP_TAPCELL_ROW_0_992 VSS VSS gf180mcu_fd_sc_mcu9t5v0__filltie
XTAP_TAPCELL_ROW_101_3753 VSS VSS gf180mcu_fd_sc_mcu9t5v0__filltie
X_13591_ _13590_/B _13591_/A2 _13591_/Z VSS VSS VSS VSS gf180mcu_fd_sc_mcu9t5v0__xor2_1
XTAP_TAPCELL_ROW_287_6965 VSS VSS gf180mcu_fd_sc_mcu9t5v0__filltie
X_12542_ _12541_/B _12542_/A2 _12542_/A3 _12542_/B1 _12542_/B2 _12543_/B2 VSS VSS
+ VSS VSS gf180mcu_fd_sc_mcu9t5v0__oai32_1
XTAP_TAPCELL_ROW_287_6954 VSS VSS gf180mcu_fd_sc_mcu9t5v0__filltie
XTAP_TAPCELL_ROW_43_2170 VSS VSS gf180mcu_fd_sc_mcu9t5v0__filltie
X_15330_ _15330_/A1 _15326_/Z _15330_/B _15332_/A2 VSS VSS VSS VSS gf180mcu_fd_sc_mcu9t5v0__aoi21_1
XTAP_TAPCELL_ROW_287_6976 VSS VSS gf180mcu_fd_sc_mcu9t5v0__filltie
X_12473_ _18311_/Q _12616_/A2 _12616_/B _12474_/B2 VSS _12473_/VNW VSS VSS gf180mcu_fd_sc_mcu9t5v0__oai21_1
X_15261_ _19731_/Q _15417_/S _15262_/B VSS VSS VSS VSS gf180mcu_fd_sc_mcu9t5v0__nand2_1
X_17000_ _18491_/Q _16999_/Z _17020_/S _18491_/D VSS VSS VSS VSS gf180mcu_fd_sc_mcu9t5v0__mux2_4
XTAP_TAPCELL_ROW_186_1_4763 VSS VSS gf180mcu_fd_sc_mcu9t5v0__filltie
X_11424_ _18710_/Q wire198/I _11425_/A2 VSS _11424_/VNW VSS VSS gf180mcu_fd_sc_mcu9t5v0__nand2_1
X_14212_ _14213_/A1 _14213_/A2 _14216_/B VSS _14212_/VNW VSS VSS gf180mcu_fd_sc_mcu9t5v0__nand2_1
X_15192_ _15192_/A1 _15192_/A2 _15192_/B _15204_/B1 VSS VSS VSS VSS gf180mcu_fd_sc_mcu9t5v0__oai21_1
XTAP_TAPCELL_ROW_56_2520 VSS VSS gf180mcu_fd_sc_mcu9t5v0__filltie
XANTENNA_8 _11151_/A3 VSS VSS VSS VSS gf180mcu_fd_sc_mcu9t5v0__antenna
X_11355_ _18877_/Q _12689_/C _11368_/A2 VSS _11355_/VNW VSS VSS gf180mcu_fd_sc_mcu9t5v0__nor2_1
X_14143_ _19175_/Q _14546_/S _14142_/Z _14143_/B2 _14144_/A2 VSS VSS VSS VSS gf180mcu_fd_sc_mcu9t5v0__aoi22_1
XTAP_TAPCELL_ROW_56_2531 VSS VSS gf180mcu_fd_sc_mcu9t5v0__filltie
X_10306_ _10724_/C _10306_/A2 _10306_/A3 _10307_/C VSS _10306_/VNW VSS VSS gf180mcu_fd_sc_mcu9t5v0__nand3_1
XTAP_TAPCELL_ROW_223_5213 VSS VSS gf180mcu_fd_sc_mcu9t5v0__filltie
X_11286_ _18182_/Q _11537_/S _11538_/B _11286_/C _11293_/A1 VSS _11286_/VNW VSS VSS
+ gf180mcu_fd_sc_mcu9t5v0__oai211_1
XTAP_TAPCELL_ROW_223_5202 VSS VSS gf180mcu_fd_sc_mcu9t5v0__filltie
X_18951_ _18951_/D _20039_/RN clkload68/I _18951_/Q VSS VSS VSS VSS gf180mcu_fd_sc_mcu9t5v0__dffrnq_1
X_14074_ _14074_/I _14092_/A1 VSS _14074_/VNW VSS VSS gf180mcu_fd_sc_mcu9t5v0__clkinv_1
XTAP_TAPCELL_ROW_52_2406 VSS VSS gf180mcu_fd_sc_mcu9t5v0__filltie
XTAP_TAPCELL_ROW_52_2417 VSS VSS gf180mcu_fd_sc_mcu9t5v0__filltie
X_10237_ _10237_/A1 _10745_/A2 wire168/I VSS VSS VSS VSS gf180mcu_fd_sc_mcu9t5v0__nand2_1
X_13025_ _19722_/Q _13025_/A2 _13044_/A1 VSS _13025_/VNW VSS VSS gf180mcu_fd_sc_mcu9t5v0__nor2_1
X_17902_ _17902_/A1 _11583_/Z _17902_/A3 _17902_/B _18838_/D VSS VSS VSS VSS gf180mcu_fd_sc_mcu9t5v0__oai31_1
X_18882_ _18882_/D _20034_/RN clkload46/I _18882_/Q VSS VSS VSS VSS gf180mcu_fd_sc_mcu9t5v0__dffrnq_1
X_10168_ _18962_/Q wire172/Z _10168_/B1 _18954_/Q _10170_/A1 VSS _16723_/VNW VSS VSS
+ gf180mcu_fd_sc_mcu9t5v0__aoi22_1
X_17833_ _19040_/Q _18810_/Q _17844_/S _18810_/D VSS VSS VSS VSS gf180mcu_fd_sc_mcu9t5v0__mux2_1
X_10099_ _18943_/Q _10133_/A2 _10168_/B1 _18951_/Q _10138_/B1 _19007_/Q _10103_/A2
+ VSS _10099_/VNW VSS VSS gf180mcu_fd_sc_mcu9t5v0__aoi222_1
X_17764_ _18757_/Q _17779_/A2 _17765_/B VSS _17764_/VNW VSS VSS gf180mcu_fd_sc_mcu9t5v0__nor2_1
X_14976_ _14976_/A1 _14973_/Z _14976_/B _14981_/A1 VSS _14976_/VNW VSS VSS gf180mcu_fd_sc_mcu9t5v0__aoi21_1
X_16715_ _16730_/A1 _16628_/B _16715_/B _16730_/C _16717_/A2 VSS VSS VSS VSS gf180mcu_fd_sc_mcu9t5v0__aoi211_1
X_19503_ _19503_/D _20143_/RN clkload42/I _19503_/Q VSS VSS VSS VSS gf180mcu_fd_sc_mcu9t5v0__dffrnq_1
X_13927_ _13927_/A1 _13925_/Z _13927_/Z VSS _13961_/VNW VSS VSS gf180mcu_fd_sc_mcu9t5v0__xor2_1
XTAP_TAPCELL_ROW_217_5039 VSS VSS gf180mcu_fd_sc_mcu9t5v0__filltie
X_17695_ _17695_/I _18725_/D VSS VSS VSS VSS gf180mcu_fd_sc_mcu9t5v0__clkinv_1
XTAP_TAPCELL_ROW_217_5028 VSS VSS gf180mcu_fd_sc_mcu9t5v0__filltie
XTAP_TAPCELL_ROW_167_3_8108 VSS VSS gf180mcu_fd_sc_mcu9t5v0__filltie
X_19434_ _19434_/D _20138_/RN clkload9/I _19434_/Q VSS VSS VSS VSS gf180mcu_fd_sc_mcu9t5v0__dffrnq_1
X_16646_ _19255_/Q _16744_/A2 wire71/Z _16648_/A2 VSS _16646_/VNW VSS VSS gf180mcu_fd_sc_mcu9t5v0__nor3_1
X_13858_ _13873_/B2 _13851_/Z _13896_/A2 _13858_/Z VSS VSS VSS VSS gf180mcu_fd_sc_mcu9t5v0__xor3_1
X_16577_ _19245_/Q _16700_/A2 wire71/I _16578_/A3 VSS VSS VSS VSS gf180mcu_fd_sc_mcu9t5v0__nor3_1
X_12809_ _12809_/I _12811_/A1 VSS _12811_/VNW VSS VSS gf180mcu_fd_sc_mcu9t5v0__clkinv_1
X_13789_ _19295_/Q _19317_/Q _19296_/Q _19316_/Q _13790_/A2 VSS VSS VSS VSS gf180mcu_fd_sc_mcu9t5v0__aoi22_1
X_19365_ _19365_/D _20069_/RN _19633_/CLK _19365_/Q VSS VSS VSS VSS gf180mcu_fd_sc_mcu9t5v0__dffrnq_1
X_18316_ _18316_/D clkload64/I _18316_/Q VSS VSS VSS VSS gf180mcu_fd_sc_mcu9t5v0__dffq_1
X_15528_ _19847_/Q _09848_/B _15544_/S _15529_/A2 VSS VSS VSS VSS gf180mcu_fd_sc_mcu9t5v0__aoi21_1
X_19296_ _19296_/D _20064_/RN clkload15/I _19296_/Q VSS VSS VSS VSS gf180mcu_fd_sc_mcu9t5v0__dffrnq_1
X_18247_ _18247_/D clkload69/I _18247_/Q VSS VSS VSS VSS gf180mcu_fd_sc_mcu9t5v0__dffq_1
X_15459_ _15438_/Z _15459_/A2 _15459_/A3 _15459_/B _19822_/D VSS _15459_/VNW VSS VSS
+ gf180mcu_fd_sc_mcu9t5v0__oai31_1
XTAP_TAPCELL_ROW_147_3_8039 VSS VSS gf180mcu_fd_sc_mcu9t5v0__filltie
X_18178_ _18178_/D clkload79/I _18178_/Q VSS VSS VSS VSS gf180mcu_fd_sc_mcu9t5v0__dffq_4
XTAP_TAPCELL_ROW_22_1575 VSS VSS gf180mcu_fd_sc_mcu9t5v0__filltie
Xmax_cap200 _14501_/S wire199/I VSS _14501_/VNW VSS VSS gf180mcu_fd_sc_mcu9t5v0__clkbuf_4
XTAP_TAPCELL_ROW_22_1586 VSS VSS gf180mcu_fd_sc_mcu9t5v0__filltie
XTAP_TAPCELL_ROW_22_1597 VSS VSS gf180mcu_fd_sc_mcu9t5v0__filltie
Xmax_cap211 _12147_/S _12689_/C VSS _13044_/VNW VSS VSS gf180mcu_fd_sc_mcu9t5v0__clkbuf_8
XTAP_TAPCELL_ROW_305_7471 VSS VSS gf180mcu_fd_sc_mcu9t5v0__filltie
XTAP_TAPCELL_ROW_305_7460 VSS VSS gf180mcu_fd_sc_mcu9t5v0__filltie
X_17129_ _17198_/A1 _17129_/A2 _17129_/A3 _17129_/B _17134_/A2 VSS _17129_/VNW VSS
+ VSS gf180mcu_fd_sc_mcu9t5v0__oai31_1
XTAP_TAPCELL_ROW_301_7346 VSS VSS gf180mcu_fd_sc_mcu9t5v0__filltie
XTAP_TAPCELL_ROW_301_7335 VSS VSS gf180mcu_fd_sc_mcu9t5v0__filltie
Xmax_cap255 _16996_/S _17006_/S VSS VSS VSS VSS gf180mcu_fd_sc_mcu9t5v0__clkbuf_16
X_20140_ _20140_/D _20140_/RN clkload48/I _20140_/Q VSS VSS VSS VSS gf180mcu_fd_sc_mcu9t5v0__dffrnq_1
X_09951_ _20042_/Q _09951_/A2 _10180_/B1 VSS _15792_/VNW VSS VSS gf180mcu_fd_sc_mcu9t5v0__nor2_1
XTAP_TAPCELL_ROW_301_7357 VSS VSS gf180mcu_fd_sc_mcu9t5v0__filltie
XTAP_TAPCELL_ROW_297_7250 VSS VSS gf180mcu_fd_sc_mcu9t5v0__filltie
XTAP_TAPCELL_ROW_35_1936 VSS VSS gf180mcu_fd_sc_mcu9t5v0__filltie
XTAP_TAPCELL_ROW_293_7136 VSS VSS gf180mcu_fd_sc_mcu9t5v0__filltie
XTAP_TAPCELL_ROW_318_7821 VSS VSS gf180mcu_fd_sc_mcu9t5v0__filltie
XTAP_TAPCELL_ROW_293_7125 VSS VSS gf180mcu_fd_sc_mcu9t5v0__filltie
XTAP_TAPCELL_ROW_318_7810 VSS VSS gf180mcu_fd_sc_mcu9t5v0__filltie
X_20071_ _20071_/D _20071_/RN clkload48/I _20071_/Q VSS VSS VSS VSS gf180mcu_fd_sc_mcu9t5v0__dffrnq_1
X_09882_ _09882_/A1 _09882_/A2 _09886_/A1 VSS VSS VSS VSS gf180mcu_fd_sc_mcu9t5v0__nor2_4
XTAP_TAPCELL_ROW_35_1947 VSS VSS gf180mcu_fd_sc_mcu9t5v0__filltie
XTAP_TAPCELL_ROW_35_1958 VSS VSS gf180mcu_fd_sc_mcu9t5v0__filltie
XTAP_TAPCELL_ROW_314_7718 VSS VSS gf180mcu_fd_sc_mcu9t5v0__filltie
XTAP_TAPCELL_ROW_314_7707 VSS VSS gf180mcu_fd_sc_mcu9t5v0__filltie
XPHY_EDGE_ROW_204_2_Left_716 VSS VSS gf180mcu_fd_sc_mcu9t5v0__endcap
XPHY_EDGE_ROW_145_1_Right_729 VSS VSS gf180mcu_fd_sc_mcu9t5v0__endcap
XTAP_TAPCELL_ROW_118_4236 VSS VSS gf180mcu_fd_sc_mcu9t5v0__filltie
XTAP_TAPCELL_ROW_118_4225 VSS VSS gf180mcu_fd_sc_mcu9t5v0__filltie
XTAP_TAPCELL_ROW_118_4214 VSS VSS gf180mcu_fd_sc_mcu9t5v0__filltie
X_09316_ _19236_/Q _16424_/A1 VSS VSS VSS VSS gf180mcu_fd_sc_mcu9t5v0__clkinv_1
XPHY_EDGE_ROW_137_2_Left_649 VSS VSS gf180mcu_fd_sc_mcu9t5v0__endcap
X_09247_ _18689_/Q _17749_/A3 VSS VSS VSS VSS gf180mcu_fd_sc_mcu9t5v0__clkinv_1
XTAP_TAPCELL_ROW_205_3_8240 VSS VSS gf180mcu_fd_sc_mcu9t5v0__filltie
XPHY_EDGE_ROW_125_Left_449 VSS VSS gf180mcu_fd_sc_mcu9t5v0__endcap
X_09178_ _19150_/Q _14400_/B1 VSS VSS VSS VSS gf180mcu_fd_sc_mcu9t5v0__clkinv_1
Xoutput12 output12/I dout[1] VSS VSS VSS VSS gf180mcu_fd_sc_mcu9t5v0__dlyd_1
X_11140_ _18252_/Q _11385_/A2 _11142_/A1 VSS VSS VSS VSS gf180mcu_fd_sc_mcu9t5v0__nor2_1
XTAP_TAPCELL_ROW_263_6294 VSS VSS gf180mcu_fd_sc_mcu9t5v0__filltie
XPHY_EDGE_ROW_199_2_Left_711 VSS VSS gf180mcu_fd_sc_mcu9t5v0__endcap
XTAP_TAPCELL_ROW_173_3_8129 VSS VSS gf180mcu_fd_sc_mcu9t5v0__filltie
X_11071_ _12694_/A1 _11072_/S _11071_/B _19070_/D VSS _11071_/VNW VSS VSS gf180mcu_fd_sc_mcu9t5v0__aoi21_1
X_10022_ _19286_/Q _10166_/B1 _10041_/A2 VSS VSS VSS VSS gf180mcu_fd_sc_mcu9t5v0__nand2_1
XTAP_TAPCELL_ROW_276_6666 VSS VSS gf180mcu_fd_sc_mcu9t5v0__filltie
XTAP_TAPCELL_ROW_276_6655 VSS VSS gf180mcu_fd_sc_mcu9t5v0__filltie
XPHY_EDGE_ROW_134_Left_458 VSS VSS gf180mcu_fd_sc_mcu9t5v0__endcap
X_14830_ _19576_/Q _14830_/I1 wire108/I _19576_/D VSS VSS VSS VSS gf180mcu_fd_sc_mcu9t5v0__mux2_1
XPHY_EDGE_ROW_147_2_Right_878 VSS VSS gf180mcu_fd_sc_mcu9t5v0__endcap
XTAP_TAPCELL_ROW_103_3826 VSS VSS gf180mcu_fd_sc_mcu9t5v0__filltie
XTAP_TAPCELL_ROW_103_3815 VSS VSS gf180mcu_fd_sc_mcu9t5v0__filltie
XTAP_TAPCELL_ROW_103_3804 VSS VSS gf180mcu_fd_sc_mcu9t5v0__filltie
X_16500_ _18307_/Q _16499_/Z _17020_/S _18307_/D VSS VSS VSS VSS gf180mcu_fd_sc_mcu9t5v0__mux2_4
X_11973_ _18295_/Q _12340_/S _11979_/C VSS VSS VSS VSS gf180mcu_fd_sc_mcu9t5v0__and2_1
X_14761_ _19554_/Q _14670_/S _14765_/B VSS VSS VSS VSS gf180mcu_fd_sc_mcu9t5v0__nand2_1
X_10924_ _16959_/A1 _18147_/S _10924_/B _10925_/I0 VSS VSS VSS VSS gf180mcu_fd_sc_mcu9t5v0__oai21_1
XPHY_EDGE_ROW_113_Right_113 VSS VSS gf180mcu_fd_sc_mcu9t5v0__endcap
XTAP_TAPCELL_ROW_45_2210 VSS VSS gf180mcu_fd_sc_mcu9t5v0__filltie
X_13712_ _19112_/Q _13712_/I1 _14501_/S _13712_/Z VSS _14666_/VNW VSS VSS gf180mcu_fd_sc_mcu9t5v0__mux2_1
X_14692_ _14692_/A1 _14692_/A2 _14696_/A2 VSS _14692_/VNW VSS VSS gf180mcu_fd_sc_mcu9t5v0__nand2_1
XTAP_TAPCELL_ROW_45_2221 VSS VSS gf180mcu_fd_sc_mcu9t5v0__filltie
XTAP_TAPCELL_ROW_45_2232 VSS VSS gf180mcu_fd_sc_mcu9t5v0__filltie
X_17480_ _09517_/I _17480_/A2 _18586_/D VSS VSS VSS VSS gf180mcu_fd_sc_mcu9t5v0__nor2_1
X_16431_ _16431_/I0 _18276_/Q _16958_/S _18276_/D VSS VSS VSS VSS gf180mcu_fd_sc_mcu9t5v0__mux2_4
X_10855_ _10855_/I0 _18966_/Q _18148_/S _18966_/D VSS VSS VSS VSS gf180mcu_fd_sc_mcu9t5v0__mux2_1
X_13643_ _19291_/Q _13497_/B _13646_/B VSS VSS VSS VSS gf180mcu_fd_sc_mcu9t5v0__nand2_1
XTAP_TAPCELL_ROW_41_2107 VSS VSS gf180mcu_fd_sc_mcu9t5v0__filltie
X_16362_ _18245_/Q _16361_/Z _16892_/S _18245_/D VSS VSS VSS VSS gf180mcu_fd_sc_mcu9t5v0__mux2_4
X_19150_ _19150_/D _20046_/RN _19798_/CLK _19150_/Q VSS VSS VSS VSS gf180mcu_fd_sc_mcu9t5v0__dffrnq_1
X_13574_ wire277/Z _13574_/A2 _13232_/Z _13574_/B _19276_/D VSS _13577_/VNW VSS VSS
+ gf180mcu_fd_sc_mcu9t5v0__oai31_1
XTAP_TAPCELL_ROW_41_2118 VSS VSS gf180mcu_fd_sc_mcu9t5v0__filltie
X_12525_ _18493_/Q _12608_/A2 _12541_/B _12526_/B2 VSS VSS VSS VSS gf180mcu_fd_sc_mcu9t5v0__oai21_1
X_10786_ _19015_/Q _10786_/A2 _10788_/A2 VSS VSS VSS VSS gf180mcu_fd_sc_mcu9t5v0__nor2_1
X_18101_ _18938_/Q _18101_/A2 _18102_/A2 VSS _18101_/VNW VSS VSS gf180mcu_fd_sc_mcu9t5v0__nand2_1
X_15313_ _15313_/I0 _19739_/Q _15417_/S _19739_/D VSS _15313_/VNW VSS VSS gf180mcu_fd_sc_mcu9t5v0__mux2_1
X_16293_ _19275_/Q _16829_/A2 _16295_/A1 VSS VSS VSS VSS gf180mcu_fd_sc_mcu9t5v0__nand2_1
X_19081_ _19081_/D _20041_/RN _19798_/CLK _19081_/Q VSS VSS VSS VSS gf180mcu_fd_sc_mcu9t5v0__dffrnq_1
X_12456_ _18261_/Q _12615_/A2 _12458_/B1 VSS _12456_/VNW VSS VSS gf180mcu_fd_sc_mcu9t5v0__nor2_1
X_15244_ _19598_/Q _15247_/A2 _15244_/A3 _15245_/I1 VSS VSS VSS VSS gf180mcu_fd_sc_mcu9t5v0__xnor3_1
X_18032_ _18032_/I0 _18917_/Q _18037_/S _18917_/D VSS _18032_/VNW VSS VSS gf180mcu_fd_sc_mcu9t5v0__mux2_1
X_11407_ _18880_/Q _12689_/C _11409_/A2 VSS VSS VSS VSS gf180mcu_fd_sc_mcu9t5v0__nor2_1
XTAP_TAPCELL_ROW_39_2047 VSS VSS gf180mcu_fd_sc_mcu9t5v0__filltie
X_12387_ _19145_/Q _12355_/I _12394_/B VSS VSS VSS VSS gf180mcu_fd_sc_mcu9t5v0__nand2_1
XTAP_TAPCELL_ROW_39_2058 VSS VSS gf180mcu_fd_sc_mcu9t5v0__filltie
X_15175_ _15430_/S _15364_/S VSS _15175_/VNW VSS VSS gf180mcu_fd_sc_mcu9t5v0__inv_2
X_11338_ _18875_/Q _12689_/C _11340_/A2 VSS VSS VSS VSS gf180mcu_fd_sc_mcu9t5v0__nor2_1
X_14126_ _14115_/Z _14127_/A2 _14191_/A2 VSS _14191_/VNW VSS VSS gf180mcu_fd_sc_mcu9t5v0__nand2_1
XPHY_EDGE_ROW_183_2_Left_695 VSS VSS gf180mcu_fd_sc_mcu9t5v0__endcap
X_19983_ _19983_/D _20047_/RN clkload46/I _19983_/Q VSS VSS VSS VSS gf180mcu_fd_sc_mcu9t5v0__dffrnq_1
X_18934_ _18934_/D _20022_/RN _19680_/CLK _18934_/Q VSS VSS VSS VSS gf180mcu_fd_sc_mcu9t5v0__dffrnq_1
X_11269_ _19084_/Q _11321_/A2 _11270_/A2 VSS VSS VSS VSS gf180mcu_fd_sc_mcu9t5v0__nand2_1
X_14057_ _14057_/A1 _14058_/A2 _14069_/B VSS _14212_/VNW VSS VSS gf180mcu_fd_sc_mcu9t5v0__nor2_1
X_18865_ _18865_/D _20145_/RN clkload45/I _18865_/Q VSS VSS VSS VSS gf180mcu_fd_sc_mcu9t5v0__dffrnq_1
X_13008_ _13008_/A1 _13008_/A2 _13007_/B _13008_/Z VSS _13008_/VNW VSS VSS gf180mcu_fd_sc_mcu9t5v0__or3_1
XTAP_TAPCELL_ROW_30_1800 VSS VSS gf180mcu_fd_sc_mcu9t5v0__filltie
XTAP_TAPCELL_ROW_30_1811 VSS VSS gf180mcu_fd_sc_mcu9t5v0__filltie
X_17816_ _19023_/Q _18793_/Q _17844_/S _18793_/D VSS _17816_/VNW VSS VSS gf180mcu_fd_sc_mcu9t5v0__mux2_1
XTAP_TAPCELL_ROW_15_1390 VSS VSS gf180mcu_fd_sc_mcu9t5v0__filltie
X_18796_ _18796_/D _20140_/RN clkload33/I _18796_/Q VSS VSS VSS VSS gf180mcu_fd_sc_mcu9t5v0__dffrnq_1
Xclkbuf_leaf_57_clk_regs clkload1/I _19798_/CLK VSS VSS VSS VSS gf180mcu_fd_sc_mcu9t5v0__clkbuf_8
XTAP_TAPCELL_ROW_186_3_8174 VSS VSS gf180mcu_fd_sc_mcu9t5v0__filltie
X_17747_ _17747_/A1 _18690_/Q _17749_/A3 _17747_/A4 _17752_/S VSS _17749_/VNW VSS
+ VSS gf180mcu_fd_sc_mcu9t5v0__nor4_1
XTAP_TAPCELL_ROW_11_1276 VSS VSS gf180mcu_fd_sc_mcu9t5v0__filltie
X_14959_ _19426_/Q _19371_/Q _14959_/Z VSS _14959_/VNW VSS VSS gf180mcu_fd_sc_mcu9t5v0__xor2_1
X_17678_ _18641_/Q _18717_/Q _17681_/S _18717_/D VSS VSS VSS VSS gf180mcu_fd_sc_mcu9t5v0__mux2_1
XTAP_TAPCELL_ROW_11_1287 VSS VSS gf180mcu_fd_sc_mcu9t5v0__filltie
XTAP_TAPCELL_ROW_11_1298 VSS VSS gf180mcu_fd_sc_mcu9t5v0__filltie
X_16629_ _19252_/Q _16744_/A2 wire71/I _16630_/A3 VSS VSS VSS VSS gf180mcu_fd_sc_mcu9t5v0__nor3_1
X_19417_ _19417_/D _20057_/RN clkload17/I _19417_/Q VSS VSS VSS VSS gf180mcu_fd_sc_mcu9t5v0__dffrnq_1
XTAP_TAPCELL_ROW_28_1740 VSS VSS gf180mcu_fd_sc_mcu9t5v0__filltie
X_19348_ _19348_/D _20052_/RN clkload19/I _19348_/Q VSS VSS VSS VSS gf180mcu_fd_sc_mcu9t5v0__dffrnq_1
XTAP_TAPCELL_ROW_28_1751 VSS VSS gf180mcu_fd_sc_mcu9t5v0__filltie
XTAP_TAPCELL_ROW_28_1762 VSS VSS gf180mcu_fd_sc_mcu9t5v0__filltie
XTAP_TAPCELL_ROW_307_7500 VSS VSS gf180mcu_fd_sc_mcu9t5v0__filltie
X_09101_ _17411_/C _17144_/A2 VSS VSS VSS VSS gf180mcu_fd_sc_mcu9t5v0__inv_2
XTAP_TAPCELL_ROW_113_4100 VSS VSS gf180mcu_fd_sc_mcu9t5v0__filltie
XTAP_TAPCELL_ROW_24_1637 VSS VSS gf180mcu_fd_sc_mcu9t5v0__filltie
XTAP_TAPCELL_ROW_24_1648 VSS VSS gf180mcu_fd_sc_mcu9t5v0__filltie
XTAP_TAPCELL_ROW_307_7522 VSS VSS gf180mcu_fd_sc_mcu9t5v0__filltie
XTAP_TAPCELL_ROW_307_7511 VSS VSS gf180mcu_fd_sc_mcu9t5v0__filltie
X_19279_ _19279_/D _20047_/RN clkload24/I _19279_/Q VSS VSS VSS VSS gf180mcu_fd_sc_mcu9t5v0__dffrnq_1
XTAP_TAPCELL_ROW_299_7301 VSS VSS gf180mcu_fd_sc_mcu9t5v0__filltie
XTAP_TAPCELL_ROW_303_7408 VSS VSS gf180mcu_fd_sc_mcu9t5v0__filltie
XPHY_EDGE_ROW_264_Right_191 VSS VSS gf180mcu_fd_sc_mcu9t5v0__endcap
X_09934_ _09934_/A1 _09934_/A2 _10659_/C _09938_/A3 VSS _10472_/VNW VSS VSS gf180mcu_fd_sc_mcu9t5v0__aoi21_1
X_20123_ _20123_/D clkload59/I _20123_/Q VSS VSS VSS VSS gf180mcu_fd_sc_mcu9t5v0__dffq_1
X_09865_ _19895_/Q _19896_/Q _19897_/Q _19898_/Q _15639_/A1 VSS VSS VSS VSS gf180mcu_fd_sc_mcu9t5v0__nor4_1
X_20054_ _20054_/D _20054_/RN _20054_/CLK _20054_/Q VSS VSS VSS VSS gf180mcu_fd_sc_mcu9t5v0__dffrnq_1
X_09796_ _18838_/Q _11600_/C _10732_/A1 VSS _10751_/VNW VSS VSS gf180mcu_fd_sc_mcu9t5v0__nor2_1
XTAP_TAPCELL_ROW_271_6530 VSS VSS gf180mcu_fd_sc_mcu9t5v0__filltie
XTAP_TAPCELL_ROW_81_3199 VSS VSS gf180mcu_fd_sc_mcu9t5v0__filltie
X_10640_ _17404_/S _18344_/Q _10642_/A3 VSS _10640_/VNW VSS VSS gf180mcu_fd_sc_mcu9t5v0__nor2_1
XTAP_TAPCELL_ROW_98_3674 VSS VSS gf180mcu_fd_sc_mcu9t5v0__filltie
X_10571_ _10389_/C _10649_/A2 _10571_/A3 _17161_/C _10572_/B2 VSS VSS VSS VSS gf180mcu_fd_sc_mcu9t5v0__oai31_1
XTAP_TAPCELL_ROW_269_6481 VSS VSS gf180mcu_fd_sc_mcu9t5v0__filltie
XTAP_TAPCELL_ROW_269_6470 VSS VSS gf180mcu_fd_sc_mcu9t5v0__filltie
XTAP_TAPCELL_ROW_98_3685 VSS VSS gf180mcu_fd_sc_mcu9t5v0__filltie
XTAP_TAPCELL_ROW_265_6367 VSS VSS gf180mcu_fd_sc_mcu9t5v0__filltie
XTAP_TAPCELL_ROW_265_6356 VSS VSS gf180mcu_fd_sc_mcu9t5v0__filltie
XTAP_TAPCELL_ROW_265_6345 VSS VSS gf180mcu_fd_sc_mcu9t5v0__filltie
X_12310_ _18920_/Q _12310_/A2 _12311_/A2 VSS VSS VSS VSS gf180mcu_fd_sc_mcu9t5v0__xnor2_1
X_13290_ _13290_/A1 _13290_/A2 _13290_/B _13325_/B2 VSS VSS VSS VSS gf180mcu_fd_sc_mcu9t5v0__aoi21_1
X_12241_ _18499_/Q _12345_/A2 _12247_/A3 VSS VSS VSS VSS gf180mcu_fd_sc_mcu9t5v0__nand2_1
X_12172_ _18912_/Q _18913_/Q _12172_/A3 _12192_/A2 VSS VSS VSS VSS gf180mcu_fd_sc_mcu9t5v0__nor3_1
XTAP_TAPCELL_ROW_278_6728 VSS VSS gf180mcu_fd_sc_mcu9t5v0__filltie
X_16980_ _18481_/Q _16979_/Z _16986_/S _18481_/D VSS VSS VSS VSS gf180mcu_fd_sc_mcu9t5v0__mux2_4
XTAP_TAPCELL_ROW_278_6717 VSS VSS gf180mcu_fd_sc_mcu9t5v0__filltie
XTAP_TAPCELL_ROW_278_6706 VSS VSS gf180mcu_fd_sc_mcu9t5v0__filltie
XTAP_TAPCELL_ROW_192_3_8195 VSS VSS gf180mcu_fd_sc_mcu9t5v0__filltie
X_11123_ _11123_/A1 _11123_/A2 _19074_/D VSS _11123_/VNW VSS VSS gf180mcu_fd_sc_mcu9t5v0__nand2_1
X_15931_ _15989_/A3 _15930_/I _15986_/A2 VSS VSS VSS VSS gf180mcu_fd_sc_mcu9t5v0__nor2_1
X_11054_ _18024_/I0 _19055_/Q _11067_/S _19055_/D VSS _11796_/VNW VSS VSS gf180mcu_fd_sc_mcu9t5v0__mux2_1
X_10005_ _10005_/A1 _10005_/A2 _10005_/A3 _10006_/B2 VSS _10005_/VNW VSS VSS gf180mcu_fd_sc_mcu9t5v0__nor3_1
X_18650_ _18650_/D _20054_/RN clkload54/I _18650_/Q VSS VSS VSS VSS gf180mcu_fd_sc_mcu9t5v0__dffrnq_1
X_15862_ _17481_/A1 _16197_/B wire79/I VSS VSS VSS VSS gf180mcu_fd_sc_mcu9t5v0__nor2_1
X_17601_ _17601_/A1 _17601_/A2 _17601_/A3 _17601_/B _18664_/D VSS VSS VSS VSS gf180mcu_fd_sc_mcu9t5v0__oai31_1
XPHY_EDGE_ROW_148_2_Right_879 VSS VSS gf180mcu_fd_sc_mcu9t5v0__endcap
X_15793_ _18028_/I0 _19963_/Q _15802_/S _19963_/D VSS VSS VSS VSS gf180mcu_fd_sc_mcu9t5v0__mux2_1
XTAP_TAPCELL_ROW_8_1197 VSS VSS gf180mcu_fd_sc_mcu9t5v0__filltie
X_14813_ _14814_/A1 _14814_/A2 _14816_/B VSS VSS VSS VSS gf180mcu_fd_sc_mcu9t5v0__nor2_1
X_18581_ _18581_/D _20145_/RN clkload28/I _18581_/Q VSS VSS VSS VSS gf180mcu_fd_sc_mcu9t5v0__dffrnq_1
X_11956_ _18326_/Q _11954_/Z _11955_/Z _11953_/Z _12345_/B _12299_/S _11956_/Z VSS
+ VSS VSS VSS gf180mcu_fd_sc_mcu9t5v0__mux4_1
X_17532_ _18664_/Q _17532_/A2 _17532_/B _17578_/I1 VSS VSS VSS VSS gf180mcu_fd_sc_mcu9t5v0__oai21_1
X_14744_ _14730_/S _14744_/A2 _14744_/B _19549_/D VSS VSS VSS VSS gf180mcu_fd_sc_mcu9t5v0__oai21_1
Xeco15_sk1_2 clkload73/I eco15_sk2_2/I VSS VSS VSS VSS gf180mcu_fd_sc_mcu9t5v0__clkbuf_16
X_10907_ _19250_/Q _19256_/Q _18145_/S _10907_/Z VSS VSS VSS VSS gf180mcu_fd_sc_mcu9t5v0__mux2_1
X_17463_ wire198/I _17960_/A4 _18578_/Q _17464_/A2 VSS VSS VSS VSS gf180mcu_fd_sc_mcu9t5v0__aoi21_1
X_11887_ _18195_/Q _12299_/S _11898_/A3 VSS VSS VSS VSS gf180mcu_fd_sc_mcu9t5v0__nor2_1
X_16414_ _16414_/A1 _16414_/A2 _16415_/I0 VSS _16414_/VNW VSS VSS gf180mcu_fd_sc_mcu9t5v0__nand2_1
XTAP_TAPCELL_ROW_250_5946 VSS VSS gf180mcu_fd_sc_mcu9t5v0__filltie
XTAP_TAPCELL_ROW_250_5935 VSS VSS gf180mcu_fd_sc_mcu9t5v0__filltie
X_19202_ _19202_/D _20034_/RN clkload44/I _19202_/Q VSS VSS VSS VSS gf180mcu_fd_sc_mcu9t5v0__dffrnq_1
X_14675_ _14675_/A1 _14675_/A2 _14675_/B _14677_/A2 VSS _17825_/VNW VSS VSS gf180mcu_fd_sc_mcu9t5v0__oai21_1
X_17394_ _18552_/Q _17394_/A2 _17413_/B VSS VSS VSS VSS gf180mcu_fd_sc_mcu9t5v0__nand2_1
XTAP_TAPCELL_ROW_250_5957 VSS VSS gf180mcu_fd_sc_mcu9t5v0__filltie
X_10838_ _09448_/B _17425_/A2 _10840_/B VSS _17426_/VNW VSS VSS gf180mcu_fd_sc_mcu9t5v0__nor2_1
X_13626_ _13043_/I _13624_/Z _13630_/A1 _13626_/B _19287_/D VSS VSS VSS VSS gf180mcu_fd_sc_mcu9t5v0__oai31_1
X_16345_ _19232_/Q _16137_/C _16881_/S _16345_/Z VSS VSS VSS VSS gf180mcu_fd_sc_mcu9t5v0__mux2_4
X_10769_ _10659_/C _10768_/Z _10809_/B _10770_/A2 VSS _10809_/VNW VSS VSS gf180mcu_fd_sc_mcu9t5v0__aoi21_1
X_13557_ _13615_/B _13561_/A2 _13558_/A2 VSS _13557_/VNW VSS VSS gf180mcu_fd_sc_mcu9t5v0__nand2_1
X_19133_ _19133_/D _20029_/RN clkload36/I _19133_/Q VSS VSS VSS VSS gf180mcu_fd_sc_mcu9t5v0__dffrnq_1
X_16276_ _18211_/Q _16276_/I1 _16818_/S _18211_/D VSS VSS VSS VSS gf180mcu_fd_sc_mcu9t5v0__mux2_4
X_12508_ _12508_/A1 _12607_/A2 _12509_/C VSS VSS VSS VSS gf180mcu_fd_sc_mcu9t5v0__nand2_1
X_13488_ _16959_/A1 _13497_/B _13488_/B1 _13488_/B2 _19258_/D VSS VSS VSS VSS gf180mcu_fd_sc_mcu9t5v0__aoi22_1
X_19064_ _19064_/D _19960_/RN clkload31/I _19064_/Q VSS VSS VSS VSS gf180mcu_fd_sc_mcu9t5v0__dffrnq_1
X_12439_ _18211_/Q wire163/Z _12442_/A3 VSS VSS VSS VSS gf180mcu_fd_sc_mcu9t5v0__nor2_1
X_15227_ _19595_/Q _19572_/Q _15227_/A3 _15228_/I1 VSS _15227_/VNW VSS VSS gf180mcu_fd_sc_mcu9t5v0__xnor3_1
X_18015_ _18031_/I0 _18900_/Q _18021_/S _18900_/D VSS _18015_/VNW VSS VSS gf180mcu_fd_sc_mcu9t5v0__mux2_1
XTAP_TAPCELL_ROW_248_5897 VSS VSS gf180mcu_fd_sc_mcu9t5v0__filltie
XTAP_TAPCELL_ROW_248_5886 VSS VSS gf180mcu_fd_sc_mcu9t5v0__filltie
X_15158_ _19700_/Q _19540_/Q _15163_/S _19700_/D VSS VSS VSS VSS gf180mcu_fd_sc_mcu9t5v0__mux2_1
X_19966_ _19966_/D _20030_/RN clkload46/I _19966_/Q VSS VSS VSS VSS gf180mcu_fd_sc_mcu9t5v0__dffrnq_1
X_14109_ _14109_/I _14185_/A1 VSS VSS VSS VSS gf180mcu_fd_sc_mcu9t5v0__clkinv_1
X_15089_ _15098_/A2 _15089_/A2 _15089_/B _15093_/A2 VSS _15098_/VNW VSS VSS gf180mcu_fd_sc_mcu9t5v0__oai21_1
XTAP_TAPCELL_ROW_17_1441 VSS VSS gf180mcu_fd_sc_mcu9t5v0__filltie
XTAP_TAPCELL_ROW_17_1452 VSS VSS gf180mcu_fd_sc_mcu9t5v0__filltie
X_18917_ _18917_/D _20069_/RN clkload32/I _18917_/Q VSS VSS VSS VSS gf180mcu_fd_sc_mcu9t5v0__dffrnq_1
XTAP_TAPCELL_ROW_17_1463 VSS VSS gf180mcu_fd_sc_mcu9t5v0__filltie
X_09650_ _09650_/I _15720_/A1 VSS VSS VSS VSS gf180mcu_fd_sc_mcu9t5v0__clkinv_1
XTAP_TAPCELL_ROW_158_2_8075 VSS VSS gf180mcu_fd_sc_mcu9t5v0__filltie
X_19897_ _19897_/D _20025_/RN clkload41/I _19897_/Q VSS VSS VSS VSS gf180mcu_fd_sc_mcu9t5v0__dffrnq_1
XTAP_TAPCELL_ROW_13_1327 VSS VSS gf180mcu_fd_sc_mcu9t5v0__filltie
X_18848_ _18848_/D _20064_/RN clkload33/I _18848_/Q VSS VSS VSS VSS gf180mcu_fd_sc_mcu9t5v0__dffrnq_1
XTAP_TAPCELL_ROW_13_1338 VSS VSS gf180mcu_fd_sc_mcu9t5v0__filltie
XTAP_TAPCELL_ROW_13_1349 VSS VSS gf180mcu_fd_sc_mcu9t5v0__filltie
X_18779_ _18779_/D _20059_/RN clkload59/I _18779_/Q VSS VSS VSS VSS gf180mcu_fd_sc_mcu9t5v0__dffrnq_1
X_09581_ _18687_/Q _18686_/Q _18688_/Q _09580_/Z _09582_/A4 VSS _09581_/VNW VSS VSS
+ gf180mcu_fd_sc_mcu9t5v0__nor4_1
XTAP_TAPCELL_ROW_288_7002 VSS VSS gf180mcu_fd_sc_mcu9t5v0__filltie
XTAP_TAPCELL_ROW_260_6220 VSS VSS gf180mcu_fd_sc_mcu9t5v0__filltie
XTAP_TAPCELL_ROW_260_6231 VSS VSS gf180mcu_fd_sc_mcu9t5v0__filltie
X_20106_ _20106_/D clkload77/I _20106_/Q VSS VSS VSS VSS gf180mcu_fd_sc_mcu9t5v0__dffq_1
X_09917_ _09916_/B _19010_/Q _09917_/B _09931_/A3 VSS VSS VSS VSS gf180mcu_fd_sc_mcu9t5v0__aoi21_1
XPHY_EDGE_ROW_194_1_Left_517 VSS VSS gf180mcu_fd_sc_mcu9t5v0__endcap
XTAP_TAPCELL_ROW_258_6171 VSS VSS gf180mcu_fd_sc_mcu9t5v0__filltie
XTAP_TAPCELL_ROW_258_6160 VSS VSS gf180mcu_fd_sc_mcu9t5v0__filltie
XTAP_TAPCELL_ROW_87_3386 VSS VSS gf180mcu_fd_sc_mcu9t5v0__filltie
XTAP_TAPCELL_ROW_87_3375 VSS VSS gf180mcu_fd_sc_mcu9t5v0__filltie
X_09848_ _09846_/Z _17231_/A3 _09848_/B _09848_/ZN VSS VSS VSS VSS gf180mcu_fd_sc_mcu9t5v0__aoi21_4
X_20037_ _20037_/D _20037_/RN clkload15/I _20037_/Q VSS VSS VSS VSS gf180mcu_fd_sc_mcu9t5v0__dffrnq_4
XTAP_TAPCELL_ROW_87_3364 VSS VSS gf180mcu_fd_sc_mcu9t5v0__filltie
XTAP_TAPCELL_ROW_254_6046 VSS VSS gf180mcu_fd_sc_mcu9t5v0__filltie
X_09779_ _18837_/Q _11591_/A2 _18838_/Q _10800_/A1 VSS _09793_/VNW VSS VSS gf180mcu_fd_sc_mcu9t5v0__nand3_1
XTAP_TAPCELL_ROW_254_6068 VSS VSS gf180mcu_fd_sc_mcu9t5v0__filltie
XTAP_TAPCELL_ROW_254_6057 VSS VSS gf180mcu_fd_sc_mcu9t5v0__filltie
X_11810_ _12071_/B _11832_/A2 _11811_/B2 VSS VSS VSS VSS gf180mcu_fd_sc_mcu9t5v0__nor2_1
XTAP_TAPCELL_ROW_168_3_8113 VSS VSS gf180mcu_fd_sc_mcu9t5v0__filltie
X_12790_ _12790_/A1 _12783_/Z _12790_/B _12793_/A2 VSS _17950_/VNW VSS VSS gf180mcu_fd_sc_mcu9t5v0__aoi21_1
XTAP_TAPCELL_ROW_3_1061 VSS VSS gf180mcu_fd_sc_mcu9t5v0__filltie
X_11741_ _11966_/B _11741_/A2 _11742_/B2 VSS VSS VSS VSS gf180mcu_fd_sc_mcu9t5v0__nor2_1
XTAP_TAPCELL_ROW_3_1072 VSS VSS gf180mcu_fd_sc_mcu9t5v0__filltie
Xclkbuf_leaf_2_clk_regs clkbuf_3_0_0_clk_regs/Z clkload8/I VSS VSS VSS VSS gf180mcu_fd_sc_mcu9t5v0__clkbuf_8
XTAP_TAPCELL_ROW_267_6418 VSS VSS gf180mcu_fd_sc_mcu9t5v0__filltie
XTAP_TAPCELL_ROW_267_6407 VSS VSS gf180mcu_fd_sc_mcu9t5v0__filltie
X_11672_ _11632_/B _12658_/A2 _11672_/Z VSS VSS VSS VSS gf180mcu_fd_sc_mcu9t5v0__and2_1
X_14460_ _14459_/Z _19457_/Q _14715_/S _19457_/D VSS VSS VSS VSS gf180mcu_fd_sc_mcu9t5v0__mux2_1
X_10623_ _10389_/C _10649_/A2 _10623_/A3 _17161_/C _10624_/B2 VSS VSS VSS VSS gf180mcu_fd_sc_mcu9t5v0__oai31_1
X_13411_ _13389_/Z _13411_/A2 _13620_/B _13430_/A2 VSS VSS VSS VSS gf180mcu_fd_sc_mcu9t5v0__aoi21_1
X_14391_ _19150_/Q _19116_/Q _14681_/A1 VSS VSS VSS VSS gf180mcu_fd_sc_mcu9t5v0__xnor2_1
X_16130_ _16722_/A1 _16130_/A2 _16130_/A3 _16130_/B _18171_/D VSS VSS VSS VSS gf180mcu_fd_sc_mcu9t5v0__oai31_4
X_10554_ _17404_/S _18341_/Q _10556_/A3 VSS _10554_/VNW VSS VSS gf180mcu_fd_sc_mcu9t5v0__nor2_1
X_13342_ _13345_/A1 _13603_/A2 _13347_/A1 VSS _13346_/VNW VSS VSS gf180mcu_fd_sc_mcu9t5v0__nor2_1
X_10485_ _18226_/Q _17406_/A2 _17405_/A2 _18242_/Q _10486_/B VSS VSS VSS VSS gf180mcu_fd_sc_mcu9t5v0__aoi22_1
X_16061_ _18161_/Q _16061_/I1 _16643_/S _18161_/D VSS _16092_/VNW VSS VSS gf180mcu_fd_sc_mcu9t5v0__mux2_4
XTAP_TAPCELL_ROW_164_2_8096 VSS VSS gf180mcu_fd_sc_mcu9t5v0__filltie
Xrebuffer271 _20041_/Q _11013_/A1 VSS VSS VSS VSS gf180mcu_fd_sc_mcu9t5v0__buf_8
X_13273_ _19737_/Q _13276_/A2 _13274_/I VSS _13273_/VNW VSS VSS gf180mcu_fd_sc_mcu9t5v0__and2_1
X_12224_ _18498_/Q _18482_/Q _12340_/S _12224_/Z VSS VSS VSS VSS gf180mcu_fd_sc_mcu9t5v0__mux2_1
X_15012_ _19377_/Q _19435_/Q _15012_/Z VSS VSS VSS VSS gf180mcu_fd_sc_mcu9t5v0__xor2_1
X_12155_ _18511_/Q _12154_/Z _12159_/B _12155_/Z VSS VSS VSS VSS gf180mcu_fd_sc_mcu9t5v0__mux2_1
X_19820_ _19820_/D _20140_/RN clkload58/I _19820_/Q VSS VSS VSS VSS gf180mcu_fd_sc_mcu9t5v0__dffrnq_1
XTAP_TAPCELL_ROW_243_5761 VSS VSS gf180mcu_fd_sc_mcu9t5v0__filltie
XTAP_TAPCELL_ROW_243_5750 VSS VSS gf180mcu_fd_sc_mcu9t5v0__filltie
XTAP_TAPCELL_ROW_72_2976 VSS VSS gf180mcu_fd_sc_mcu9t5v0__filltie
XTAP_TAPCELL_ROW_72_2965 VSS VSS gf180mcu_fd_sc_mcu9t5v0__filltie
XTAP_TAPCELL_ROW_72_2954 VSS VSS gf180mcu_fd_sc_mcu9t5v0__filltie
X_11106_ _18695_/Q _12527_/A2 wire208/Z _11106_/B2 wire213/Z _11108_/A3 VSS VSS VSS
+ VSS gf180mcu_fd_sc_mcu9t5v0__aoi221_2
X_19751_ _19751_/D _20071_/RN clkload24/I _19751_/Q VSS VSS VSS VSS gf180mcu_fd_sc_mcu9t5v0__dffrnq_1
X_12086_ _12516_/A1 _12046_/S _12087_/C VSS _12088_/VNW VSS VSS gf180mcu_fd_sc_mcu9t5v0__nor2_1
X_16963_ _19244_/Q _17059_/I1 _16971_/S _16963_/Z VSS VSS VSS VSS gf180mcu_fd_sc_mcu9t5v0__mux2_1
X_18702_ _18702_/D clkload71/I _18702_/Q VSS VSS VSS VSS gf180mcu_fd_sc_mcu9t5v0__dffq_1
X_16894_ _18439_/Q _16893_/Z wire38/Z _18439_/D VSS VSS VSS VSS gf180mcu_fd_sc_mcu9t5v0__mux2_1
X_15914_ _20123_/Q _19244_/Q _15920_/S _20123_/D VSS VSS VSS VSS gf180mcu_fd_sc_mcu9t5v0__mux2_1
X_19682_ _19682_/D _20066_/RN clkload16/I _19682_/Q VSS VSS VSS VSS gf180mcu_fd_sc_mcu9t5v0__dffrnq_1
X_11037_ _18023_/I0 _19038_/Q wire174/Z _19038_/D VSS VSS VSS VSS gf180mcu_fd_sc_mcu9t5v0__mux2_1
X_15845_ _17521_/S _15845_/A2 _20141_/D VSS VSS VSS VSS gf180mcu_fd_sc_mcu9t5v0__nand2_1
X_18633_ _18633_/D _20037_/RN clkload47/I _18633_/Q VSS VSS VSS VSS gf180mcu_fd_sc_mcu9t5v0__dffrnq_1
X_18564_ _18564_/D _20064_/RN clkload53/I _18564_/Q VSS VSS VSS VSS gf180mcu_fd_sc_mcu9t5v0__dffrnq_4
XTAP_TAPCELL_ROW_237_5587 VSS VSS gf180mcu_fd_sc_mcu9t5v0__filltie
X_17515_ wire301/Z _18620_/Q _17521_/S _18620_/D VSS VSS VSS VSS gf180mcu_fd_sc_mcu9t5v0__mux2_1
XTAP_TAPCELL_ROW_237_5576 VSS VSS gf180mcu_fd_sc_mcu9t5v0__filltie
X_15776_ input6/Z _19946_/Q _15786_/S _19946_/D VSS VSS VSS VSS gf180mcu_fd_sc_mcu9t5v0__mux2_1
X_12988_ _12989_/A1 _12989_/A2 _13507_/B _12990_/A2 VSS _12988_/VNW VSS VSS gf180mcu_fd_sc_mcu9t5v0__nand3_1
X_18495_ _18495_/D _18495_/CLK _18495_/Q VSS VSS VSS VSS gf180mcu_fd_sc_mcu9t5v0__dffq_4
XTAP_TAPCELL_ROW_237_5598 VSS VSS gf180mcu_fd_sc_mcu9t5v0__filltie
X_11939_ _12299_/S _11939_/A2 _11939_/A3 _11940_/B VSS _11976_/VNW VSS VSS gf180mcu_fd_sc_mcu9t5v0__nand3_1
X_14727_ _14726_/Z _19544_/Q _14730_/S _19544_/D VSS VSS VSS VSS gf180mcu_fd_sc_mcu9t5v0__mux2_1
X_14658_ _19526_/Q _14715_/S _14659_/B VSS VSS VSS VSS gf180mcu_fd_sc_mcu9t5v0__nand2_1
X_17446_ _17462_/A1 _17446_/A2 _18569_/D VSS VSS VSS VSS gf180mcu_fd_sc_mcu9t5v0__nor2_1
X_17377_ _09261_/I _17377_/A2 _17377_/A3 _17377_/B _17386_/A2 VSS VSS VSS VSS gf180mcu_fd_sc_mcu9t5v0__oai31_1
X_13609_ _13610_/A1 _13610_/A2 _13615_/A3 VSS _13609_/VNW VSS VSS gf180mcu_fd_sc_mcu9t5v0__nor2_1
X_16328_ _18229_/Q _16327_/Z _16854_/S _18229_/D VSS VSS VSS VSS gf180mcu_fd_sc_mcu9t5v0__mux2_4
XTAP_TAPCELL_ROW_194_3_8203 VSS VSS gf180mcu_fd_sc_mcu9t5v0__filltie
X_14589_ _19173_/Q _19139_/Q _14764_/A1 VSS VSS VSS VSS gf180mcu_fd_sc_mcu9t5v0__xnor2_1
X_19116_ _19116_/D _20140_/RN clkload30/I _19116_/Q VSS VSS VSS VSS gf180mcu_fd_sc_mcu9t5v0__dffrnq_1
X_16259_ _16259_/A1 _16420_/B _16260_/I1 VSS VSS VSS VSS gf180mcu_fd_sc_mcu9t5v0__nand2_1
X_19047_ _19047_/D _20071_/RN clkload34/I _19047_/Q VSS VSS VSS VSS gf180mcu_fd_sc_mcu9t5v0__dffrnq_1
XTAP_TAPCELL_ROW_19_1503 VSS VSS gf180mcu_fd_sc_mcu9t5v0__filltie
XTAP_TAPCELL_ROW_19_1514 VSS VSS gf180mcu_fd_sc_mcu9t5v0__filltie
XTAP_TAPCELL_ROW_321_7894 VSS VSS gf180mcu_fd_sc_mcu9t5v0__filltie
XTAP_TAPCELL_ROW_174_3_8134 VSS VSS gf180mcu_fd_sc_mcu9t5v0__filltie
Xclkbuf_leaf_72_clk_regs clkload0/I clkload26/I VSS _13338_/VNW VSS VSS gf180mcu_fd_sc_mcu9t5v0__clkbuf_8
X_19949_ _19949_/D _20141_/RN clkload66/I _19949_/Q VSS VSS VSS VSS gf180mcu_fd_sc_mcu9t5v0__dffrnq_1
X_09702_ _20013_/Q _15946_/A3 _15946_/A4 _17601_/A2 VSS _09702_/VNW VSS VSS gf180mcu_fd_sc_mcu9t5v0__nand3_1
XPHY_EDGE_ROW_146_2_Left_658 VSS VSS gf180mcu_fd_sc_mcu9t5v0__endcap
X_09633_ _17767_/A1 _09646_/A3 _15703_/A2 VSS _09661_/VNW VSS VSS gf180mcu_fd_sc_mcu9t5v0__nand2_1
X_09564_ _20004_/Q _20072_/Q _09565_/A3 VSS _15764_/VNW VSS VSS gf180mcu_fd_sc_mcu9t5v0__nor2_1
XTAP_TAPCELL_ROW_82_3250 VSS VSS gf180mcu_fd_sc_mcu9t5v0__filltie
XTAP_TAPCELL_ROW_121_4298 VSS VSS gf180mcu_fd_sc_mcu9t5v0__filltie
X_09495_ _18748_/Q _09495_/A2 _09518_/A1 VSS VSS VSS VSS gf180mcu_fd_sc_mcu9t5v0__nand2_1
XTAP_TAPCELL_ROW_95_3600 VSS VSS gf180mcu_fd_sc_mcu9t5v0__filltie
XTAP_TAPCELL_ROW_134_4659 VSS VSS gf180mcu_fd_sc_mcu9t5v0__filltie
XTAP_TAPCELL_ROW_76_3065 VSS VSS gf180mcu_fd_sc_mcu9t5v0__filltie
XTAP_TAPCELL_ROW_76_3076 VSS VSS gf180mcu_fd_sc_mcu9t5v0__filltie
X_10270_ _18154_/Q _17282_/A2 _17282_/B1 _18170_/Q _10271_/B VSS VSS VSS VSS gf180mcu_fd_sc_mcu9t5v0__aoi22_1
XTAP_TAPCELL_ROW_89_3437 VSS VSS gf180mcu_fd_sc_mcu9t5v0__filltie
XTAP_TAPCELL_ROW_89_3426 VSS VSS gf180mcu_fd_sc_mcu9t5v0__filltie
XTAP_TAPCELL_ROW_256_6119 VSS VSS gf180mcu_fd_sc_mcu9t5v0__filltie
XTAP_TAPCELL_ROW_256_6108 VSS VSS gf180mcu_fd_sc_mcu9t5v0__filltie
X_13960_ _13927_/Z _13960_/A2 _13960_/B _13978_/A1 VSS VSS VSS VSS gf180mcu_fd_sc_mcu9t5v0__oai21_1
X_12911_ _19775_/Q _12909_/Z _12918_/B VSS _12911_/VNW VSS VSS gf180mcu_fd_sc_mcu9t5v0__nand2_1
XTAP_TAPCELL_ROW_5_1112 VSS VSS gf180mcu_fd_sc_mcu9t5v0__filltie
XTAP_TAPCELL_ROW_5_1123 VSS VSS gf180mcu_fd_sc_mcu9t5v0__filltie
X_15630_ _10192_/I _15672_/B _15649_/A2 VSS _15639_/VNW VSS VSS gf180mcu_fd_sc_mcu9t5v0__nor2_1
X_13891_ _19293_/Q _19322_/Q _19323_/Q _13891_/B2 _13928_/A2 VSS _13891_/VNW VSS VSS
+ gf180mcu_fd_sc_mcu9t5v0__aoi22_1
X_12842_ _12842_/I0 _19211_/Q _13497_/B _19211_/D VSS VSS VSS VSS gf180mcu_fd_sc_mcu9t5v0__mux2_1
XTAP_TAPCELL_ROW_1_1009 VSS VSS gf180mcu_fd_sc_mcu9t5v0__filltie
X_15561_ _19874_/Q _15558_/Z _15561_/Z VSS VSS VSS VSS gf180mcu_fd_sc_mcu9t5v0__and2_1
X_12773_ _19755_/Q _12772_/Z _12783_/A1 VSS VSS VSS VSS gf180mcu_fd_sc_mcu9t5v0__nor2_1
XTAP_TAPCELL_ROW_65_2780 VSS VSS gf180mcu_fd_sc_mcu9t5v0__filltie
X_18280_ _18280_/D clkload81/I _18280_/Q VSS VSS VSS VSS gf180mcu_fd_sc_mcu9t5v0__dffq_4
X_17300_ _17358_/A1 _18387_/Q _17303_/A2 VSS VSS VSS VSS gf180mcu_fd_sc_mcu9t5v0__nor2_1
X_15492_ _19833_/Q wire300/Z _15502_/S _15492_/Z VSS _15532_/VNW VSS VSS gf180mcu_fd_sc_mcu9t5v0__mux2_1
XTAP_TAPCELL_ROW_232_5440 VSS VSS gf180mcu_fd_sc_mcu9t5v0__filltie
X_11724_ _18891_/Q _18892_/Q _18893_/Q _11724_/Z VSS _11724_/VNW VSS VSS gf180mcu_fd_sc_mcu9t5v0__or3_1
XTAP_TAPCELL_ROW_61_2655 VSS VSS gf180mcu_fd_sc_mcu9t5v0__filltie
X_14512_ _19164_/Q _14512_/A2 _14513_/B VSS VSS VSS VSS gf180mcu_fd_sc_mcu9t5v0__or2_1
X_17231_ _17779_/A1 _19816_/Q _17231_/A3 _17231_/B _17412_/A1 VSS VSS VSS VSS gf180mcu_fd_sc_mcu9t5v0__oai31_4
XTAP_TAPCELL_ROW_232_5462 VSS VSS gf180mcu_fd_sc_mcu9t5v0__filltie
XTAP_TAPCELL_ROW_232_5451 VSS VSS gf180mcu_fd_sc_mcu9t5v0__filltie
X_11655_ _12720_/S _11655_/A2 _11661_/A2 VSS VSS VSS VSS gf180mcu_fd_sc_mcu9t5v0__nor2_1
X_14443_ _14439_/Z _14444_/A2 _14443_/Z VSS _14702_/VNW VSS VSS gf180mcu_fd_sc_mcu9t5v0__or2_1
XTAP_TAPCELL_ROW_61_2666 VSS VSS gf180mcu_fd_sc_mcu9t5v0__filltie
X_17162_ _19859_/Q _17161_/C _17162_/B _17164_/A3 VSS VSS VSS VSS gf180mcu_fd_sc_mcu9t5v0__oai21_1
X_10606_ _17358_/A1 _18263_/Q _10609_/A2 VSS _10606_/VNW VSS VSS gf180mcu_fd_sc_mcu9t5v0__nor2_1
XTAP_TAPCELL_ROW_180_3_8155 VSS VSS gf180mcu_fd_sc_mcu9t5v0__filltie
XTAP_TAPCELL_ROW_179_3_8149 VSS VSS gf180mcu_fd_sc_mcu9t5v0__filltie
X_14374_ _14374_/A1 _14374_/A2 _19441_/D VSS VSS VSS VSS gf180mcu_fd_sc_mcu9t5v0__nand2_1
X_11586_ _17902_/A1 _11583_/Z _11587_/A2 _11586_/Z VSS VSS VSS VSS gf180mcu_fd_sc_mcu9t5v0__or3_1
X_10537_ _10514_/B _10536_/Z _10539_/B1 VSS _11084_/VNW VSS VSS gf180mcu_fd_sc_mcu9t5v0__nand2_1
X_16113_ _16700_/A2 _16714_/A3 _16695_/B _16688_/A1 VSS _16594_/VNW VSS VSS gf180mcu_fd_sc_mcu9t5v0__oai21_1
XTAP_TAPCELL_ROW_245_5812 VSS VSS gf180mcu_fd_sc_mcu9t5v0__filltie
X_17093_ _17409_/B _17093_/A2 _17094_/C VSS VSS VSS VSS gf180mcu_fd_sc_mcu9t5v0__nand2_1
XTAP_TAPCELL_ROW_245_5801 VSS VSS gf180mcu_fd_sc_mcu9t5v0__filltie
X_13325_ _19771_/Q _13325_/A2 _13325_/B1 _13325_/B2 _13327_/A3 VSS VSS VSS VSS gf180mcu_fd_sc_mcu9t5v0__oai22_1
X_10468_ _10468_/A1 _10468_/A2 _17306_/C _10469_/B VSS VSS VSS VSS gf180mcu_fd_sc_mcu9t5v0__aoi21_1
X_16044_ _19234_/Q _16700_/A2 wire71/Z _16046_/A3 VSS VSS VSS VSS gf180mcu_fd_sc_mcu9t5v0__nor3_4
X_13256_ _13256_/A1 _13255_/B _13259_/A2 VSS _13256_/VNW VSS VSS gf180mcu_fd_sc_mcu9t5v0__xnor2_1
XTAP_TAPCELL_ROW_59_2595 VSS VSS gf180mcu_fd_sc_mcu9t5v0__filltie
X_12207_ _12159_/B _12207_/A2 _12207_/A3 _12208_/B VSS _12209_/VNW VSS VSS gf180mcu_fd_sc_mcu9t5v0__nand3_1
XTAP_TAPCELL_ROW_241_5709 VSS VSS gf180mcu_fd_sc_mcu9t5v0__filltie
XTAP_TAPCELL_ROW_226_5299 VSS VSS gf180mcu_fd_sc_mcu9t5v0__filltie
X_10399_ _18207_/Q _18191_/Q _17404_/S _10399_/Z VSS _18137_/VNW VSS VSS gf180mcu_fd_sc_mcu9t5v0__mux2_1
XTAP_TAPCELL_ROW_226_5288 VSS VSS gf180mcu_fd_sc_mcu9t5v0__filltie
XTAP_TAPCELL_ROW_226_5277 VSS VSS gf180mcu_fd_sc_mcu9t5v0__filltie
X_13187_ _13198_/A2 _19797_/Q _13203_/A2 VSS VSS VSS VSS gf180mcu_fd_sc_mcu9t5v0__nand2_1
X_12138_ _18478_/Q _12315_/S _12208_/C _12139_/A2 VSS _12157_/VNW VSS VSS gf180mcu_fd_sc_mcu9t5v0__aoi21_1
X_17995_ _18881_/Q _18028_/I0 _17997_/S _18881_/D VSS VSS VSS VSS gf180mcu_fd_sc_mcu9t5v0__mux2_1
X_19803_ _19803_/D _20059_/RN clkload10/I _19803_/Q VSS VSS VSS VSS gf180mcu_fd_sc_mcu9t5v0__dffrnq_1
X_16946_ _16945_/Z _18464_/Q _16960_/S _18464_/D VSS VSS VSS VSS gf180mcu_fd_sc_mcu9t5v0__mux2_4
X_12069_ _12208_/C _12069_/A2 _12069_/A3 _12261_/B _12070_/B2 VSS VSS VSS VSS gf180mcu_fd_sc_mcu9t5v0__oai31_1
X_19734_ _19734_/D _20054_/RN clkload22/I _19734_/Q VSS VSS VSS VSS gf180mcu_fd_sc_mcu9t5v0__dffrnq_1
XTAP_TAPCELL_ROW_239_5638 VSS VSS gf180mcu_fd_sc_mcu9t5v0__filltie
X_19665_ _19665_/D _20049_/RN clkload42/I _19665_/Q VSS VSS VSS VSS gf180mcu_fd_sc_mcu9t5v0__dffrnq_1
X_16877_ _19250_/Q _16614_/B _16881_/S _16877_/Z VSS VSS VSS VSS gf180mcu_fd_sc_mcu9t5v0__mux2_4
X_18616_ _18616_/D clkload76/I _18616_/Q VSS VSS VSS VSS gf180mcu_fd_sc_mcu9t5v0__dffq_1
XTAP_TAPCELL_ROW_239_5649 VSS VSS gf180mcu_fd_sc_mcu9t5v0__filltie
X_15828_ _15827_/B _15834_/B2 _15828_/B _19992_/D VSS VSS VSS VSS gf180mcu_fd_sc_mcu9t5v0__aoi21_1
X_19596_ _19596_/D _20044_/RN clkload18/I _19596_/Q VSS VSS VSS VSS gf180mcu_fd_sc_mcu9t5v0__dffrnq_1
X_18547_ _18547_/D _20047_/RN clkload75/I _18547_/Q VSS VSS VSS VSS gf180mcu_fd_sc_mcu9t5v0__dffrnq_4
X_15759_ _15759_/A1 _15685_/I _15759_/A3 _15760_/A2 VSS VSS VSS VSS gf180mcu_fd_sc_mcu9t5v0__nand3_1
X_18478_ _18478_/D clkload62/I _18478_/Q VSS VSS VSS VSS gf180mcu_fd_sc_mcu9t5v0__dffq_1
X_09280_ _20017_/Q _09740_/A1 VSS _17617_/VNW VSS VSS gf180mcu_fd_sc_mcu9t5v0__clkinv_1
XTAP_TAPCELL_ROW_310_7595 VSS VSS gf180mcu_fd_sc_mcu9t5v0__filltie
XTAP_TAPCELL_ROW_310_7584 VSS VSS gf180mcu_fd_sc_mcu9t5v0__filltie
X_17429_ _17429_/A1 _17429_/A2 _18563_/D VSS VSS VSS VSS gf180mcu_fd_sc_mcu9t5v0__nand2_1
XTAP_TAPCELL_ROW_215_4981 VSS VSS gf180mcu_fd_sc_mcu9t5v0__filltie
XTAP_TAPCELL_ROW_215_4970 VSS VSS gf180mcu_fd_sc_mcu9t5v0__filltie
XTAP_TAPCELL_ROW_215_4992 VSS VSS gf180mcu_fd_sc_mcu9t5v0__filltie
XTAP_TAPCELL_ROW_323_7945 VSS VSS gf180mcu_fd_sc_mcu9t5v0__filltie
XTAP_TAPCELL_ROW_211_4878 VSS VSS gf180mcu_fd_sc_mcu9t5v0__filltie
XTAP_TAPCELL_ROW_211_4867 VSS VSS gf180mcu_fd_sc_mcu9t5v0__filltie
XTAP_TAPCELL_ROW_323_7989 VSS VSS gf180mcu_fd_sc_mcu9t5v0__filltie
XTAP_TAPCELL_ROW_323_7978 VSS VSS gf180mcu_fd_sc_mcu9t5v0__filltie
XTAP_TAPCELL_ROW_323_7967 VSS VSS gf180mcu_fd_sc_mcu9t5v0__filltie
XTAP_TAPCELL_ROW_323_7956 VSS VSS gf180mcu_fd_sc_mcu9t5v0__filltie
Xclkload61 clkload61/I clkload61/ZN VSS VSS VSS VSS gf180mcu_fd_sc_mcu9t5v0__inv_4
Xclkload50 clkload50/I clkload50/ZN VSS VSS VSS VSS gf180mcu_fd_sc_mcu9t5v0__clkinv_1
Xclkload72 clkload72/I clkload72/ZN VSS VSS VSS VSS gf180mcu_fd_sc_mcu9t5v0__inv_4
XTAP_TAPCELL_ROW_209_4796 VSS VSS gf180mcu_fd_sc_mcu9t5v0__filltie
XTAP_TAPCELL_ROW_209_4785 VSS VSS gf180mcu_fd_sc_mcu9t5v0__filltie
XTAP_TAPCELL_ROW_127_4463 VSS VSS gf180mcu_fd_sc_mcu9t5v0__filltie
XTAP_TAPCELL_ROW_127_4485 VSS VSS gf180mcu_fd_sc_mcu9t5v0__filltie
XTAP_TAPCELL_ROW_84_3301 VSS VSS gf180mcu_fd_sc_mcu9t5v0__filltie
XTAP_TAPCELL_ROW_127_4474 VSS VSS gf180mcu_fd_sc_mcu9t5v0__filltie
X_09616_ _10843_/A1 _09616_/A2 _09617_/A2 VSS _17736_/VNW VSS VSS gf180mcu_fd_sc_mcu9t5v0__nor2_1
X_09547_ _09700_/A1 _09547_/A2 _09547_/B _09547_/C output10/I VSS VSS VSS VSS gf180mcu_fd_sc_mcu9t5v0__oai211_1
XTAP_TAPCELL_ROW_78_3116 VSS VSS gf180mcu_fd_sc_mcu9t5v0__filltie
X_09478_ _17888_/B _18857_/Q _12686_/C VSS _12771_/VNW VSS VSS gf180mcu_fd_sc_mcu9t5v0__and2_1
XTAP_TAPCELL_ROW_78_3138 VSS VSS gf180mcu_fd_sc_mcu9t5v0__filltie
XTAP_TAPCELL_ROW_78_3127 VSS VSS gf180mcu_fd_sc_mcu9t5v0__filltie
X_11440_ _18465_/Q _11524_/S _11520_/B _11442_/A2 VSS _12208_/VNW VSS VSS gf180mcu_fd_sc_mcu9t5v0__oai21_1
Xclkload0 clkload0/I clkload0/ZN VSS VSS VSS VSS gf180mcu_fd_sc_mcu9t5v0__clkinv_16
X_11371_ _18444_/Q _11385_/A2 _11373_/A1 VSS _17146_/VNW VSS VSS gf180mcu_fd_sc_mcu9t5v0__nor2_1
X_10322_ _17195_/A1 _18188_/Q _10325_/A2 VSS _17060_/VNW VSS VSS gf180mcu_fd_sc_mcu9t5v0__nor2_1
XPHY_EDGE_ROW_138_1_Left_461 VSS VSS gf180mcu_fd_sc_mcu9t5v0__endcap
X_13110_ _13145_/B1 _13109_/I _13111_/A2 VSS VSS VSS VSS gf180mcu_fd_sc_mcu9t5v0__xnor2_1
X_14090_ _14090_/A1 _14088_/Z _14090_/Z VSS _14090_/VNW VSS VSS gf180mcu_fd_sc_mcu9t5v0__xor2_1
X_13041_ _13061_/A1 _13041_/A2 _13049_/B1 VSS _13041_/VNW VSS VSS gf180mcu_fd_sc_mcu9t5v0__nand2_1
X_10253_ _18939_/Q wire166/Z _10258_/A1 VSS _16258_/VNW VSS VSS gf180mcu_fd_sc_mcu9t5v0__nand2_1
Xload_slew109 _15148_/S _15163_/S VSS VSS VSS VSS gf180mcu_fd_sc_mcu9t5v0__clkbuf_16
X_10184_ _20036_/Q _20037_/Q _14323_/A2 VSS _10185_/VNW VSS VSS gf180mcu_fd_sc_mcu9t5v0__nor2_1
XTAP_TAPCELL_ROW_54_2470 VSS VSS gf180mcu_fd_sc_mcu9t5v0__filltie
XTAP_TAPCELL_ROW_54_2481 VSS VSS gf180mcu_fd_sc_mcu9t5v0__filltie
X_16800_ _18398_/Q _16799_/Z _16818_/S _18398_/D VSS VSS VSS VSS gf180mcu_fd_sc_mcu9t5v0__mux2_4
XTAP_TAPCELL_ROW_221_5152 VSS VSS gf180mcu_fd_sc_mcu9t5v0__filltie
X_17780_ _17780_/A1 _17780_/A2 _18769_/D _17781_/A2 VSS VSS VSS VSS gf180mcu_fd_sc_mcu9t5v0__oai21_1
XTAP_TAPCELL_ROW_221_5141 VSS VSS gf180mcu_fd_sc_mcu9t5v0__filltie
XTAP_TAPCELL_ROW_50_2345 VSS VSS gf180mcu_fd_sc_mcu9t5v0__filltie
XTAP_TAPCELL_ROW_50_2356 VSS VSS gf180mcu_fd_sc_mcu9t5v0__filltie
XTAP_TAPCELL_ROW_50_2367 VSS VSS gf180mcu_fd_sc_mcu9t5v0__filltie
X_16731_ _19287_/Q _16695_/B _16732_/A3 VSS VSS VSS VSS gf180mcu_fd_sc_mcu9t5v0__nor2_1
X_14992_ _14992_/A1 _14992_/A2 _14992_/B _14996_/A1 VSS VSS VSS VSS gf180mcu_fd_sc_mcu9t5v0__oai21_1
X_13943_ _13944_/A1 _13942_/Z _13984_/A2 VSS VSS VSS VSS gf180mcu_fd_sc_mcu9t5v0__nand2_1
XTAP_TAPCELL_ROW_67_2820 VSS VSS gf180mcu_fd_sc_mcu9t5v0__filltie
XTAP_TAPCELL_ROW_67_2831 VSS VSS gf180mcu_fd_sc_mcu9t5v0__filltie
Xload_slew56 _16863_/S _16861_/S VSS VSS VSS VSS gf180mcu_fd_sc_mcu9t5v0__clkbuf_8
X_16662_ _16675_/A1 _16662_/A2 _16662_/A3 _16662_/B _16663_/I1 VSS VSS VSS VSS gf180mcu_fd_sc_mcu9t5v0__oai31_1
X_13874_ _19316_/Q _19299_/Q _13876_/A2 VSS _13876_/VNW VSS VSS gf180mcu_fd_sc_mcu9t5v0__nand2_1
XTAP_TAPCELL_ROW_63_2706 VSS VSS gf180mcu_fd_sc_mcu9t5v0__filltie
X_19450_ _19450_/D _20026_/RN clkload32/I _19450_/Q VSS VSS VSS VSS gf180mcu_fd_sc_mcu9t5v0__dffrnq_1
X_18401_ _18401_/D clkload73/I _18401_/Q VSS VSS VSS VSS gf180mcu_fd_sc_mcu9t5v0__dffq_4
X_16593_ _19247_/Q _16700_/A2 wire71/I _16594_/A3 VSS VSS VSS VSS gf180mcu_fd_sc_mcu9t5v0__nor3_1
XTAP_TAPCELL_ROW_234_5513 VSS VSS gf180mcu_fd_sc_mcu9t5v0__filltie
XTAP_TAPCELL_ROW_234_5502 VSS VSS gf180mcu_fd_sc_mcu9t5v0__filltie
X_15613_ _15677_/B _15612_/Z _19889_/D VSS VSS VSS VSS gf180mcu_fd_sc_mcu9t5v0__nand2_1
X_12825_ _19208_/Q _13419_/B _12826_/B VSS _13167_/VNW VSS VSS gf180mcu_fd_sc_mcu9t5v0__nand2_1
X_19381_ _19381_/D _20021_/RN _19633_/CLK _19381_/Q VSS VSS VSS VSS gf180mcu_fd_sc_mcu9t5v0__dffrnq_1
XTAP_TAPCELL_ROW_63_2717 VSS VSS gf180mcu_fd_sc_mcu9t5v0__filltie
XTAP_TAPCELL_ROW_63_2728 VSS VSS gf180mcu_fd_sc_mcu9t5v0__filltie
XTAP_TAPCELL_ROW_219_5092 VSS VSS gf180mcu_fd_sc_mcu9t5v0__filltie
X_15544_ _19862_/Q input7/Z _15544_/S _19862_/D VSS VSS VSS VSS gf180mcu_fd_sc_mcu9t5v0__mux2_1
X_18332_ _18332_/D clkload52/I _18332_/Q VSS VSS VSS VSS gf180mcu_fd_sc_mcu9t5v0__dffq_1
XTAP_TAPCELL_ROW_219_5081 VSS VSS gf180mcu_fd_sc_mcu9t5v0__filltie
XTAP_TAPCELL_ROW_48_2296 VSS VSS gf180mcu_fd_sc_mcu9t5v0__filltie
X_12756_ _19753_/Q _12754_/Z _12762_/A2 VSS _12756_/VNW VSS VSS gf180mcu_fd_sc_mcu9t5v0__xnor2_1
X_11707_ _18171_/Q _18155_/Q _12046_/S _11707_/Z VSS VSS VSS VSS gf180mcu_fd_sc_mcu9t5v0__mux2_1
X_15475_ _19874_/Q _19876_/Q _19875_/Q _15476_/A2 VSS VSS VSS VSS gf180mcu_fd_sc_mcu9t5v0__nand3_1
X_18263_ _18263_/D clkload69/I _18263_/Q VSS VSS VSS VSS gf180mcu_fd_sc_mcu9t5v0__dffq_1
X_12687_ _19182_/Q _12655_/S _12688_/B VSS _14166_/VNW VSS VSS gf180mcu_fd_sc_mcu9t5v0__nand2_1
X_18194_ _18194_/D clkload80/I _18194_/Q VSS VSS VSS VSS gf180mcu_fd_sc_mcu9t5v0__dffq_1
X_17214_ _18431_/Q _17282_/B1 _17220_/B1 VSS VSS VSS VSS gf180mcu_fd_sc_mcu9t5v0__nand2_1
X_11638_ _11656_/A1 _11639_/A2 _12632_/B VSS VSS VSS VSS gf180mcu_fd_sc_mcu9t5v0__nor2_1
X_14426_ _14426_/A1 _14426_/A2 _19452_/D VSS VSS VSS VSS gf180mcu_fd_sc_mcu9t5v0__nand2_1
X_17145_ _18460_/Q _18444_/Q _17260_/S _17145_/Z VSS VSS VSS VSS gf180mcu_fd_sc_mcu9t5v0__mux2_1
X_14357_ _14357_/I0 _19427_/Q _14367_/S _19427_/D VSS VSS VSS VSS gf180mcu_fd_sc_mcu9t5v0__mux2_1
X_11569_ _18233_/Q _12181_/A2 _11573_/A1 VSS VSS VSS VSS gf180mcu_fd_sc_mcu9t5v0__nand2_1
XTAP_TAPCELL_ROW_228_5339 VSS VSS gf180mcu_fd_sc_mcu9t5v0__filltie
XTAP_TAPCELL_ROW_228_5328 VSS VSS gf180mcu_fd_sc_mcu9t5v0__filltie
X_13308_ _19771_/Q _19805_/Q _13308_/A3 _13309_/I VSS VSS VSS VSS gf180mcu_fd_sc_mcu9t5v0__xnor3_1
X_17076_ _09065_/I _10648_/C _10821_/B _17095_/A2 VSS VSS VSS VSS gf180mcu_fd_sc_mcu9t5v0__nand3_1
Xdelaybuf_0_core_clk clk delaybuf_1_core_clk/I VSS VSS VSS VSS gf180mcu_fd_sc_mcu9t5v0__clkbuf_16
X_14288_ _14355_/I0 _19361_/Q _14304_/S _19361_/D VSS VSS VSS VSS gf180mcu_fd_sc_mcu9t5v0__mux2_1
X_16027_ _19264_/Q _15996_/B _16032_/B VSS VSS VSS VSS gf180mcu_fd_sc_mcu9t5v0__nand2_1
X_13239_ _13245_/A1 _13238_/Z _13239_/Z VSS _13243_/VNW VSS VSS gf180mcu_fd_sc_mcu9t5v0__and2_1
XPHY_EDGE_ROW_29_Left_353 VSS VSS gf180mcu_fd_sc_mcu9t5v0__endcap
XPHY_EDGE_ROW_127_Right_127 VSS VSS gf180mcu_fd_sc_mcu9t5v0__endcap
X_17978_ _18865_/Q _18028_/I0 _17978_/S _18865_/D VSS _17978_/VNW VSS VSS gf180mcu_fd_sc_mcu9t5v0__mux2_1
XTAP_TAPCELL_ROW_291_7086 VSS VSS gf180mcu_fd_sc_mcu9t5v0__filltie
XTAP_TAPCELL_ROW_316_7760 VSS VSS gf180mcu_fd_sc_mcu9t5v0__filltie
XTAP_TAPCELL_ROW_291_7075 VSS VSS gf180mcu_fd_sc_mcu9t5v0__filltie
XTAP_TAPCELL_ROW_291_7064 VSS VSS gf180mcu_fd_sc_mcu9t5v0__filltie
X_16929_ _19244_/Q _16932_/A2 _16930_/B VSS VSS VSS VSS gf180mcu_fd_sc_mcu9t5v0__nand2_1
XTAP_TAPCELL_ROW_33_1886 VSS VSS gf180mcu_fd_sc_mcu9t5v0__filltie
XTAP_TAPCELL_ROW_33_1897 VSS VSS gf180mcu_fd_sc_mcu9t5v0__filltie
X_19717_ _19717_/D _20037_/RN clkload16/I _19717_/Q VSS VSS VSS VSS gf180mcu_fd_sc_mcu9t5v0__dffrnq_1
XTAP_TAPCELL_ROW_316_7771 VSS VSS gf180mcu_fd_sc_mcu9t5v0__filltie
X_19648_ _19648_/D _09246_/I clkload9/I _19648_/Q VSS VSS VSS VSS gf180mcu_fd_sc_mcu9t5v0__dffrnq_1
XTAP_TAPCELL_ROW_312_7657 VSS VSS gf180mcu_fd_sc_mcu9t5v0__filltie
XTAP_TAPCELL_ROW_312_7646 VSS VSS gf180mcu_fd_sc_mcu9t5v0__filltie
X_09401_ _09878_/A1 _09399_/Z _09413_/A2 VSS VSS VSS VSS gf180mcu_fd_sc_mcu9t5v0__nor2_4
X_19579_ _19579_/D _19963_/RN clkload16/I _19579_/Q VSS VSS VSS VSS gf180mcu_fd_sc_mcu9t5v0__dffrnq_1
X_09332_ _19209_/Q _18130_/A1 VSS VSS VSS VSS gf180mcu_fd_sc_mcu9t5v0__clkinv_1
XTAP_TAPCELL_ROW_135_4732 VSS VSS gf180mcu_fd_sc_mcu9t5v0__filltie
XTAP_TAPCELL_ROW_135_4721 VSS VSS gf180mcu_fd_sc_mcu9t5v0__filltie
XTAP_TAPCELL_ROW_135_4710 VSS VSS gf180mcu_fd_sc_mcu9t5v0__filltie
XPHY_EDGE_ROW_38_Left_362 VSS VSS gf180mcu_fd_sc_mcu9t5v0__endcap
X_09263_ _19827_/Q _17401_/C VSS VSS VSS VSS gf180mcu_fd_sc_mcu9t5v0__clkinv_1
XTAP_TAPCELL_ROW_213_4929 VSS VSS gf180mcu_fd_sc_mcu9t5v0__filltie
XTAP_TAPCELL_ROW_213_4918 VSS VSS gf180mcu_fd_sc_mcu9t5v0__filltie
XTAP_TAPCELL_ROW_116_4186 VSS VSS gf180mcu_fd_sc_mcu9t5v0__filltie
XTAP_TAPCELL_ROW_116_4175 VSS VSS gf180mcu_fd_sc_mcu9t5v0__filltie
XTAP_TAPCELL_ROW_116_4164 VSS VSS gf180mcu_fd_sc_mcu9t5v0__filltie
X_09194_ _19166_/Q _14530_/A1 VSS VSS VSS VSS gf180mcu_fd_sc_mcu9t5v0__clkinv_1
XTAP_TAPCELL_ROW_73_3002 VSS VSS gf180mcu_fd_sc_mcu9t5v0__filltie
XTAP_TAPCELL_ROW_129_4525 VSS VSS gf180mcu_fd_sc_mcu9t5v0__filltie
XTAP_TAPCELL_ROW_129_4536 VSS VSS gf180mcu_fd_sc_mcu9t5v0__filltie
XPHY_EDGE_ROW_47_Left_371 VSS VSS gf180mcu_fd_sc_mcu9t5v0__endcap
XPHY_EDGE_ROW_191_3_Left_849 VSS VSS gf180mcu_fd_sc_mcu9t5v0__endcap
X_10940_ _18928_/Q _18935_/Q _10940_/B _10941_/I VSS _10969_/VNW VSS VSS gf180mcu_fd_sc_mcu9t5v0__oai21_1
XTAP_TAPCELL_ROW_274_6594 VSS VSS gf180mcu_fd_sc_mcu9t5v0__filltie
X_10871_ _19238_/Q _19232_/Q _18117_/S _10871_/Z VSS _10872_/VNW VSS VSS gf180mcu_fd_sc_mcu9t5v0__mux2_1
XTAP_TAPCELL_ROW_101_3765 VSS VSS gf180mcu_fd_sc_mcu9t5v0__filltie
X_12610_ wire175/Z wire119/Z _12618_/B _12612_/A3 VSS _12610_/VNW VSS VSS gf180mcu_fd_sc_mcu9t5v0__aoi21_1
XTAP_TAPCELL_ROW_0_960 VSS VSS gf180mcu_fd_sc_mcu9t5v0__filltie
XPHY_EDGE_ROW_56_Left_380 VSS VSS gf180mcu_fd_sc_mcu9t5v0__endcap
XTAP_TAPCELL_ROW_0_971 VSS VSS gf180mcu_fd_sc_mcu9t5v0__filltie
XTAP_TAPCELL_ROW_0_982 VSS VSS gf180mcu_fd_sc_mcu9t5v0__filltie
XTAP_TAPCELL_ROW_101_3754 VSS VSS gf180mcu_fd_sc_mcu9t5v0__filltie
X_13590_ _13275_/Z _13590_/A2 _13590_/B _13595_/A3 VSS VSS VSS VSS gf180mcu_fd_sc_mcu9t5v0__oai21_1
XTAP_TAPCELL_ROW_0_993 VSS VSS gf180mcu_fd_sc_mcu9t5v0__filltie
X_12541_ _18495_/Q _12383_/S _12541_/B _12542_/B2 VSS VSS VSS VSS gf180mcu_fd_sc_mcu9t5v0__oai21_1
XTAP_TAPCELL_ROW_287_6955 VSS VSS gf180mcu_fd_sc_mcu9t5v0__filltie
XTAP_TAPCELL_ROW_43_2160 VSS VSS gf180mcu_fd_sc_mcu9t5v0__filltie
XTAP_TAPCELL_ROW_43_2171 VSS VSS gf180mcu_fd_sc_mcu9t5v0__filltie
XTAP_TAPCELL_ROW_287_6966 VSS VSS gf180mcu_fd_sc_mcu9t5v0__filltie
X_12472_ _18263_/Q _12615_/A2 _12474_/B1 VSS VSS VSS VSS gf180mcu_fd_sc_mcu9t5v0__nor2_1
X_15260_ _15260_/A1 _15259_/B _15260_/A3 _15263_/B VSS VSS VSS VSS gf180mcu_fd_sc_mcu9t5v0__and3_1
X_11423_ _11423_/A1 _11423_/A2 _11423_/A3 _11423_/B _19096_/D VSS VSS VSS VSS gf180mcu_fd_sc_mcu9t5v0__oai31_1
X_14211_ _14211_/I _14213_/A2 VSS VSS VSS VSS gf180mcu_fd_sc_mcu9t5v0__clkinv_1
XANTENNA_9 _11185_/A3 VSS VSS VSS VSS gf180mcu_fd_sc_mcu9t5v0__antenna
XTAP_TAPCELL_ROW_56_2510 VSS VSS gf180mcu_fd_sc_mcu9t5v0__filltie
XTAP_TAPCELL_ROW_56_2521 VSS VSS gf180mcu_fd_sc_mcu9t5v0__filltie
X_15191_ _15417_/S _15191_/A2 _15191_/B _19718_/D VSS VSS VSS VSS gf180mcu_fd_sc_mcu9t5v0__oai21_1
X_11354_ _11423_/A1 _11354_/A2 _11354_/A3 _11354_/B _19091_/D VSS VSS VSS VSS gf180mcu_fd_sc_mcu9t5v0__oai31_1
X_14142_ _19474_/Q _19482_/Q _14165_/S _14142_/Z VSS VSS VSS VSS gf180mcu_fd_sc_mcu9t5v0__mux2_1
XTAP_TAPCELL_ROW_56_2532 VSS VSS gf180mcu_fd_sc_mcu9t5v0__filltie
X_10305_ _18589_/Q _17409_/B _17225_/B _10305_/C _10306_/A3 VSS VSS VSS VSS gf180mcu_fd_sc_mcu9t5v0__oai211_1
XTAP_TAPCELL_ROW_223_5214 VSS VSS gf180mcu_fd_sc_mcu9t5v0__filltie
X_11285_ _16288_/A1 _11534_/S _11537_/S _11285_/C _11286_/C VSS _11286_/VNW VSS VSS
+ gf180mcu_fd_sc_mcu9t5v0__oai211_1
XTAP_TAPCELL_ROW_223_5203 VSS VSS gf180mcu_fd_sc_mcu9t5v0__filltie
X_18950_ _18950_/D _20038_/RN clkload68/I _18950_/Q VSS VSS VSS VSS gf180mcu_fd_sc_mcu9t5v0__dffrnq_1
X_14073_ _13994_/B _14133_/A2 _14074_/I VSS _14092_/VNW VSS VSS gf180mcu_fd_sc_mcu9t5v0__xnor2_1
XTAP_TAPCELL_ROW_52_2407 VSS VSS gf180mcu_fd_sc_mcu9t5v0__filltie
XTAP_TAPCELL_ROW_52_2418 VSS VSS gf180mcu_fd_sc_mcu9t5v0__filltie
X_10236_ _10237_/A1 _10745_/A2 _17408_/B VSS VSS VSS VSS gf180mcu_fd_sc_mcu9t5v0__and2_2
X_18881_ _18881_/D _20033_/RN _20054_/CLK _18881_/Q VSS VSS VSS VSS gf180mcu_fd_sc_mcu9t5v0__dffrnq_1
X_17901_ _18838_/Q _17901_/A2 _17902_/B VSS _17901_/VNW VSS VSS gf180mcu_fd_sc_mcu9t5v0__nand2_1
X_13024_ _13024_/A1 _13024_/A2 _13031_/B1 VSS VSS VSS VSS gf180mcu_fd_sc_mcu9t5v0__nand2_1
X_17832_ _19039_/Q _18809_/Q _17844_/S _18809_/D VSS VSS VSS VSS gf180mcu_fd_sc_mcu9t5v0__mux2_1
X_10167_ _10167_/A1 _10167_/A2 _10176_/B VSS _10167_/VNW VSS VSS gf180mcu_fd_sc_mcu9t5v0__nand2_1
X_10098_ _18999_/Q wire285/Z _09998_/C _18975_/Q _10133_/B1 _19014_/Q _10103_/A1 VSS
+ _10099_/VNW VSS VSS gf180mcu_fd_sc_mcu9t5v0__aoi222_1
X_17763_ _18756_/Q _17763_/A2 _17763_/A3 _17773_/A2 VSS VSS VSS VSS gf180mcu_fd_sc_mcu9t5v0__nor3_1
X_14975_ _20039_/D _14975_/A2 _14975_/B _19617_/D VSS VSS VSS VSS gf180mcu_fd_sc_mcu9t5v0__aoi21_1
X_16714_ _16714_/A1 _16744_/A2 _16714_/A3 _16715_/B VSS _16714_/VNW VSS VSS gf180mcu_fd_sc_mcu9t5v0__nor3_1
X_17694_ _18725_/Q _17742_/S _17743_/B _18649_/Q _17694_/C _17695_/I VSS VSS VSS VSS
+ gf180mcu_fd_sc_mcu9t5v0__aoi221_1
X_19502_ _19502_/D _20142_/RN clkload42/I _19502_/Q VSS VSS VSS VSS gf180mcu_fd_sc_mcu9t5v0__dffrnq_1
X_13926_ _19318_/Q _19298_/Q _13925_/Z _13956_/B VSS _13961_/VNW VSS VSS gf180mcu_fd_sc_mcu9t5v0__nand3_1
X_16645_ _16645_/A1 _16042_/S _16672_/B _16647_/B VSS VSS VSS VSS gf180mcu_fd_sc_mcu9t5v0__oai21_2
XTAP_TAPCELL_ROW_217_5029 VSS VSS gf180mcu_fd_sc_mcu9t5v0__filltie
XTAP_TAPCELL_ROW_167_3_8109 VSS VSS gf180mcu_fd_sc_mcu9t5v0__filltie
X_19433_ _19433_/D _20073_/RN clkload9/I _19433_/Q VSS VSS VSS VSS gf180mcu_fd_sc_mcu9t5v0__dffrnq_1
X_13857_ _13896_/A1 _13896_/A2 _13897_/A1 VSS _15227_/VNW VSS VSS gf180mcu_fd_sc_mcu9t5v0__nand2_1
X_16576_ _16750_/A1 _16628_/A2 _16576_/B _16578_/A2 VSS VSS VSS VSS gf180mcu_fd_sc_mcu9t5v0__aoi21_1
X_12808_ _19760_/Q _12806_/Z _12809_/I VSS _12811_/VNW VSS VSS gf180mcu_fd_sc_mcu9t5v0__xnor2_1
X_13788_ _19316_/Q _19295_/Q _19317_/Q _19296_/Q _13788_/Z VSS VSS VSS VSS gf180mcu_fd_sc_mcu9t5v0__and4_1
X_19364_ _19364_/D _20068_/RN clkload7/I _19364_/Q VSS VSS VSS VSS gf180mcu_fd_sc_mcu9t5v0__dffrnq_1
X_18315_ _18315_/D _18315_/CLK _18315_/Q VSS VSS VSS VSS gf180mcu_fd_sc_mcu9t5v0__dffq_4
X_15527_ _15566_/A1 _15527_/A2 _15526_/Z _19846_/D VSS VSS VSS VSS gf180mcu_fd_sc_mcu9t5v0__nor3_1
X_19295_ _19295_/D _20063_/RN clkload15/I _19295_/Q VSS VSS VSS VSS gf180mcu_fd_sc_mcu9t5v0__dffrnq_1
X_12739_ _12739_/I0 _19196_/Q _13304_/B _19196_/D VSS VSS VSS VSS gf180mcu_fd_sc_mcu9t5v0__mux2_1
X_15458_ _19822_/Q _15437_/Z _15459_/A3 VSS VSS VSS VSS gf180mcu_fd_sc_mcu9t5v0__nor2_1
X_18246_ _18246_/D clkload81/I _18246_/Q VSS VSS VSS VSS gf180mcu_fd_sc_mcu9t5v0__dffq_1
XTAP_TAPCELL_ROW_26_1690 VSS VSS gf180mcu_fd_sc_mcu9t5v0__filltie
X_14409_ _19152_/Q _19118_/Q _14692_/A1 VSS _14410_/VNW VSS VSS gf180mcu_fd_sc_mcu9t5v0__nand2_1
XPHY_EDGE_ROW_245_Right_172 VSS VSS gf180mcu_fd_sc_mcu9t5v0__endcap
X_18177_ _18177_/D clkload82/I _18177_/Q VSS VSS VSS VSS gf180mcu_fd_sc_mcu9t5v0__dffq_4
XPHY_EDGE_ROW_155_2_Left_667 VSS VSS gf180mcu_fd_sc_mcu9t5v0__endcap
X_15389_ _19674_/Q _19774_/Q _15420_/S _19774_/D VSS VSS VSS VSS gf180mcu_fd_sc_mcu9t5v0__mux2_1
XTAP_TAPCELL_ROW_22_1576 VSS VSS gf180mcu_fd_sc_mcu9t5v0__filltie
XTAP_TAPCELL_ROW_22_1587 VSS VSS gf180mcu_fd_sc_mcu9t5v0__filltie
Xmax_cap201 _14475_/B _14501_/S VSS VSS VSS VSS gf180mcu_fd_sc_mcu9t5v0__clkbuf_4
XTAP_TAPCELL_ROW_305_7461 VSS VSS gf180mcu_fd_sc_mcu9t5v0__filltie
XTAP_TAPCELL_ROW_305_7450 VSS VSS gf180mcu_fd_sc_mcu9t5v0__filltie
X_17128_ _18347_/Q _17322_/A2 _17255_/B1 _18363_/Q _17129_/B VSS VSS VSS VSS gf180mcu_fd_sc_mcu9t5v0__aoi22_1
XTAP_TAPCELL_ROW_22_1598 VSS VSS gf180mcu_fd_sc_mcu9t5v0__filltie
Xmax_cap212 _12147_/S _12548_/A1 VSS VSS VSS VSS gf180mcu_fd_sc_mcu9t5v0__clkbuf_8
XTAP_TAPCELL_ROW_301_7347 VSS VSS gf180mcu_fd_sc_mcu9t5v0__filltie
XTAP_TAPCELL_ROW_301_7336 VSS VSS gf180mcu_fd_sc_mcu9t5v0__filltie
X_17059_ _18521_/Q _17059_/I1 _17062_/S _18521_/D VSS VSS VSS VSS gf180mcu_fd_sc_mcu9t5v0__mux2_1
X_09950_ _18807_/Q _10153_/A2 _10153_/B _09964_/A1 VSS _09963_/VNW VSS VSS gf180mcu_fd_sc_mcu9t5v0__oai21_1
XTAP_TAPCELL_ROW_301_7358 VSS VSS gf180mcu_fd_sc_mcu9t5v0__filltie
XTAP_TAPCELL_ROW_297_7251 VSS VSS gf180mcu_fd_sc_mcu9t5v0__filltie
XTAP_TAPCELL_ROW_297_7240 VSS VSS gf180mcu_fd_sc_mcu9t5v0__filltie
X_20070_ _20070_/D _20070_/RN clkload50/I _20070_/Q VSS VSS VSS VSS gf180mcu_fd_sc_mcu9t5v0__dffrnq_1
XTAP_TAPCELL_ROW_293_7137 VSS VSS gf180mcu_fd_sc_mcu9t5v0__filltie
XTAP_TAPCELL_ROW_293_7126 VSS VSS gf180mcu_fd_sc_mcu9t5v0__filltie
XTAP_TAPCELL_ROW_318_7811 VSS VSS gf180mcu_fd_sc_mcu9t5v0__filltie
XTAP_TAPCELL_ROW_293_7115 VSS VSS gf180mcu_fd_sc_mcu9t5v0__filltie
XTAP_TAPCELL_ROW_124_4400 VSS VSS gf180mcu_fd_sc_mcu9t5v0__filltie
X_09881_ _09881_/A1 _09881_/A2 _09881_/A3 _09882_/A2 VSS VSS VSS VSS gf180mcu_fd_sc_mcu9t5v0__nor3_4
XTAP_TAPCELL_ROW_35_1937 VSS VSS gf180mcu_fd_sc_mcu9t5v0__filltie
XTAP_TAPCELL_ROW_35_1948 VSS VSS gf180mcu_fd_sc_mcu9t5v0__filltie
XTAP_TAPCELL_ROW_318_7822 VSS VSS gf180mcu_fd_sc_mcu9t5v0__filltie
XTAP_TAPCELL_ROW_314_7719 VSS VSS gf180mcu_fd_sc_mcu9t5v0__filltie
XTAP_TAPCELL_ROW_314_7708 VSS VSS gf180mcu_fd_sc_mcu9t5v0__filltie
Xu_transform_scheduler_core.u_fft_scratch_sram.u_lo.g_pin_drive\[5\].u_data_driver
+ _10397_/ZN u_transform_scheduler_core.u_fft_scratch_sram.u_lo.u_sram/D[5] VSS VSS
+ VSS VSS gf180mcu_fd_sc_mcu9t5v0__buf_8
XTAP_TAPCELL_ROW_118_4237 VSS VSS gf180mcu_fd_sc_mcu9t5v0__filltie
XTAP_TAPCELL_ROW_118_4226 VSS VSS gf180mcu_fd_sc_mcu9t5v0__filltie
XTAP_TAPCELL_ROW_118_4215 VSS VSS gf180mcu_fd_sc_mcu9t5v0__filltie
X_09315_ _19237_/Q _16426_/A1 VSS VSS VSS VSS gf180mcu_fd_sc_mcu9t5v0__clkinv_1
X_09246_ _09246_/I _17747_/A1 VSS _09246_/VNW VSS VSS gf180mcu_fd_sc_mcu9t5v0__clkinv_1
XTAP_TAPCELL_ROW_205_3_8241 VSS VSS gf180mcu_fd_sc_mcu9t5v0__filltie
XTAP_TAPCELL_ROW_282_6830 VSS VSS gf180mcu_fd_sc_mcu9t5v0__filltie
X_09177_ _19149_/Q _14400_/A1 VSS VSS VSS VSS gf180mcu_fd_sc_mcu9t5v0__clkinv_1
Xoutput13 output13/I dout[2] VSS VSS VSS VSS gf180mcu_fd_sc_mcu9t5v0__dlyd_1
XTAP_TAPCELL_ROW_263_6295 VSS VSS gf180mcu_fd_sc_mcu9t5v0__filltie
XTAP_TAPCELL_ROW_92_3499 VSS VSS gf180mcu_fd_sc_mcu9t5v0__filltie
X_11070_ _19070_/Q _11072_/S _11071_/B VSS _11070_/VNW VSS VSS gf180mcu_fd_sc_mcu9t5v0__nor2_1
X_10021_ _10841_/A2 _16196_/A1 _10021_/B _10040_/B1 VSS _10021_/VNW VSS VSS gf180mcu_fd_sc_mcu9t5v0__oai21_1
XTAP_TAPCELL_ROW_276_6667 VSS VSS gf180mcu_fd_sc_mcu9t5v0__filltie
XTAP_TAPCELL_ROW_276_6656 VSS VSS gf180mcu_fd_sc_mcu9t5v0__filltie
XTAP_TAPCELL_ROW_107_3930 VSS VSS gf180mcu_fd_sc_mcu9t5v0__filltie
XTAP_TAPCELL_ROW_103_3827 VSS VSS gf180mcu_fd_sc_mcu9t5v0__filltie
XTAP_TAPCELL_ROW_103_3816 VSS VSS gf180mcu_fd_sc_mcu9t5v0__filltie
X_14760_ _19553_/Q _14760_/I1 _14764_/B _19553_/D VSS VSS VSS VSS gf180mcu_fd_sc_mcu9t5v0__mux2_1
XTAP_TAPCELL_ROW_103_3805 VSS VSS gf180mcu_fd_sc_mcu9t5v0__filltie
X_11972_ _18247_/Q _12345_/A2 _11978_/A1 VSS _11978_/VNW VSS VSS gf180mcu_fd_sc_mcu9t5v0__nand2_1
X_13711_ _13711_/A1 _14666_/A1 _13712_/I1 VSS VSS VSS VSS gf180mcu_fd_sc_mcu9t5v0__xnor2_1
X_10923_ _10923_/I0 _19000_/Q _18148_/S _19000_/D VSS VSS VSS VSS gf180mcu_fd_sc_mcu9t5v0__mux2_1
XTAP_TAPCELL_ROW_45_2211 VSS VSS gf180mcu_fd_sc_mcu9t5v0__filltie
X_14691_ _14410_/Z _14691_/A2 _14692_/A2 VSS VSS VSS VSS gf180mcu_fd_sc_mcu9t5v0__nand2_1
XTAP_TAPCELL_ROW_45_2222 VSS VSS gf180mcu_fd_sc_mcu9t5v0__filltie
XPHY_EDGE_ROW_19_Right_19 VSS VSS gf180mcu_fd_sc_mcu9t5v0__endcap
XTAP_TAPCELL_ROW_45_2233 VSS VSS gf180mcu_fd_sc_mcu9t5v0__filltie
X_16430_ _16430_/A1 _16809_/S _16430_/B _16431_/I0 VSS VSS VSS VSS gf180mcu_fd_sc_mcu9t5v0__oai21_1
X_10854_ _16645_/A1 _18147_/S _10860_/B _10855_/I0 VSS VSS VSS VSS gf180mcu_fd_sc_mcu9t5v0__oai21_1
X_13642_ _13642_/A1 _13642_/A2 _13642_/B _19290_/D VSS VSS VSS VSS gf180mcu_fd_sc_mcu9t5v0__oai21_1
XTAP_TAPCELL_ROW_41_2108 VSS VSS gf180mcu_fd_sc_mcu9t5v0__filltie
X_16361_ _19240_/Q _16177_/C _16865_/S _16361_/Z VSS VSS VSS VSS gf180mcu_fd_sc_mcu9t5v0__mux2_1
Xeco7_buf_15962 _15962_/ZN _16199_/A1 VSS VSS VSS VSS gf180mcu_fd_sc_mcu9t5v0__clkbuf_16
X_13573_ _19276_/Q _13304_/B _13574_/B VSS _13573_/VNW VSS VSS gf180mcu_fd_sc_mcu9t5v0__nand2_1
XTAP_TAPCELL_ROW_41_2119 VSS VSS gf180mcu_fd_sc_mcu9t5v0__filltie
X_12524_ _18445_/Q _12607_/A2 _12526_/B1 VSS VSS VSS VSS gf180mcu_fd_sc_mcu9t5v0__nor2_1
X_18100_ _18100_/A1 _18099_/Z _18937_/D VSS _18100_/VNW VSS VSS gf180mcu_fd_sc_mcu9t5v0__nor2_1
X_19080_ _19080_/D _20040_/RN clkload36/I _19080_/Q VSS VSS VSS VSS gf180mcu_fd_sc_mcu9t5v0__dffrnq_1
X_15312_ _19639_/Q _19616_/Q _15314_/A2 _15313_/I0 VSS VSS VSS VSS gf180mcu_fd_sc_mcu9t5v0__xnor3_1
X_10785_ _18852_/Q _10785_/A2 _10785_/B _10803_/C _10789_/A2 VSS VSS VSS VSS gf180mcu_fd_sc_mcu9t5v0__oai211_1
X_16292_ _18215_/Q _16292_/I1 _16824_/S _18215_/D VSS _16292_/VNW VSS VSS gf180mcu_fd_sc_mcu9t5v0__mux2_4
X_18031_ _18031_/I0 _18916_/Q _18037_/S _18916_/D VSS _18031_/VNW VSS VSS gf180mcu_fd_sc_mcu9t5v0__mux2_1
X_12455_ _18213_/Q wire163/Z _12458_/A3 VSS VSS VSS VSS gf180mcu_fd_sc_mcu9t5v0__nor2_1
X_15243_ _19598_/Q _15247_/A2 _15249_/A1 VSS VSS VSS VSS gf180mcu_fd_sc_mcu9t5v0__nand2_1
X_11406_ _11526_/B _11406_/A2 _11406_/B1 _11406_/B2 _11408_/B2 VSS VSS VSS VSS gf180mcu_fd_sc_mcu9t5v0__aoi22_1
X_15174_ _19193_/Q _15174_/A2 _15420_/S VSS VSS VSS VSS gf180mcu_fd_sc_mcu9t5v0__nand2_2
XTAP_TAPCELL_ROW_39_2048 VSS VSS gf180mcu_fd_sc_mcu9t5v0__filltie
X_12386_ _12628_/A1 _12355_/I _12386_/A3 _12386_/B _19144_/D VSS _13677_/VNW VSS VSS
+ gf180mcu_fd_sc_mcu9t5v0__oai31_1
XTAP_TAPCELL_ROW_39_2059 VSS VSS gf180mcu_fd_sc_mcu9t5v0__filltie
X_11337_ wire283/I _11337_/A2 _11337_/B1 _11337_/B2 _11339_/B2 VSS VSS VSS VSS gf180mcu_fd_sc_mcu9t5v0__aoi22_1
X_14125_ _14117_/I _14125_/A2 _14127_/A2 VSS VSS VSS VSS gf180mcu_fd_sc_mcu9t5v0__xnor2_1
XPHY_EDGE_ROW_28_Right_28 VSS VSS gf180mcu_fd_sc_mcu9t5v0__endcap
X_19982_ _19982_/D _20046_/RN _20054_/CLK _19982_/Q VSS VSS VSS VSS gf180mcu_fd_sc_mcu9t5v0__dffrnq_1
X_11268_ _18870_/Q _11878_/A1 _11320_/B1 _11268_/B2 _11320_/C _11270_/A1 VSS _11268_/VNW
+ VSS VSS gf180mcu_fd_sc_mcu9t5v0__oai221_1
X_18933_ _18933_/D _20021_/RN clkload39/I _18933_/Q VSS VSS VSS VSS gf180mcu_fd_sc_mcu9t5v0__dffrnq_1
X_14056_ _14069_/A1 _14055_/Z _14058_/A2 VSS VSS VSS VSS gf180mcu_fd_sc_mcu9t5v0__xnor2_1
X_10219_ _17260_/S _10514_/B _17380_/B1 VSS VSS VSS VSS gf180mcu_fd_sc_mcu9t5v0__nor2_4
Xu_transform_scheduler_core.u_fft_scratch_sram.u_hi.g_pin_drive\[7\].u_data_driver
+ _10656_/ZN u_transform_scheduler_core.u_fft_scratch_sram.u_hi.u_sram/D[7] VSS VSS
+ VSS VSS gf180mcu_fd_sc_mcu9t5v0__buf_8
X_11199_ _11321_/A2 _11199_/A2 _11199_/A3 _11199_/B _19079_/D VSS VSS VSS VSS gf180mcu_fd_sc_mcu9t5v0__oai31_1
X_18864_ _18864_/D _20144_/RN clkload35/I _18864_/Q VSS VSS VSS VSS gf180mcu_fd_sc_mcu9t5v0__dffrnq_1
X_13007_ _13008_/A1 _13008_/A2 _13007_/B _13028_/A2 VSS _13007_/VNW VSS VSS gf180mcu_fd_sc_mcu9t5v0__oai21_1
XTAP_TAPCELL_ROW_30_1801 VSS VSS gf180mcu_fd_sc_mcu9t5v0__filltie
XTAP_TAPCELL_ROW_30_1812 VSS VSS gf180mcu_fd_sc_mcu9t5v0__filltie
X_18795_ _18795_/D _20139_/RN clkload34/I _18795_/Q VSS VSS VSS VSS gf180mcu_fd_sc_mcu9t5v0__dffrnq_1
X_17815_ _19022_/Q _18792_/Q _17844_/S _18792_/D VSS VSS VSS VSS gf180mcu_fd_sc_mcu9t5v0__mux2_1
X_17746_ _18749_/Q _18747_/Q _17751_/S _18749_/D VSS VSS VSS VSS gf180mcu_fd_sc_mcu9t5v0__mux2_1
XTAP_TAPCELL_ROW_15_1391 VSS VSS gf180mcu_fd_sc_mcu9t5v0__filltie
Xclkbuf_3_6_0_clk_regs clkbuf_0_clk_regs/Z clkload5/I VSS VSS VSS VSS gf180mcu_fd_sc_mcu9t5v0__clkbuf_8
XPHY_EDGE_ROW_37_Right_37 VSS VSS gf180mcu_fd_sc_mcu9t5v0__endcap
X_14958_ _19426_/Q _19371_/Q _14964_/A1 VSS _14958_/VNW VSS VSS gf180mcu_fd_sc_mcu9t5v0__nand2_1
XPHY_EDGE_ROW_314_Right_241 VSS VSS gf180mcu_fd_sc_mcu9t5v0__endcap
X_17677_ _18640_/Q _18716_/Q _17681_/S _18716_/D VSS _17677_/VNW VSS VSS gf180mcu_fd_sc_mcu9t5v0__mux2_1
XTAP_TAPCELL_ROW_186_3_8175 VSS VSS gf180mcu_fd_sc_mcu9t5v0__filltie
X_13909_ _13909_/A1 _13909_/A2 _13944_/A1 VSS VSS VSS VSS gf180mcu_fd_sc_mcu9t5v0__nand2_1
X_14889_ _19414_/Q _19355_/Q _14891_/A1 _14890_/A2 VSS VSS VSS VSS gf180mcu_fd_sc_mcu9t5v0__xnor3_1
XTAP_TAPCELL_ROW_11_1277 VSS VSS gf180mcu_fd_sc_mcu9t5v0__filltie
XTAP_TAPCELL_ROW_11_1288 VSS VSS gf180mcu_fd_sc_mcu9t5v0__filltie
X_16628_ _16668_/A1 _16628_/A2 _16628_/B _16630_/A2 VSS _16628_/VNW VSS VSS gf180mcu_fd_sc_mcu9t5v0__aoi21_1
XTAP_TAPCELL_ROW_28_1741 VSS VSS gf180mcu_fd_sc_mcu9t5v0__filltie
X_19416_ _19416_/D _19992_/RN clkload18/I _19416_/Q VSS VSS VSS VSS gf180mcu_fd_sc_mcu9t5v0__dffrnq_1
X_16559_ _18342_/Q _16182_/B _17069_/S _18342_/D VSS VSS VSS VSS gf180mcu_fd_sc_mcu9t5v0__mux2_1
Xclkbuf_leaf_26_clk_regs clkload4/I clkload64/I VSS VSS VSS VSS gf180mcu_fd_sc_mcu9t5v0__clkbuf_8
X_19347_ _19347_/D _20051_/RN clkload19/I _19347_/Q VSS VSS VSS VSS gf180mcu_fd_sc_mcu9t5v0__dffrnq_1
XTAP_TAPCELL_ROW_28_1752 VSS VSS gf180mcu_fd_sc_mcu9t5v0__filltie
XTAP_TAPCELL_ROW_28_1763 VSS VSS gf180mcu_fd_sc_mcu9t5v0__filltie
X_09100_ _18567_/Q _11095_/S VSS VSS VSS VSS gf180mcu_fd_sc_mcu9t5v0__clkinv_8
XTAP_TAPCELL_ROW_24_1638 VSS VSS gf180mcu_fd_sc_mcu9t5v0__filltie
XTAP_TAPCELL_ROW_307_7523 VSS VSS gf180mcu_fd_sc_mcu9t5v0__filltie
XTAP_TAPCELL_ROW_307_7512 VSS VSS gf180mcu_fd_sc_mcu9t5v0__filltie
XTAP_TAPCELL_ROW_307_7501 VSS VSS gf180mcu_fd_sc_mcu9t5v0__filltie
XTAP_TAPCELL_ROW_113_4101 VSS VSS gf180mcu_fd_sc_mcu9t5v0__filltie
X_19278_ _19278_/D _20046_/RN clkload24/I _19278_/Q VSS VSS VSS VSS gf180mcu_fd_sc_mcu9t5v0__dffrnq_1
XTAP_TAPCELL_ROW_24_1649 VSS VSS gf180mcu_fd_sc_mcu9t5v0__filltie
X_18229_ _18229_/D clkload69/I _18229_/Q VSS VSS VSS VSS gf180mcu_fd_sc_mcu9t5v0__dffq_4
XPHY_EDGE_ROW_46_Right_46 VSS VSS gf180mcu_fd_sc_mcu9t5v0__endcap
XTAP_TAPCELL_ROW_299_7302 VSS VSS gf180mcu_fd_sc_mcu9t5v0__filltie
XTAP_TAPCELL_ROW_303_7409 VSS VSS gf180mcu_fd_sc_mcu9t5v0__filltie
X_20122_ _20122_/D clkload74/I _20122_/Q VSS VSS VSS VSS gf180mcu_fd_sc_mcu9t5v0__dffq_1
X_09933_ _18995_/Q wire285/I _10169_/B1 _18979_/Q _18955_/Q wire172/Z _09934_/A2 VSS
+ _10451_/VNW VSS VSS gf180mcu_fd_sc_mcu9t5v0__aoi222_1
X_09864_ _19895_/Q _19896_/Q _15633_/A1 VSS _15633_/VNW VSS VSS gf180mcu_fd_sc_mcu9t5v0__nor2_1
X_20053_ _20053_/D _20053_/RN clkload26/I _20053_/Q VSS VSS VSS VSS gf180mcu_fd_sc_mcu9t5v0__dffrnq_1
Xload_slew292 _10718_/C _10809_/B VSS VSS VSS VSS gf180mcu_fd_sc_mcu9t5v0__clkbuf_8
X_09795_ _18843_/Q _10776_/A1 _17918_/A1 VSS VSS VSS VSS gf180mcu_fd_sc_mcu9t5v0__xnor2_1
XPHY_EDGE_ROW_55_Right_55 VSS VSS gf180mcu_fd_sc_mcu9t5v0__endcap
XTAP_TAPCELL_ROW_271_6531 VSS VSS gf180mcu_fd_sc_mcu9t5v0__filltie
XTAP_TAPCELL_ROW_271_6520 VSS VSS gf180mcu_fd_sc_mcu9t5v0__filltie
XPHY_EDGE_ROW_147_1_Left_470 VSS VSS gf180mcu_fd_sc_mcu9t5v0__endcap
XTAP_TAPCELL_ROW_98_3664 VSS VSS gf180mcu_fd_sc_mcu9t5v0__filltie
X_10570_ _18599_/Q _17306_/C _10570_/B1 _10570_/B2 _10648_/C _10571_/A3 VSS VSS VSS
+ VSS gf180mcu_fd_sc_mcu9t5v0__aoi221_1
XTAP_TAPCELL_ROW_269_6471 VSS VSS gf180mcu_fd_sc_mcu9t5v0__filltie
XTAP_TAPCELL_ROW_269_6460 VSS VSS gf180mcu_fd_sc_mcu9t5v0__filltie
XPHY_EDGE_ROW_202_3_Left_860 VSS VSS gf180mcu_fd_sc_mcu9t5v0__endcap
XTAP_TAPCELL_ROW_98_3686 VSS VSS gf180mcu_fd_sc_mcu9t5v0__filltie
XTAP_TAPCELL_ROW_98_3675 VSS VSS gf180mcu_fd_sc_mcu9t5v0__filltie
XPHY_EDGE_ROW_64_Right_64 VSS VSS gf180mcu_fd_sc_mcu9t5v0__endcap
XTAP_TAPCELL_ROW_265_6357 VSS VSS gf180mcu_fd_sc_mcu9t5v0__filltie
XTAP_TAPCELL_ROW_265_6346 VSS VSS gf180mcu_fd_sc_mcu9t5v0__filltie
X_09229_ _19294_/Q _13970_/A1 VSS VSS VSS VSS gf180mcu_fd_sc_mcu9t5v0__clkinv_1
XTAP_TAPCELL_ROW_265_6368 VSS VSS gf180mcu_fd_sc_mcu9t5v0__filltie
X_12240_ _18483_/Q _12340_/S _12247_/A2 VSS VSS VSS VSS gf180mcu_fd_sc_mcu9t5v0__nand2_1
X_12171_ _14512_/A2 _12311_/B _12171_/B _19130_/D VSS _12171_/VNW VSS VSS gf180mcu_fd_sc_mcu9t5v0__aoi21_1
Xu_transform_scheduler_core.u_fft_scratch_sram.u_lo.g_pin_drive\[0\].u_addr_driver
+ _10662_/Z u_transform_scheduler_core.u_fft_scratch_sram.u_lo.u_sram/A[0] VSS _10676_/VNW
+ VSS VSS gf180mcu_fd_sc_mcu9t5v0__buf_8
XTAP_TAPCELL_ROW_278_6729 VSS VSS gf180mcu_fd_sc_mcu9t5v0__filltie
XTAP_TAPCELL_ROW_278_6718 VSS VSS gf180mcu_fd_sc_mcu9t5v0__filltie
XTAP_TAPCELL_ROW_278_6707 VSS VSS gf180mcu_fd_sc_mcu9t5v0__filltie
XTAP_TAPCELL_ROW_192_3_8196 VSS VSS gf180mcu_fd_sc_mcu9t5v0__filltie
X_11122_ _18860_/Q _12689_/C _11320_/C _11122_/C _11123_/A2 VSS VSS VSS VSS gf180mcu_fd_sc_mcu9t5v0__oai211_1
X_15930_ _15930_/I _15936_/A1 VSS VSS VSS VSS gf180mcu_fd_sc_mcu9t5v0__clkinv_1
Xeco6_buf_10314 _10314_/ZN eco6_buf_10314/Z VSS VSS VSS VSS gf180mcu_fd_sc_mcu9t5v0__clkbuf_16
X_11053_ _18023_/I0 _19054_/Q _11067_/S _19054_/D VSS _11053_/VNW VSS VSS gf180mcu_fd_sc_mcu9t5v0__mux2_1
X_10004_ _10004_/A1 _10004_/A2 _10004_/B1 _09917_/B _10005_/A3 VSS _10005_/VNW VSS
+ VSS gf180mcu_fd_sc_mcu9t5v0__oai22_1
X_15861_ _17438_/A1 _16198_/A2 _16197_/B VSS VSS VSS VSS gf180mcu_fd_sc_mcu9t5v0__nand2_4
XPHY_EDGE_ROW_73_Right_73 VSS VSS gf180mcu_fd_sc_mcu9t5v0__endcap
X_17600_ _18664_/Q _09737_/Z _17601_/B VSS _17600_/VNW VSS VSS gf180mcu_fd_sc_mcu9t5v0__nand2_1
X_14812_ _19401_/Q _19338_/Q _14812_/B _14814_/A2 VSS VSS VSS VSS gf180mcu_fd_sc_mcu9t5v0__oai21_1
X_15792_ _18027_/I0 _19962_/Q _15802_/S _19962_/D VSS _15792_/VNW VSS VSS gf180mcu_fd_sc_mcu9t5v0__mux2_1
XTAP_TAPCELL_ROW_8_1198 VSS VSS gf180mcu_fd_sc_mcu9t5v0__filltie
X_18580_ _18580_/D _20144_/RN clkload27/I _18580_/Q VSS VSS VSS VSS gf180mcu_fd_sc_mcu9t5v0__dffrnq_1
X_11955_ _18310_/Q _18294_/Q _12340_/S _11955_/Z VSS VSS VSS VSS gf180mcu_fd_sc_mcu9t5v0__mux2_1
X_17531_ _18664_/Q wire301/Z _17532_/B VSS VSS VSS VSS gf180mcu_fd_sc_mcu9t5v0__nand2_1
X_14743_ _19549_/Q _14730_/S _14744_/B VSS VSS VSS VSS gf180mcu_fd_sc_mcu9t5v0__nand2_1
Xeco15_sk1_3 clkload74/I eco15_sk2_3/I VSS VSS VSS VSS gf180mcu_fd_sc_mcu9t5v0__clkbuf_16
X_10906_ _10905_/Z _18992_/Q _18152_/S _18992_/D VSS VSS VSS VSS gf180mcu_fd_sc_mcu9t5v0__mux2_1
X_14674_ _19148_/Q _19114_/Q _14675_/B VSS VSS VSS VSS gf180mcu_fd_sc_mcu9t5v0__nand2_1
X_17462_ _17462_/A1 _17462_/A2 _18577_/D VSS VSS VSS VSS gf180mcu_fd_sc_mcu9t5v0__nor2_1
X_11886_ _12347_/C _11885_/Z _11898_/A2 VSS VSS VSS VSS gf180mcu_fd_sc_mcu9t5v0__nor2_1
X_16413_ _19231_/Q _16932_/A2 _16414_/A2 VSS _16413_/VNW VSS VSS gf180mcu_fd_sc_mcu9t5v0__nand2_1
XTAP_TAPCELL_ROW_250_5947 VSS VSS gf180mcu_fd_sc_mcu9t5v0__filltie
XTAP_TAPCELL_ROW_250_5936 VSS VSS gf180mcu_fd_sc_mcu9t5v0__filltie
XTAP_TAPCELL_ROW_174_1_4757 VSS VSS gf180mcu_fd_sc_mcu9t5v0__filltie
X_13625_ _13625_/A1 _13625_/A2 _13625_/B _13630_/A1 VSS _13625_/VNW VSS VSS gf180mcu_fd_sc_mcu9t5v0__aoi21_1
X_19201_ _19201_/D _20033_/RN clkload26/I _19201_/Q VSS VSS VSS VSS gf180mcu_fd_sc_mcu9t5v0__dffrnq_1
X_17393_ _17250_/Z _17393_/A2 _17393_/B _18551_/D VSS VSS VSS VSS gf180mcu_fd_sc_mcu9t5v0__oai21_4
XTAP_TAPCELL_ROW_250_5958 VSS VSS gf180mcu_fd_sc_mcu9t5v0__filltie
X_10837_ _20040_/Q _10837_/A2 _20070_/D VSS _10837_/VNW VSS VSS gf180mcu_fd_sc_mcu9t5v0__nor2_1
XPHY_EDGE_ROW_82_Right_82 VSS VSS gf180mcu_fd_sc_mcu9t5v0__endcap
X_19132_ _19132_/D _20028_/RN clkload35/I _19132_/Q VSS VSS VSS VSS gf180mcu_fd_sc_mcu9t5v0__dffrnq_1
X_16344_ _18236_/Q _16343_/Z wire38/I _18236_/D VSS VSS VSS VSS gf180mcu_fd_sc_mcu9t5v0__mux2_1
X_10768_ _19938_/Q _19890_/Q _20043_/Q _10768_/Z VSS VSS VSS VSS gf180mcu_fd_sc_mcu9t5v0__mux2_1
X_13556_ _13556_/A1 _13556_/A2 _13556_/B _13561_/A2 VSS VSS VSS VSS gf180mcu_fd_sc_mcu9t5v0__oai21_1
X_16275_ _16275_/A1 _16428_/B _16276_/I1 VSS VSS VSS VSS gf180mcu_fd_sc_mcu9t5v0__nand2_1
X_12507_ _18395_/Q _12582_/A2 _12510_/A3 VSS _17200_/VNW VSS VSS gf180mcu_fd_sc_mcu9t5v0__nor2_1
X_13487_ _13497_/A1 _13487_/A2 _13497_/B _13488_/B2 VSS _13487_/VNW VSS VSS gf180mcu_fd_sc_mcu9t5v0__aoi21_1
X_19063_ _19063_/D _20023_/RN clkload32/I _19063_/Q VSS VSS VSS VSS gf180mcu_fd_sc_mcu9t5v0__dffrnq_1
X_12438_ _18163_/Q _12613_/A2 _12442_/A2 VSS VSS VSS VSS gf180mcu_fd_sc_mcu9t5v0__nor2_1
X_10699_ _10679_/B _15474_/A2 _10700_/B1 VSS VSS VSS VSS gf180mcu_fd_sc_mcu9t5v0__nor2_1
X_15226_ _15229_/A1 _15229_/A3 _15227_/A3 VSS _15226_/VNW VSS VSS gf180mcu_fd_sc_mcu9t5v0__nor2_1
X_18014_ _18030_/I0 _18899_/Q _18021_/S _18899_/D VSS VSS VSS VSS gf180mcu_fd_sc_mcu9t5v0__mux2_1
XTAP_TAPCELL_ROW_248_5898 VSS VSS gf180mcu_fd_sc_mcu9t5v0__filltie
XTAP_TAPCELL_ROW_248_5887 VSS VSS gf180mcu_fd_sc_mcu9t5v0__filltie
XTAP_TAPCELL_ROW_178_2_8145 VSS VSS gf180mcu_fd_sc_mcu9t5v0__filltie
X_12369_ _18250_/Q _12501_/A2 _12541_/B _12369_/C _12370_/B VSS VSS VSS VSS gf180mcu_fd_sc_mcu9t5v0__oai211_1
X_15157_ _19699_/Q _19539_/Q wire108/Z _19699_/D VSS VSS VSS VSS gf180mcu_fd_sc_mcu9t5v0__mux2_1
X_19965_ _19965_/D _20029_/RN clkload46/I _19965_/Q VSS VSS VSS VSS gf180mcu_fd_sc_mcu9t5v0__dffrnq_1
X_14108_ _13994_/B _14209_/A2 _14109_/I VSS _14130_/VNW VSS VSS gf180mcu_fd_sc_mcu9t5v0__xnor2_1
X_15088_ _15089_/B _15098_/A2 _15089_/A2 _15092_/A1 VSS _15092_/VNW VSS VSS gf180mcu_fd_sc_mcu9t5v0__nor3_1
XPHY_EDGE_ROW_91_Right_91 VSS VSS gf180mcu_fd_sc_mcu9t5v0__endcap
X_14039_ _14006_/Z _14039_/A2 _14039_/B _14069_/A1 VSS _14039_/VNW VSS VSS gf180mcu_fd_sc_mcu9t5v0__oai21_1
XTAP_TAPCELL_ROW_17_1442 VSS VSS gf180mcu_fd_sc_mcu9t5v0__filltie
XTAP_TAPCELL_ROW_17_1453 VSS VSS gf180mcu_fd_sc_mcu9t5v0__filltie
X_18916_ _18916_/D _20068_/RN clkload35/I _18916_/Q VSS VSS VSS VSS gf180mcu_fd_sc_mcu9t5v0__dffrnq_1
X_19896_ _19896_/D _19960_/RN clkload41/I _19896_/Q VSS VSS VSS VSS gf180mcu_fd_sc_mcu9t5v0__dffrnq_1
XTAP_TAPCELL_ROW_13_1328 VSS VSS gf180mcu_fd_sc_mcu9t5v0__filltie
X_18847_ _18847_/D _20063_/RN clkload33/I _18847_/Q VSS VSS VSS VSS gf180mcu_fd_sc_mcu9t5v0__dffrnq_1
XTAP_TAPCELL_ROW_13_1339 VSS VSS gf180mcu_fd_sc_mcu9t5v0__filltie
X_18778_ _18778_/D _20058_/RN clkload50/I _18778_/Q VSS VSS VSS VSS gf180mcu_fd_sc_mcu9t5v0__dffrnq_1
X_09580_ _18583_/Q _18584_/Q _18585_/Q _18586_/Q _09580_/Z VSS VSS VSS VSS gf180mcu_fd_sc_mcu9t5v0__or4_1
XTAP_TAPCELL_ROW_288_7003 VSS VSS gf180mcu_fd_sc_mcu9t5v0__filltie
X_17729_ _17532_/B _17685_/S _17729_/B _18740_/D VSS VSS VSS VSS gf180mcu_fd_sc_mcu9t5v0__oai21_1
Xu_transform_scheduler_core.u_fft_scratch_sram.u_hi.g_pin_drive\[2\].u_addr_driver
+ _10696_/ZN u_transform_scheduler_core.u_fft_scratch_sram.u_hi.u_sram/A[2] VSS VSS
+ VSS VSS gf180mcu_fd_sc_mcu9t5v0__buf_8
XTAP_TAPCELL_ROW_93_3550 VSS VSS gf180mcu_fd_sc_mcu9t5v0__filltie
XTAP_TAPCELL_ROW_260_6210 VSS VSS gf180mcu_fd_sc_mcu9t5v0__filltie
XTAP_TAPCELL_ROW_260_6232 VSS VSS gf180mcu_fd_sc_mcu9t5v0__filltie
XTAP_TAPCELL_ROW_260_6221 VSS VSS gf180mcu_fd_sc_mcu9t5v0__filltie
X_20105_ _20105_/D clkload77/I _20105_/Q VSS VSS VSS VSS gf180mcu_fd_sc_mcu9t5v0__dffq_1
X_09916_ _20055_/Q _10064_/S _09916_/B _09917_/B VSS VSS VSS VSS gf180mcu_fd_sc_mcu9t5v0__aoi21_1
X_20036_ _20036_/D _20036_/RN clkload15/I _20036_/Q VSS VSS VSS VSS gf180mcu_fd_sc_mcu9t5v0__dffrnq_1
X_09847_ _10794_/A2 _15442_/A1 _09849_/A2 VSS VSS VSS VSS gf180mcu_fd_sc_mcu9t5v0__nand2_1
XTAP_TAPCELL_ROW_258_6172 VSS VSS gf180mcu_fd_sc_mcu9t5v0__filltie
XTAP_TAPCELL_ROW_258_6161 VSS VSS gf180mcu_fd_sc_mcu9t5v0__filltie
XTAP_TAPCELL_ROW_87_3387 VSS VSS gf180mcu_fd_sc_mcu9t5v0__filltie
XTAP_TAPCELL_ROW_87_3376 VSS VSS gf180mcu_fd_sc_mcu9t5v0__filltie
XTAP_TAPCELL_ROW_87_3365 VSS VSS gf180mcu_fd_sc_mcu9t5v0__filltie
X_09778_ _18837_/Q _11591_/A2 _11585_/A2 VSS VSS VSS VSS gf180mcu_fd_sc_mcu9t5v0__nand2_1
XTAP_TAPCELL_ROW_254_6069 VSS VSS gf180mcu_fd_sc_mcu9t5v0__filltie
XTAP_TAPCELL_ROW_254_6058 VSS VSS gf180mcu_fd_sc_mcu9t5v0__filltie
XTAP_TAPCELL_ROW_254_6047 VSS VSS gf180mcu_fd_sc_mcu9t5v0__filltie
X_11740_ _12628_/A1 _11740_/A2 _11741_/A2 VSS _11740_/VNW VSS VSS gf180mcu_fd_sc_mcu9t5v0__nor2_1
XTAP_TAPCELL_ROW_3_1062 VSS VSS gf180mcu_fd_sc_mcu9t5v0__filltie
XTAP_TAPCELL_ROW_184_2_8166 VSS VSS gf180mcu_fd_sc_mcu9t5v0__filltie
XTAP_TAPCELL_ROW_3_1073 VSS VSS gf180mcu_fd_sc_mcu9t5v0__filltie
XTAP_TAPCELL_ROW_267_6408 VSS VSS gf180mcu_fd_sc_mcu9t5v0__filltie
X_11671_ _12643_/A1 _11671_/A2 _11671_/B _12665_/B _11675_/B VSS _11671_/VNW VSS VSS
+ gf180mcu_fd_sc_mcu9t5v0__oai211_1
XTAP_TAPCELL_ROW_267_6419 VSS VSS gf180mcu_fd_sc_mcu9t5v0__filltie
X_10622_ _18601_/Q _17306_/C _10622_/B _10648_/C _10623_/A3 VSS VSS VSS VSS gf180mcu_fd_sc_mcu9t5v0__aoi211_1
X_13410_ _13389_/Z _13411_/A2 _13620_/B _13413_/A1 VSS VSS VSS VSS gf180mcu_fd_sc_mcu9t5v0__nand3_1
X_14390_ _19150_/Q _19116_/Q _14688_/A1 VSS _14687_/VNW VSS VSS gf180mcu_fd_sc_mcu9t5v0__nor2_1
X_10553_ _17358_/A1 _18325_/Q _10556_/A2 VSS VSS VSS VSS gf180mcu_fd_sc_mcu9t5v0__nor2_1
X_13341_ _16943_/A1 _13320_/B _13334_/Z _13341_/B2 _19250_/D VSS VSS VSS VSS gf180mcu_fd_sc_mcu9t5v0__aoi22_1
X_16060_ _16675_/A1 _16060_/A2 _16060_/A3 _16060_/B _16061_/I1 VSS VSS VSS VSS gf180mcu_fd_sc_mcu9t5v0__oai31_1
XTAP_TAPCELL_ROW_230_5390 VSS VSS gf180mcu_fd_sc_mcu9t5v0__filltie
X_10484_ _17260_/S _18274_/Q _10486_/A3 VSS _11239_/VNW VSS VSS gf180mcu_fd_sc_mcu9t5v0__nor2_1
Xrebuffer261 _16443_/A1 _16301_/A1 VSS VSS VSS VSS gf180mcu_fd_sc_mcu9t5v0__buf_8
Xrebuffer272 _09513_/A2 _17961_/A4 VSS VSS VSS VSS gf180mcu_fd_sc_mcu9t5v0__buf_8
X_15011_ _15011_/A1 _15011_/A2 _15013_/A1 VSS _15011_/VNW VSS VSS gf180mcu_fd_sc_mcu9t5v0__nand2_1
X_13272_ _13272_/A1 _13271_/B _13276_/A2 VSS _13273_/VNW VSS VSS gf180mcu_fd_sc_mcu9t5v0__xnor2_1
X_12223_ _18434_/Q _18418_/Q _12340_/S _12223_/Z VSS VSS VSS VSS gf180mcu_fd_sc_mcu9t5v0__mux2_1
X_12154_ _18495_/Q _18479_/Q _12315_/S _12154_/Z VSS VSS VSS VSS gf180mcu_fd_sc_mcu9t5v0__mux2_1
XTAP_TAPCELL_ROW_243_5751 VSS VSS gf180mcu_fd_sc_mcu9t5v0__filltie
XTAP_TAPCELL_ROW_243_5740 VSS VSS gf180mcu_fd_sc_mcu9t5v0__filltie
XTAP_TAPCELL_ROW_72_2966 VSS VSS gf180mcu_fd_sc_mcu9t5v0__filltie
XTAP_TAPCELL_ROW_72_2955 VSS VSS gf180mcu_fd_sc_mcu9t5v0__filltie
X_11105_ _11359_/B _11105_/A2 _11105_/B _11106_/B2 VSS VSS VSS VSS gf180mcu_fd_sc_mcu9t5v0__oai21_1
XTAP_TAPCELL_ROW_243_5762 VSS VSS gf180mcu_fd_sc_mcu9t5v0__filltie
X_19750_ _19750_/D _20070_/RN clkload23/I _19750_/Q VSS VSS VSS VSS gf180mcu_fd_sc_mcu9t5v0__dffrnq_1
X_12085_ _18508_/Q _12092_/B _12116_/C _12088_/A1 VSS VSS VSS VSS gf180mcu_fd_sc_mcu9t5v0__oai21_1
X_16962_ _16962_/I0 _18472_/Q _16962_/S _18472_/D VSS VSS VSS VSS gf180mcu_fd_sc_mcu9t5v0__mux2_4
X_18701_ _18701_/D _20099_/CLK _18701_/Q VSS VSS VSS VSS gf180mcu_fd_sc_mcu9t5v0__dffq_1
X_16893_ _19258_/Q _16668_/B _16893_/S _16893_/Z VSS VSS VSS VSS gf180mcu_fd_sc_mcu9t5v0__mux2_1
X_15913_ _20122_/Q _19258_/Q wire79/Z _20122_/D VSS _16494_/VNW VSS VSS gf180mcu_fd_sc_mcu9t5v0__mux2_1
X_19681_ _19681_/D _20065_/RN clkload43/I _19681_/Q VSS VSS VSS VSS gf180mcu_fd_sc_mcu9t5v0__dffrnq_1
X_11036_ _18022_/I0 _19037_/Q wire174/Z _19037_/D VSS _17830_/VNW VSS VSS gf180mcu_fd_sc_mcu9t5v0__mux2_1
X_18632_ _18632_/D _20036_/RN clkload63/I _18632_/Q VSS VSS VSS VSS gf180mcu_fd_sc_mcu9t5v0__dffrnq_1
X_15844_ _20141_/Q _15850_/A2 _15845_/A2 VSS VSS VSS VSS gf180mcu_fd_sc_mcu9t5v0__nand2_1
X_15775_ input5/Z _19945_/Q _15786_/S _19945_/D VSS VSS VSS VSS gf180mcu_fd_sc_mcu9t5v0__mux2_1
X_18563_ _18563_/D _20063_/RN clkload53/I _18563_/Q VSS VSS VSS VSS gf180mcu_fd_sc_mcu9t5v0__dffrnq_1
XPHY_EDGE_ROW_164_2_Left_676 VSS VSS gf180mcu_fd_sc_mcu9t5v0__endcap
XTAP_TAPCELL_ROW_237_5577 VSS VSS gf180mcu_fd_sc_mcu9t5v0__filltie
X_17514_ _09065_/I _18619_/Q _17521_/S _18619_/D VSS _17514_/VNW VSS VSS gf180mcu_fd_sc_mcu9t5v0__mux2_1
X_14726_ _14726_/A1 _14728_/A2 _14726_/Z VSS VSS VSS VSS gf180mcu_fd_sc_mcu9t5v0__xor2_1
X_12987_ _19720_/Q _12987_/A2 _13507_/B VSS VSS VSS VSS gf180mcu_fd_sc_mcu9t5v0__xnor2_1
X_18494_ _18494_/D clkload62/I _18494_/Q VSS VSS VSS VSS gf180mcu_fd_sc_mcu9t5v0__dffq_1
XTAP_TAPCELL_ROW_237_5599 VSS VSS gf180mcu_fd_sc_mcu9t5v0__filltie
X_11938_ _18309_/Q _12345_/A2 _11939_/A3 VSS _11938_/VNW VSS VSS gf180mcu_fd_sc_mcu9t5v0__nand2_1
XTAP_TAPCELL_ROW_237_5588 VSS VSS gf180mcu_fd_sc_mcu9t5v0__filltie
X_11869_ _18226_/Q _12340_/S _12347_/C _11872_/A2 VSS VSS VSS VSS gf180mcu_fd_sc_mcu9t5v0__aoi21_1
X_14657_ _14657_/A1 _14656_/B _14657_/A3 _14657_/Z VSS _14657_/VNW VSS VSS gf180mcu_fd_sc_mcu9t5v0__and3_1
X_17445_ _17461_/A1 _11072_/S _18569_/Q _17446_/A2 VSS VSS VSS VSS gf180mcu_fd_sc_mcu9t5v0__aoi21_1
X_17376_ _18487_/Q _17380_/A2 _17380_/B1 _18503_/Q _17377_/B VSS VSS VSS VSS gf180mcu_fd_sc_mcu9t5v0__aoi22_1
X_13608_ _13608_/A1 _13608_/A2 _13608_/B _13610_/A2 VSS VSS VSS VSS gf180mcu_fd_sc_mcu9t5v0__aoi21_1
X_14588_ _19173_/Q _19139_/Q _14767_/A1 VSS VSS VSS VSS gf180mcu_fd_sc_mcu9t5v0__nor2_1
X_16327_ _19240_/Q _16177_/C _16833_/S _16327_/Z VSS VSS VSS VSS gf180mcu_fd_sc_mcu9t5v0__mux2_1
X_13539_ _19269_/Q _13419_/B _13542_/B VSS _13539_/VNW VSS VSS gf180mcu_fd_sc_mcu9t5v0__nand2_1
X_19115_ _19115_/D _20139_/RN clkload30/I _19115_/Q VSS VSS VSS VSS gf180mcu_fd_sc_mcu9t5v0__dffrnq_1
XTAP_TAPCELL_ROW_194_3_8204 VSS VSS gf180mcu_fd_sc_mcu9t5v0__filltie
X_19046_ _19046_/D _20070_/RN clkload35/I _19046_/Q VSS VSS VSS VSS gf180mcu_fd_sc_mcu9t5v0__dffrnq_1
X_16258_ _16147_/C _16787_/S _16420_/B VSS _16258_/VNW VSS VSS gf180mcu_fd_sc_mcu9t5v0__nand2_1
X_16189_ _16730_/A1 _16189_/A2 _16189_/B _16189_/C _16190_/I1 VSS VSS VSS VSS gf180mcu_fd_sc_mcu9t5v0__oai211_4
X_15209_ _15209_/A1 _15209_/A2 _15209_/A3 _15209_/B _15216_/A1 VSS VSS VSS VSS gf180mcu_fd_sc_mcu9t5v0__oai31_1
XTAP_TAPCELL_ROW_19_1504 VSS VSS gf180mcu_fd_sc_mcu9t5v0__filltie
XTAP_TAPCELL_ROW_321_7895 VSS VSS gf180mcu_fd_sc_mcu9t5v0__filltie
XTAP_TAPCELL_ROW_19_1515 VSS VSS gf180mcu_fd_sc_mcu9t5v0__filltie
XPHY_EDGE_ROW_10_Left_334 VSS VSS gf180mcu_fd_sc_mcu9t5v0__endcap
X_19948_ _19948_/D _20140_/RN _20099_/CLK _19948_/Q VSS VSS VSS VSS gf180mcu_fd_sc_mcu9t5v0__dffrnq_1
X_09701_ _15946_/A3 _15946_/A4 _15850_/A2 VSS VSS VSS VSS gf180mcu_fd_sc_mcu9t5v0__nand2_1
XTAP_TAPCELL_ROW_190_2_8187 VSS VSS gf180mcu_fd_sc_mcu9t5v0__filltie
X_19879_ _19879_/D _20071_/RN clkload45/I _19879_/Q VSS VSS VSS VSS gf180mcu_fd_sc_mcu9t5v0__dffrnq_1
X_09632_ wire300/Z wire301/Z _09675_/A1 _09703_/A3 VSS _09698_/VNW VSS VSS gf180mcu_fd_sc_mcu9t5v0__nor3_1
Xclkbuf_leaf_41_clk_regs clkload6/I clkload78/I VSS VSS VSS VSS gf180mcu_fd_sc_mcu9t5v0__clkbuf_8
X_09563_ _20009_/Q _19998_/Q _20000_/Q _09680_/A1 VSS VSS VSS VSS gf180mcu_fd_sc_mcu9t5v0__nor3_2
XTAP_TAPCELL_ROW_82_3240 VSS VSS gf180mcu_fd_sc_mcu9t5v0__filltie
XTAP_TAPCELL_ROW_82_3251 VSS VSS gf180mcu_fd_sc_mcu9t5v0__filltie
XTAP_TAPCELL_ROW_121_4299 VSS VSS gf180mcu_fd_sc_mcu9t5v0__filltie
X_09494_ _18748_/Q _09495_/A2 _09494_/Z VSS VSS VSS VSS gf180mcu_fd_sc_mcu9t5v0__and2_4
XTAP_TAPCELL_ROW_95_3601 VSS VSS gf180mcu_fd_sc_mcu9t5v0__filltie
XTAP_TAPCELL_ROW_76_3066 VSS VSS gf180mcu_fd_sc_mcu9t5v0__filltie
XTAP_TAPCELL_ROW_76_3077 VSS VSS gf180mcu_fd_sc_mcu9t5v0__filltie
XTAP_TAPCELL_ROW_89_3438 VSS VSS gf180mcu_fd_sc_mcu9t5v0__filltie
XTAP_TAPCELL_ROW_89_3427 VSS VSS gf180mcu_fd_sc_mcu9t5v0__filltie
XTAP_TAPCELL_ROW_256_6109 VSS VSS gf180mcu_fd_sc_mcu9t5v0__filltie
X_20019_ _20019_/D _20019_/RN clkload50/I _20019_/Q VSS VSS VSS VSS gf180mcu_fd_sc_mcu9t5v0__dffrnq_1
X_12910_ _19775_/Q _12909_/Z _12918_/A2 VSS VSS VSS VSS gf180mcu_fd_sc_mcu9t5v0__nor2_1
X_13890_ _13891_/B2 _19293_/Q _19322_/Q _19323_/Q _13928_/B VSS VSS VSS VSS gf180mcu_fd_sc_mcu9t5v0__nand4_1
XTAP_TAPCELL_ROW_5_1113 VSS VSS gf180mcu_fd_sc_mcu9t5v0__filltie
X_12841_ _19765_/Q _12841_/A2 _12840_/Z _12842_/I0 VSS VSS VSS VSS gf180mcu_fd_sc_mcu9t5v0__xnor3_1
XTAP_TAPCELL_ROW_5_1124 VSS VSS gf180mcu_fd_sc_mcu9t5v0__filltie
X_15560_ _15566_/A1 _15558_/Z _15560_/A3 _19873_/D VSS VSS VSS VSS gf180mcu_fd_sc_mcu9t5v0__nor3_1
XTAP_TAPCELL_ROW_199_3_8219 VSS VSS gf180mcu_fd_sc_mcu9t5v0__filltie
X_12772_ _19723_/Q _19788_/Q _12948_/S _12772_/Z VSS VSS VSS VSS gf180mcu_fd_sc_mcu9t5v0__mux2_1
XTAP_TAPCELL_ROW_65_2770 VSS VSS gf180mcu_fd_sc_mcu9t5v0__filltie
XTAP_TAPCELL_ROW_65_2781 VSS VSS gf180mcu_fd_sc_mcu9t5v0__filltie
X_15491_ _17422_/S _15490_/Z _19832_/D VSS VSS VSS VSS gf180mcu_fd_sc_mcu9t5v0__and2_1
X_14511_ _14510_/Z _19463_/Q _14670_/S _19463_/D VSS VSS VSS VSS gf180mcu_fd_sc_mcu9t5v0__mux2_1
X_11723_ _13683_/A2 _11966_/B _11723_/B _19109_/D VSS VSS VSS VSS gf180mcu_fd_sc_mcu9t5v0__aoi21_1
X_17230_ _18544_/Q _17394_/A2 _17251_/B VSS VSS VSS VSS gf180mcu_fd_sc_mcu9t5v0__nand2_1
XTAP_TAPCELL_ROW_232_5463 VSS VSS gf180mcu_fd_sc_mcu9t5v0__filltie
XTAP_TAPCELL_ROW_232_5452 VSS VSS gf180mcu_fd_sc_mcu9t5v0__filltie
XTAP_TAPCELL_ROW_232_5441 VSS VSS gf180mcu_fd_sc_mcu9t5v0__filltie
XTAP_TAPCELL_ROW_61_2656 VSS VSS gf180mcu_fd_sc_mcu9t5v0__filltie
X_11654_ _11604_/Z _12643_/A2 _12665_/B _11654_/C _11655_/A2 VSS _11654_/VNW VSS VSS
+ gf180mcu_fd_sc_mcu9t5v0__aoi211_1
X_14442_ _14442_/A1 _14442_/A2 _14442_/B _14444_/A2 VSS _14442_/VNW VSS VSS gf180mcu_fd_sc_mcu9t5v0__oai21_1
XTAP_TAPCELL_ROW_61_2667 VSS VSS gf180mcu_fd_sc_mcu9t5v0__filltie
X_17161_ _17231_/A3 _17161_/A2 _17161_/B1 _17161_/B2 _17161_/C _17162_/B VSS VSS VSS
+ VSS gf180mcu_fd_sc_mcu9t5v0__oai221_1
X_10605_ _20092_/Q _17408_/B _10621_/A1 VSS _15898_/VNW VSS VSS gf180mcu_fd_sc_mcu9t5v0__nand2_1
X_16112_ _16668_/A1 _16750_/A2 _16725_/C _16741_/A1 VSS VSS VSS VSS gf180mcu_fd_sc_mcu9t5v0__aoi21_4
X_14373_ _19441_/Q _14715_/S _14374_/A2 VSS _14373_/VNW VSS VSS gf180mcu_fd_sc_mcu9t5v0__nand2_1
X_11585_ _18849_/Q _11585_/A2 _17907_/A2 _18848_/Q _11587_/A2 VSS VSS VSS VSS gf180mcu_fd_sc_mcu9t5v0__oai22_1
X_10536_ _18276_/Q _18260_/Q _17404_/S _10536_/Z VSS VSS VSS VSS gf180mcu_fd_sc_mcu9t5v0__mux2_1
XTAP_TAPCELL_ROW_204_3_8237 VSS VSS gf180mcu_fd_sc_mcu9t5v0__filltie
X_17092_ _20108_/Q wire168/I _17092_/B _17093_/A2 VSS VSS VSS VSS gf180mcu_fd_sc_mcu9t5v0__oai21_1
XTAP_TAPCELL_ROW_245_5802 VSS VSS gf180mcu_fd_sc_mcu9t5v0__filltie
X_13324_ _19772_/Q _19806_/Q _13326_/B VSS VSS VSS VSS gf180mcu_fd_sc_mcu9t5v0__xor2_1
X_10467_ _20101_/Q _17304_/C wire168/Z _10467_/C _10468_/A2 VSS VSS VSS VSS gf180mcu_fd_sc_mcu9t5v0__oai211_1
XTAP_TAPCELL_ROW_245_5813 VSS VSS gf180mcu_fd_sc_mcu9t5v0__filltie
X_16043_ _16750_/A1 _16668_/A2 _16147_/C _16046_/A2 VSS VSS VSS VSS gf180mcu_fd_sc_mcu9t5v0__aoi21_1
XPHY_EDGE_ROW_108_Right_108 VSS VSS gf180mcu_fd_sc_mcu9t5v0__endcap
XTAP_TAPCELL_ROW_59_2596 VSS VSS gf180mcu_fd_sc_mcu9t5v0__filltie
X_13255_ _13255_/A1 _13255_/A2 _13255_/B _13271_/A2 VSS VSS VSS VSS gf180mcu_fd_sc_mcu9t5v0__aoi21_1
X_12206_ _18513_/Q _12159_/B _12206_/B _12320_/C _12209_/A1 VSS _17262_/VNW VSS VSS
+ gf180mcu_fd_sc_mcu9t5v0__oai211_1
X_10398_ _10648_/C _18671_/Q _10821_/B _10415_/A2 VSS VSS VSS VSS gf180mcu_fd_sc_mcu9t5v0__nand3_1
XTAP_TAPCELL_ROW_226_5289 VSS VSS gf180mcu_fd_sc_mcu9t5v0__filltie
XTAP_TAPCELL_ROW_226_5278 VSS VSS gf180mcu_fd_sc_mcu9t5v0__filltie
X_13186_ _13169_/Z _13186_/A2 _13186_/B _13203_/A1 VSS VSS VSS VSS gf180mcu_fd_sc_mcu9t5v0__oai21_1
X_19802_ _19802_/D _20058_/RN clkload16/I _19802_/Q VSS VSS VSS VSS gf180mcu_fd_sc_mcu9t5v0__dffrnq_1
X_12137_ _12208_/C _12137_/A2 _12137_/A3 _12141_/A1 VSS VSS VSS VSS gf180mcu_fd_sc_mcu9t5v0__nand3_1
X_17994_ _18880_/Q _18027_/I0 _17997_/S _18880_/D VSS VSS VSS VSS gf180mcu_fd_sc_mcu9t5v0__mux2_1
X_16945_ _19251_/Q _16622_/B _16949_/S _16945_/Z VSS _16945_/VNW VSS VSS gf180mcu_fd_sc_mcu9t5v0__mux2_1
X_12068_ _18507_/Q _12159_/B _12069_/A3 VSS VSS VSS VSS gf180mcu_fd_sc_mcu9t5v0__nor2_1
X_19733_ _19733_/D _20053_/RN clkload11/I _19733_/Q VSS VSS VSS VSS gf180mcu_fd_sc_mcu9t5v0__dffrnq_1
X_11019_ _11019_/A1 _11019_/A2 _19020_/D VSS VSS VSS VSS gf180mcu_fd_sc_mcu9t5v0__nand2_1
X_19664_ _19664_/D _20048_/RN clkload41/I _19664_/Q VSS VSS VSS VSS gf180mcu_fd_sc_mcu9t5v0__dffrnq_1
X_18615_ _18615_/D clkload74/I _18615_/Q VSS VSS VSS VSS gf180mcu_fd_sc_mcu9t5v0__dffq_1
X_16876_ _18430_/Q _16875_/Z _16882_/S _18430_/D VSS VSS VSS VSS gf180mcu_fd_sc_mcu9t5v0__mux2_4
XTAP_TAPCELL_ROW_239_5639 VSS VSS gf180mcu_fd_sc_mcu9t5v0__filltie
X_15827_ _10063_/C _15827_/A2 _15827_/B _15828_/B VSS _15827_/VNW VSS VSS gf180mcu_fd_sc_mcu9t5v0__aoi21_1
X_19595_ _19595_/D _20043_/RN clkload18/I _19595_/Q VSS VSS VSS VSS gf180mcu_fd_sc_mcu9t5v0__dffrnq_1
X_18546_ _18546_/D _20046_/RN clkload76/I _18546_/Q VSS VSS VSS VSS gf180mcu_fd_sc_mcu9t5v0__dffrnq_4
X_15758_ _15759_/A1 _15757_/B _15758_/B _19931_/D VSS _15758_/VNW VSS VSS gf180mcu_fd_sc_mcu9t5v0__aoi21_1
X_18477_ _18477_/D clkload61/I _18477_/Q VSS VSS VSS VSS gf180mcu_fd_sc_mcu9t5v0__dffq_1
X_15689_ _15743_/C _19914_/Q _15689_/S _19914_/D VSS _15689_/VNW VSS VSS gf180mcu_fd_sc_mcu9t5v0__mux2_1
X_14709_ _14464_/Z _14712_/A2 _14710_/I0 VSS VSS VSS VSS gf180mcu_fd_sc_mcu9t5v0__xnor2_1
XTAP_TAPCELL_ROW_310_7596 VSS VSS gf180mcu_fd_sc_mcu9t5v0__filltie
XTAP_TAPCELL_ROW_310_7585 VSS VSS gf180mcu_fd_sc_mcu9t5v0__filltie
X_17428_ _18563_/Q _09688_/B _17428_/A3 _17429_/A2 VSS _17428_/VNW VSS VSS gf180mcu_fd_sc_mcu9t5v0__nand3_1
XTAP_TAPCELL_ROW_215_4971 VSS VSS gf180mcu_fd_sc_mcu9t5v0__filltie
XTAP_TAPCELL_ROW_215_4993 VSS VSS gf180mcu_fd_sc_mcu9t5v0__filltie
X_17359_ _17404_/S _18534_/Q _17361_/A3 VSS VSS VSS VSS gf180mcu_fd_sc_mcu9t5v0__nor2_1
XTAP_TAPCELL_ROW_215_4982 VSS VSS gf180mcu_fd_sc_mcu9t5v0__filltie
XTAP_TAPCELL_ROW_323_7946 VSS VSS gf180mcu_fd_sc_mcu9t5v0__filltie
XTAP_TAPCELL_ROW_211_4879 VSS VSS gf180mcu_fd_sc_mcu9t5v0__filltie
XTAP_TAPCELL_ROW_211_4868 VSS VSS gf180mcu_fd_sc_mcu9t5v0__filltie
XTAP_TAPCELL_ROW_323_7979 VSS VSS gf180mcu_fd_sc_mcu9t5v0__filltie
XTAP_TAPCELL_ROW_323_7968 VSS VSS gf180mcu_fd_sc_mcu9t5v0__filltie
XTAP_TAPCELL_ROW_323_7957 VSS VSS gf180mcu_fd_sc_mcu9t5v0__filltie
Xclkload62 clkload62/I clkload62/ZN VSS _12118_/VNW VSS VSS gf180mcu_fd_sc_mcu9t5v0__inv_2
Xclkload51 clkload51/I clkload51/ZN VSS VSS VSS VSS gf180mcu_fd_sc_mcu9t5v0__inv_2
Xclkload40 clkload40/I clkload40/Z VSS _11268_/VNW VSS VSS gf180mcu_fd_sc_mcu9t5v0__clkbuf_4
X_19029_ _19029_/D _20053_/RN clkload36/I _19029_/Q VSS VSS VSS VSS gf180mcu_fd_sc_mcu9t5v0__dffrnq_1
Xclkload73 clkload73/I clkload73/ZN VSS _10379_/VNW VSS VSS gf180mcu_fd_sc_mcu9t5v0__inv_4
XTAP_TAPCELL_ROW_209_4797 VSS VSS gf180mcu_fd_sc_mcu9t5v0__filltie
XTAP_TAPCELL_ROW_209_4786 VSS VSS gf180mcu_fd_sc_mcu9t5v0__filltie
XTAP_TAPCELL_ROW_209_4775 VSS VSS gf180mcu_fd_sc_mcu9t5v0__filltie
XTAP_TAPCELL_ROW_127_4464 VSS VSS gf180mcu_fd_sc_mcu9t5v0__filltie
XTAP_TAPCELL_ROW_127_4486 VSS VSS gf180mcu_fd_sc_mcu9t5v0__filltie
XTAP_TAPCELL_ROW_127_4475 VSS VSS gf180mcu_fd_sc_mcu9t5v0__filltie
XTAP_TAPCELL_ROW_84_3302 VSS VSS gf180mcu_fd_sc_mcu9t5v0__filltie
X_09615_ _09615_/A1 _09615_/A2 _09616_/A2 VSS _09615_/VNW VSS VSS gf180mcu_fd_sc_mcu9t5v0__nor2_1
X_09546_ _09547_/B _09547_/C _09637_/A2 VSS VSS VSS VSS gf180mcu_fd_sc_mcu9t5v0__nand2_1
XPHY_EDGE_ROW_259_Right_186 VSS VSS gf180mcu_fd_sc_mcu9t5v0__endcap
X_09477_ _18685_/Q _17631_/A1 _09477_/A3 _12689_/A2 VSS _09582_/VNW VSS VSS gf180mcu_fd_sc_mcu9t5v0__nand3_1
XTAP_TAPCELL_ROW_78_3117 VSS VSS gf180mcu_fd_sc_mcu9t5v0__filltie
XTAP_TAPCELL_ROW_78_3139 VSS VSS gf180mcu_fd_sc_mcu9t5v0__filltie
XTAP_TAPCELL_ROW_78_3128 VSS VSS gf180mcu_fd_sc_mcu9t5v0__filltie
Xclkload1 clkload1/I clkload1/ZN VSS VSS VSS VSS gf180mcu_fd_sc_mcu9t5v0__clkinv_12
X_11370_ _18428_/Q _11098_/B _11373_/C VSS VSS VSS VSS gf180mcu_fd_sc_mcu9t5v0__nand2_1
X_10321_ _18236_/Q _17255_/B1 _10319_/Z _10514_/B _17278_/C _10326_/B2 VSS _16377_/VNW
+ VSS VSS gf180mcu_fd_sc_mcu9t5v0__aoi221_1
X_13040_ _13184_/A1 _13040_/A2 _13041_/A2 VSS VSS VSS VSS gf180mcu_fd_sc_mcu9t5v0__nor2_1
X_10252_ _18830_/Q _10804_/A2 wire166/I VSS VSS VSS VSS gf180mcu_fd_sc_mcu9t5v0__nor2_1
XTAP_TAPCELL_ROW_54_2460 VSS VSS gf180mcu_fd_sc_mcu9t5v0__filltie
X_10183_ _20036_/Q _10187_/A2 _20036_/D VSS VSS VSS VSS gf180mcu_fd_sc_mcu9t5v0__nor2_1
XTAP_TAPCELL_ROW_54_2471 VSS VSS gf180mcu_fd_sc_mcu9t5v0__filltie
XTAP_TAPCELL_ROW_221_5153 VSS VSS gf180mcu_fd_sc_mcu9t5v0__filltie
XTAP_TAPCELL_ROW_221_5142 VSS VSS gf180mcu_fd_sc_mcu9t5v0__filltie
XTAP_TAPCELL_ROW_50_2346 VSS VSS gf180mcu_fd_sc_mcu9t5v0__filltie
XTAP_TAPCELL_ROW_50_2357 VSS VSS gf180mcu_fd_sc_mcu9t5v0__filltie
XTAP_TAPCELL_ROW_50_2368 VSS VSS gf180mcu_fd_sc_mcu9t5v0__filltie
X_14991_ _19621_/Q _15163_/S _14997_/B VSS VSS VSS VSS gf180mcu_fd_sc_mcu9t5v0__nor2_1
X_16730_ _16730_/A1 _16647_/B _16730_/B _16730_/C _16732_/A2 VSS VSS VSS VSS gf180mcu_fd_sc_mcu9t5v0__aoi211_1
Xfanout260 _16114_/Z _16722_/A1 VSS VSS VSS VSS gf180mcu_fd_sc_mcu9t5v0__buf_8
X_13942_ _13942_/A1 _13940_/Z _13942_/Z VSS _13942_/VNW VSS VSS gf180mcu_fd_sc_mcu9t5v0__xor2_1
XTAP_TAPCELL_ROW_67_2821 VSS VSS gf180mcu_fd_sc_mcu9t5v0__filltie
XTAP_TAPCELL_ROW_67_2832 VSS VSS gf180mcu_fd_sc_mcu9t5v0__filltie
X_16661_ _19289_/Q _16675_/A1 _16662_/B VSS VSS VSS VSS gf180mcu_fd_sc_mcu9t5v0__nand2_1
X_13873_ _13873_/A1 _13885_/A1 _13850_/Z _13873_/B2 _13879_/A1 VSS _13873_/VNW VSS
+ VSS gf180mcu_fd_sc_mcu9t5v0__oai22_1
X_18400_ _18400_/D clkload72/I _18400_/Q VSS VSS VSS VSS gf180mcu_fd_sc_mcu9t5v0__dffq_4
X_16592_ _16750_/A1 _16628_/A2 _16592_/B _16594_/A2 VSS VSS VSS VSS gf180mcu_fd_sc_mcu9t5v0__aoi21_1
XTAP_TAPCELL_ROW_234_5514 VSS VSS gf180mcu_fd_sc_mcu9t5v0__filltie
XTAP_TAPCELL_ROW_234_5503 VSS VSS gf180mcu_fd_sc_mcu9t5v0__filltie
X_15612_ _19889_/Q _15611_/I _15612_/Z VSS VSS VSS VSS gf180mcu_fd_sc_mcu9t5v0__xor2_1
X_12824_ _12816_/Z _12824_/A2 _12824_/B _12826_/A3 VSS VSS VSS VSS gf180mcu_fd_sc_mcu9t5v0__aoi21_1
XTAP_TAPCELL_ROW_63_2707 VSS VSS gf180mcu_fd_sc_mcu9t5v0__filltie
XTAP_TAPCELL_ROW_63_2718 VSS VSS gf180mcu_fd_sc_mcu9t5v0__filltie
X_19380_ _19380_/D _20020_/RN _19633_/CLK _19380_/Q VSS VSS VSS VSS gf180mcu_fd_sc_mcu9t5v0__dffrnq_1
X_18331_ _18331_/D clkload60/I _18331_/Q VSS VSS VSS VSS gf180mcu_fd_sc_mcu9t5v0__dffq_1
X_15543_ _19861_/Q input6/Z _15551_/S _19861_/D VSS VSS VSS VSS gf180mcu_fd_sc_mcu9t5v0__mux2_1
XPHY_EDGE_ROW_226_Right_153 VSS VSS gf180mcu_fd_sc_mcu9t5v0__endcap
XTAP_TAPCELL_ROW_219_5093 VSS VSS gf180mcu_fd_sc_mcu9t5v0__filltie
XTAP_TAPCELL_ROW_219_5082 VSS VSS gf180mcu_fd_sc_mcu9t5v0__filltie
XTAP_TAPCELL_ROW_48_2297 VSS VSS gf180mcu_fd_sc_mcu9t5v0__filltie
X_12755_ _19753_/Q _12754_/Z _12762_/B VSS _12761_/VNW VSS VSS gf180mcu_fd_sc_mcu9t5v0__nand2_1
X_18262_ _18262_/D clkload81/I _18262_/Q VSS VSS VSS VSS gf180mcu_fd_sc_mcu9t5v0__dffq_1
X_11706_ _11706_/A1 _11697_/Z _11706_/B _11720_/A1 VSS VSS VSS VSS gf180mcu_fd_sc_mcu9t5v0__aoi21_1
X_15474_ _10679_/B _15474_/A2 _15474_/A3 _15471_/S _17406_/C _19828_/D VSS VSS VSS
+ VSS gf180mcu_fd_sc_mcu9t5v0__oai32_1
X_12686_ _12686_/A1 wire198/I wire208/I _12164_/B _12686_/C _12688_/A3 VSS VSS VSS
+ VSS gf180mcu_fd_sc_mcu9t5v0__aoi221_1
X_17213_ _18463_/Q _18447_/Q _17404_/S _17213_/Z VSS VSS VSS VSS gf180mcu_fd_sc_mcu9t5v0__mux2_1
X_18193_ _18193_/D clkload68/I _18193_/Q VSS VSS VSS VSS gf180mcu_fd_sc_mcu9t5v0__dffq_1
X_11637_ _11632_/B _12632_/A1 _11663_/A2 _12661_/A3 VSS VSS VSS VSS gf180mcu_fd_sc_mcu9t5v0__nand3_1
X_14425_ _19119_/Q wire199/Z _14704_/S _14425_/C _14426_/A2 VSS _14425_/VNW VSS VSS
+ gf180mcu_fd_sc_mcu9t5v0__oai211_1
X_17144_ input4/Z _17144_/A2 _17161_/A2 VSS VSS VSS VSS gf180mcu_fd_sc_mcu9t5v0__nand2_1
X_11568_ _11568_/A1 _11568_/A2 _11574_/A2 VSS _16377_/VNW VSS VSS gf180mcu_fd_sc_mcu9t5v0__nor2_1
X_14356_ _13772_/Z _19426_/Q _14367_/S _19426_/D VSS VSS VSS VSS gf180mcu_fd_sc_mcu9t5v0__mux2_1
X_10519_ _18163_/Q _17406_/A2 _17405_/A2 _18179_/Q _10520_/B VSS _12431_/VNW VSS VSS
+ gf180mcu_fd_sc_mcu9t5v0__aoi22_1
XTAP_TAPCELL_ROW_228_5329 VSS VSS gf180mcu_fd_sc_mcu9t5v0__filltie
X_17075_ _17075_/A1 _17075_/A2 _17420_/S VSS VSS VSS VSS gf180mcu_fd_sc_mcu9t5v0__nand2_4
X_13307_ _19771_/Q _13325_/A2 _13327_/A1 VSS VSS VSS VSS gf180mcu_fd_sc_mcu9t5v0__nand2_1
X_11499_ _11520_/B _11497_/Z _11526_/B _11500_/B2 VSS _11499_/VNW VSS VSS gf180mcu_fd_sc_mcu9t5v0__aoi21_1
X_16026_ _18156_/Q _16026_/I1 _16602_/S _18156_/D VSS VSS VSS VSS gf180mcu_fd_sc_mcu9t5v0__mux2_4
X_14287_ _13757_/Z _19360_/Q _14304_/S _19360_/D VSS VSS VSS VSS gf180mcu_fd_sc_mcu9t5v0__mux2_1
X_13238_ _13238_/A1 _13237_/B _13238_/Z VSS _13238_/VNW VSS VSS gf180mcu_fd_sc_mcu9t5v0__xor2_1
X_13169_ _19762_/Q _19796_/Q _13169_/Z VSS VSS VSS VSS gf180mcu_fd_sc_mcu9t5v0__xor2_1
XTAP_TAPCELL_ROW_37_1990 VSS VSS gf180mcu_fd_sc_mcu9t5v0__filltie
XTAP_TAPCELL_ROW_295_7190 VSS VSS gf180mcu_fd_sc_mcu9t5v0__filltie
X_17977_ _18864_/Q _18027_/I0 _17978_/S _18864_/D VSS VSS VSS VSS gf180mcu_fd_sc_mcu9t5v0__mux2_1
X_19716_ _19716_/D _20036_/RN clkload9/I _19716_/Q VSS VSS VSS VSS gf180mcu_fd_sc_mcu9t5v0__dffrnq_1
XTAP_TAPCELL_ROW_291_7076 VSS VSS gf180mcu_fd_sc_mcu9t5v0__filltie
X_16928_ _16927_/Z _18456_/Q _16928_/S _18456_/D VSS VSS VSS VSS gf180mcu_fd_sc_mcu9t5v0__mux2_1
XTAP_TAPCELL_ROW_316_7750 VSS VSS gf180mcu_fd_sc_mcu9t5v0__filltie
XTAP_TAPCELL_ROW_291_7065 VSS VSS gf180mcu_fd_sc_mcu9t5v0__filltie
XTAP_TAPCELL_ROW_122_4350 VSS VSS gf180mcu_fd_sc_mcu9t5v0__filltie
XTAP_TAPCELL_ROW_33_1887 VSS VSS gf180mcu_fd_sc_mcu9t5v0__filltie
XTAP_TAPCELL_ROW_33_1898 VSS VSS gf180mcu_fd_sc_mcu9t5v0__filltie
XTAP_TAPCELL_ROW_316_7772 VSS VSS gf180mcu_fd_sc_mcu9t5v0__filltie
XTAP_TAPCELL_ROW_316_7761 VSS VSS gf180mcu_fd_sc_mcu9t5v0__filltie
X_16859_ _19257_/Q _16660_/B _16863_/S _16859_/Z VSS VSS VSS VSS gf180mcu_fd_sc_mcu9t5v0__mux2_1
X_19647_ _19647_/D _20031_/RN clkload23/I _19647_/Q VSS VSS VSS VSS gf180mcu_fd_sc_mcu9t5v0__dffrnq_1
XTAP_TAPCELL_ROW_312_7658 VSS VSS gf180mcu_fd_sc_mcu9t5v0__filltie
XTAP_TAPCELL_ROW_312_7647 VSS VSS gf180mcu_fd_sc_mcu9t5v0__filltie
XPHY_EDGE_ROW_155_3_Right_270 VSS VSS gf180mcu_fd_sc_mcu9t5v0__endcap
X_09400_ _09400_/A1 wire216/I _09875_/A2 _09863_/A2 VSS VSS VSS VSS gf180mcu_fd_sc_mcu9t5v0__nand3_1
X_19578_ _19578_/D _20026_/RN clkload16/I _19578_/Q VSS VSS VSS VSS gf180mcu_fd_sc_mcu9t5v0__dffrnq_1
X_18529_ _18529_/D clkload74/I _18529_/Q VSS VSS VSS VSS gf180mcu_fd_sc_mcu9t5v0__dffq_1
X_09331_ _19241_/Q _16434_/A1 VSS VSS VSS VSS gf180mcu_fd_sc_mcu9t5v0__clkinv_1
XTAP_TAPCELL_ROW_135_4733 VSS VSS gf180mcu_fd_sc_mcu9t5v0__filltie
XTAP_TAPCELL_ROW_135_4722 VSS VSS gf180mcu_fd_sc_mcu9t5v0__filltie
XTAP_TAPCELL_ROW_135_4711 VSS VSS gf180mcu_fd_sc_mcu9t5v0__filltie
XTAP_TAPCELL_ROW_135_4700 VSS VSS gf180mcu_fd_sc_mcu9t5v0__filltie
X_09262_ _10543_/C _17406_/C VSS VSS VSS VSS gf180mcu_fd_sc_mcu9t5v0__inv_2
XTAP_TAPCELL_ROW_213_4919 VSS VSS gf180mcu_fd_sc_mcu9t5v0__filltie
XTAP_TAPCELL_ROW_116_4176 VSS VSS gf180mcu_fd_sc_mcu9t5v0__filltie
XTAP_TAPCELL_ROW_116_4165 VSS VSS gf180mcu_fd_sc_mcu9t5v0__filltie
X_09193_ _19131_/Q _14514_/A2 VSS VSS VSS VSS gf180mcu_fd_sc_mcu9t5v0__clkinv_1
XTAP_TAPCELL_ROW_73_3003 VSS VSS gf180mcu_fd_sc_mcu9t5v0__filltie
XPHY_EDGE_ROW_189_2_Left_701 VSS VSS gf180mcu_fd_sc_mcu9t5v0__endcap
XTAP_TAPCELL_ROW_280_6780 VSS VSS gf180mcu_fd_sc_mcu9t5v0__filltie
XTAP_TAPCELL_ROW_129_4537 VSS VSS gf180mcu_fd_sc_mcu9t5v0__filltie
XTAP_TAPCELL_ROW_129_4526 VSS VSS gf180mcu_fd_sc_mcu9t5v0__filltie
XPHY_EDGE_ROW_166_1_Right_750 VSS VSS gf180mcu_fd_sc_mcu9t5v0__endcap
XTAP_TAPCELL_ROW_274_6595 VSS VSS gf180mcu_fd_sc_mcu9t5v0__filltie
XPHY_EDGE_ROW_270_Right_197 VSS VSS gf180mcu_fd_sc_mcu9t5v0__endcap
X_10870_ _10869_/Z _18974_/Q _18152_/S _18974_/D VSS _10870_/VNW VSS VSS gf180mcu_fd_sc_mcu9t5v0__mux2_1
XTAP_TAPCELL_ROW_105_3880 VSS VSS gf180mcu_fd_sc_mcu9t5v0__filltie
XTAP_TAPCELL_ROW_0_950 VSS VSS gf180mcu_fd_sc_mcu9t5v0__filltie
X_09529_ _19843_/Q _19844_/Q _19842_/Q _09531_/A2 VSS VSS VSS VSS gf180mcu_fd_sc_mcu9t5v0__nor3_1
XTAP_TAPCELL_ROW_101_3766 VSS VSS gf180mcu_fd_sc_mcu9t5v0__filltie
XTAP_TAPCELL_ROW_0_961 VSS VSS gf180mcu_fd_sc_mcu9t5v0__filltie
XTAP_TAPCELL_ROW_0_972 VSS VSS gf180mcu_fd_sc_mcu9t5v0__filltie
XTAP_TAPCELL_ROW_0_983 VSS VSS gf180mcu_fd_sc_mcu9t5v0__filltie
XTAP_TAPCELL_ROW_101_3755 VSS VSS gf180mcu_fd_sc_mcu9t5v0__filltie
XTAP_TAPCELL_ROW_0_994 VSS VSS gf180mcu_fd_sc_mcu9t5v0__filltie
X_12540_ _18447_/Q _12607_/A2 _12542_/B1 VSS VSS VSS VSS gf180mcu_fd_sc_mcu9t5v0__nor2_1
XTAP_TAPCELL_ROW_287_6956 VSS VSS gf180mcu_fd_sc_mcu9t5v0__filltie
XTAP_TAPCELL_ROW_43_2161 VSS VSS gf180mcu_fd_sc_mcu9t5v0__filltie
XTAP_TAPCELL_ROW_43_2172 VSS VSS gf180mcu_fd_sc_mcu9t5v0__filltie
XTAP_TAPCELL_ROW_287_6967 VSS VSS gf180mcu_fd_sc_mcu9t5v0__filltie
X_12471_ _18215_/Q wire163/Z _12474_/A3 VSS _12471_/VNW VSS VSS gf180mcu_fd_sc_mcu9t5v0__nor2_1
X_11422_ _18709_/Q wire198/Z wire208/Z _11422_/B2 wire213/Z _11423_/A3 VSS VSS VSS
+ VSS gf180mcu_fd_sc_mcu9t5v0__aoi221_4
X_14210_ _14210_/A1 _14208_/Z _14211_/I VSS VSS VSS VSS gf180mcu_fd_sc_mcu9t5v0__xor2_1
X_15190_ _19718_/Q _15417_/S _15191_/B VSS VSS VSS VSS gf180mcu_fd_sc_mcu9t5v0__nand2_1
X_14141_ _20036_/Q _13652_/B _14165_/S VSS _14141_/VNW VSS VSS gf180mcu_fd_sc_mcu9t5v0__nand2_1
XTAP_TAPCELL_ROW_56_2511 VSS VSS gf180mcu_fd_sc_mcu9t5v0__filltie
X_11353_ _18704_/Q _12527_/A2 wire208/Z _11353_/B2 wire213/Z _11354_/A3 VSS VSS VSS
+ VSS gf180mcu_fd_sc_mcu9t5v0__aoi221_4
XTAP_TAPCELL_ROW_56_2522 VSS VSS gf180mcu_fd_sc_mcu9t5v0__filltie
XTAP_TAPCELL_ROW_56_2533 VSS VSS gf180mcu_fd_sc_mcu9t5v0__filltie
X_10304_ _17409_/B _10304_/A2 _10304_/A3 _10305_/C VSS VSS VSS VSS gf180mcu_fd_sc_mcu9t5v0__nand3_1
X_11284_ _18198_/Q _11534_/S _11285_/C VSS VSS VSS VSS gf180mcu_fd_sc_mcu9t5v0__nand2_1
XTAP_TAPCELL_ROW_223_5204 VSS VSS gf180mcu_fd_sc_mcu9t5v0__filltie
XPHY_EDGE_ROW_173_2_Left_685 VSS VSS gf180mcu_fd_sc_mcu9t5v0__endcap
X_14072_ _14034_/B _14133_/A2 _14134_/A1 VSS _14092_/VNW VSS VSS gf180mcu_fd_sc_mcu9t5v0__nand2_1
XTAP_TAPCELL_ROW_52_2408 VSS VSS gf180mcu_fd_sc_mcu9t5v0__filltie
XTAP_TAPCELL_ROW_52_2419 VSS VSS gf180mcu_fd_sc_mcu9t5v0__filltie
X_10235_ _17195_/A1 _19826_/Q _10745_/A2 VSS VSS VSS VSS gf180mcu_fd_sc_mcu9t5v0__nor2_1
XTAP_TAPCELL_ROW_223_5215 VSS VSS gf180mcu_fd_sc_mcu9t5v0__filltie
X_18880_ _18880_/D _09246_/I _20054_/CLK _18880_/Q VSS VSS VSS VSS gf180mcu_fd_sc_mcu9t5v0__dffrnq_1
X_17900_ _17900_/A1 _17939_/A1 _17902_/A3 _17900_/B2 _18837_/D VSS _17900_/VNW VSS
+ VSS gf180mcu_fd_sc_mcu9t5v0__oai22_1
X_13023_ _12734_/Z _13039_/A2 _13024_/A2 VSS _13031_/VNW VSS VSS gf180mcu_fd_sc_mcu9t5v0__nor2_1
X_17831_ _19038_/Q _18808_/Q _17844_/S _18808_/D VSS VSS VSS VSS gf180mcu_fd_sc_mcu9t5v0__mux2_1
X_10166_ _19275_/Q _10166_/A2 _10166_/B1 _19291_/Q _10167_/A2 VSS _10166_/VNW VSS
+ VSS gf180mcu_fd_sc_mcu9t5v0__aoi22_1
X_10097_ _10097_/A1 _10097_/A2 _10131_/A2 VSS VSS VSS VSS gf180mcu_fd_sc_mcu9t5v0__nand2_1
X_17762_ _18769_/D _17779_/C _17762_/A3 _18756_/D VSS VSS VSS VSS gf180mcu_fd_sc_mcu9t5v0__nor3_1
X_14974_ _19428_/Q _19373_/Q _14976_/A1 _14975_/A2 VSS VSS VSS VSS gf180mcu_fd_sc_mcu9t5v0__xnor3_1
X_16713_ _18369_/Q _16747_/A2 _16747_/A3 _16717_/B VSS _17236_/VNW VSS VSS gf180mcu_fd_sc_mcu9t5v0__nand3_1
X_17693_ _17693_/A1 _17742_/S _17694_/C VSS _17693_/VNW VSS VSS gf180mcu_fd_sc_mcu9t5v0__nor2_1
X_19501_ _19501_/D _20141_/RN clkload42/I _19501_/Q VSS VSS VSS VSS gf180mcu_fd_sc_mcu9t5v0__dffrnq_1
X_13925_ _13956_/A1 _13956_/A2 _13925_/Z VSS _13961_/VNW VSS VSS gf180mcu_fd_sc_mcu9t5v0__xor2_1
X_16644_ _19287_/Q _15996_/B _16648_/B VSS VSS VSS VSS gf180mcu_fd_sc_mcu9t5v0__nand2_1
X_13856_ _13856_/A1 _13855_/Z _13896_/A2 VSS _13856_/VNW VSS VSS gf180mcu_fd_sc_mcu9t5v0__nor2_1
X_19432_ _19432_/D _20072_/RN clkload8/I _19432_/Q VSS VSS VSS VSS gf180mcu_fd_sc_mcu9t5v0__dffrnq_1
X_12807_ _19760_/Q _12806_/Z _12822_/A1 VSS VSS VSS VSS gf180mcu_fd_sc_mcu9t5v0__nand2_1
X_16575_ _16576_/B _16684_/A2 VSS VSS VSS VSS gf180mcu_fd_sc_mcu9t5v0__clkinv_1
X_10999_ _18934_/Q _18042_/A2 _18933_/Q _11000_/B VSS VSS VSS VSS gf180mcu_fd_sc_mcu9t5v0__oai21_1
X_19363_ _19363_/D _20067_/RN _19633_/CLK _19363_/Q VSS VSS VSS VSS gf180mcu_fd_sc_mcu9t5v0__dffrnq_1
X_13787_ _19305_/Q _14357_/I0 _14139_/S _19305_/D VSS VSS VSS VSS gf180mcu_fd_sc_mcu9t5v0__mux2_1
X_15526_ _19845_/Q _19846_/Q _15521_/Z _15526_/Z VSS _15526_/VNW VSS VSS gf180mcu_fd_sc_mcu9t5v0__and3_1
X_18314_ _18314_/D clkload52/I _18314_/Q VSS VSS VSS VSS gf180mcu_fd_sc_mcu9t5v0__dffq_1
X_19294_ _19294_/D _20062_/RN clkload15/I _19294_/Q VSS VSS VSS VSS gf180mcu_fd_sc_mcu9t5v0__dffrnq_1
X_12738_ _19750_/Q _12738_/A2 _12739_/I0 VSS _12956_/VNW VSS VSS gf180mcu_fd_sc_mcu9t5v0__xnor2_1
X_15457_ _19822_/Q _15445_/B _15459_/B VSS VSS VSS VSS gf180mcu_fd_sc_mcu9t5v0__nand2_1
X_18245_ _18245_/D clkload69/I _18245_/Q VSS VSS VSS VSS gf180mcu_fd_sc_mcu9t5v0__dffq_1
X_12669_ _12655_/S _12685_/B _12667_/Z _12669_/B _19179_/D VSS VSS VSS VSS gf180mcu_fd_sc_mcu9t5v0__oai31_1
XTAP_TAPCELL_ROW_26_1691 VSS VSS gf180mcu_fd_sc_mcu9t5v0__filltie
X_14408_ _14408_/A1 _14408_/A2 _14408_/A3 _14408_/B _14421_/A1 VSS VSS VSS VSS gf180mcu_fd_sc_mcu9t5v0__oai31_1
X_18176_ _18176_/D clkload74/I _18176_/Q VSS VSS VSS VSS gf180mcu_fd_sc_mcu9t5v0__dffq_4
Xmax_cap202 _10643_/B2 _10353_/C VSS VSS VSS VSS gf180mcu_fd_sc_mcu9t5v0__clkbuf_4
XTAP_TAPCELL_ROW_111_4040 VSS VSS gf180mcu_fd_sc_mcu9t5v0__filltie
X_15388_ _19673_/Q _19773_/Q _15420_/S _19773_/D VSS VSS VSS VSS gf180mcu_fd_sc_mcu9t5v0__mux2_1
XTAP_TAPCELL_ROW_22_1577 VSS VSS gf180mcu_fd_sc_mcu9t5v0__filltie
XTAP_TAPCELL_ROW_22_1588 VSS VSS gf180mcu_fd_sc_mcu9t5v0__filltie
XTAP_TAPCELL_ROW_305_7462 VSS VSS gf180mcu_fd_sc_mcu9t5v0__filltie
X_17127_ _17260_/S _18395_/Q _17129_/A3 VSS _17127_/VNW VSS VSS gf180mcu_fd_sc_mcu9t5v0__nor2_1
XTAP_TAPCELL_ROW_305_7451 VSS VSS gf180mcu_fd_sc_mcu9t5v0__filltie
X_14339_ _13757_/Z _19410_/Q _14352_/S _19410_/D VSS _14339_/VNW VSS VSS gf180mcu_fd_sc_mcu9t5v0__mux2_1
XTAP_TAPCELL_ROW_22_1599 VSS VSS gf180mcu_fd_sc_mcu9t5v0__filltie
X_17058_ _17057_/Z _18520_/Q _17058_/S _18520_/D VSS VSS VSS VSS gf180mcu_fd_sc_mcu9t5v0__mux2_1
XTAP_TAPCELL_ROW_301_7337 VSS VSS gf180mcu_fd_sc_mcu9t5v0__filltie
XTAP_TAPCELL_ROW_297_7230 VSS VSS gf180mcu_fd_sc_mcu9t5v0__filltie
XTAP_TAPCELL_ROW_301_7359 VSS VSS gf180mcu_fd_sc_mcu9t5v0__filltie
XTAP_TAPCELL_ROW_301_7348 VSS VSS gf180mcu_fd_sc_mcu9t5v0__filltie
XTAP_TAPCELL_ROW_297_7241 VSS VSS gf180mcu_fd_sc_mcu9t5v0__filltie
X_16009_ _16750_/A1 _16628_/A2 _16009_/B _16011_/A2 VSS VSS VSS VSS gf180mcu_fd_sc_mcu9t5v0__aoi21_1
X_09880_ _20034_/Q _09880_/A2 _17075_/A1 wire81/I VSS VSS VSS VSS gf180mcu_fd_sc_mcu9t5v0__nor3_4
XTAP_TAPCELL_ROW_293_7127 VSS VSS gf180mcu_fd_sc_mcu9t5v0__filltie
XTAP_TAPCELL_ROW_318_7812 VSS VSS gf180mcu_fd_sc_mcu9t5v0__filltie
XTAP_TAPCELL_ROW_293_7116 VSS VSS gf180mcu_fd_sc_mcu9t5v0__filltie
XTAP_TAPCELL_ROW_124_4401 VSS VSS gf180mcu_fd_sc_mcu9t5v0__filltie
XTAP_TAPCELL_ROW_35_1938 VSS VSS gf180mcu_fd_sc_mcu9t5v0__filltie
XTAP_TAPCELL_ROW_35_1949 VSS VSS gf180mcu_fd_sc_mcu9t5v0__filltie
XTAP_TAPCELL_ROW_293_7138 VSS VSS gf180mcu_fd_sc_mcu9t5v0__filltie
XTAP_TAPCELL_ROW_318_7823 VSS VSS gf180mcu_fd_sc_mcu9t5v0__filltie
XTAP_TAPCELL_ROW_314_7709 VSS VSS gf180mcu_fd_sc_mcu9t5v0__filltie
XPHY_EDGE_ROW_289_Left_612 VSS VSS gf180mcu_fd_sc_mcu9t5v0__endcap
XPHY_EDGE_ROW_156_3_Right_271 VSS VSS gf180mcu_fd_sc_mcu9t5v0__endcap
XTAP_TAPCELL_ROW_118_4238 VSS VSS gf180mcu_fd_sc_mcu9t5v0__filltie
XTAP_TAPCELL_ROW_118_4227 VSS VSS gf180mcu_fd_sc_mcu9t5v0__filltie
XTAP_TAPCELL_ROW_118_4216 VSS VSS gf180mcu_fd_sc_mcu9t5v0__filltie
X_09314_ _19229_/Q _16408_/I0 VSS VSS VSS VSS gf180mcu_fd_sc_mcu9t5v0__clkinv_1
X_09245_ _18564_/Q _11547_/A2 VSS VSS VSS VSS gf180mcu_fd_sc_mcu9t5v0__clkinv_1
XTAP_TAPCELL_ROW_205_3_8242 VSS VSS gf180mcu_fd_sc_mcu9t5v0__filltie
XTAP_TAPCELL_ROW_282_6831 VSS VSS gf180mcu_fd_sc_mcu9t5v0__filltie
XTAP_TAPCELL_ROW_282_6820 VSS VSS gf180mcu_fd_sc_mcu9t5v0__filltie
X_09176_ _19114_/Q _13739_/A2 VSS VSS VSS VSS gf180mcu_fd_sc_mcu9t5v0__clkinv_1
XPHY_EDGE_ROW_298_Left_621 VSS VSS gf180mcu_fd_sc_mcu9t5v0__endcap
XPHY_EDGE_ROW_2_Left_326 VSS VSS gf180mcu_fd_sc_mcu9t5v0__endcap
Xoutput14 output14/I dout[3] VSS VSS VSS VSS gf180mcu_fd_sc_mcu9t5v0__dlyd_1
XTAP_TAPCELL_ROW_263_6296 VSS VSS gf180mcu_fd_sc_mcu9t5v0__filltie
X_10020_ _09916_/B _19005_/Q _10021_/B VSS VSS VSS VSS gf180mcu_fd_sc_mcu9t5v0__nand2_1
XTAP_TAPCELL_ROW_276_6668 VSS VSS gf180mcu_fd_sc_mcu9t5v0__filltie
XTAP_TAPCELL_ROW_276_6657 VSS VSS gf180mcu_fd_sc_mcu9t5v0__filltie
XTAP_TAPCELL_ROW_107_3931 VSS VSS gf180mcu_fd_sc_mcu9t5v0__filltie
XTAP_TAPCELL_ROW_107_3920 VSS VSS gf180mcu_fd_sc_mcu9t5v0__filltie
X_11971_ _18183_/Q _18167_/Q _12340_/S _11971_/Z VSS VSS VSS VSS gf180mcu_fd_sc_mcu9t5v0__mux2_1
XPHY_EDGE_ROW_167_1_Right_751 VSS VSS gf180mcu_fd_sc_mcu9t5v0__endcap
XTAP_TAPCELL_ROW_103_3817 VSS VSS gf180mcu_fd_sc_mcu9t5v0__filltie
XTAP_TAPCELL_ROW_103_3806 VSS VSS gf180mcu_fd_sc_mcu9t5v0__filltie
X_10922_ _16957_/A1 _18147_/S _10924_/B _10923_/I0 VSS VSS VSS VSS gf180mcu_fd_sc_mcu9t5v0__oai21_1
XTAP_TAPCELL_ROW_103_3828 VSS VSS gf180mcu_fd_sc_mcu9t5v0__filltie
X_13710_ _19146_/Q _19112_/Q _14666_/A1 VSS VSS VSS VSS gf180mcu_fd_sc_mcu9t5v0__xnor2_1
XTAP_TAPCELL_ROW_45_2212 VSS VSS gf180mcu_fd_sc_mcu9t5v0__filltie
X_14690_ _19534_/Q _14690_/I1 _14704_/S _19534_/D VSS VSS VSS VSS gf180mcu_fd_sc_mcu9t5v0__mux2_1
XTAP_TAPCELL_ROW_45_2223 VSS VSS gf180mcu_fd_sc_mcu9t5v0__filltie
X_10853_ _10853_/I0 _18965_/Q _18152_/S _18965_/D VSS _10853_/VNW VSS VSS gf180mcu_fd_sc_mcu9t5v0__mux2_1
X_13641_ _13615_/B _13645_/A2 _13642_/A2 VSS _13641_/VNW VSS VSS gf180mcu_fd_sc_mcu9t5v0__nand2_1
X_16360_ _18244_/Q _16359_/Z _16892_/S _18244_/D VSS _16360_/VNW VSS VSS gf180mcu_fd_sc_mcu9t5v0__mux2_4
X_13572_ _13043_/I _13572_/A2 _13571_/Z _13572_/B _19275_/D VSS _13572_/VNW VSS VSS
+ gf180mcu_fd_sc_mcu9t5v0__oai31_1
X_10784_ _18852_/Q _10784_/A2 _10785_/B VSS VSS VSS VSS gf180mcu_fd_sc_mcu9t5v0__nand2_1
XTAP_TAPCELL_ROW_41_2109 VSS VSS gf180mcu_fd_sc_mcu9t5v0__filltie
X_12523_ _18397_/Q _12582_/A2 _12526_/A3 VSS VSS VSS VSS gf180mcu_fd_sc_mcu9t5v0__nor2_1
X_16291_ _16291_/A1 _16436_/B _16292_/I1 VSS VSS VSS VSS gf180mcu_fd_sc_mcu9t5v0__nand2_4
X_15311_ _15311_/A1 _15306_/Z _15311_/B _15314_/A2 VSS _15311_/VNW VSS VSS gf180mcu_fd_sc_mcu9t5v0__oai21_1
X_15242_ _15242_/A1 _19574_/Q _15242_/B _15244_/A3 VSS _15242_/VNW VSS VSS gf180mcu_fd_sc_mcu9t5v0__aoi21_1
X_18030_ _18030_/I0 _18915_/Q _18037_/S _18915_/D VSS _18030_/VNW VSS VSS gf180mcu_fd_sc_mcu9t5v0__mux2_1
X_12454_ _18165_/Q _12613_/A2 _12458_/A2 VSS VSS VSS VSS gf180mcu_fd_sc_mcu9t5v0__nor2_1
X_11405_ _11428_/B _11403_/Z _11526_/B _11406_/B2 VSS _16684_/VNW VSS VSS gf180mcu_fd_sc_mcu9t5v0__aoi21_1
X_12385_ _18734_/Q _12527_/A2 _12543_/B1 _12384_/Z _12386_/A3 VSS VSS VSS VSS gf180mcu_fd_sc_mcu9t5v0__aoi22_2
XTAP_TAPCELL_ROW_39_2049 VSS VSS gf180mcu_fd_sc_mcu9t5v0__filltie
X_15173_ _19715_/Q _19555_/Q wire108/Z _19715_/D VSS VSS VSS VSS gf180mcu_fd_sc_mcu9t5v0__mux2_1
X_11336_ _18361_/Q wire136/I wire283/I _11337_/B2 VSS VSS VSS VSS gf180mcu_fd_sc_mcu9t5v0__aoi21_1
X_19981_ _19981_/D _20045_/RN clkload46/I _19981_/Q VSS VSS VSS VSS gf180mcu_fd_sc_mcu9t5v0__dffrnq_1
X_14124_ _14124_/A1 _14125_/A2 _14191_/A1 VSS _14191_/VNW VSS VSS gf180mcu_fd_sc_mcu9t5v0__nand2_1
X_18932_ _18932_/D _20020_/RN clkload40/I _18932_/Q VSS VSS VSS VSS gf180mcu_fd_sc_mcu9t5v0__dffrnq_1
X_14055_ _14055_/A1 _14053_/Z _14055_/Z VSS VSS VSS VSS gf180mcu_fd_sc_mcu9t5v0__xor2_1
X_11267_ _11267_/A1 _11267_/A2 _11788_/B _11268_/B2 VSS _11267_/VNW VSS VSS gf180mcu_fd_sc_mcu9t5v0__aoi21_2
XPHY_EDGE_ROW_302_Left_625 VSS VSS gf180mcu_fd_sc_mcu9t5v0__endcap
X_13006_ _19721_/Q _19753_/Q _13007_/B VSS _13008_/VNW VSS VSS gf180mcu_fd_sc_mcu9t5v0__xnor2_1
X_10218_ _18265_/Q _18249_/Q _17404_/S _10218_/Z VSS VSS VSS VSS gf180mcu_fd_sc_mcu9t5v0__mux2_1
X_11198_ _18701_/Q wire198/Z wire208/Z _11198_/B2 wire213/Z _11199_/A3 VSS VSS VSS
+ VSS gf180mcu_fd_sc_mcu9t5v0__aoi221_4
X_18863_ _18863_/D _20143_/RN clkload26/I _18863_/Q VSS VSS VSS VSS gf180mcu_fd_sc_mcu9t5v0__dffrnq_1
X_10149_ _19282_/Q _10165_/B1 _10166_/B1 _19290_/Q _19274_/Q _10166_/A2 _10151_/A3
+ VSS _10165_/VNW VSS VSS gf180mcu_fd_sc_mcu9t5v0__aoi222_1
XTAP_TAPCELL_ROW_30_1802 VSS VSS gf180mcu_fd_sc_mcu9t5v0__filltie
XTAP_TAPCELL_ROW_30_1813 VSS VSS gf180mcu_fd_sc_mcu9t5v0__filltie
X_18794_ _18794_/D _20138_/RN clkload34/I _18794_/Q VSS VSS VSS VSS gf180mcu_fd_sc_mcu9t5v0__dffrnq_1
X_17814_ _19021_/Q _18791_/Q _17845_/S _18791_/D VSS _17814_/VNW VSS VSS gf180mcu_fd_sc_mcu9t5v0__mux2_1
X_17745_ _17747_/A1 _18690_/Q _17745_/A3 _17751_/S VSS VSS VSS VSS gf180mcu_fd_sc_mcu9t5v0__nor3_1
XTAP_TAPCELL_ROW_15_1392 VSS VSS gf180mcu_fd_sc_mcu9t5v0__filltie
X_14957_ _14957_/A1 _14957_/A2 _14957_/B _14961_/A1 VSS _14957_/VNW VSS VSS gf180mcu_fd_sc_mcu9t5v0__oai21_1
X_17676_ _18639_/Q _18715_/Q _17742_/S _18715_/D VSS VSS VSS VSS gf180mcu_fd_sc_mcu9t5v0__mux2_1
XTAP_TAPCELL_ROW_186_3_8176 VSS VSS gf180mcu_fd_sc_mcu9t5v0__filltie
X_14888_ _19414_/Q _19355_/Q _14888_/Z VSS VSS VSS VSS gf180mcu_fd_sc_mcu9t5v0__or2_1
X_13908_ _13908_/I _13945_/A1 VSS VSS VSS VSS gf180mcu_fd_sc_mcu9t5v0__clkinv_1
XTAP_TAPCELL_ROW_11_1278 VSS VSS gf180mcu_fd_sc_mcu9t5v0__filltie
XTAP_TAPCELL_ROW_11_1289 VSS VSS gf180mcu_fd_sc_mcu9t5v0__filltie
X_16627_ _16627_/A1 _16042_/S _16672_/B _16628_/B VSS VSS VSS VSS gf180mcu_fd_sc_mcu9t5v0__oai21_2
X_13839_ _19317_/Q _19297_/Q _19298_/Q _19316_/Q _13842_/A1 VSS VSS VSS VSS gf180mcu_fd_sc_mcu9t5v0__aoi22_1
X_19415_ _19415_/D _20055_/RN clkload18/I _19415_/Q VSS VSS VSS VSS gf180mcu_fd_sc_mcu9t5v0__dffrnq_1
XPHY_EDGE_ROW_311_Left_634 VSS VSS gf180mcu_fd_sc_mcu9t5v0__endcap
X_16558_ _18341_/Q _16177_/C _17069_/S _18341_/D VSS _16558_/VNW VSS VSS gf180mcu_fd_sc_mcu9t5v0__mux2_1
XTAP_TAPCELL_ROW_28_1742 VSS VSS gf180mcu_fd_sc_mcu9t5v0__filltie
X_19346_ _19346_/D _20050_/RN clkload19/I _19346_/Q VSS VSS VSS VSS gf180mcu_fd_sc_mcu9t5v0__dffrnq_1
XTAP_TAPCELL_ROW_28_1753 VSS VSS gf180mcu_fd_sc_mcu9t5v0__filltie
XTAP_TAPCELL_ROW_28_1764 VSS VSS gf180mcu_fd_sc_mcu9t5v0__filltie
X_15509_ _19840_/Q _19839_/Q _15512_/B VSS _15509_/VNW VSS VSS gf180mcu_fd_sc_mcu9t5v0__nand2_1
XTAP_TAPCELL_ROW_24_1639 VSS VSS gf180mcu_fd_sc_mcu9t5v0__filltie
XTAP_TAPCELL_ROW_307_7524 VSS VSS gf180mcu_fd_sc_mcu9t5v0__filltie
X_16489_ _19233_/Q _16142_/C _17023_/S _16489_/Z VSS VSS VSS VSS gf180mcu_fd_sc_mcu9t5v0__mux2_1
XTAP_TAPCELL_ROW_307_7513 VSS VSS gf180mcu_fd_sc_mcu9t5v0__filltie
XTAP_TAPCELL_ROW_307_7502 VSS VSS gf180mcu_fd_sc_mcu9t5v0__filltie
XTAP_TAPCELL_ROW_113_4102 VSS VSS gf180mcu_fd_sc_mcu9t5v0__filltie
X_19277_ _19277_/D _20045_/RN clkload25/I _19277_/Q VSS VSS VSS VSS gf180mcu_fd_sc_mcu9t5v0__dffrnq_1
X_18228_ _18228_/D clkload81/I _18228_/Q VSS VSS VSS VSS gf180mcu_fd_sc_mcu9t5v0__dffq_4
Xclkbuf_leaf_66_clk_regs clkload1/I clkload36/I VSS VSS VSS VSS gf180mcu_fd_sc_mcu9t5v0__clkbuf_8
XPHY_EDGE_ROW_75_Left_399 VSS VSS gf180mcu_fd_sc_mcu9t5v0__endcap
XTAP_TAPCELL_ROW_299_7303 VSS VSS gf180mcu_fd_sc_mcu9t5v0__filltie
X_18159_ _18159_/D _20099_/CLK _18159_/Q VSS VSS VSS VSS gf180mcu_fd_sc_mcu9t5v0__dffq_1
X_20121_ _20121_/D clkload76/I _20121_/Q VSS VSS VSS VSS gf180mcu_fd_sc_mcu9t5v0__dffq_1
XPHY_EDGE_ROW_320_Left_643 VSS VSS gf180mcu_fd_sc_mcu9t5v0__endcap
X_09932_ _18939_/Q _10172_/A2 _10168_/B1 _18947_/Q _09998_/C _18971_/Q _09934_/A1
+ VSS _10870_/VNW VSS VSS gf180mcu_fd_sc_mcu9t5v0__aoi222_1
XPHY_EDGE_ROW_184_1_Left_507 VSS VSS gf180mcu_fd_sc_mcu9t5v0__endcap
X_20052_ _20052_/D _20052_/RN clkload51/I _20052_/Q VSS VSS VSS VSS gf180mcu_fd_sc_mcu9t5v0__dffrnq_1
X_09863_ _09880_/A2 _09863_/A2 _09863_/B _09863_/C _20032_/D VSS VSS VSS VSS gf180mcu_fd_sc_mcu9t5v0__oai211_1
X_09794_ _17900_/A1 _11591_/A2 _18838_/Q _10776_/A1 VSS VSS VSS VSS gf180mcu_fd_sc_mcu9t5v0__nand3_1
Xload_slew293 _11334_/A2 _11403_/S VSS VSS VSS VSS gf180mcu_fd_sc_mcu9t5v0__clkbuf_8
XTAP_TAPCELL_ROW_271_6532 VSS VSS gf180mcu_fd_sc_mcu9t5v0__filltie
XTAP_TAPCELL_ROW_271_6521 VSS VSS gf180mcu_fd_sc_mcu9t5v0__filltie
XTAP_TAPCELL_ROW_271_6510 VSS VSS gf180mcu_fd_sc_mcu9t5v0__filltie
XPHY_EDGE_ROW_157_3_Right_272 VSS VSS gf180mcu_fd_sc_mcu9t5v0__endcap
XTAP_TAPCELL_ROW_98_3665 VSS VSS gf180mcu_fd_sc_mcu9t5v0__filltie
XTAP_TAPCELL_ROW_269_6472 VSS VSS gf180mcu_fd_sc_mcu9t5v0__filltie
XTAP_TAPCELL_ROW_269_6461 VSS VSS gf180mcu_fd_sc_mcu9t5v0__filltie
XTAP_TAPCELL_ROW_98_3687 VSS VSS gf180mcu_fd_sc_mcu9t5v0__filltie
XTAP_TAPCELL_ROW_98_3676 VSS VSS gf180mcu_fd_sc_mcu9t5v0__filltie
XTAP_TAPCELL_ROW_265_6358 VSS VSS gf180mcu_fd_sc_mcu9t5v0__filltie
XTAP_TAPCELL_ROW_265_6347 VSS VSS gf180mcu_fd_sc_mcu9t5v0__filltie
X_09228_ _19293_/Q _13931_/A1 VSS VSS VSS VSS gf180mcu_fd_sc_mcu9t5v0__clkinv_1
XTAP_TAPCELL_ROW_265_6369 VSS VSS gf180mcu_fd_sc_mcu9t5v0__filltie
X_09159_ _19744_/Q _13415_/A1 VSS VSS VSS VSS gf180mcu_fd_sc_mcu9t5v0__clkinv_1
X_12170_ wire213/I _12170_/A2 _12170_/B _12311_/B _12171_/B VSS VSS VSS VSS gf180mcu_fd_sc_mcu9t5v0__aoi211_1
X_11121_ _19074_/Q _11321_/A2 _11123_/A1 VSS VSS VSS VSS gf180mcu_fd_sc_mcu9t5v0__nand2_1
XTAP_TAPCELL_ROW_278_6719 VSS VSS gf180mcu_fd_sc_mcu9t5v0__filltie
XTAP_TAPCELL_ROW_278_6708 VSS VSS gf180mcu_fd_sc_mcu9t5v0__filltie
XTAP_TAPCELL_ROW_192_3_8197 VSS VSS gf180mcu_fd_sc_mcu9t5v0__filltie
X_11052_ _18022_/I0 _19053_/Q _11067_/S _19053_/D VSS VSS VSS VSS gf180mcu_fd_sc_mcu9t5v0__mux2_1
X_15860_ _15953_/B _15989_/A4 _15973_/B VSS VSS VSS VSS gf180mcu_fd_sc_mcu9t5v0__or2_4
X_10003_ _09916_/B _10003_/A2 _10003_/B1 _10133_/B1 _10004_/B1 VSS VSS VSS VSS gf180mcu_fd_sc_mcu9t5v0__aoi22_1
XTAP_TAPCELL_ROW_241_5690 VSS VSS gf180mcu_fd_sc_mcu9t5v0__filltie
XTAP_TAPCELL_ROW_70_2894 VSS VSS gf180mcu_fd_sc_mcu9t5v0__filltie
X_14811_ _14811_/A1 _14811_/A2 _14812_/B VSS VSS VSS VSS gf180mcu_fd_sc_mcu9t5v0__nand2_1
X_15791_ _18026_/I0 _19961_/Q _15802_/S _19961_/D VSS _15791_/VNW VSS VSS gf180mcu_fd_sc_mcu9t5v0__mux2_1
XTAP_TAPCELL_ROW_8_1199 VSS VSS gf180mcu_fd_sc_mcu9t5v0__filltie
X_11954_ _18278_/Q _18262_/Q _12340_/S _11954_/Z VSS VSS VSS VSS gf180mcu_fd_sc_mcu9t5v0__mux2_1
X_17530_ _09065_/I _18635_/Q _17571_/S _18635_/D VSS VSS VSS VSS gf180mcu_fd_sc_mcu9t5v0__mux2_1
XPHY_EDGE_ROW_168_1_Right_752 VSS VSS gf180mcu_fd_sc_mcu9t5v0__endcap
X_14742_ _14540_/Z _14747_/A2 _14744_/A2 VSS _14742_/VNW VSS VSS gf180mcu_fd_sc_mcu9t5v0__xnor2_1
X_11885_ _18179_/Q _18163_/Q _12315_/S _11885_/Z VSS VSS VSS VSS gf180mcu_fd_sc_mcu9t5v0__mux2_1
Xeco15_sk1_4 _20132_/CLK eco15_sk2_4/I VSS VSS VSS VSS gf180mcu_fd_sc_mcu9t5v0__clkbuf_16
X_10905_ _19249_/Q _19255_/Q _18151_/S _10905_/Z VSS VSS VSS VSS gf180mcu_fd_sc_mcu9t5v0__mux2_1
X_14673_ _19530_/Q _14672_/Z _14704_/S _19530_/D VSS VSS VSS VSS gf180mcu_fd_sc_mcu9t5v0__mux2_1
X_17461_ _17461_/A1 _17479_/A2 _18577_/Q _17462_/A2 VSS _17479_/VNW VSS VSS gf180mcu_fd_sc_mcu9t5v0__aoi21_1
X_16412_ _16412_/I0 _18267_/Q _16940_/S _18267_/D VSS VSS VSS VSS gf180mcu_fd_sc_mcu9t5v0__mux2_1
XTAP_TAPCELL_ROW_250_5937 VSS VSS gf180mcu_fd_sc_mcu9t5v0__filltie
X_10836_ _20070_/Q _09709_/Z _10821_/B _10836_/B2 _10837_/A2 VSS VSS VSS VSS gf180mcu_fd_sc_mcu9t5v0__aoi22_1
XTAP_TAPCELL_ROW_198_2_8215 VSS VSS gf180mcu_fd_sc_mcu9t5v0__filltie
X_13624_ _13625_/A1 _13625_/B _13625_/A2 _13624_/Z VSS _13625_/VNW VSS VSS gf180mcu_fd_sc_mcu9t5v0__and3_1
X_19200_ _19200_/D _09246_/I clkload26/I _19200_/Q VSS VSS VSS VSS gf180mcu_fd_sc_mcu9t5v0__dffrnq_1
X_17392_ _17412_/A1 _17392_/A2 _17412_/B _17393_/A2 VSS VSS VSS VSS gf180mcu_fd_sc_mcu9t5v0__aoi21_1
XTAP_TAPCELL_ROW_250_5959 VSS VSS gf180mcu_fd_sc_mcu9t5v0__filltie
XTAP_TAPCELL_ROW_250_5948 VSS VSS gf180mcu_fd_sc_mcu9t5v0__filltie
X_19131_ _19131_/D _19963_/RN clkload35/I _19131_/Q VSS VSS VSS VSS gf180mcu_fd_sc_mcu9t5v0__dffrnq_1
X_16343_ _19231_/Q _16131_/B _16871_/S _16343_/Z VSS VSS VSS VSS gf180mcu_fd_sc_mcu9t5v0__mux2_1
X_10767_ _10693_/B _10767_/A2 _10767_/A3 _10770_/A1 VSS _10767_/VNW VSS VSS gf180mcu_fd_sc_mcu9t5v0__nand3_1
X_13555_ _13556_/B _13556_/A1 _13556_/A2 _13558_/A1 VSS VSS VSS VSS gf180mcu_fd_sc_mcu9t5v0__nor3_1
X_16274_ _16167_/B _16955_/S _16428_/B VSS VSS VSS VSS gf180mcu_fd_sc_mcu9t5v0__nand2_1
X_12506_ _18347_/Q _12382_/S _12510_/A2 VSS VSS VSS VSS gf180mcu_fd_sc_mcu9t5v0__nor2_1
X_10698_ _19827_/Q _17322_/A2 _19828_/Q _15474_/A2 VSS VSS VSS VSS gf180mcu_fd_sc_mcu9t5v0__aoi21_1
XPHY_EDGE_ROW_203_2_Left_715 VSS VSS gf180mcu_fd_sc_mcu9t5v0__endcap
X_13486_ _13486_/A1 _19780_/Q _13495_/A2 _13487_/A2 VSS VSS VSS VSS gf180mcu_fd_sc_mcu9t5v0__xnor3_1
X_19062_ _19062_/D _20022_/RN clkload32/I _19062_/Q VSS VSS VSS VSS gf180mcu_fd_sc_mcu9t5v0__dffrnq_1
X_12437_ _12355_/I _12485_/A2 _12437_/A3 _12437_/B _19150_/D VSS VSS VSS VSS gf180mcu_fd_sc_mcu9t5v0__oai31_1
X_15225_ _15225_/A1 _19571_/Q _15225_/B _15229_/A3 VSS VSS VSS VSS gf180mcu_fd_sc_mcu9t5v0__aoi21_1
X_18013_ _18029_/I0 _18898_/Q _18021_/S _18898_/D VSS VSS VSS VSS gf180mcu_fd_sc_mcu9t5v0__mux2_1
XTAP_TAPCELL_ROW_248_5888 VSS VSS gf180mcu_fd_sc_mcu9t5v0__filltie
XTAP_TAPCELL_ROW_248_5877 VSS VSS gf180mcu_fd_sc_mcu9t5v0__filltie
X_15156_ _19698_/Q _19538_/Q wire108/Z _19698_/D VSS VSS VSS VSS gf180mcu_fd_sc_mcu9t5v0__mux2_1
XTAP_TAPCELL_ROW_248_5899 VSS VSS gf180mcu_fd_sc_mcu9t5v0__filltie
X_12368_ _12368_/A1 _12501_/A2 _12369_/C VSS VSS VSS VSS gf180mcu_fd_sc_mcu9t5v0__nand2_1
X_14107_ _14034_/B _14209_/A2 _14210_/A1 VSS _14209_/VNW VSS VSS gf180mcu_fd_sc_mcu9t5v0__nand2_1
X_11319_ _11319_/A1 _11319_/A2 _11788_/B _11319_/ZN VSS VSS VSS VSS gf180mcu_fd_sc_mcu9t5v0__aoi21_1
X_12299_ _18390_/Q _12298_/Z _12299_/S _12299_/Z VSS VSS VSS VSS gf180mcu_fd_sc_mcu9t5v0__mux2_1
X_19964_ _19964_/D _20028_/RN clkload46/I _19964_/Q VSS VSS VSS VSS gf180mcu_fd_sc_mcu9t5v0__dffrnq_1
X_15087_ _15099_/A1 _15099_/A2 _15089_/A2 VSS _15087_/VNW VSS VSS gf180mcu_fd_sc_mcu9t5v0__nand2_1
X_19895_ _19895_/D _20023_/RN clkload40/I _19895_/Q VSS VSS VSS VSS gf180mcu_fd_sc_mcu9t5v0__dffrnq_1
XTAP_TAPCELL_ROW_17_1443 VSS VSS gf180mcu_fd_sc_mcu9t5v0__filltie
X_14038_ _14038_/I _14057_/A1 VSS VSS VSS VSS gf180mcu_fd_sc_mcu9t5v0__clkinv_1
XTAP_TAPCELL_ROW_17_1454 VSS VSS gf180mcu_fd_sc_mcu9t5v0__filltie
X_18915_ _18915_/D _20067_/RN _19806_/CLK _18915_/Q VSS VSS VSS VSS gf180mcu_fd_sc_mcu9t5v0__dffrnq_1
XPHY_EDGE_ROW_136_2_Left_648 VSS VSS gf180mcu_fd_sc_mcu9t5v0__endcap
X_18846_ _18846_/D _20062_/RN clkload33/I _18846_/Q VSS VSS VSS VSS gf180mcu_fd_sc_mcu9t5v0__dffrnq_1
XTAP_TAPCELL_ROW_13_1329 VSS VSS gf180mcu_fd_sc_mcu9t5v0__filltie
X_18777_ _18777_/D _20057_/RN clkload51/I _18777_/Q VSS VSS VSS VSS gf180mcu_fd_sc_mcu9t5v0__dffrnq_1
X_15989_ _10064_/S _16234_/A1 _15989_/A3 _15989_/A4 _15990_/B VSS VSS VSS VSS gf180mcu_fd_sc_mcu9t5v0__nor4_1
X_17728_ _18740_/Q _17685_/S _17729_/B VSS VSS VSS VSS gf180mcu_fd_sc_mcu9t5v0__nand2_1
XTAP_TAPCELL_ROW_288_7004 VSS VSS gf180mcu_fd_sc_mcu9t5v0__filltie
X_17659_ _18622_/Q _18698_/Q _17685_/S _18698_/D VSS VSS VSS VSS gf180mcu_fd_sc_mcu9t5v0__mux2_1
XPHY_EDGE_ROW_198_2_Left_710 VSS VSS gf180mcu_fd_sc_mcu9t5v0__endcap
XTAP_TAPCELL_ROW_80_3190 VSS VSS gf180mcu_fd_sc_mcu9t5v0__filltie
XPHY_EDGE_ROW_83_Left_407 VSS VSS gf180mcu_fd_sc_mcu9t5v0__endcap
X_19329_ _19329_/D _20033_/RN clkload19/I _19329_/Q VSS VSS VSS VSS gf180mcu_fd_sc_mcu9t5v0__dffrnq_1
XTAP_TAPCELL_ROW_93_3551 VSS VSS gf180mcu_fd_sc_mcu9t5v0__filltie
XTAP_TAPCELL_ROW_93_3540 VSS VSS gf180mcu_fd_sc_mcu9t5v0__filltie
XTAP_TAPCELL_ROW_132_4599 VSS VSS gf180mcu_fd_sc_mcu9t5v0__filltie
XTAP_TAPCELL_ROW_260_6211 VSS VSS gf180mcu_fd_sc_mcu9t5v0__filltie
XTAP_TAPCELL_ROW_260_6233 VSS VSS gf180mcu_fd_sc_mcu9t5v0__filltie
XTAP_TAPCELL_ROW_260_6222 VSS VSS gf180mcu_fd_sc_mcu9t5v0__filltie
X_20104_ _20104_/D clkload78/I _20104_/Q VSS VSS VSS VSS gf180mcu_fd_sc_mcu9t5v0__dffq_1
X_09915_ _10057_/A1 _10054_/A2 _10133_/B1 VSS VSS VSS VSS gf180mcu_fd_sc_mcu9t5v0__nor2_1
XPHY_EDGE_ROW_92_Left_416 VSS VSS gf180mcu_fd_sc_mcu9t5v0__endcap
X_09846_ _10794_/A2 _15442_/A1 _09846_/Z VSS VSS VSS VSS gf180mcu_fd_sc_mcu9t5v0__and2_1
X_20035_ _20035_/D _20035_/RN _20054_/CLK _20035_/Q VSS VSS VSS VSS gf180mcu_fd_sc_mcu9t5v0__dffrnq_1
XTAP_TAPCELL_ROW_258_6162 VSS VSS gf180mcu_fd_sc_mcu9t5v0__filltie
XTAP_TAPCELL_ROW_87_3377 VSS VSS gf180mcu_fd_sc_mcu9t5v0__filltie
XTAP_TAPCELL_ROW_87_3366 VSS VSS gf180mcu_fd_sc_mcu9t5v0__filltie
XTAP_TAPCELL_ROW_258_6173 VSS VSS gf180mcu_fd_sc_mcu9t5v0__filltie
XTAP_TAPCELL_ROW_87_3388 VSS VSS gf180mcu_fd_sc_mcu9t5v0__filltie
X_09777_ _18846_/Q _10688_/B _09791_/C VSS VSS VSS VSS gf180mcu_fd_sc_mcu9t5v0__xnor2_1
XTAP_TAPCELL_ROW_254_6059 VSS VSS gf180mcu_fd_sc_mcu9t5v0__filltie
XTAP_TAPCELL_ROW_254_6048 VSS VSS gf180mcu_fd_sc_mcu9t5v0__filltie
XTAP_TAPCELL_ROW_3_1052 VSS VSS gf180mcu_fd_sc_mcu9t5v0__filltie
XTAP_TAPCELL_ROW_3_1063 VSS VSS gf180mcu_fd_sc_mcu9t5v0__filltie
XPHY_EDGE_ROW_182_2_Left_694 VSS VSS gf180mcu_fd_sc_mcu9t5v0__endcap
XTAP_TAPCELL_ROW_3_1074 VSS VSS gf180mcu_fd_sc_mcu9t5v0__filltie
XTAP_TAPCELL_ROW_267_6409 VSS VSS gf180mcu_fd_sc_mcu9t5v0__filltie
XPHY_EDGE_ROW_158_3_Right_273 VSS VSS gf180mcu_fd_sc_mcu9t5v0__endcap
X_11670_ _11621_/Z _11671_/A2 _11671_/B VSS _11671_/VNW VSS VSS gf180mcu_fd_sc_mcu9t5v0__nand2_1
X_10621_ _10621_/A1 _10621_/A2 _17306_/C _10622_/B VSS _10621_/VNW VSS VSS gf180mcu_fd_sc_mcu9t5v0__aoi21_1
XPHY_EDGE_ROW_226_Left_549 VSS VSS gf180mcu_fd_sc_mcu9t5v0__endcap
X_10552_ _10552_/A1 _10552_/A2 _10552_/B1 _10809_/B _10552_/ZN VSS VSS VSS VSS gf180mcu_fd_sc_mcu9t5v0__aoi22_4
X_13340_ _12734_/Z _13339_/Z _13419_/B _13341_/B2 VSS VSS VSS VSS gf180mcu_fd_sc_mcu9t5v0__aoi21_1
XTAP_TAPCELL_ROW_230_5391 VSS VSS gf180mcu_fd_sc_mcu9t5v0__filltie
X_13271_ _13271_/A1 _13271_/A2 _13271_/B _13290_/A2 VSS _13271_/VNW VSS VSS gf180mcu_fd_sc_mcu9t5v0__oai21_1
X_10483_ _17399_/A1 _18258_/Q _10486_/A2 VSS _10495_/VNW VSS VSS gf180mcu_fd_sc_mcu9t5v0__nor2_1
X_12222_ _18466_/Q _18450_/Q _12340_/S _12222_/Z VSS VSS VSS VSS gf180mcu_fd_sc_mcu9t5v0__mux2_1
Xrebuffer273 _16511_/A4 _16477_/A1 VSS _16571_/VNW VSS VSS gf180mcu_fd_sc_mcu9t5v0__buf_8
Xrebuffer262 _15855_/ZN _15953_/B VSS VSS VSS VSS gf180mcu_fd_sc_mcu9t5v0__buf_8
X_15010_ _19623_/Q _15010_/I1 _15163_/S _19623_/D VSS VSS VSS VSS gf180mcu_fd_sc_mcu9t5v0__mux2_1
X_12153_ _18383_/Q _12183_/C _12153_/B _12162_/A2 VSS VSS VSS VSS gf180mcu_fd_sc_mcu9t5v0__aoi21_1
XTAP_TAPCELL_ROW_243_5752 VSS VSS gf180mcu_fd_sc_mcu9t5v0__filltie
XTAP_TAPCELL_ROW_243_5741 VSS VSS gf180mcu_fd_sc_mcu9t5v0__filltie
XTAP_TAPCELL_ROW_72_2967 VSS VSS gf180mcu_fd_sc_mcu9t5v0__filltie
XTAP_TAPCELL_ROW_72_2956 VSS VSS gf180mcu_fd_sc_mcu9t5v0__filltie
X_12084_ _11736_/C _12084_/A2 _12094_/B2 VSS _12088_/VNW VSS VSS gf180mcu_fd_sc_mcu9t5v0__nand2_1
X_11104_ _11521_/B _11104_/A2 _11104_/B _11105_/A2 VSS VSS VSS VSS gf180mcu_fd_sc_mcu9t5v0__oai21_1
XTAP_TAPCELL_ROW_243_5763 VSS VSS gf180mcu_fd_sc_mcu9t5v0__filltie
X_16961_ _16961_/A1 _16809_/S _16961_/B _16962_/I0 VSS _16961_/VNW VSS VSS gf180mcu_fd_sc_mcu9t5v0__oai21_4
XPHY_EDGE_ROW_235_Left_558 VSS VSS gf180mcu_fd_sc_mcu9t5v0__endcap
X_15912_ _20121_/Q _19257_/Q _15912_/S _20121_/D VSS _17280_/VNW VSS VSS gf180mcu_fd_sc_mcu9t5v0__mux2_1
X_18700_ _18700_/D _20099_/CLK _18700_/Q VSS VSS VSS VSS gf180mcu_fd_sc_mcu9t5v0__dffq_1
X_11035_ _19068_/Q _19036_/Q _11051_/S _19036_/D VSS _11035_/VNW VSS VSS gf180mcu_fd_sc_mcu9t5v0__mux2_1
X_16892_ _18438_/Q _16891_/Z _16892_/S _18438_/D VSS VSS VSS VSS gf180mcu_fd_sc_mcu9t5v0__mux2_4
X_19680_ _19680_/D _20064_/RN _19680_/CLK _19680_/Q VSS VSS VSS VSS gf180mcu_fd_sc_mcu9t5v0__dffrnq_1
X_18631_ _18631_/D _20035_/RN clkload64/I _18631_/Q VSS VSS VSS VSS gf180mcu_fd_sc_mcu9t5v0__dffrnq_1
X_15843_ _20018_/Q _09758_/B _17521_/S VSS VSS VSS VSS gf180mcu_fd_sc_mcu9t5v0__nand2_2
X_18562_ _18562_/D _20062_/RN clkload51/I _18562_/Q VSS VSS VSS VSS gf180mcu_fd_sc_mcu9t5v0__dffrnq_1
X_15774_ input4/Z _19944_/Q _15786_/S _19944_/D VSS VSS VSS VSS gf180mcu_fd_sc_mcu9t5v0__mux2_1
X_12986_ _12986_/A1 _12987_/A2 _13512_/A1 VSS VSS VSS VSS gf180mcu_fd_sc_mcu9t5v0__nand2_1
X_17513_ _18618_/Q _19259_/Q _17513_/S _18618_/D VSS VSS VSS VSS gf180mcu_fd_sc_mcu9t5v0__mux2_1
XTAP_TAPCELL_ROW_237_5578 VSS VSS gf180mcu_fd_sc_mcu9t5v0__filltie
XPHY_EDGE_ROW_169_1_Right_753 VSS VSS gf180mcu_fd_sc_mcu9t5v0__endcap
X_14725_ _19162_/Q _19128_/Q _14725_/B _14728_/A2 VSS VSS VSS VSS gf180mcu_fd_sc_mcu9t5v0__aoi21_1
X_18493_ _18493_/D clkload60/I _18493_/Q VSS VSS VSS VSS gf180mcu_fd_sc_mcu9t5v0__dffq_1
X_11937_ _18293_/Q _12340_/S _11939_/A2 VSS _11937_/VNW VSS VSS gf180mcu_fd_sc_mcu9t5v0__nand2_1
XTAP_TAPCELL_ROW_237_5589 VSS VSS gf180mcu_fd_sc_mcu9t5v0__filltie
X_11868_ _18242_/Q _12345_/A2 _11872_/A1 VSS VSS VSS VSS gf180mcu_fd_sc_mcu9t5v0__nand2_1
XPHY_EDGE_ROW_244_Left_567 VSS VSS gf180mcu_fd_sc_mcu9t5v0__endcap
X_14656_ _14657_/A1 _14657_/A3 _14656_/B _14660_/B VSS _14656_/VNW VSS VSS gf180mcu_fd_sc_mcu9t5v0__aoi21_1
X_17444_ _20010_/Q _17444_/A2 _17462_/A1 VSS VSS VSS VSS gf180mcu_fd_sc_mcu9t5v0__nor2_1
X_17375_ _17260_/S _18535_/Q _17377_/A3 VSS VSS VSS VSS gf180mcu_fd_sc_mcu9t5v0__nor2_1
X_10819_ _10820_/B2 _10819_/A2 _10819_/Z VSS VSS VSS VSS gf180mcu_fd_sc_mcu9t5v0__and2_1
X_11799_ _12183_/C _11797_/Z _11799_/B _12342_/C _11806_/A1 VSS VSS VSS VSS gf180mcu_fd_sc_mcu9t5v0__oai211_1
X_13607_ _19284_/Q _13419_/B _13612_/B VSS VSS VSS VSS gf180mcu_fd_sc_mcu9t5v0__nand2_1
X_14587_ _19172_/Q _14587_/A2 _14587_/B _14591_/A1 VSS VSS VSS VSS gf180mcu_fd_sc_mcu9t5v0__oai21_1
X_16326_ _18228_/Q _16325_/Z _16854_/S _18228_/D VSS _16326_/VNW VSS VSS gf180mcu_fd_sc_mcu9t5v0__mux2_4
X_13538_ _13541_/A3 _13538_/A2 _13538_/B _19268_/D VSS _13538_/VNW VSS VSS gf180mcu_fd_sc_mcu9t5v0__oai21_1
X_19114_ _19114_/D _20138_/RN clkload32/I _19114_/Q VSS VSS VSS VSS gf180mcu_fd_sc_mcu9t5v0__dffrnq_1
X_19045_ _19045_/D _20069_/RN clkload35/I _19045_/Q VSS VSS VSS VSS gf180mcu_fd_sc_mcu9t5v0__dffrnq_1
X_16257_ _19266_/Q _16815_/A2 _16259_/A1 VSS VSS VSS VSS gf180mcu_fd_sc_mcu9t5v0__nand2_1
X_13469_ _13469_/A1 _13469_/A2 _13485_/A1 _13470_/A2 VSS VSS VSS VSS gf180mcu_fd_sc_mcu9t5v0__xnor3_1
X_16188_ _19274_/Q _16725_/C _16189_/C VSS VSS VSS VSS gf180mcu_fd_sc_mcu9t5v0__nand2_1
X_15208_ _15417_/S _15208_/A2 _15208_/B _19721_/D VSS VSS VSS VSS gf180mcu_fd_sc_mcu9t5v0__oai21_1
XTAP_TAPCELL_ROW_19_1505 VSS VSS gf180mcu_fd_sc_mcu9t5v0__filltie
XTAP_TAPCELL_ROW_321_7885 VSS VSS gf180mcu_fd_sc_mcu9t5v0__filltie
XPHY_EDGE_ROW_253_Left_576 VSS VSS gf180mcu_fd_sc_mcu9t5v0__endcap
X_15139_ _19681_/Q _19521_/Q wire108/Z _19681_/D VSS _15139_/VNW VSS VSS gf180mcu_fd_sc_mcu9t5v0__mux2_1
XTAP_TAPCELL_ROW_19_1516 VSS VSS gf180mcu_fd_sc_mcu9t5v0__filltie
XTAP_TAPCELL_ROW_321_7896 VSS VSS gf180mcu_fd_sc_mcu9t5v0__filltie
X_19947_ _19947_/D _20139_/RN clkload48/I _19947_/Q VSS VSS VSS VSS gf180mcu_fd_sc_mcu9t5v0__dffrnq_1
X_09700_ _09700_/A1 _17763_/A3 _09758_/B VSS VSS VSS VSS gf180mcu_fd_sc_mcu9t5v0__nor2_4
X_19878_ _19878_/D _20070_/RN clkload46/I _19878_/Q VSS VSS VSS VSS gf180mcu_fd_sc_mcu9t5v0__dffrnq_1
X_18829_ _18829_/D _20045_/RN clkload55/I _18829_/Q VSS VSS VSS VSS gf180mcu_fd_sc_mcu9t5v0__dffrnq_1
X_09631_ wire300/Z _09675_/A1 _09646_/A3 VSS VSS VSS VSS gf180mcu_fd_sc_mcu9t5v0__nor2_1
X_09562_ _20005_/Q _10034_/A2 _10157_/B1 VSS VSS VSS VSS gf180mcu_fd_sc_mcu9t5v0__nor2_1
XTAP_TAPCELL_ROW_82_3230 VSS VSS gf180mcu_fd_sc_mcu9t5v0__filltie
XTAP_TAPCELL_ROW_82_3241 VSS VSS gf180mcu_fd_sc_mcu9t5v0__filltie
XPHY_EDGE_ROW_262_Left_585 VSS VSS gf180mcu_fd_sc_mcu9t5v0__endcap
X_09493_ _18584_/Q _12487_/A1 _12354_/A1 _18583_/Q _09495_/A2 VSS VSS VSS VSS gf180mcu_fd_sc_mcu9t5v0__oai22_4
XPHY_EDGE_ROW_286_Right_213 VSS VSS gf180mcu_fd_sc_mcu9t5v0__endcap
Xclkbuf_leaf_81_clk_regs clkbuf_3_0_0_clk_regs/Z clkload16/I VSS VSS VSS VSS gf180mcu_fd_sc_mcu9t5v0__clkbuf_8
Xclkbuf_leaf_10_clk_regs clkload3/I clkload47/I VSS VSS VSS VSS gf180mcu_fd_sc_mcu9t5v0__clkbuf_8
XTAP_TAPCELL_ROW_95_3602 VSS VSS gf180mcu_fd_sc_mcu9t5v0__filltie
XTAP_TAPCELL_ROW_76_3078 VSS VSS gf180mcu_fd_sc_mcu9t5v0__filltie
XTAP_TAPCELL_ROW_76_3067 VSS VSS gf180mcu_fd_sc_mcu9t5v0__filltie
XPHY_EDGE_ROW_271_Left_594 VSS VSS gf180mcu_fd_sc_mcu9t5v0__endcap
XTAP_TAPCELL_ROW_89_3428 VSS VSS gf180mcu_fd_sc_mcu9t5v0__filltie
XTAP_TAPCELL_ROW_89_3417 VSS VSS gf180mcu_fd_sc_mcu9t5v0__filltie
XTAP_TAPCELL_ROW_89_3439 VSS VSS gf180mcu_fd_sc_mcu9t5v0__filltie
X_20018_ _20018_/D _20018_/RN _20049_/CLK _20018_/Q VSS VSS VSS VSS gf180mcu_fd_sc_mcu9t5v0__dffrnq_1
X_09829_ _09829_/A1 _09829_/A2 _09830_/A2 VSS _09829_/VNW VSS VSS gf180mcu_fd_sc_mcu9t5v0__nand2_1
XTAP_TAPCELL_ROW_5_1114 VSS VSS gf180mcu_fd_sc_mcu9t5v0__filltie
X_12840_ _19733_/Q _19798_/Q _12948_/S _12840_/Z VSS VSS VSS VSS gf180mcu_fd_sc_mcu9t5v0__mux2_1
XTAP_TAPCELL_ROW_5_1125 VSS VSS gf180mcu_fd_sc_mcu9t5v0__filltie
XTAP_TAPCELL_ROW_65_2760 VSS VSS gf180mcu_fd_sc_mcu9t5v0__filltie
XTAP_TAPCELL_ROW_65_2771 VSS VSS gf180mcu_fd_sc_mcu9t5v0__filltie
X_12771_ _12771_/A1 _12771_/A2 _12771_/B _12776_/A1 VSS _12771_/VNW VSS VSS gf180mcu_fd_sc_mcu9t5v0__oai21_1
X_15490_ _19832_/Q wire301/Z _15502_/S _15490_/Z VSS VSS VSS VSS gf180mcu_fd_sc_mcu9t5v0__mux2_1
X_11722_ _12628_/A1 _11722_/A2 _11722_/B _11966_/B _11723_/B VSS VSS VSS VSS gf180mcu_fd_sc_mcu9t5v0__aoi211_1
X_14510_ _19130_/Q _14510_/I1 wire199/I _14510_/Z VSS _14510_/VNW VSS VSS gf180mcu_fd_sc_mcu9t5v0__mux2_1
XTAP_TAPCELL_ROW_65_2782 VSS VSS gf180mcu_fd_sc_mcu9t5v0__filltie
XTAP_TAPCELL_ROW_232_5464 VSS VSS gf180mcu_fd_sc_mcu9t5v0__filltie
XTAP_TAPCELL_ROW_232_5453 VSS VSS gf180mcu_fd_sc_mcu9t5v0__filltie
XTAP_TAPCELL_ROW_232_5442 VSS VSS gf180mcu_fd_sc_mcu9t5v0__filltie
X_11653_ _11656_/A1 _11659_/A1 _12643_/A2 VSS _11654_/VNW VSS VSS gf180mcu_fd_sc_mcu9t5v0__nand2_1
X_14441_ _14441_/A1 _19120_/Q _14442_/B VSS VSS VSS VSS gf180mcu_fd_sc_mcu9t5v0__nand2_1
XTAP_TAPCELL_ROW_61_2657 VSS VSS gf180mcu_fd_sc_mcu9t5v0__filltie
XTAP_TAPCELL_ROW_61_2668 VSS VSS gf180mcu_fd_sc_mcu9t5v0__filltie
X_17160_ _18606_/Q _17409_/B _17225_/B _17161_/B2 VSS _17160_/VNW VSS VSS gf180mcu_fd_sc_mcu9t5v0__oai21_1
X_10604_ _10809_/B _10604_/A2 _10604_/B1 _10604_/B2 _10604_/ZN VSS VSS VSS VSS gf180mcu_fd_sc_mcu9t5v0__aoi22_4
XPHY_EDGE_ROW_159_3_Right_274 VSS VSS gf180mcu_fd_sc_mcu9t5v0__endcap
X_14372_ _14372_/A1 _14372_/A2 _19440_/D VSS _14372_/VNW VSS VSS gf180mcu_fd_sc_mcu9t5v0__nand2_1
X_16111_ _18568_/Q _16111_/A2 _16751_/B VSS VSS VSS VSS gf180mcu_fd_sc_mcu9t5v0__nand2_4
X_13323_ _13335_/A2 _19806_/Q _13345_/A1 VSS VSS VSS VSS gf180mcu_fd_sc_mcu9t5v0__nor2_1
X_11584_ _17902_/A1 _11583_/Z _11611_/B VSS _11584_/VNW VSS VSS gf180mcu_fd_sc_mcu9t5v0__nor2_1
X_10535_ _18308_/Q _17405_/A2 _10533_/Z _10514_/B _19827_/Q _10539_/A2 VSS VSS VSS
+ VSS gf180mcu_fd_sc_mcu9t5v0__aoi221_1
XTAP_TAPCELL_ROW_204_3_8238 VSS VSS gf180mcu_fd_sc_mcu9t5v0__filltie
X_17091_ _17177_/B _17091_/A2 _17091_/B wire168/I _17092_/B VSS _17091_/VNW VSS VSS
+ gf180mcu_fd_sc_mcu9t5v0__oai211_1
XTAP_TAPCELL_ROW_245_5803 VSS VSS gf180mcu_fd_sc_mcu9t5v0__filltie
X_10466_ _17275_/C _10466_/A2 _10466_/B _17304_/C _10467_/C VSS VSS VSS VSS gf180mcu_fd_sc_mcu9t5v0__oai211_1
XTAP_TAPCELL_ROW_245_5814 VSS VSS gf180mcu_fd_sc_mcu9t5v0__filltie
X_16042_ _19202_/Q _16041_/Z _16042_/S _16147_/C VSS VSS VSS VSS gf180mcu_fd_sc_mcu9t5v0__mux2_1
XTAP_TAPCELL_ROW_59_2597 VSS VSS gf180mcu_fd_sc_mcu9t5v0__filltie
X_13254_ _19768_/Q _19802_/Q _13255_/B VSS _13256_/VNW VSS VSS gf180mcu_fd_sc_mcu9t5v0__xor2_1
X_12205_ _12159_/B _12205_/A2 _12205_/A3 _12206_/B VSS VSS VSS VSS gf180mcu_fd_sc_mcu9t5v0__nand3_1
X_13185_ _16432_/A1 _13419_/B _13185_/B1 _13185_/B2 _19240_/D VSS VSS VSS VSS gf180mcu_fd_sc_mcu9t5v0__aoi22_1
X_12136_ _18494_/Q _12203_/A2 _12139_/A1 VSS VSS VSS VSS gf180mcu_fd_sc_mcu9t5v0__nand2_1
XTAP_TAPCELL_ROW_226_5279 VSS VSS gf180mcu_fd_sc_mcu9t5v0__filltie
X_10397_ _10655_/B _10397_/A2 _10397_/B1 _10397_/B2 _10397_/ZN VSS VSS VSS VSS gf180mcu_fd_sc_mcu9t5v0__aoi22_4
X_19801_ _19801_/D _20057_/RN clkload24/I _19801_/Q VSS VSS VSS VSS gf180mcu_fd_sc_mcu9t5v0__dffrnq_1
X_17993_ _18879_/Q _18026_/I0 _17997_/S _18879_/D VSS _17993_/VNW VSS VSS gf180mcu_fd_sc_mcu9t5v0__mux2_1
X_12067_ _18491_/Q _12203_/A2 _12322_/B _12067_/C _12069_/A2 VSS VSS VSS VSS gf180mcu_fd_sc_mcu9t5v0__aoi211_1
X_16944_ _16944_/I0 _18463_/Q _16960_/S _18463_/D VSS VSS VSS VSS gf180mcu_fd_sc_mcu9t5v0__mux2_1
X_19732_ _19732_/D _20052_/RN clkload16/I _19732_/Q VSS VSS VSS VSS gf180mcu_fd_sc_mcu9t5v0__dffrnq_1
X_16875_ _19249_/Q _16606_/B _16881_/S _16875_/Z VSS VSS VSS VSS gf180mcu_fd_sc_mcu9t5v0__mux2_4
X_11018_ _11018_/A1 _11013_/B _11018_/B _19020_/Q _11019_/A2 VSS _11018_/VNW VSS VSS
+ gf180mcu_fd_sc_mcu9t5v0__oai211_1
X_19663_ _19663_/D _20047_/RN clkload42/I _19663_/Q VSS VSS VSS VSS gf180mcu_fd_sc_mcu9t5v0__dffrnq_1
X_18614_ _18614_/D clkload74/I _18614_/Q VSS VSS VSS VSS gf180mcu_fd_sc_mcu9t5v0__dffq_1
X_15826_ _10063_/C _15827_/A2 _15834_/A2 VSS _15826_/VNW VSS VSS gf180mcu_fd_sc_mcu9t5v0__nand2_1
X_19594_ _19594_/D _20042_/RN clkload18/I _19594_/Q VSS VSS VSS VSS gf180mcu_fd_sc_mcu9t5v0__dffrnq_1
X_18545_ _18545_/D _20045_/RN clkload76/I _18545_/Q VSS VSS VSS VSS gf180mcu_fd_sc_mcu9t5v0__dffrnq_4
X_15757_ _19999_/Q _15757_/A2 _15757_/B _15757_/C _15758_/B VSS _15757_/VNW VSS VSS
+ gf180mcu_fd_sc_mcu9t5v0__aoi211_1
X_12969_ _19719_/Q _19751_/Q _12970_/B VSS _13506_/VNW VSS VSS gf180mcu_fd_sc_mcu9t5v0__xnor2_1
X_18476_ _18476_/D _20129_/CLK _18476_/Q VSS VSS VSS VSS gf180mcu_fd_sc_mcu9t5v0__dffq_1
X_15688_ _15703_/A2 _15747_/A2 _19999_/Q _15743_/C VSS VSS VSS VSS gf180mcu_fd_sc_mcu9t5v0__aoi21_1
X_14708_ _19158_/Q _19124_/Q _14712_/A2 VSS VSS VSS VSS gf180mcu_fd_sc_mcu9t5v0__nand2_1
XTAP_TAPCELL_ROW_310_7597 VSS VSS gf180mcu_fd_sc_mcu9t5v0__filltie
XTAP_TAPCELL_ROW_310_7586 VSS VSS gf180mcu_fd_sc_mcu9t5v0__filltie
X_17427_ _17427_/A1 _17427_/A2 _17428_/A3 VSS _17560_/VNW VSS VSS gf180mcu_fd_sc_mcu9t5v0__nand2_1
XPHY_EDGE_ROW_193_1_Left_516 VSS VSS gf180mcu_fd_sc_mcu9t5v0__endcap
X_14639_ _19101_/Q _19517_/Q _14730_/S _19517_/D VSS VSS VSS VSS gf180mcu_fd_sc_mcu9t5v0__mux2_1
XTAP_TAPCELL_ROW_215_4972 VSS VSS gf180mcu_fd_sc_mcu9t5v0__filltie
XTAP_TAPCELL_ROW_215_4994 VSS VSS gf180mcu_fd_sc_mcu9t5v0__filltie
X_17358_ _17358_/A1 _18518_/Q _17361_/A2 VSS VSS VSS VSS gf180mcu_fd_sc_mcu9t5v0__nor2_1
XTAP_TAPCELL_ROW_215_4983 VSS VSS gf180mcu_fd_sc_mcu9t5v0__filltie
XTAP_TAPCELL_ROW_133_4650 VSS VSS gf180mcu_fd_sc_mcu9t5v0__filltie
X_17289_ _17411_/C _17289_/A2 _17289_/A3 _17290_/A2 VSS _17507_/VNW VSS VSS gf180mcu_fd_sc_mcu9t5v0__nand3_1
X_16309_ _19231_/Q _16131_/B _16863_/S _16309_/Z VSS VSS VSS VSS gf180mcu_fd_sc_mcu9t5v0__mux2_1
XTAP_TAPCELL_ROW_211_4869 VSS VSS gf180mcu_fd_sc_mcu9t5v0__filltie
XPHY_EDGE_ROW_309_Right_236 VSS VSS gf180mcu_fd_sc_mcu9t5v0__endcap
XTAP_TAPCELL_ROW_323_7969 VSS VSS gf180mcu_fd_sc_mcu9t5v0__filltie
XTAP_TAPCELL_ROW_323_7958 VSS VSS gf180mcu_fd_sc_mcu9t5v0__filltie
XTAP_TAPCELL_ROW_323_7947 VSS VSS gf180mcu_fd_sc_mcu9t5v0__filltie
Xclkload52 clkload52/I clkload52/ZN VSS VSS VSS VSS gf180mcu_fd_sc_mcu9t5v0__clkinv_8
Xclkload41 clkload41/I clkload41/ZN VSS VSS VSS VSS gf180mcu_fd_sc_mcu9t5v0__inv_2
X_19028_ _19028_/D _20052_/RN clkload36/I _19028_/Q VSS VSS VSS VSS gf180mcu_fd_sc_mcu9t5v0__dffrnq_1
Xclkload30 clkload30/I clkload30/ZN VSS VSS VSS VSS gf180mcu_fd_sc_mcu9t5v0__clkinv_1
Xclkload74 clkload74/I clkload74/ZN VSS VSS VSS VSS gf180mcu_fd_sc_mcu9t5v0__inv_2
Xclkload63 clkload63/I clkload63/Z VSS VSS VSS VSS gf180mcu_fd_sc_mcu9t5v0__clkbuf_4
XTAP_TAPCELL_ROW_209_4798 VSS VSS gf180mcu_fd_sc_mcu9t5v0__filltie
XTAP_TAPCELL_ROW_209_4787 VSS VSS gf180mcu_fd_sc_mcu9t5v0__filltie
XTAP_TAPCELL_ROW_209_4776 VSS VSS gf180mcu_fd_sc_mcu9t5v0__filltie
XPHY_EDGE_ROW_251_Right_178 VSS VSS gf180mcu_fd_sc_mcu9t5v0__endcap
XTAP_TAPCELL_ROW_127_4487 VSS VSS gf180mcu_fd_sc_mcu9t5v0__filltie
XTAP_TAPCELL_ROW_127_4476 VSS VSS gf180mcu_fd_sc_mcu9t5v0__filltie
XTAP_TAPCELL_ROW_127_4465 VSS VSS gf180mcu_fd_sc_mcu9t5v0__filltie
XPHY_EDGE_ROW_181_3_Left_839 VSS VSS gf180mcu_fd_sc_mcu9t5v0__endcap
XTAP_TAPCELL_ROW_84_3303 VSS VSS gf180mcu_fd_sc_mcu9t5v0__filltie
X_09614_ _20072_/Q _09614_/A2 _15834_/B2 VSS VSS VSS VSS gf180mcu_fd_sc_mcu9t5v0__nand2_1
X_09545_ _20144_/Q _20006_/Q _20007_/Q _09547_/C VSS _15836_/VNW VSS VSS gf180mcu_fd_sc_mcu9t5v0__nor3_1
X_09476_ _18685_/Q _17631_/A1 _09477_/A3 wire198/I VSS _09583_/VNW VSS VSS gf180mcu_fd_sc_mcu9t5v0__and3_2
XTAP_TAPCELL_ROW_78_3129 VSS VSS gf180mcu_fd_sc_mcu9t5v0__filltie
XTAP_TAPCELL_ROW_78_3118 VSS VSS gf180mcu_fd_sc_mcu9t5v0__filltie
Xwire128 wire128/I wire128/Z VSS VSS VSS VSS gf180mcu_fd_sc_mcu9t5v0__clkbuf_4
Xclkload2 clkload2/I clkload2/ZN VSS VSS VSS VSS gf180mcu_fd_sc_mcu9t5v0__clkinv_16
XTAP_TAPCELL_ROW_285_6895 VSS VSS gf180mcu_fd_sc_mcu9t5v0__filltie
X_10320_ _18220_/Q _17282_/A2 _10326_/B1 VSS _10320_/VNW VSS VSS gf180mcu_fd_sc_mcu9t5v0__nand2_1
X_10251_ _18832_/Q _17878_/A1 _10804_/A2 VSS VSS VSS VSS gf180mcu_fd_sc_mcu9t5v0__nand2_1
X_10182_ _10063_/C _10182_/A2 _10182_/B output18/I VSS VSS VSS VSS gf180mcu_fd_sc_mcu9t5v0__oai21_1
XTAP_TAPCELL_ROW_54_2461 VSS VSS gf180mcu_fd_sc_mcu9t5v0__filltie
XTAP_TAPCELL_ROW_54_2472 VSS VSS gf180mcu_fd_sc_mcu9t5v0__filltie
Xfanout250 wire28/Z _16986_/S VSS VSS VSS VSS gf180mcu_fd_sc_mcu9t5v0__clkbuf_16
XTAP_TAPCELL_ROW_221_5143 VSS VSS gf180mcu_fd_sc_mcu9t5v0__filltie
XTAP_TAPCELL_ROW_50_2347 VSS VSS gf180mcu_fd_sc_mcu9t5v0__filltie
XTAP_TAPCELL_ROW_50_2358 VSS VSS gf180mcu_fd_sc_mcu9t5v0__filltie
X_14990_ _19620_/Q _14990_/I1 _15163_/S _19620_/D VSS _14990_/VNW VSS VSS gf180mcu_fd_sc_mcu9t5v0__mux2_1
XTAP_TAPCELL_ROW_221_5154 VSS VSS gf180mcu_fd_sc_mcu9t5v0__filltie
XTAP_TAPCELL_ROW_146_1_4743 VSS VSS gf180mcu_fd_sc_mcu9t5v0__filltie
X_13941_ _13942_/A1 _13940_/Z _13941_/Z VSS _13942_/VNW VSS VSS gf180mcu_fd_sc_mcu9t5v0__or2_1
XTAP_TAPCELL_ROW_50_2369 VSS VSS gf180mcu_fd_sc_mcu9t5v0__filltie
XTAP_TAPCELL_ROW_67_2822 VSS VSS gf180mcu_fd_sc_mcu9t5v0__filltie
Xload_slew47 _17033_/S _17057_/S VSS VSS VSS VSS gf180mcu_fd_sc_mcu9t5v0__clkbuf_8
X_16660_ _16750_/A1 _16674_/A2 _16660_/B _16662_/A3 VSS VSS VSS VSS gf180mcu_fd_sc_mcu9t5v0__aoi21_1
Xu_transform_scheduler_core.u_fft_scratch_sram.u_lo.g_pin_drive\[0\].u_data_driver
+ _10261_/ZN u_transform_scheduler_core.u_fft_scratch_sram.u_lo.u_sram/D[0] VSS VSS
+ VSS VSS gf180mcu_fd_sc_mcu9t5v0__buf_8
X_13872_ _13872_/A1 _13860_/Z _13872_/B _13901_/A2 VSS _13872_/VNW VSS VSS gf180mcu_fd_sc_mcu9t5v0__oai21_1
XTAP_TAPCELL_ROW_67_2833 VSS VSS gf180mcu_fd_sc_mcu9t5v0__filltie
X_16591_ _16592_/B _16692_/A2 VSS VSS VSS VSS gf180mcu_fd_sc_mcu9t5v0__clkinv_1
XTAP_TAPCELL_ROW_234_5515 VSS VSS gf180mcu_fd_sc_mcu9t5v0__filltie
XTAP_TAPCELL_ROW_234_5504 VSS VSS gf180mcu_fd_sc_mcu9t5v0__filltie
X_15611_ _15611_/I _15616_/A2 VSS VSS VSS VSS gf180mcu_fd_sc_mcu9t5v0__clkinv_1
X_12823_ _12816_/Z _12824_/B _12824_/A2 _12827_/B VSS VSS VSS VSS gf180mcu_fd_sc_mcu9t5v0__and3_1
XTAP_TAPCELL_ROW_63_2708 VSS VSS gf180mcu_fd_sc_mcu9t5v0__filltie
XTAP_TAPCELL_ROW_63_2719 VSS VSS gf180mcu_fd_sc_mcu9t5v0__filltie
X_15542_ _19860_/Q input5/Z _15551_/S _19860_/D VSS VSS VSS VSS gf180mcu_fd_sc_mcu9t5v0__mux2_1
XTAP_TAPCELL_ROW_219_5094 VSS VSS gf180mcu_fd_sc_mcu9t5v0__filltie
X_18330_ _18330_/D clkload52/I _18330_/Q VSS VSS VSS VSS gf180mcu_fd_sc_mcu9t5v0__dffq_1
XTAP_TAPCELL_ROW_219_5083 VSS VSS gf180mcu_fd_sc_mcu9t5v0__filltie
XTAP_TAPCELL_ROW_48_2298 VSS VSS gf180mcu_fd_sc_mcu9t5v0__filltie
X_12754_ _19721_/Q _19786_/Q _13244_/B _12754_/Z VSS _12756_/VNW VSS VSS gf180mcu_fd_sc_mcu9t5v0__mux2_1
X_18261_ _18261_/D clkload69/I _18261_/Q VSS VSS VSS VSS gf180mcu_fd_sc_mcu9t5v0__dffq_1
X_11705_ _11706_/A1 _11697_/Z _11748_/A1 VSS VSS VSS VSS gf180mcu_fd_sc_mcu9t5v0__nand2_4
X_15473_ _17401_/C _15471_/S _15473_/B _19827_/D VSS VSS VSS VSS gf180mcu_fd_sc_mcu9t5v0__oai21_1
X_17212_ _18495_/Q _17282_/B1 _17210_/Z _10514_/B _17275_/C _17220_/A2 VSS VSS VSS
+ VSS gf180mcu_fd_sc_mcu9t5v0__aoi221_1
X_12685_ _12685_/A1 _12645_/C _12685_/B _12688_/A2 VSS VSS VSS VSS gf180mcu_fd_sc_mcu9t5v0__aoi21_1
X_18192_ _18192_/D clkload74/I _18192_/Q VSS VSS VSS VSS gf180mcu_fd_sc_mcu9t5v0__dffq_1
XPHY_EDGE_ROW_145_2_Left_657 VSS VSS gf180mcu_fd_sc_mcu9t5v0__endcap
X_11636_ _11632_/B _12632_/A1 _11663_/A3 VSS VSS VSS VSS gf180mcu_fd_sc_mcu9t5v0__nand2_1
X_14424_ wire199/Z _14424_/A2 _14425_/C VSS _14425_/VNW VSS VSS gf180mcu_fd_sc_mcu9t5v0__nand2_1
X_11567_ _18297_/Q _12181_/A2 _12090_/B _11567_/C _11568_/A2 VSS _11567_/VNW VSS VSS
+ gf180mcu_fd_sc_mcu9t5v0__aoi211_1
X_17143_ _20030_/Q _17420_/S _17143_/A3 _17143_/B _18539_/D VSS VSS VSS VSS gf180mcu_fd_sc_mcu9t5v0__oai31_1
X_14355_ _14355_/I0 _19425_/Q _14367_/S _19425_/D VSS VSS VSS VSS gf180mcu_fd_sc_mcu9t5v0__mux2_1
X_10518_ _17260_/S _18211_/Q _10518_/B _10520_/A2 VSS VSS VSS VSS gf180mcu_fd_sc_mcu9t5v0__oai21_1
X_17074_ _18536_/Q _16750_/B _17074_/S _18536_/D VSS VSS VSS VSS gf180mcu_fd_sc_mcu9t5v0__mux2_1
X_14286_ _19192_/Q _14286_/A2 _14304_/S VSS VSS VSS VSS gf180mcu_fd_sc_mcu9t5v0__nand2_2
X_13306_ _13325_/B1 _13325_/B2 _13308_/A3 VSS _15162_/VNW VSS VSS gf180mcu_fd_sc_mcu9t5v0__nor2_1
X_11498_ _18566_/Q _18373_/Q _11500_/B1 VSS _11499_/VNW VSS VSS gf180mcu_fd_sc_mcu9t5v0__nand2_1
X_16025_ _16025_/A1 _16025_/A2 _16025_/B _16026_/I1 VSS VSS VSS VSS gf180mcu_fd_sc_mcu9t5v0__oai21_1
X_13237_ _13237_/A1 _19766_/Q _13237_/B _13255_/A2 VSS VSS VSS VSS gf180mcu_fd_sc_mcu9t5v0__oai21_1
X_10449_ _10654_/A2 _10449_/A2 _10449_/A3 _10450_/B VSS VSS VSS VSS gf180mcu_fd_sc_mcu9t5v0__nand3_1
XTAP_TAPCELL_ROW_303_7390 VSS VSS gf180mcu_fd_sc_mcu9t5v0__filltie
X_13168_ _19762_/Q _13168_/A2 _13186_/B VSS VSS VSS VSS gf180mcu_fd_sc_mcu9t5v0__nand2_1
X_12119_ _18381_/Q _12322_/B _12261_/B _12120_/B2 VSS _12119_/VNW VSS VSS gf180mcu_fd_sc_mcu9t5v0__aoi21_1
X_13099_ _19726_/Q _13101_/A2 _13100_/I VSS _13101_/VNW VSS VSS gf180mcu_fd_sc_mcu9t5v0__nand2_1
XTAP_TAPCELL_ROW_37_1991 VSS VSS gf180mcu_fd_sc_mcu9t5v0__filltie
X_17976_ _18863_/Q _18026_/I0 _17978_/S _18863_/D VSS _17976_/VNW VSS VSS gf180mcu_fd_sc_mcu9t5v0__mux2_1
XTAP_TAPCELL_ROW_295_7191 VSS VSS gf180mcu_fd_sc_mcu9t5v0__filltie
XTAP_TAPCELL_ROW_295_7180 VSS VSS gf180mcu_fd_sc_mcu9t5v0__filltie
X_16927_ _16750_/B _19259_/Q _16927_/S _16927_/Z VSS _16927_/VNW VSS VSS gf180mcu_fd_sc_mcu9t5v0__mux2_1
X_19715_ _19715_/D _20035_/RN clkload30/I _19715_/Q VSS VSS VSS VSS gf180mcu_fd_sc_mcu9t5v0__dffrnq_1
XTAP_TAPCELL_ROW_291_7077 VSS VSS gf180mcu_fd_sc_mcu9t5v0__filltie
XTAP_TAPCELL_ROW_316_7751 VSS VSS gf180mcu_fd_sc_mcu9t5v0__filltie
XTAP_TAPCELL_ROW_291_7066 VSS VSS gf180mcu_fd_sc_mcu9t5v0__filltie
XTAP_TAPCELL_ROW_122_4351 VSS VSS gf180mcu_fd_sc_mcu9t5v0__filltie
XTAP_TAPCELL_ROW_122_4340 VSS VSS gf180mcu_fd_sc_mcu9t5v0__filltie
XTAP_TAPCELL_ROW_33_1877 VSS VSS gf180mcu_fd_sc_mcu9t5v0__filltie
XTAP_TAPCELL_ROW_33_1888 VSS VSS gf180mcu_fd_sc_mcu9t5v0__filltie
XTAP_TAPCELL_ROW_33_1899 VSS VSS gf180mcu_fd_sc_mcu9t5v0__filltie
XTAP_TAPCELL_ROW_316_7773 VSS VSS gf180mcu_fd_sc_mcu9t5v0__filltie
X_16858_ _18421_/Q _16857_/Z _16862_/S _18421_/D VSS _16858_/VNW VSS VSS gf180mcu_fd_sc_mcu9t5v0__mux2_1
XTAP_TAPCELL_ROW_316_7762 VSS VSS gf180mcu_fd_sc_mcu9t5v0__filltie
X_19646_ _19646_/D _20030_/RN clkload23/I _19646_/Q VSS VSS VSS VSS gf180mcu_fd_sc_mcu9t5v0__dffrnq_1
XTAP_TAPCELL_ROW_312_7659 VSS VSS gf180mcu_fd_sc_mcu9t5v0__filltie
XTAP_TAPCELL_ROW_312_7648 VSS VSS gf180mcu_fd_sc_mcu9t5v0__filltie
XTAP_TAPCELL_ROW_312_7637 VSS VSS gf180mcu_fd_sc_mcu9t5v0__filltie
X_16789_ _19277_/Q _16932_/A2 _16791_/A1 VSS VSS VSS VSS gf180mcu_fd_sc_mcu9t5v0__nand2_1
X_15809_ input6/Z _19978_/Q _15811_/S _19978_/D VSS _15809_/VNW VSS VSS gf180mcu_fd_sc_mcu9t5v0__mux2_1
X_19577_ _19577_/D _20025_/RN clkload16/I _19577_/Q VSS VSS VSS VSS gf180mcu_fd_sc_mcu9t5v0__dffrnq_1
X_18528_ _18528_/D clkload72/I _18528_/Q VSS VSS VSS VSS gf180mcu_fd_sc_mcu9t5v0__dffq_1
X_09330_ _19233_/Q _13049_/A1 VSS _09330_/VNW VSS VSS gf180mcu_fd_sc_mcu9t5v0__clkinv_1
X_09261_ _09261_/I _10514_/B VSS _09261_/VNW VSS VSS gf180mcu_fd_sc_mcu9t5v0__inv_3
XTAP_TAPCELL_ROW_135_4723 VSS VSS gf180mcu_fd_sc_mcu9t5v0__filltie
XTAP_TAPCELL_ROW_135_4712 VSS VSS gf180mcu_fd_sc_mcu9t5v0__filltie
XTAP_TAPCELL_ROW_135_4701 VSS VSS gf180mcu_fd_sc_mcu9t5v0__filltie
X_18459_ _18459_/D clkload61/I _18459_/Q VSS VSS VSS VSS gf180mcu_fd_sc_mcu9t5v0__dffq_1
XTAP_TAPCELL_ROW_135_4734 VSS VSS gf180mcu_fd_sc_mcu9t5v0__filltie
XTAP_TAPCELL_ROW_116_4177 VSS VSS gf180mcu_fd_sc_mcu9t5v0__filltie
X_09192_ _19130_/Q _14512_/A2 VSS VSS VSS VSS gf180mcu_fd_sc_mcu9t5v0__clkinv_1
XTAP_TAPCELL_ROW_116_4166 VSS VSS gf180mcu_fd_sc_mcu9t5v0__filltie
XPHY_EDGE_ROW_320_Right_247 VSS VSS gf180mcu_fd_sc_mcu9t5v0__endcap
XTAP_TAPCELL_ROW_280_6781 VSS VSS gf180mcu_fd_sc_mcu9t5v0__filltie
XTAP_TAPCELL_ROW_280_6770 VSS VSS gf180mcu_fd_sc_mcu9t5v0__filltie
XTAP_TAPCELL_ROW_202_2_8229 VSS VSS gf180mcu_fd_sc_mcu9t5v0__filltie
XTAP_TAPCELL_ROW_129_4538 VSS VSS gf180mcu_fd_sc_mcu9t5v0__filltie
XTAP_TAPCELL_ROW_129_4527 VSS VSS gf180mcu_fd_sc_mcu9t5v0__filltie
Xu_transform_scheduler_core.u_fft_scratch_sram.u_hi.g_pin_drive\[2\].u_data_driver
+ _10527_/ZN u_transform_scheduler_core.u_fft_scratch_sram.u_hi.u_sram/D[2] VSS VSS
+ VSS VSS gf180mcu_fd_sc_mcu9t5v0__buf_8
XTAP_TAPCELL_ROW_274_6596 VSS VSS gf180mcu_fd_sc_mcu9t5v0__filltie
XTAP_TAPCELL_ROW_105_3881 VSS VSS gf180mcu_fd_sc_mcu9t5v0__filltie
XTAP_TAPCELL_ROW_105_3870 VSS VSS gf180mcu_fd_sc_mcu9t5v0__filltie
XTAP_TAPCELL_ROW_0_940 VSS VSS gf180mcu_fd_sc_mcu9t5v0__filltie
X_09528_ _17423_/A1 _19841_/Q _19840_/Q _09528_/B2 _09531_/A1 VSS VSS VSS VSS gf180mcu_fd_sc_mcu9t5v0__oai22_1
XTAP_TAPCELL_ROW_101_3767 VSS VSS gf180mcu_fd_sc_mcu9t5v0__filltie
XTAP_TAPCELL_ROW_0_951 VSS VSS gf180mcu_fd_sc_mcu9t5v0__filltie
XTAP_TAPCELL_ROW_0_962 VSS VSS gf180mcu_fd_sc_mcu9t5v0__filltie
XTAP_TAPCELL_ROW_0_973 VSS VSS gf180mcu_fd_sc_mcu9t5v0__filltie
XTAP_TAPCELL_ROW_101_3756 VSS VSS gf180mcu_fd_sc_mcu9t5v0__filltie
XTAP_TAPCELL_ROW_0_984 VSS VSS gf180mcu_fd_sc_mcu9t5v0__filltie
XTAP_TAPCELL_ROW_0_995 VSS VSS gf180mcu_fd_sc_mcu9t5v0__filltie
X_09459_ _10189_/S _09458_/Z _13763_/S VSS VSS VSS VSS gf180mcu_fd_sc_mcu9t5v0__nand2_4
XTAP_TAPCELL_ROW_43_2162 VSS VSS gf180mcu_fd_sc_mcu9t5v0__filltie
XTAP_TAPCELL_ROW_43_2173 VSS VSS gf180mcu_fd_sc_mcu9t5v0__filltie
XTAP_TAPCELL_ROW_287_6968 VSS VSS gf180mcu_fd_sc_mcu9t5v0__filltie
XTAP_TAPCELL_ROW_287_6957 VSS VSS gf180mcu_fd_sc_mcu9t5v0__filltie
X_12470_ _18167_/Q _12613_/A2 _12474_/A2 VSS VSS VSS VSS gf180mcu_fd_sc_mcu9t5v0__nor2_1
X_11421_ _18881_/Q _12689_/C _11423_/A2 VSS _11421_/VNW VSS VSS gf180mcu_fd_sc_mcu9t5v0__nor2_1
X_11352_ _18876_/Q _12689_/C _11354_/A2 VSS VSS VSS VSS gf180mcu_fd_sc_mcu9t5v0__nor2_1
X_14140_ _19316_/Q _14166_/B _14144_/A1 VSS VSS VSS VSS gf180mcu_fd_sc_mcu9t5v0__nand2_1
XTAP_TAPCELL_ROW_56_2512 VSS VSS gf180mcu_fd_sc_mcu9t5v0__filltie
X_10303_ _20080_/Q _17408_/B _10304_/A3 VSS VSS VSS VSS gf180mcu_fd_sc_mcu9t5v0__nand2_1
XTAP_TAPCELL_ROW_56_2523 VSS VSS gf180mcu_fd_sc_mcu9t5v0__filltie
XTAP_TAPCELL_ROW_56_2534 VSS VSS gf180mcu_fd_sc_mcu9t5v0__filltie
XTAP_TAPCELL_ROW_223_5205 VSS VSS gf180mcu_fd_sc_mcu9t5v0__filltie
X_11283_ _11283_/A1 _11283_/A2 _19085_/D VSS _11283_/VNW VSS VSS gf180mcu_fd_sc_mcu9t5v0__nand2_1
X_14071_ _14071_/A1 _14079_/A2 _14043_/Z _14115_/A1 _14133_/A2 VSS VSS VSS VSS gf180mcu_fd_sc_mcu9t5v0__oai22_1
XTAP_TAPCELL_ROW_52_2409 VSS VSS gf180mcu_fd_sc_mcu9t5v0__filltie
X_10234_ _17278_/C _10234_/A2 _17304_/C _10234_/C _10238_/B VSS VSS VSS VSS gf180mcu_fd_sc_mcu9t5v0__oai211_1
XTAP_TAPCELL_ROW_223_5216 VSS VSS gf180mcu_fd_sc_mcu9t5v0__filltie
X_13022_ _13022_/A1 _13022_/A2 _13516_/B _13039_/A2 VSS _13022_/VNW VSS VSS gf180mcu_fd_sc_mcu9t5v0__aoi21_1
X_10165_ _19267_/Q _10165_/A2 _10165_/B1 _19283_/Q _10167_/A1 VSS _10165_/VNW VSS
+ VSS gf180mcu_fd_sc_mcu9t5v0__aoi22_1
X_17830_ _19037_/Q _18807_/Q _17844_/S _18807_/D VSS _17830_/VNW VSS VSS gf180mcu_fd_sc_mcu9t5v0__mux2_1
X_10096_ _19201_/Q _10172_/A2 _10169_/B1 _19241_/Q _10096_/C _10097_/A2 VSS VSS VSS
+ VSS gf180mcu_fd_sc_mcu9t5v0__aoi221_1
X_17761_ _18756_/Q _17761_/A2 _17762_/A3 VSS VSS VSS VSS gf180mcu_fd_sc_mcu9t5v0__nor2_1
X_19500_ _19500_/D _20140_/RN clkload42/I _19500_/Q VSS VSS VSS VSS gf180mcu_fd_sc_mcu9t5v0__dffrnq_1
X_14973_ _19428_/Q _19373_/Q _14973_/Z VSS _14973_/VNW VSS VSS gf180mcu_fd_sc_mcu9t5v0__or2_1
X_16712_ _16722_/A1 _16712_/A2 _16712_/A3 _16712_/B _18368_/D VSS VSS VSS VSS gf180mcu_fd_sc_mcu9t5v0__oai31_4
X_17692_ _17692_/A1 _17673_/S _17692_/B _17692_/C _18724_/D VSS _17692_/VNW VSS VSS
+ gf180mcu_fd_sc_mcu9t5v0__oai211_1
X_13924_ _19319_/Q _19297_/Q _13956_/A2 VSS _13924_/VNW VSS VSS gf180mcu_fd_sc_mcu9t5v0__nand2_1
X_16643_ _18355_/Q _16643_/I1 _16643_/S _18355_/D VSS VSS VSS VSS gf180mcu_fd_sc_mcu9t5v0__mux2_4
X_13855_ _19292_/Q _19321_/Q _19293_/Q _19322_/Q _13855_/Z VSS _13855_/VNW VSS VSS
+ gf180mcu_fd_sc_mcu9t5v0__and4_1
X_19431_ _19431_/D _20071_/RN clkload8/I _19431_/Q VSS VSS VSS VSS gf180mcu_fd_sc_mcu9t5v0__dffrnq_1
X_12806_ _19728_/Q _19793_/Q _12948_/S _12806_/Z VSS VSS VSS VSS gf180mcu_fd_sc_mcu9t5v0__mux2_1
X_19362_ _19362_/D _20066_/RN _19633_/CLK _19362_/Q VSS VSS VSS VSS gf180mcu_fd_sc_mcu9t5v0__dffrnq_1
X_18313_ _18313_/D clkload63/I _18313_/Q VSS VSS VSS VSS gf180mcu_fd_sc_mcu9t5v0__dffq_1
X_16574_ _19213_/Q _16573_/Z _16598_/S _16576_/B VSS VSS VSS VSS gf180mcu_fd_sc_mcu9t5v0__mux2_1
X_10998_ _18925_/Q _11001_/B1 _10998_/A3 _11003_/A2 VSS VSS VSS VSS gf180mcu_fd_sc_mcu9t5v0__nand3_1
X_13786_ _13807_/A1 _13785_/Z _14357_/I0 VSS _13786_/VNW VSS VSS gf180mcu_fd_sc_mcu9t5v0__nor2_1
X_15525_ _19845_/Q _15521_/Z _19846_/Q _15527_/A2 VSS _15525_/VNW VSS VSS gf180mcu_fd_sc_mcu9t5v0__aoi21_1
X_19293_ _19293_/D _20061_/RN clkload15/I _19293_/Q VSS VSS VSS VSS gf180mcu_fd_sc_mcu9t5v0__dffrnq_1
X_12737_ _12952_/A2 _12738_/A2 _12737_/Z VSS VSS VSS VSS gf180mcu_fd_sc_mcu9t5v0__or2_1
X_18244_ _18244_/D clkload81/I _18244_/Q VSS VSS VSS VSS gf180mcu_fd_sc_mcu9t5v0__dffq_1
X_15456_ _15437_/Z _15459_/A2 _15456_/A3 _15456_/B _19821_/D VSS VSS VSS VSS gf180mcu_fd_sc_mcu9t5v0__oai31_1
X_12668_ _19179_/Q _12655_/S _12669_/B VSS VSS VSS VSS gf180mcu_fd_sc_mcu9t5v0__nand2_1
X_18175_ _18175_/D _20099_/CLK _18175_/Q VSS VSS VSS VSS gf180mcu_fd_sc_mcu9t5v0__dffq_4
XTAP_TAPCELL_ROW_26_1692 VSS VSS gf180mcu_fd_sc_mcu9t5v0__filltie
X_11619_ _11659_/A1 _11631_/C _12649_/A2 VSS _11619_/VNW VSS VSS gf180mcu_fd_sc_mcu9t5v0__nand2_1
X_14407_ _19451_/Q _14766_/A2 _14415_/A1 VSS VSS VSS VSS gf180mcu_fd_sc_mcu9t5v0__nand2_1
X_17126_ _17195_/A1 _18379_/Q _17129_/A2 VSS VSS VSS VSS gf180mcu_fd_sc_mcu9t5v0__nor2_1
X_12599_ _18454_/Q _12615_/A2 _12601_/B1 VSS VSS VSS VSS gf180mcu_fd_sc_mcu9t5v0__nor2_1
XTAP_TAPCELL_ROW_111_4030 VSS VSS gf180mcu_fd_sc_mcu9t5v0__filltie
XTAP_TAPCELL_ROW_22_1578 VSS VSS gf180mcu_fd_sc_mcu9t5v0__filltie
X_15387_ _19672_/Q _19772_/Q _15420_/S _19772_/D VSS VSS VSS VSS gf180mcu_fd_sc_mcu9t5v0__mux2_1
XTAP_TAPCELL_ROW_305_7463 VSS VSS gf180mcu_fd_sc_mcu9t5v0__filltie
XTAP_TAPCELL_ROW_305_7452 VSS VSS gf180mcu_fd_sc_mcu9t5v0__filltie
XTAP_TAPCELL_ROW_111_4041 VSS VSS gf180mcu_fd_sc_mcu9t5v0__filltie
X_14338_ _09458_/Z _14338_/A2 _14352_/S VSS VSS VSS VSS gf180mcu_fd_sc_mcu9t5v0__nand2_1
XTAP_TAPCELL_ROW_22_1589 VSS VSS gf180mcu_fd_sc_mcu9t5v0__filltie
Xmax_cap203 _17844_/S _17845_/S VSS VSS VSS VSS gf180mcu_fd_sc_mcu9t5v0__clkbuf_8
X_17057_ _16750_/B _19259_/Q _17057_/S _17057_/Z VSS _17057_/VNW VSS VSS gf180mcu_fd_sc_mcu9t5v0__mux2_1
XTAP_TAPCELL_ROW_301_7338 VSS VSS gf180mcu_fd_sc_mcu9t5v0__filltie
X_14269_ _14355_/I0 _19343_/Q _14285_/S _19343_/D VSS VSS VSS VSS gf180mcu_fd_sc_mcu9t5v0__mux2_1
XTAP_TAPCELL_ROW_301_7349 VSS VSS gf180mcu_fd_sc_mcu9t5v0__filltie
XTAP_TAPCELL_ROW_297_7242 VSS VSS gf180mcu_fd_sc_mcu9t5v0__filltie
XTAP_TAPCELL_ROW_297_7231 VSS VSS gf180mcu_fd_sc_mcu9t5v0__filltie
X_16008_ _19197_/Q _16007_/Z _16598_/S _16009_/B VSS _16008_/VNW VSS VSS gf180mcu_fd_sc_mcu9t5v0__mux2_1
XTAP_TAPCELL_ROW_293_7128 VSS VSS gf180mcu_fd_sc_mcu9t5v0__filltie
XTAP_TAPCELL_ROW_318_7802 VSS VSS gf180mcu_fd_sc_mcu9t5v0__filltie
XTAP_TAPCELL_ROW_293_7117 VSS VSS gf180mcu_fd_sc_mcu9t5v0__filltie
XTAP_TAPCELL_ROW_124_4402 VSS VSS gf180mcu_fd_sc_mcu9t5v0__filltie
XTAP_TAPCELL_ROW_35_1939 VSS VSS gf180mcu_fd_sc_mcu9t5v0__filltie
XTAP_TAPCELL_ROW_318_7824 VSS VSS gf180mcu_fd_sc_mcu9t5v0__filltie
XTAP_TAPCELL_ROW_293_7139 VSS VSS gf180mcu_fd_sc_mcu9t5v0__filltie
XTAP_TAPCELL_ROW_318_7813 VSS VSS gf180mcu_fd_sc_mcu9t5v0__filltie
X_17959_ _17959_/A1 _17959_/A2 _18856_/D VSS _17959_/VNW VSS VSS gf180mcu_fd_sc_mcu9t5v0__nand2_1
Xeco5_buf_10340 _10340_/ZN eco5_buf_10340/Z VSS VSS VSS VSS gf180mcu_fd_sc_mcu9t5v0__clkbuf_16
XPHY_EDGE_ROW_137_1_Left_460 VSS VSS gf180mcu_fd_sc_mcu9t5v0__endcap
X_19629_ _19629_/D _20141_/RN _19633_/CLK _19629_/Q VSS VSS VSS VSS gf180mcu_fd_sc_mcu9t5v0__dffrnq_1
XTAP_TAPCELL_ROW_118_4228 VSS VSS gf180mcu_fd_sc_mcu9t5v0__filltie
X_09313_ _19878_/Q _15583_/A1 VSS VSS VSS VSS gf180mcu_fd_sc_mcu9t5v0__clkinv_1
XTAP_TAPCELL_ROW_118_4217 VSS VSS gf180mcu_fd_sc_mcu9t5v0__filltie
XTAP_TAPCELL_ROW_118_4239 VSS VSS gf180mcu_fd_sc_mcu9t5v0__filltie
X_09244_ _20032_/Q _09878_/A1 VSS _09592_/VNW VSS VSS gf180mcu_fd_sc_mcu9t5v0__clkinv_1
X_09175_ _19113_/Q _13720_/A2 VSS VSS VSS VSS gf180mcu_fd_sc_mcu9t5v0__clkinv_1
XTAP_TAPCELL_ROW_282_6832 VSS VSS gf180mcu_fd_sc_mcu9t5v0__filltie
XTAP_TAPCELL_ROW_282_6821 VSS VSS gf180mcu_fd_sc_mcu9t5v0__filltie
Xoutput15 output15/I dout[4] VSS VSS VSS VSS gf180mcu_fd_sc_mcu9t5v0__dlyd_1
XTAP_TAPCELL_ROW_263_6297 VSS VSS gf180mcu_fd_sc_mcu9t5v0__filltie
XPHY_EDGE_ROW_1_Right_1 VSS VSS gf180mcu_fd_sc_mcu9t5v0__endcap
XTAP_TAPCELL_ROW_276_6669 VSS VSS gf180mcu_fd_sc_mcu9t5v0__filltie
XTAP_TAPCELL_ROW_276_6658 VSS VSS gf180mcu_fd_sc_mcu9t5v0__filltie
XTAP_TAPCELL_ROW_276_6647 VSS VSS gf180mcu_fd_sc_mcu9t5v0__filltie
XTAP_TAPCELL_ROW_107_3932 VSS VSS gf180mcu_fd_sc_mcu9t5v0__filltie
XTAP_TAPCELL_ROW_107_3921 VSS VSS gf180mcu_fd_sc_mcu9t5v0__filltie
X_11970_ _11988_/B _11988_/A1 _11983_/A1 VSS VSS VSS VSS gf180mcu_fd_sc_mcu9t5v0__nor2_4
XTAP_TAPCELL_ROW_103_3818 VSS VSS gf180mcu_fd_sc_mcu9t5v0__filltie
XTAP_TAPCELL_ROW_103_3807 VSS VSS gf180mcu_fd_sc_mcu9t5v0__filltie
X_10921_ _10921_/I0 _18999_/Q _18148_/S _18999_/D VSS VSS VSS VSS gf180mcu_fd_sc_mcu9t5v0__mux2_1
XTAP_TAPCELL_ROW_45_2213 VSS VSS gf180mcu_fd_sc_mcu9t5v0__filltie
XTAP_TAPCELL_ROW_45_2224 VSS VSS gf180mcu_fd_sc_mcu9t5v0__filltie
XPHY_EDGE_ROW_103_Left_427 VSS VSS gf180mcu_fd_sc_mcu9t5v0__endcap
XTAP_TAPCELL_ROW_216_5020 VSS VSS gf180mcu_fd_sc_mcu9t5v0__filltie
X_10852_ _16639_/A1 _18151_/S _10860_/B _10853_/I0 VSS VSS VSS VSS gf180mcu_fd_sc_mcu9t5v0__oai21_1
X_13640_ _13640_/A1 _13640_/A2 _13640_/B _13645_/A2 VSS _13640_/VNW VSS VSS gf180mcu_fd_sc_mcu9t5v0__oai21_1
X_13571_ _13571_/A1 _13570_/B _13571_/A3 _13571_/Z VSS _13572_/VNW VSS VSS gf180mcu_fd_sc_mcu9t5v0__and3_1
X_10783_ _10783_/A1 _10799_/A1 _10785_/A2 _10784_/A2 VSS VSS VSS VSS gf180mcu_fd_sc_mcu9t5v0__xnor3_1
X_12522_ _18349_/Q _12382_/S _12526_/A2 VSS VSS VSS VSS gf180mcu_fd_sc_mcu9t5v0__nor2_1
X_16290_ _16187_/C _16809_/S _16436_/B VSS _16432_/VNW VSS VSS gf180mcu_fd_sc_mcu9t5v0__nand2_4
XTAP_TAPCELL_ROW_252_5990 VSS VSS gf180mcu_fd_sc_mcu9t5v0__filltie
X_15310_ _19639_/Q _19616_/Q _15314_/A1 VSS VSS VSS VSS gf180mcu_fd_sc_mcu9t5v0__nor2_1
X_15241_ _15417_/S _15238_/Z _15242_/B _15241_/B _19727_/D VSS VSS VSS VSS gf180mcu_fd_sc_mcu9t5v0__oai31_1
X_12453_ _12355_/I _12485_/A2 _12453_/A3 _12453_/B _19152_/D VSS _12484_/VNW VSS VSS
+ gf180mcu_fd_sc_mcu9t5v0__oai31_1
X_11404_ _18566_/Q _18366_/Q _11406_/B1 VSS _16802_/VNW VSS VSS gf180mcu_fd_sc_mcu9t5v0__nand2_1
X_12384_ _12382_/Z _12383_/Z _12541_/B _12384_/Z VSS VSS VSS VSS gf180mcu_fd_sc_mcu9t5v0__mux2_1
XPHY_EDGE_ROW_112_Left_436 VSS VSS gf180mcu_fd_sc_mcu9t5v0__endcap
X_15172_ _19714_/Q _19554_/Q wire108/Z _19714_/D VSS _15172_/VNW VSS VSS gf180mcu_fd_sc_mcu9t5v0__mux2_1
X_19980_ _19980_/D _20044_/RN clkload66/I _19980_/Q VSS VSS VSS VSS gf180mcu_fd_sc_mcu9t5v0__dffrnq_1
X_11335_ _18377_/Q _11385_/A2 _11428_/B _11335_/C _11337_/B1 VSS VSS VSS VSS gf180mcu_fd_sc_mcu9t5v0__oai211_1
X_14123_ _14123_/A1 _14121_/Z _14125_/A2 VSS VSS VSS VSS gf180mcu_fd_sc_mcu9t5v0__xnor2_1
X_11266_ wire136/Z _11261_/Z _11266_/B wire283/Z _11267_/A2 VSS VSS VSS VSS gf180mcu_fd_sc_mcu9t5v0__oai211_1
X_18931_ _18931_/D _20019_/RN clkload39/I _18931_/Q VSS VSS VSS VSS gf180mcu_fd_sc_mcu9t5v0__dffrnq_1
X_14054_ _14055_/A1 _14053_/Z _14075_/A2 VSS _14075_/VNW VSS VSS gf180mcu_fd_sc_mcu9t5v0__nand2_1
X_10217_ _17406_/C _19827_/Q _17278_/C VSS VSS VSS VSS gf180mcu_fd_sc_mcu9t5v0__nand2_2
X_13005_ _13005_/A1 _19753_/Q _13028_/A1 VSS VSS VSS VSS gf180mcu_fd_sc_mcu9t5v0__nand2_1
X_11197_ _18865_/Q _12028_/C _11199_/A2 VSS _17978_/VNW VSS VSS gf180mcu_fd_sc_mcu9t5v0__nor2_1
X_18862_ _18862_/D _20142_/RN clkload24/I _18862_/Q VSS VSS VSS VSS gf180mcu_fd_sc_mcu9t5v0__dffrnq_1
X_10148_ _19266_/Q _10165_/A2 _10151_/A2 VSS VSS VSS VSS gf180mcu_fd_sc_mcu9t5v0__nand2_1
X_17813_ _17756_/Z _17813_/A2 _18790_/D VSS VSS VSS VSS gf180mcu_fd_sc_mcu9t5v0__nand2_1
XTAP_TAPCELL_ROW_30_1803 VSS VSS gf180mcu_fd_sc_mcu9t5v0__filltie
XTAP_TAPCELL_ROW_30_1814 VSS VSS gf180mcu_fd_sc_mcu9t5v0__filltie
X_18793_ _18793_/D _20073_/RN _19806_/CLK _18793_/Q VSS VSS VSS VSS gf180mcu_fd_sc_mcu9t5v0__dffrnq_1
X_10079_ _19232_/Q _10069_/C _10079_/B _10079_/C _10080_/B1 VSS VSS VSS VSS gf180mcu_fd_sc_mcu9t5v0__aoi211_1
X_17744_ _17744_/I _18748_/D VSS VSS VSS VSS gf180mcu_fd_sc_mcu9t5v0__clkinv_1
X_14956_ _19615_/Q _20039_/D _14962_/B VSS _14962_/VNW VSS VSS gf180mcu_fd_sc_mcu9t5v0__nor2_1
XTAP_TAPCELL_ROW_15_1382 VSS VSS gf180mcu_fd_sc_mcu9t5v0__filltie
XTAP_TAPCELL_ROW_15_1393 VSS VSS gf180mcu_fd_sc_mcu9t5v0__filltie
XPHY_EDGE_ROW_121_Left_445 VSS VSS gf180mcu_fd_sc_mcu9t5v0__endcap
X_13907_ _13907_/A1 _13900_/Z _13907_/B _13908_/I VSS VSS VSS VSS gf180mcu_fd_sc_mcu9t5v0__aoi21_1
X_17675_ _18638_/Q _18714_/Q _17742_/S _18714_/D VSS VSS VSS VSS gf180mcu_fd_sc_mcu9t5v0__mux2_1
X_19414_ _19414_/D _20054_/RN clkload18/I _19414_/Q VSS VSS VSS VSS gf180mcu_fd_sc_mcu9t5v0__dffrnq_1
X_14887_ _19414_/Q _19355_/Q _14891_/B VSS VSS VSS VSS gf180mcu_fd_sc_mcu9t5v0__and2_1
XTAP_TAPCELL_ROW_11_1279 VSS VSS gf180mcu_fd_sc_mcu9t5v0__filltie
X_16626_ _19284_/Q _15996_/B _16630_/B VSS _16626_/VNW VSS VSS gf180mcu_fd_sc_mcu9t5v0__nand2_1
Xmax_cap90 _16679_/B _16725_/C VSS VSS VSS VSS gf180mcu_fd_sc_mcu9t5v0__buf_4
X_13838_ _13838_/A1 _13838_/A2 _13838_/B _13870_/A1 VSS VSS VSS VSS gf180mcu_fd_sc_mcu9t5v0__aoi21_1
X_16557_ _18340_/Q _16172_/C _17069_/S _18340_/D VSS VSS VSS VSS gf180mcu_fd_sc_mcu9t5v0__mux2_1
X_13769_ _13891_/B2 _14148_/A1 _13803_/A1 _13782_/A1 _13769_/B2 _13771_/A4 VSS VSS
+ VSS VSS gf180mcu_fd_sc_mcu9t5v0__oai32_1
X_19345_ _19345_/D _20049_/RN clkload7/I _19345_/Q VSS VSS VSS VSS gf180mcu_fd_sc_mcu9t5v0__dffrnq_1
XTAP_TAPCELL_ROW_28_1743 VSS VSS gf180mcu_fd_sc_mcu9t5v0__filltie
XTAP_TAPCELL_ROW_28_1754 VSS VSS gf180mcu_fd_sc_mcu9t5v0__filltie
XTAP_TAPCELL_ROW_28_1765 VSS VSS gf180mcu_fd_sc_mcu9t5v0__filltie
X_15508_ _15566_/A1 _15507_/Z _19840_/D VSS VSS VSS VSS gf180mcu_fd_sc_mcu9t5v0__nor2_1
X_19276_ _19276_/D _20044_/RN clkload25/I _19276_/Q VSS VSS VSS VSS gf180mcu_fd_sc_mcu9t5v0__dffrnq_1
XTAP_TAPCELL_ROW_24_1629 VSS VSS gf180mcu_fd_sc_mcu9t5v0__filltie
X_18227_ _18227_/D clkload80/I _18227_/Q VSS VSS VSS VSS gf180mcu_fd_sc_mcu9t5v0__dffq_1
X_16488_ _18301_/Q _16487_/Z _17020_/S _18301_/D VSS VSS VSS VSS gf180mcu_fd_sc_mcu9t5v0__mux2_4
XTAP_TAPCELL_ROW_307_7514 VSS VSS gf180mcu_fd_sc_mcu9t5v0__filltie
XTAP_TAPCELL_ROW_307_7503 VSS VSS gf180mcu_fd_sc_mcu9t5v0__filltie
XTAP_TAPCELL_ROW_113_4103 VSS VSS gf180mcu_fd_sc_mcu9t5v0__filltie
XTAP_TAPCELL_ROW_307_7525 VSS VSS gf180mcu_fd_sc_mcu9t5v0__filltie
X_15439_ _19823_/Q _15438_/Z _15465_/A2 VSS VSS VSS VSS gf180mcu_fd_sc_mcu9t5v0__nand2_1
XPHY_EDGE_ROW_130_Left_454 VSS VSS gf180mcu_fd_sc_mcu9t5v0__endcap
XTAP_TAPCELL_ROW_299_7304 VSS VSS gf180mcu_fd_sc_mcu9t5v0__filltie
X_18158_ _18158_/D clkload72/I _18158_/Q VSS VSS VSS VSS gf180mcu_fd_sc_mcu9t5v0__dffq_1
XPHY_EDGE_ROW_190_3_Left_848 VSS VSS gf180mcu_fd_sc_mcu9t5v0__endcap
X_17109_ _19825_/Q _18394_/Q _17111_/A3 VSS _17109_/VNW VSS VSS gf180mcu_fd_sc_mcu9t5v0__nor2_1
X_18089_ _18933_/Q _18934_/Q _18932_/Q _18089_/Z VSS VSS VSS VSS gf180mcu_fd_sc_mcu9t5v0__and3_1
X_20120_ _20120_/D clkload74/I _20120_/Q VSS VSS VSS VSS gf180mcu_fd_sc_mcu9t5v0__dffq_1
X_09931_ _10057_/A1 _10054_/A2 _09931_/A3 _09931_/B _09938_/A2 VSS VSS VSS VSS gf180mcu_fd_sc_mcu9t5v0__oai31_1
XTAP_TAPCELL_ROW_91_3490 VSS VSS gf180mcu_fd_sc_mcu9t5v0__filltie
Xclkbuf_leaf_35_clk_regs clkload6/I clkload72/I VSS VSS VSS VSS gf180mcu_fd_sc_mcu9t5v0__clkbuf_8
X_20051_ _20051_/D _20051_/RN clkload55/I _20051_/Q VSS VSS VSS VSS gf180mcu_fd_sc_mcu9t5v0__dffrnq_1
X_09862_ _09849_/B _17231_/A3 _09846_/Z _09863_/C VSS VSS VSS VSS gf180mcu_fd_sc_mcu9t5v0__nand3_1
X_09793_ _18847_/Q _17902_/A1 _09793_/B _09793_/C _17909_/A1 VSS _09793_/VNW VSS VSS
+ gf180mcu_fd_sc_mcu9t5v0__aoi211_1
Xload_slew294 _10026_/B1 _10168_/B1 VSS VSS VSS VSS gf180mcu_fd_sc_mcu9t5v0__buf_4
XTAP_TAPCELL_ROW_271_6522 VSS VSS gf180mcu_fd_sc_mcu9t5v0__filltie
XTAP_TAPCELL_ROW_271_6511 VSS VSS gf180mcu_fd_sc_mcu9t5v0__filltie
XTAP_TAPCELL_ROW_271_6533 VSS VSS gf180mcu_fd_sc_mcu9t5v0__filltie
XTAP_TAPCELL_ROW_269_6473 VSS VSS gf180mcu_fd_sc_mcu9t5v0__filltie
XTAP_TAPCELL_ROW_269_6462 VSS VSS gf180mcu_fd_sc_mcu9t5v0__filltie
XTAP_TAPCELL_ROW_98_3688 VSS VSS gf180mcu_fd_sc_mcu9t5v0__filltie
XTAP_TAPCELL_ROW_98_3677 VSS VSS gf180mcu_fd_sc_mcu9t5v0__filltie
XTAP_TAPCELL_ROW_98_3666 VSS VSS gf180mcu_fd_sc_mcu9t5v0__filltie
XTAP_TAPCELL_ROW_265_6348 VSS VSS gf180mcu_fd_sc_mcu9t5v0__filltie
X_09227_ _18924_/Q _11004_/A2 VSS _09227_/VNW VSS VSS gf180mcu_fd_sc_mcu9t5v0__clkinv_1
XTAP_TAPCELL_ROW_265_6359 VSS VSS gf180mcu_fd_sc_mcu9t5v0__filltie
X_09158_ _19775_/Q _13387_/A1 VSS _09158_/VNW VSS VSS gf180mcu_fd_sc_mcu9t5v0__clkinv_1
X_09089_ _20042_/Q _10052_/A1 VSS VSS VSS VSS gf180mcu_fd_sc_mcu9t5v0__clkinv_1
X_11120_ _12071_/B _11120_/A2 _11120_/A3 _11120_/B _11122_/C VSS VSS VSS VSS gf180mcu_fd_sc_mcu9t5v0__oai31_2
XTAP_TAPCELL_ROW_278_6709 VSS VSS gf180mcu_fd_sc_mcu9t5v0__filltie
X_11051_ _15581_/B _19052_/Q _11051_/S _19052_/D VSS VSS VSS VSS gf180mcu_fd_sc_mcu9t5v0__mux2_1
XTAP_TAPCELL_ROW_241_5691 VSS VSS gf180mcu_fd_sc_mcu9t5v0__filltie
X_10002_ _09916_/B _10692_/A1 _10003_/B1 VSS VSS VSS VSS gf180mcu_fd_sc_mcu9t5v0__nand2_1
XTAP_TAPCELL_ROW_70_2895 VSS VSS gf180mcu_fd_sc_mcu9t5v0__filltie
X_14810_ _19402_/Q _19339_/Q _14814_/A1 VSS VSS VSS VSS gf180mcu_fd_sc_mcu9t5v0__xnor2_1
XPHY_EDGE_ROW_154_2_Left_666 VSS VSS gf180mcu_fd_sc_mcu9t5v0__endcap
X_15790_ _18025_/I0 _19960_/Q _15802_/S _19960_/D VSS VSS VSS VSS gf180mcu_fd_sc_mcu9t5v0__mux2_1
XTAP_TAPCELL_ROW_8_1189 VSS VSS gf180mcu_fd_sc_mcu9t5v0__filltie
X_11953_ _18246_/Q _18230_/Q _12340_/S _11953_/Z VSS _11953_/VNW VSS VSS gf180mcu_fd_sc_mcu9t5v0__mux2_1
X_14741_ _14741_/A1 _14741_/A2 _14741_/B _14747_/A2 VSS VSS VSS VSS gf180mcu_fd_sc_mcu9t5v0__aoi21_1
Xeco15_sk1_5 clkload62/I eco15_sk2_5/I VSS VSS VSS VSS gf180mcu_fd_sc_mcu9t5v0__clkbuf_16
X_10904_ _10903_/Z _18991_/Q _18152_/S _18991_/D VSS _10904_/VNW VSS VSS gf180mcu_fd_sc_mcu9t5v0__mux2_1
X_11884_ _11884_/A1 _11884_/A2 _11988_/B _11909_/A1 VSS VSS VSS VSS gf180mcu_fd_sc_mcu9t5v0__aoi21_4
X_14672_ _14675_/A1 _14675_/A2 _14672_/Z VSS VSS VSS VSS gf180mcu_fd_sc_mcu9t5v0__xor2_1
X_17460_ _17462_/A1 _17460_/A2 _18576_/D VSS _17460_/VNW VSS VSS gf180mcu_fd_sc_mcu9t5v0__nor2_1
X_17391_ _17411_/C _17391_/A2 _17391_/A3 _17392_/A2 VSS VSS VSS VSS gf180mcu_fd_sc_mcu9t5v0__nand3_1
X_16411_ _16411_/A1 _16411_/A2 _16412_/I0 VSS VSS VSS VSS gf180mcu_fd_sc_mcu9t5v0__nand2_1
XTAP_TAPCELL_ROW_250_5938 VSS VSS gf180mcu_fd_sc_mcu9t5v0__filltie
X_10835_ _15936_/C _10835_/A2 _10835_/A3 _09749_/B _10835_/B2 _20069_/D VSS VSS VSS
+ VSS gf180mcu_fd_sc_mcu9t5v0__oai32_1
X_13623_ _19287_/Q _13497_/B _13626_/B VSS _13623_/VNW VSS VSS gf180mcu_fd_sc_mcu9t5v0__nand2_1
X_16342_ _18235_/Q _16341_/Z wire38/I _18235_/D VSS _16342_/VNW VSS VSS gf180mcu_fd_sc_mcu9t5v0__mux2_1
XTAP_TAPCELL_ROW_250_5949 VSS VSS gf180mcu_fd_sc_mcu9t5v0__filltie
X_19130_ _19130_/D _20026_/RN clkload11/I _19130_/Q VSS VSS VSS VSS gf180mcu_fd_sc_mcu9t5v0__dffrnq_1
X_10766_ _10715_/C _10766_/A2 _10766_/A3 _10806_/B _10767_/A3 VSS VSS VSS VSS gf180mcu_fd_sc_mcu9t5v0__oai31_1
X_13554_ _19729_/Q _13155_/I _13556_/A2 VSS VSS VSS VSS gf180mcu_fd_sc_mcu9t5v0__nor2_1
X_16273_ _19270_/Q _16829_/A2 _16275_/A1 VSS VSS VSS VSS gf180mcu_fd_sc_mcu9t5v0__nand2_1
X_10697_ _18825_/Q _20030_/Q _10703_/B VSS VSS VSS VSS gf180mcu_fd_sc_mcu9t5v0__nand2_1
X_13485_ _13485_/A1 _13485_/A2 _13485_/B _13495_/A2 VSS _13485_/VNW VSS VSS gf180mcu_fd_sc_mcu9t5v0__aoi21_1
X_19061_ _19061_/D _20021_/RN clkload36/I _19061_/Q VSS VSS VSS VSS gf180mcu_fd_sc_mcu9t5v0__dffrnq_1
X_12505_ _12686_/C _12488_/I _12505_/A3 _12505_/B _19159_/D VSS _12505_/VNW VSS VSS
+ gf180mcu_fd_sc_mcu9t5v0__oai31_1
X_12436_ _19150_/Q _12355_/I _12437_/B VSS _12436_/VNW VSS VSS gf180mcu_fd_sc_mcu9t5v0__nand2_1
X_15224_ _15224_/A1 _19572_/Q _15229_/A2 VSS VSS VSS VSS gf180mcu_fd_sc_mcu9t5v0__nor2_1
X_18012_ _18028_/I0 _18897_/Q _18021_/S _18897_/D VSS _18012_/VNW VSS VSS gf180mcu_fd_sc_mcu9t5v0__mux2_1
XTAP_TAPCELL_ROW_248_5889 VSS VSS gf180mcu_fd_sc_mcu9t5v0__filltie
XTAP_TAPCELL_ROW_248_5878 VSS VSS gf180mcu_fd_sc_mcu9t5v0__filltie
X_15155_ _19697_/Q _19537_/Q wire108/Z _19697_/D VSS VSS VSS VSS gf180mcu_fd_sc_mcu9t5v0__mux2_1
X_12367_ _18202_/Q wire163/I _12370_/A3 VSS VSS VSS VSS gf180mcu_fd_sc_mcu9t5v0__nor2_1
X_14106_ _14115_/A1 _14077_/Z _14111_/A2 _14106_/B2 _14209_/A2 VSS _14106_/VNW VSS
+ VSS gf180mcu_fd_sc_mcu9t5v0__oai22_1
X_11318_ wire136/Z _11313_/Z _11318_/B wire283/Z _11319_/A2 VSS _12000_/VNW VSS VSS
+ gf180mcu_fd_sc_mcu9t5v0__oai211_1
X_12298_ _18374_/Q _18358_/Q _12340_/S _12298_/Z VSS _17363_/VNW VSS VSS gf180mcu_fd_sc_mcu9t5v0__mux2_1
X_19963_ _19963_/D _19963_/RN clkload45/I _19963_/Q VSS VSS VSS VSS gf180mcu_fd_sc_mcu9t5v0__dffrnq_1
X_15086_ _15086_/A1 _15086_/A2 _15098_/A2 VSS _15086_/VNW VSS VSS gf180mcu_fd_sc_mcu9t5v0__nor2_1
X_11249_ _11249_/A1 _11249_/A2 _11521_/B _11249_/C _11250_/B VSS VSS VSS VSS gf180mcu_fd_sc_mcu9t5v0__oai211_1
X_19894_ _19894_/D _20022_/RN clkload38/I _19894_/Q VSS VSS VSS VSS gf180mcu_fd_sc_mcu9t5v0__dffrnq_1
XTAP_TAPCELL_ROW_17_1444 VSS VSS gf180mcu_fd_sc_mcu9t5v0__filltie
X_14037_ _14096_/A1 _14037_/A2 _14038_/I VSS _14102_/VNW VSS VSS gf180mcu_fd_sc_mcu9t5v0__nor2_1
X_18914_ _18914_/D _20066_/RN _19806_/CLK _18914_/Q VSS VSS VSS VSS gf180mcu_fd_sc_mcu9t5v0__dffrnq_1
X_18845_ _18845_/D _20061_/RN clkload33/I _18845_/Q VSS VSS VSS VSS gf180mcu_fd_sc_mcu9t5v0__dffrnq_1
XTAP_TAPCELL_ROW_17_1455 VSS VSS gf180mcu_fd_sc_mcu9t5v0__filltie
X_15988_ _15973_/B _15988_/A2 _15988_/B _15988_/C _16107_/B VSS VSS VSS VSS gf180mcu_fd_sc_mcu9t5v0__oai211_4
X_18776_ _18776_/D _19992_/RN _20049_/CLK _18776_/Q VSS VSS VSS VSS gf180mcu_fd_sc_mcu9t5v0__dffrnq_1
X_17727_ _17727_/I _18739_/D VSS VSS VSS VSS gf180mcu_fd_sc_mcu9t5v0__clkinv_1
X_14939_ _19603_/Q _14939_/I1 _20039_/D _19603_/D VSS VSS VSS VSS gf180mcu_fd_sc_mcu9t5v0__mux2_1
X_17658_ _18621_/Q _18697_/Q _17685_/S _18697_/D VSS _17658_/VNW VSS VSS gf180mcu_fd_sc_mcu9t5v0__mux2_1
X_16609_ _18350_/Q _16609_/I1 _16670_/S _18350_/D VSS VSS VSS VSS gf180mcu_fd_sc_mcu9t5v0__mux2_1
XTAP_TAPCELL_ROW_80_3180 VSS VSS gf180mcu_fd_sc_mcu9t5v0__filltie
X_17589_ _17589_/A1 _17589_/A2 _18654_/D VSS VSS VSS VSS gf180mcu_fd_sc_mcu9t5v0__nand2_1
XTAP_TAPCELL_ROW_80_3191 VSS VSS gf180mcu_fd_sc_mcu9t5v0__filltie
X_19328_ _19328_/D _09246_/I clkload19/I _19328_/Q VSS VSS VSS VSS gf180mcu_fd_sc_mcu9t5v0__dffrnq_1
X_19259_ _19259_/D _19963_/RN _19680_/CLK _19259_/Q VSS VSS VSS VSS gf180mcu_fd_sc_mcu9t5v0__dffrnq_1
XTAP_TAPCELL_ROW_93_3552 VSS VSS gf180mcu_fd_sc_mcu9t5v0__filltie
XTAP_TAPCELL_ROW_93_3541 VSS VSS gf180mcu_fd_sc_mcu9t5v0__filltie
XTAP_TAPCELL_ROW_93_3530 VSS VSS gf180mcu_fd_sc_mcu9t5v0__filltie
XTAP_TAPCELL_ROW_260_6234 VSS VSS gf180mcu_fd_sc_mcu9t5v0__filltie
XTAP_TAPCELL_ROW_260_6223 VSS VSS gf180mcu_fd_sc_mcu9t5v0__filltie
XTAP_TAPCELL_ROW_260_6212 VSS VSS gf180mcu_fd_sc_mcu9t5v0__filltie
X_20103_ _20103_/D clkload78/I _20103_/Q VSS VSS VSS VSS gf180mcu_fd_sc_mcu9t5v0__dffq_1
X_09914_ _09981_/A1 _09914_/A2 _10028_/B _09938_/A1 VSS VSS VSS VSS gf180mcu_fd_sc_mcu9t5v0__aoi21_1
X_09845_ _19816_/Q _09849_/B _15442_/A1 VSS _09845_/VNW VSS VSS gf180mcu_fd_sc_mcu9t5v0__nand2_1
X_20034_ _20034_/D _20034_/RN _20054_/CLK _20034_/Q VSS VSS VSS VSS gf180mcu_fd_sc_mcu9t5v0__dffrnq_1
XTAP_TAPCELL_ROW_258_6163 VSS VSS gf180mcu_fd_sc_mcu9t5v0__filltie
XTAP_TAPCELL_ROW_258_6152 VSS VSS gf180mcu_fd_sc_mcu9t5v0__filltie
XTAP_TAPCELL_ROW_87_3378 VSS VSS gf180mcu_fd_sc_mcu9t5v0__filltie
XTAP_TAPCELL_ROW_87_3367 VSS VSS gf180mcu_fd_sc_mcu9t5v0__filltie
XTAP_TAPCELL_ROW_258_6174 VSS VSS gf180mcu_fd_sc_mcu9t5v0__filltie
X_09776_ _18837_/Q _18838_/Q _10688_/B VSS VSS VSS VSS gf180mcu_fd_sc_mcu9t5v0__nor2_1
XTAP_TAPCELL_ROW_254_6049 VSS VSS gf180mcu_fd_sc_mcu9t5v0__filltie
XTAP_TAPCELL_ROW_3_1053 VSS VSS gf180mcu_fd_sc_mcu9t5v0__filltie
XTAP_TAPCELL_ROW_3_1064 VSS VSS gf180mcu_fd_sc_mcu9t5v0__filltie
XTAP_TAPCELL_ROW_3_1075 VSS VSS gf180mcu_fd_sc_mcu9t5v0__filltie
X_10620_ _20107_/Q _17304_/C wire168/Z _10620_/C _10621_/A2 VSS VSS VSS VSS gf180mcu_fd_sc_mcu9t5v0__oai211_1
X_10551_ _18548_/Q wire80/Z _10650_/B1 _10551_/B2 _10552_/B1 VSS VSS VSS VSS gf180mcu_fd_sc_mcu9t5v0__aoi22_4
X_10482_ _19950_/Q wire216/Z _10655_/B _10503_/A2 VSS VSS VSS VSS gf180mcu_fd_sc_mcu9t5v0__aoi21_1
XTAP_TAPCELL_ROW_230_5392 VSS VSS gf180mcu_fd_sc_mcu9t5v0__filltie
X_13270_ _19769_/Q _19803_/Q _13271_/B VSS _13271_/VNW VSS VSS gf180mcu_fd_sc_mcu9t5v0__xnor2_1
X_12221_ _18386_/Q _12220_/Z _12299_/S _12221_/Z VSS VSS VSS VSS gf180mcu_fd_sc_mcu9t5v0__mux2_1
Xrebuffer263 _15953_/ZN _16297_/B2 VSS VSS VSS VSS gf180mcu_fd_sc_mcu9t5v0__buf_8
X_12152_ _12159_/B _12151_/Z _12162_/A1 VSS VSS VSS VSS gf180mcu_fd_sc_mcu9t5v0__nand2_1
XTAP_TAPCELL_ROW_243_5742 VSS VSS gf180mcu_fd_sc_mcu9t5v0__filltie
XTAP_TAPCELL_ROW_72_2957 VSS VSS gf180mcu_fd_sc_mcu9t5v0__filltie
X_16960_ _16960_/I0 _18471_/Q _16960_/S _18471_/D VSS _16960_/VNW VSS VSS gf180mcu_fd_sc_mcu9t5v0__mux2_1
X_12083_ _18380_/Q _12090_/B _12084_/A2 VSS VSS VSS VSS gf180mcu_fd_sc_mcu9t5v0__nand2_1
X_11103_ _11103_/A1 _11103_/A2 _11103_/B _11521_/B _11104_/B VSS _11567_/VNW VSS VSS
+ gf180mcu_fd_sc_mcu9t5v0__oai211_1
XTAP_TAPCELL_ROW_243_5764 VSS VSS gf180mcu_fd_sc_mcu9t5v0__filltie
XTAP_TAPCELL_ROW_243_5753 VSS VSS gf180mcu_fd_sc_mcu9t5v0__filltie
XTAP_TAPCELL_ROW_72_2968 VSS VSS gf180mcu_fd_sc_mcu9t5v0__filltie
X_15911_ _20120_/Q _19256_/Q wire79/Z _20120_/D VSS VSS VSS VSS gf180mcu_fd_sc_mcu9t5v0__mux2_1
X_11034_ _19067_/Q _19035_/Q _11051_/S _19035_/D VSS VSS VSS VSS gf180mcu_fd_sc_mcu9t5v0__mux2_1
X_16891_ _19257_/Q _16660_/B _16895_/S _16891_/Z VSS _16891_/VNW VSS VSS gf180mcu_fd_sc_mcu9t5v0__mux2_1
X_18630_ _18630_/D _20034_/RN clkload48/I _18630_/Q VSS VSS VSS VSS gf180mcu_fd_sc_mcu9t5v0__dffrnq_1
X_15842_ _15842_/A1 _09758_/B _17571_/S _20142_/D VSS VSS VSS VSS gf180mcu_fd_sc_mcu9t5v0__oai21_1
X_18561_ _18561_/D _20061_/RN clkload56/I _18561_/Q VSS VSS VSS VSS gf180mcu_fd_sc_mcu9t5v0__dffrnq_1
X_15773_ wire300/Z _19943_/Q _15786_/S _19943_/D VSS VSS VSS VSS gf180mcu_fd_sc_mcu9t5v0__mux2_1
X_12985_ _19720_/Q _12987_/A2 _12985_/Z VSS VSS VSS VSS gf180mcu_fd_sc_mcu9t5v0__and2_1
X_17512_ _18617_/Q _19258_/Q _17513_/S _18617_/D VSS VSS VSS VSS gf180mcu_fd_sc_mcu9t5v0__mux2_1
X_18492_ _18492_/D clkload60/I _18492_/Q VSS VSS VSS VSS gf180mcu_fd_sc_mcu9t5v0__dffq_1
X_11936_ _11936_/A1 _11936_/A2 _11936_/B1 _11936_/B2 _12116_/C _11942_/B1 VSS _11936_/VNW
+ VSS VSS gf180mcu_fd_sc_mcu9t5v0__aoi221_1
X_14724_ _14730_/S _14721_/Z _14725_/B _14724_/B _19543_/D VSS _14724_/VNW VSS VSS
+ gf180mcu_fd_sc_mcu9t5v0__oai31_1
X_17443_ _15939_/B _17443_/A2 _17443_/B1 _17443_/B2 _18568_/D VSS VSS VSS VSS gf180mcu_fd_sc_mcu9t5v0__oai22_1
XTAP_TAPCELL_ROW_237_5579 VSS VSS gf180mcu_fd_sc_mcu9t5v0__filltie
X_11867_ _18322_/Q _12299_/S _11867_/B _12320_/C _11874_/A2 VSS _11867_/VNW VSS VSS
+ gf180mcu_fd_sc_mcu9t5v0__oai211_1
X_14655_ _14715_/S _14655_/A2 _14655_/B _19525_/D VSS VSS VSS VSS gf180mcu_fd_sc_mcu9t5v0__oai21_1
X_17374_ _17378_/A1 _18519_/Q _17377_/A2 VSS _17374_/VNW VSS VSS gf180mcu_fd_sc_mcu9t5v0__nor2_1
X_10818_ _20061_/Q _10818_/A2 _09719_/Z _10818_/B _20061_/D VSS VSS VSS VSS gf180mcu_fd_sc_mcu9t5v0__oai31_1
X_11798_ _18191_/Q _12159_/B _11799_/B VSS VSS VSS VSS gf180mcu_fd_sc_mcu9t5v0__or2_1
X_13606_ _13043_/I _13606_/A2 _13605_/Z _13606_/B _19283_/D VSS VSS VSS VSS gf180mcu_fd_sc_mcu9t5v0__oai31_1
X_14586_ _14586_/A1 _14766_/A2 _14586_/B1 _14586_/B2 _19471_/D VSS VSS VSS VSS gf180mcu_fd_sc_mcu9t5v0__aoi22_1
X_16325_ _19239_/Q _16172_/C _16833_/S _16325_/Z VSS VSS VSS VSS gf180mcu_fd_sc_mcu9t5v0__mux2_1
X_10749_ _20030_/Q _10749_/A2 _10749_/B _17418_/I0 VSS VSS VSS VSS gf180mcu_fd_sc_mcu9t5v0__oai21_4
X_13537_ _13534_/B _13103_/B _13530_/Z _13615_/B _13538_/A2 VSS VSS VSS VSS gf180mcu_fd_sc_mcu9t5v0__oai31_1
X_19113_ _19113_/D _20073_/RN _19806_/CLK _19113_/Q VSS VSS VSS VSS gf180mcu_fd_sc_mcu9t5v0__dffrnq_1
X_16256_ _18206_/Q _16255_/Z _16818_/S _18206_/D VSS VSS VSS VSS gf180mcu_fd_sc_mcu9t5v0__mux2_4
X_19044_ _19044_/D _20068_/RN clkload36/I _19044_/Q VSS VSS VSS VSS gf180mcu_fd_sc_mcu9t5v0__dffrnq_1
XPHY_EDGE_ROW_232_Right_159 VSS VSS gf180mcu_fd_sc_mcu9t5v0__endcap
X_13468_ _19747_/Q _13469_/A2 _13485_/B VSS _13468_/VNW VSS VSS gf180mcu_fd_sc_mcu9t5v0__nor2_1
X_15207_ _19721_/Q _15417_/S _15208_/B VSS VSS VSS VSS gf180mcu_fd_sc_mcu9t5v0__nand2_1
X_12419_ wire146/Z _12419_/A2 _12419_/A3 _12419_/B1 _12419_/B2 wire125/I VSS VSS VSS
+ VSS gf180mcu_fd_sc_mcu9t5v0__oai32_1
X_16187_ _16751_/A2 _16751_/A3 _16751_/B _16187_/C _16189_/B VSS VSS VSS VSS gf180mcu_fd_sc_mcu9t5v0__oai211_4
X_13399_ _13497_/A1 _13399_/A2 _13419_/B _13400_/B2 VSS _13399_/VNW VSS VSS gf180mcu_fd_sc_mcu9t5v0__aoi21_1
XTAP_TAPCELL_ROW_321_7886 VSS VSS gf180mcu_fd_sc_mcu9t5v0__filltie
X_15138_ _19680_/Q _19520_/Q wire108/Z _19680_/D VSS VSS VSS VSS gf180mcu_fd_sc_mcu9t5v0__mux2_1
XTAP_TAPCELL_ROW_19_1506 VSS VSS gf180mcu_fd_sc_mcu9t5v0__filltie
XTAP_TAPCELL_ROW_19_1517 VSS VSS gf180mcu_fd_sc_mcu9t5v0__filltie
XTAP_TAPCELL_ROW_321_7897 VSS VSS gf180mcu_fd_sc_mcu9t5v0__filltie
X_19946_ _19946_/D _20138_/RN clkload54/I _19946_/Q VSS VSS VSS VSS gf180mcu_fd_sc_mcu9t5v0__dffrnq_1
X_15069_ _19309_/Q _19394_/Q _15073_/B VSS _15069_/VNW VSS VSS gf180mcu_fd_sc_mcu9t5v0__nand2_1
X_19877_ _19877_/D _20069_/RN clkload56/I _19877_/Q VSS VSS VSS VSS gf180mcu_fd_sc_mcu9t5v0__dffrnq_1
X_18828_ _18828_/D _20044_/RN clkload55/I _18828_/Q VSS VSS VSS VSS gf180mcu_fd_sc_mcu9t5v0__dffrnq_1
X_09630_ input4/Z wire300/Z _09635_/A2 _09741_/A2 _09639_/A2 VSS _09630_/VNW VSS VSS
+ gf180mcu_fd_sc_mcu9t5v0__nand4_1
X_18759_ _18759_/D _20039_/RN clkload51/I _18759_/Q VSS VSS VSS VSS gf180mcu_fd_sc_mcu9t5v0__dffrnq_1
X_09561_ _10052_/A1 _09951_/A2 _10034_/A2 VSS VSS VSS VSS gf180mcu_fd_sc_mcu9t5v0__nand2_1
XTAP_TAPCELL_ROW_82_3231 VSS VSS gf180mcu_fd_sc_mcu9t5v0__filltie
XTAP_TAPCELL_ROW_82_3242 VSS VSS gf180mcu_fd_sc_mcu9t5v0__filltie
X_09492_ _19140_/Q _14370_/A1 _09492_/B _12354_/A1 VSS VSS VSS VSS gf180mcu_fd_sc_mcu9t5v0__aoi21_4
XTAP_TAPCELL_ROW_95_3603 VSS VSS gf180mcu_fd_sc_mcu9t5v0__filltie
Xclkbuf_leaf_50_clk_regs clkload2/I clkload38/I VSS VSS VSS VSS gf180mcu_fd_sc_mcu9t5v0__clkbuf_8
XTAP_TAPCELL_ROW_76_3079 VSS VSS gf180mcu_fd_sc_mcu9t5v0__filltie
XTAP_TAPCELL_ROW_76_3068 VSS VSS gf180mcu_fd_sc_mcu9t5v0__filltie
XTAP_TAPCELL_ROW_89_3429 VSS VSS gf180mcu_fd_sc_mcu9t5v0__filltie
XTAP_TAPCELL_ROW_89_3418 VSS VSS gf180mcu_fd_sc_mcu9t5v0__filltie
XTAP_TAPCELL_ROW_110_3994 VSS VSS gf180mcu_fd_sc_mcu9t5v0__filltie
XTAP_TAPCELL_ROW_9_1240 VSS VSS gf180mcu_fd_sc_mcu9t5v0__filltie
X_20017_ _20017_/D _20145_/RN clkload55/I _20017_/Q VSS VSS VSS VSS gf180mcu_fd_sc_mcu9t5v0__dffrnq_1
XPHY_EDGE_ROW_122_Right_122 VSS VSS gf180mcu_fd_sc_mcu9t5v0__endcap
X_09828_ _11013_/B _09826_/B _09829_/A2 VSS VSS VSS VSS gf180mcu_fd_sc_mcu9t5v0__nor2_1
X_09759_ _20015_/Q _09759_/A2 _09761_/A3 VSS VSS VSS VSS gf180mcu_fd_sc_mcu9t5v0__nand2_1
XTAP_TAPCELL_ROW_5_1115 VSS VSS gf180mcu_fd_sc_mcu9t5v0__filltie
XTAP_TAPCELL_ROW_5_1126 VSS VSS gf180mcu_fd_sc_mcu9t5v0__filltie
X_12770_ _13320_/B _12770_/A2 _12770_/B _19200_/D VSS VSS VSS VSS gf180mcu_fd_sc_mcu9t5v0__oai21_1
XTAP_TAPCELL_ROW_65_2761 VSS VSS gf180mcu_fd_sc_mcu9t5v0__filltie
XTAP_TAPCELL_ROW_65_2772 VSS VSS gf180mcu_fd_sc_mcu9t5v0__filltie
X_11721_ _11721_/A1 _11721_/A2 wire213/Z _11722_/B VSS VSS VSS VSS gf180mcu_fd_sc_mcu9t5v0__aoi21_2
XTAP_TAPCELL_ROW_65_2783 VSS VSS gf180mcu_fd_sc_mcu9t5v0__filltie
XTAP_TAPCELL_ROW_232_5454 VSS VSS gf180mcu_fd_sc_mcu9t5v0__filltie
XTAP_TAPCELL_ROW_232_5443 VSS VSS gf180mcu_fd_sc_mcu9t5v0__filltie
XTAP_TAPCELL_ROW_61_2647 VSS VSS gf180mcu_fd_sc_mcu9t5v0__filltie
X_11652_ _12649_/A4 _11652_/A2 _11652_/B1 _12664_/C _12626_/B VSS _12635_/VNW VSS
+ VSS gf180mcu_fd_sc_mcu9t5v0__aoi22_1
X_14440_ _14441_/A1 _19120_/Q _14442_/A2 VSS _14440_/VNW VSS VSS gf180mcu_fd_sc_mcu9t5v0__nor2_1
XTAP_TAPCELL_ROW_61_2658 VSS VSS gf180mcu_fd_sc_mcu9t5v0__filltie
XTAP_TAPCELL_ROW_61_2669 VSS VSS gf180mcu_fd_sc_mcu9t5v0__filltie
X_10603_ _19954_/Q wire216/Z _10655_/B _10604_/B2 VSS VSS VSS VSS gf180mcu_fd_sc_mcu9t5v0__aoi21_1
X_14371_ _19440_/Q _14715_/S _14372_/A2 VSS _14372_/VNW VSS VSS gf180mcu_fd_sc_mcu9t5v0__nand2_1
X_16110_ _15939_/B _15967_/B _16679_/B VSS VSS VSS VSS gf180mcu_fd_sc_mcu9t5v0__nor2_1
X_13322_ _19739_/Q _13322_/A2 _13333_/A2 VSS _13598_/VNW VSS VSS gf180mcu_fd_sc_mcu9t5v0__nand2_1
X_11583_ _18837_/Q _18836_/Q _18838_/Q _11583_/Z VSS VSS VSS VSS gf180mcu_fd_sc_mcu9t5v0__and3_1
X_10534_ _18292_/Q _17406_/A2 _10539_/A1 VSS _11264_/VNW VSS VSS gf180mcu_fd_sc_mcu9t5v0__nand2_1
XTAP_TAPCELL_ROW_204_3_8239 VSS VSS gf180mcu_fd_sc_mcu9t5v0__filltie
X_17090_ _20123_/Q _17177_/B _17091_/B VSS VSS VSS VSS gf180mcu_fd_sc_mcu9t5v0__nand2_1
XTAP_TAPCELL_ROW_245_5815 VSS VSS gf180mcu_fd_sc_mcu9t5v0__filltie
X_10465_ _10643_/A1 _10465_/A2 _10465_/B1 _19828_/Q _10466_/B VSS VSS VSS VSS gf180mcu_fd_sc_mcu9t5v0__aoi22_1
XTAP_TAPCELL_ROW_245_5804 VSS VSS gf180mcu_fd_sc_mcu9t5v0__filltie
X_16041_ _18679_/Q _18776_/Q _16619_/S _16041_/Z VSS _16041_/VNW VSS VSS gf180mcu_fd_sc_mcu9t5v0__mux2_1
XTAP_TAPCELL_ROW_59_2598 VSS VSS gf180mcu_fd_sc_mcu9t5v0__filltie
X_13253_ _13253_/A1 _19802_/Q _13271_/A1 VSS _13253_/VNW VSS VSS gf180mcu_fd_sc_mcu9t5v0__nor2_1
X_12204_ _18481_/Q _12315_/S _12205_/A3 VSS VSS VSS VSS gf180mcu_fd_sc_mcu9t5v0__nand2_1
X_10396_ _19946_/Q wire216/Z _10655_/B _10397_/B2 VSS _10396_/VNW VSS VSS gf180mcu_fd_sc_mcu9t5v0__aoi21_1
X_13184_ _13184_/A1 _13184_/A2 _13419_/B _13185_/B2 VSS VSS VSS VSS gf180mcu_fd_sc_mcu9t5v0__aoi21_1
X_12135_ _18430_/Q _12203_/A2 _12137_/A3 VSS VSS VSS VSS gf180mcu_fd_sc_mcu9t5v0__nand2_1
X_19800_ _19800_/D _19992_/RN clkload16/I _19800_/Q VSS VSS VSS VSS gf180mcu_fd_sc_mcu9t5v0__dffrnq_1
X_17992_ _18878_/Q _18025_/I0 _17997_/S _18878_/D VSS VSS VSS VSS gf180mcu_fd_sc_mcu9t5v0__mux2_1
X_12066_ _12066_/A1 _12066_/A2 _12066_/B1 _12066_/B2 _12116_/C _12070_/B1 VSS VSS
+ VSS VSS gf180mcu_fd_sc_mcu9t5v0__aoi221_1
X_16943_ _16943_/A1 _16949_/S _16943_/B _16944_/I0 VSS VSS VSS VSS gf180mcu_fd_sc_mcu9t5v0__oai21_1
X_19731_ _19731_/D _20051_/RN clkload17/I _19731_/Q VSS VSS VSS VSS gf180mcu_fd_sc_mcu9t5v0__dffrnq_1
X_16874_ _18429_/Q _16873_/Z _16882_/S _18429_/D VSS VSS VSS VSS gf180mcu_fd_sc_mcu9t5v0__mux2_4
X_11017_ _18060_/B _10996_/S _11018_/B VSS VSS VSS VSS gf180mcu_fd_sc_mcu9t5v0__nor2_1
X_19662_ _19662_/D _20046_/RN clkload42/I _19662_/Q VSS VSS VSS VSS gf180mcu_fd_sc_mcu9t5v0__dffrnq_1
X_18613_ _18613_/D clkload75/I _18613_/Q VSS VSS VSS VSS gf180mcu_fd_sc_mcu9t5v0__dffq_1
X_15825_ _15825_/A1 _15823_/B _15825_/B _19991_/D VSS _15825_/VNW VSS VSS gf180mcu_fd_sc_mcu9t5v0__aoi21_1
X_19593_ _19593_/D _20041_/RN clkload18/I _19593_/Q VSS VSS VSS VSS gf180mcu_fd_sc_mcu9t5v0__dffrnq_1
X_18544_ _18544_/D _20044_/RN clkload72/I _18544_/Q VSS VSS VSS VSS gf180mcu_fd_sc_mcu9t5v0__dffrnq_4
X_15756_ _15759_/A1 _15759_/A3 _15757_/A2 VSS _15756_/VNW VSS VSS gf180mcu_fd_sc_mcu9t5v0__xnor2_1
XTAP_TAPCELL_ROW_120_4290 VSS VSS gf180mcu_fd_sc_mcu9t5v0__filltie
X_12968_ _12968_/A1 _19751_/Q _12978_/A1 VSS VSS VSS VSS gf180mcu_fd_sc_mcu9t5v0__nand2_1
XPHY_EDGE_ROW_301_Right_228 VSS VSS gf180mcu_fd_sc_mcu9t5v0__endcap
X_11919_ _18260_/Q _12340_/S _11921_/B1 VSS VSS VSS VSS gf180mcu_fd_sc_mcu9t5v0__nand2_1
X_18475_ _18475_/D clkload62/I _18475_/Q VSS VSS VSS VSS gf180mcu_fd_sc_mcu9t5v0__dffq_1
X_15687_ _19999_/Q _15703_/A2 _15757_/C VSS _15729_/VNW VSS VSS gf180mcu_fd_sc_mcu9t5v0__nor2_1
X_12899_ _12899_/A1 _12898_/B _12900_/I0 VSS VSS VSS VSS gf180mcu_fd_sc_mcu9t5v0__xnor2_1
X_14707_ _14766_/A2 _14707_/A2 _14707_/A3 _14707_/B _19539_/D VSS VSS VSS VSS gf180mcu_fd_sc_mcu9t5v0__oai31_1
XTAP_TAPCELL_ROW_310_7598 VSS VSS gf180mcu_fd_sc_mcu9t5v0__filltie
XTAP_TAPCELL_ROW_310_7587 VSS VSS gf180mcu_fd_sc_mcu9t5v0__filltie
X_17426_ _17426_/A1 _20011_/Q _20010_/Q _17427_/A2 VSS _17426_/VNW VSS VSS gf180mcu_fd_sc_mcu9t5v0__nor3_1
X_14638_ _19100_/Q _19516_/Q _14730_/S _19516_/D VSS _15361_/VNW VSS VSS gf180mcu_fd_sc_mcu9t5v0__mux2_1
X_17357_ _10459_/C _17357_/A2 _17357_/A3 _17357_/B _17362_/A1 VSS _17357_/VNW VSS
+ VSS gf180mcu_fd_sc_mcu9t5v0__oai31_1
X_16308_ _18219_/Q _16307_/Z _16850_/S _18219_/D VSS VSS VSS VSS gf180mcu_fd_sc_mcu9t5v0__mux2_4
XTAP_TAPCELL_ROW_215_4995 VSS VSS gf180mcu_fd_sc_mcu9t5v0__filltie
XTAP_TAPCELL_ROW_215_4984 VSS VSS gf180mcu_fd_sc_mcu9t5v0__filltie
XTAP_TAPCELL_ROW_215_4973 VSS VSS gf180mcu_fd_sc_mcu9t5v0__filltie
XTAP_TAPCELL_ROW_133_4651 VSS VSS gf180mcu_fd_sc_mcu9t5v0__filltie
XTAP_TAPCELL_ROW_133_4640 VSS VSS gf180mcu_fd_sc_mcu9t5v0__filltie
X_14569_ _19171_/Q _19137_/Q _14758_/B VSS _14569_/VNW VSS VSS gf180mcu_fd_sc_mcu9t5v0__nor2_1
X_17288_ _18612_/Q _17306_/C _17289_/A3 VSS VSS VSS VSS gf180mcu_fd_sc_mcu9t5v0__nand2_1
Xclkload20 clkload20/I clkload20/ZN VSS VSS VSS VSS gf180mcu_fd_sc_mcu9t5v0__clkinv_1
XTAP_TAPCELL_ROW_323_7959 VSS VSS gf180mcu_fd_sc_mcu9t5v0__filltie
XTAP_TAPCELL_ROW_323_7948 VSS VSS gf180mcu_fd_sc_mcu9t5v0__filltie
X_16239_ _16239_/A1 _16406_/A1 _16240_/I1 VSS VSS VSS VSS gf180mcu_fd_sc_mcu9t5v0__nand2_1
Xclkload53 clkload53/I clkload53/ZN VSS VSS VSS VSS gf180mcu_fd_sc_mcu9t5v0__inv_4
Xclkload42 clkload42/I clkload42/ZN VSS VSS VSS VSS gf180mcu_fd_sc_mcu9t5v0__inv_4
X_19027_ _19027_/D _20051_/RN clkload34/I _19027_/Q VSS VSS VSS VSS gf180mcu_fd_sc_mcu9t5v0__dffrnq_1
Xclkload31 clkload31/I clkload31/ZN VSS VSS VSS VSS gf180mcu_fd_sc_mcu9t5v0__clkinv_1
Xclkload75 clkload75/I clkload75/ZN VSS clkload75/VNW VSS VSS gf180mcu_fd_sc_mcu9t5v0__inv_2
Xclkload64 clkload64/I clkload64/ZN VSS VSS VSS VSS gf180mcu_fd_sc_mcu9t5v0__inv_2
XTAP_TAPCELL_ROW_208_1_4774 VSS VSS gf180mcu_fd_sc_mcu9t5v0__filltie
XTAP_TAPCELL_ROW_209_4788 VSS VSS gf180mcu_fd_sc_mcu9t5v0__filltie
XTAP_TAPCELL_ROW_209_4777 VSS VSS gf180mcu_fd_sc_mcu9t5v0__filltie
XTAP_TAPCELL_ROW_209_4799 VSS VSS gf180mcu_fd_sc_mcu9t5v0__filltie
X_19929_ _19929_/D _20057_/RN clkload49/I _19929_/Q VSS VSS VSS VSS gf180mcu_fd_sc_mcu9t5v0__dffrnq_1
XTAP_TAPCELL_ROW_127_4488 VSS VSS gf180mcu_fd_sc_mcu9t5v0__filltie
XTAP_TAPCELL_ROW_127_4477 VSS VSS gf180mcu_fd_sc_mcu9t5v0__filltie
XTAP_TAPCELL_ROW_127_4466 VSS VSS gf180mcu_fd_sc_mcu9t5v0__filltie
XTAP_TAPCELL_ROW_84_3304 VSS VSS gf180mcu_fd_sc_mcu9t5v0__filltie
X_09613_ _12071_/B _09613_/A2 _09688_/B _17444_/A2 _20055_/D VSS wire208/VNW VSS VSS
+ gf180mcu_fd_sc_mcu9t5v0__nand4_1
X_09544_ _20145_/Q _20001_/Q _09547_/B VSS _15837_/VNW VSS VSS gf180mcu_fd_sc_mcu9t5v0__nor2_1
X_09475_ _18694_/Q _18693_/Q _09477_/A3 VSS _17652_/VNW VSS VSS gf180mcu_fd_sc_mcu9t5v0__nand2_1
XTAP_TAPCELL_ROW_78_3119 VSS VSS gf180mcu_fd_sc_mcu9t5v0__filltie
Xclkload3 clkload3/I clkload3/ZN VSS VSS VSS VSS gf180mcu_fd_sc_mcu9t5v0__clkinv_8
XTAP_TAPCELL_ROW_285_6896 VSS VSS gf180mcu_fd_sc_mcu9t5v0__filltie
XPHY_EDGE_ROW_163_2_Left_675 VSS VSS gf180mcu_fd_sc_mcu9t5v0__endcap
X_10250_ _17879_/B2 _18831_/Q _10786_/A2 VSS VSS VSS VSS gf180mcu_fd_sc_mcu9t5v0__nor2_1
X_10181_ _10181_/A1 _10181_/A2 _10182_/B VSS _10181_/VNW VSS VSS gf180mcu_fd_sc_mcu9t5v0__nand2_1
XTAP_TAPCELL_ROW_54_2462 VSS VSS gf180mcu_fd_sc_mcu9t5v0__filltie
XTAP_TAPCELL_ROW_54_2473 VSS VSS gf180mcu_fd_sc_mcu9t5v0__filltie
XTAP_TAPCELL_ROW_221_5144 VSS VSS gf180mcu_fd_sc_mcu9t5v0__filltie
XTAP_TAPCELL_ROW_50_2348 VSS VSS gf180mcu_fd_sc_mcu9t5v0__filltie
XTAP_TAPCELL_ROW_50_2359 VSS VSS gf180mcu_fd_sc_mcu9t5v0__filltie
Xfanout251 _16828_/S _16818_/S VSS VSS VSS VSS gf180mcu_fd_sc_mcu9t5v0__clkbuf_16
XTAP_TAPCELL_ROW_221_5155 VSS VSS gf180mcu_fd_sc_mcu9t5v0__filltie
X_13940_ _13952_/A1 _13940_/A2 _13937_/Z _13940_/Z VSS VSS VSS VSS gf180mcu_fd_sc_mcu9t5v0__xor3_1
XTAP_TAPCELL_ROW_67_2812 VSS VSS gf180mcu_fd_sc_mcu9t5v0__filltie
XTAP_TAPCELL_ROW_67_2823 VSS VSS gf180mcu_fd_sc_mcu9t5v0__filltie
X_15610_ _19886_/Q _19887_/Q _19888_/Q _15629_/B _15611_/I VSS VSS VSS VSS gf180mcu_fd_sc_mcu9t5v0__nand4_1
X_13871_ _13871_/A1 _13871_/A2 _13871_/B _13907_/A1 VSS VSS VSS VSS gf180mcu_fd_sc_mcu9t5v0__oai21_1
XTAP_TAPCELL_ROW_67_2834 VSS VSS gf180mcu_fd_sc_mcu9t5v0__filltie
XTAP_TAPCELL_ROW_234_5516 VSS VSS gf180mcu_fd_sc_mcu9t5v0__filltie
XTAP_TAPCELL_ROW_234_5505 VSS VSS gf180mcu_fd_sc_mcu9t5v0__filltie
X_16590_ _19215_/Q _16589_/Z _16612_/S _16592_/B VSS VSS VSS VSS gf180mcu_fd_sc_mcu9t5v0__mux2_1
X_12822_ _12822_/A1 _12822_/A2 _12822_/A3 _12824_/A2 VSS _13164_/VNW VSS VSS gf180mcu_fd_sc_mcu9t5v0__nand3_1
XTAP_TAPCELL_ROW_63_2709 VSS VSS gf180mcu_fd_sc_mcu9t5v0__filltie
X_15541_ _19859_/Q input4/Z _15551_/S _19859_/D VSS _17118_/VNW VSS VSS gf180mcu_fd_sc_mcu9t5v0__mux2_1
XTAP_TAPCELL_ROW_219_5095 VSS VSS gf180mcu_fd_sc_mcu9t5v0__filltie
XTAP_TAPCELL_ROW_219_5084 VSS VSS gf180mcu_fd_sc_mcu9t5v0__filltie
XTAP_TAPCELL_ROW_48_2299 VSS VSS gf180mcu_fd_sc_mcu9t5v0__filltie
X_12753_ _12753_/A1 _12753_/A2 _12753_/B _12762_/A1 VSS VSS VSS VSS gf180mcu_fd_sc_mcu9t5v0__aoi21_1
X_18260_ _18260_/D _18291_/CLK _18260_/Q VSS VSS VSS VSS gf180mcu_fd_sc_mcu9t5v0__dffq_4
X_15472_ _15472_/A1 _15472_/A2 _15471_/S _15473_/B VSS _16801_/VNW VSS VSS gf180mcu_fd_sc_mcu9t5v0__nand3_1
X_11704_ _18713_/Q _12527_/A2 _11721_/A1 VSS VSS VSS VSS gf180mcu_fd_sc_mcu9t5v0__nand2_1
X_17211_ _18479_/Q _17282_/A2 _17220_/A1 VSS VSS VSS VSS gf180mcu_fd_sc_mcu9t5v0__nand2_1
X_12684_ _12655_/S _12684_/A2 _12684_/B _19181_/D VSS VSS VSS VSS gf180mcu_fd_sc_mcu9t5v0__oai21_1
X_14423_ _14419_/I _14428_/A2 _14424_/A2 VSS VSS VSS VSS gf180mcu_fd_sc_mcu9t5v0__xnor2_1
X_18191_ _18191_/D _20099_/CLK _18191_/Q VSS VSS VSS VSS gf180mcu_fd_sc_mcu9t5v0__dffq_1
X_11635_ _12665_/B _12658_/A2 _11635_/Z VSS VSS VSS VSS gf180mcu_fd_sc_mcu9t5v0__and2_1
X_11566_ _11566_/A1 _12181_/A2 _11567_/C VSS VSS VSS VSS gf180mcu_fd_sc_mcu9t5v0__nor2_1
X_17142_ _18539_/Q _17420_/S _17143_/B VSS VSS VSS VSS gf180mcu_fd_sc_mcu9t5v0__nand2_1
X_14354_ _13757_/Z _19424_/Q _14367_/S _19424_/D VSS VSS VSS VSS gf180mcu_fd_sc_mcu9t5v0__mux2_1
X_17073_ _18535_/Q _16668_/B _17073_/S _18535_/D VSS VSS VSS VSS gf180mcu_fd_sc_mcu9t5v0__mux2_4
X_10517_ _17260_/S _11251_/A1 _10518_/B VSS _10517_/VNW VSS VSS gf180mcu_fd_sc_mcu9t5v0__nand2_1
X_13305_ _16695_/A1 _13304_/B _13305_/B1 _13305_/B2 _19248_/D VSS VSS VSS VSS gf180mcu_fd_sc_mcu9t5v0__aoi22_1
X_14285_ _14322_/I0 _19359_/Q _14285_/S _19359_/D VSS VSS VSS VSS gf180mcu_fd_sc_mcu9t5v0__mux2_1
X_11497_ _18405_/Q _18389_/Q _11524_/S _11497_/Z VSS VSS VSS VSS gf180mcu_fd_sc_mcu9t5v0__mux2_1
X_16024_ _19231_/Q _16700_/A2 wire71/I _16024_/B _16025_/A2 VSS _16024_/VNW VSS VSS
+ gf180mcu_fd_sc_mcu9t5v0__oai31_1
X_13236_ _19767_/Q _19801_/Q _13237_/B VSS VSS VSS VSS gf180mcu_fd_sc_mcu9t5v0__xnor2_1
X_10448_ _18962_/Q wire165/Z _10652_/B1 _18978_/Q _10449_/A3 VSS VSS VSS VSS gf180mcu_fd_sc_mcu9t5v0__aoi22_1
X_10379_ _17260_/S _18334_/Q _10381_/A3 VSS _10379_/VNW VSS VSS gf180mcu_fd_sc_mcu9t5v0__nor2_1
XTAP_TAPCELL_ROW_303_7391 VSS VSS gf180mcu_fd_sc_mcu9t5v0__filltie
X_13167_ _16430_/A1 _13419_/B _13167_/B1 _13167_/B2 _19239_/D VSS _13167_/VNW VSS
+ VSS gf180mcu_fd_sc_mcu9t5v0__aoi22_2
X_12118_ _12159_/B _12107_/Z _12120_/B1 VSS _12118_/VNW VSS VSS gf180mcu_fd_sc_mcu9t5v0__nand2_1
XTAP_TAPCELL_ROW_295_7170 VSS VSS gf180mcu_fd_sc_mcu9t5v0__filltie
X_13098_ _13098_/I _13540_/A1 VSS _13098_/VNW VSS VSS gf180mcu_fd_sc_mcu9t5v0__clkinv_1
XTAP_TAPCELL_ROW_37_1992 VSS VSS gf180mcu_fd_sc_mcu9t5v0__filltie
X_17975_ _18862_/Q _18025_/I0 _17978_/S _18862_/D VSS VSS VSS VSS gf180mcu_fd_sc_mcu9t5v0__mux2_1
XTAP_TAPCELL_ROW_295_7192 VSS VSS gf180mcu_fd_sc_mcu9t5v0__filltie
X_16926_ _16925_/Z _18455_/Q _16926_/S _18455_/D VSS _16926_/VNW VSS VSS gf180mcu_fd_sc_mcu9t5v0__mux2_4
XTAP_TAPCELL_ROW_295_7181 VSS VSS gf180mcu_fd_sc_mcu9t5v0__filltie
X_12049_ _11736_/C _12049_/A2 _12049_/A3 _12049_/B1 _12049_/B2 _12057_/A2 VSS VSS
+ VSS VSS gf180mcu_fd_sc_mcu9t5v0__oai32_4
X_19714_ _19714_/D _20034_/RN clkload30/I _19714_/Q VSS VSS VSS VSS gf180mcu_fd_sc_mcu9t5v0__dffrnq_1
XTAP_TAPCELL_ROW_291_7067 VSS VSS gf180mcu_fd_sc_mcu9t5v0__filltie
XTAP_TAPCELL_ROW_122_4341 VSS VSS gf180mcu_fd_sc_mcu9t5v0__filltie
XTAP_TAPCELL_ROW_122_4330 VSS VSS gf180mcu_fd_sc_mcu9t5v0__filltie
XTAP_TAPCELL_ROW_33_1878 VSS VSS gf180mcu_fd_sc_mcu9t5v0__filltie
XTAP_TAPCELL_ROW_33_1889 VSS VSS gf180mcu_fd_sc_mcu9t5v0__filltie
XTAP_TAPCELL_ROW_316_7774 VSS VSS gf180mcu_fd_sc_mcu9t5v0__filltie
X_16857_ _19256_/Q _16654_/B _16861_/S _16857_/Z VSS VSS VSS VSS gf180mcu_fd_sc_mcu9t5v0__mux2_1
XTAP_TAPCELL_ROW_316_7763 VSS VSS gf180mcu_fd_sc_mcu9t5v0__filltie
XTAP_TAPCELL_ROW_291_7078 VSS VSS gf180mcu_fd_sc_mcu9t5v0__filltie
XTAP_TAPCELL_ROW_316_7752 VSS VSS gf180mcu_fd_sc_mcu9t5v0__filltie
X_19645_ _19645_/D _20029_/RN clkload20/I _19645_/Q VSS VSS VSS VSS gf180mcu_fd_sc_mcu9t5v0__dffrnq_1
XTAP_TAPCELL_ROW_312_7649 VSS VSS gf180mcu_fd_sc_mcu9t5v0__filltie
XTAP_TAPCELL_ROW_312_7638 VSS VSS gf180mcu_fd_sc_mcu9t5v0__filltie
X_15808_ input5/Z _19977_/Q _15811_/S _19977_/D VSS VSS VSS VSS gf180mcu_fd_sc_mcu9t5v0__mux2_1
X_16788_ _18393_/Q _16787_/Z _16798_/S _18393_/D VSS VSS VSS VSS gf180mcu_fd_sc_mcu9t5v0__mux2_1
X_19576_ _19576_/D _19960_/RN clkload17/I _19576_/Q VSS VSS VSS VSS gf180mcu_fd_sc_mcu9t5v0__dffrnq_1
X_18527_ _18527_/D _20099_/CLK _18527_/Q VSS VSS VSS VSS gf180mcu_fd_sc_mcu9t5v0__dffq_1
X_15739_ _15761_/A1 _15739_/A2 _19926_/D VSS _15739_/VNW VSS VSS gf180mcu_fd_sc_mcu9t5v0__nor2_1
X_09260_ _17260_/S _17399_/A1 VSS VSS VSS VSS gf180mcu_fd_sc_mcu9t5v0__inv_1
XTAP_TAPCELL_ROW_135_4724 VSS VSS gf180mcu_fd_sc_mcu9t5v0__filltie
XTAP_TAPCELL_ROW_135_4713 VSS VSS gf180mcu_fd_sc_mcu9t5v0__filltie
XTAP_TAPCELL_ROW_135_4702 VSS VSS gf180mcu_fd_sc_mcu9t5v0__filltie
X_18458_ _18458_/D clkload61/I _18458_/Q VSS VSS VSS VSS gf180mcu_fd_sc_mcu9t5v0__dffq_1
XTAP_TAPCELL_ROW_135_4735 VSS VSS gf180mcu_fd_sc_mcu9t5v0__filltie
X_18389_ _18389_/D clkload78/I _18389_/Q VSS VSS VSS VSS gf180mcu_fd_sc_mcu9t5v0__dffq_1
X_17409_ _20076_/Q wire168/Z _17409_/B _17411_/A2 VSS _17409_/VNW VSS VSS gf180mcu_fd_sc_mcu9t5v0__oai21_1
XTAP_TAPCELL_ROW_116_4167 VSS VSS gf180mcu_fd_sc_mcu9t5v0__filltie
X_09191_ _19163_/Q _14507_/A1 VSS _12104_/VNW VSS VSS gf180mcu_fd_sc_mcu9t5v0__clkinv_1
XTAP_TAPCELL_ROW_116_4178 VSS VSS gf180mcu_fd_sc_mcu9t5v0__filltie
XTAP_TAPCELL_ROW_280_6782 VSS VSS gf180mcu_fd_sc_mcu9t5v0__filltie
XTAP_TAPCELL_ROW_280_6771 VSS VSS gf180mcu_fd_sc_mcu9t5v0__filltie
XTAP_TAPCELL_ROW_280_6760 VSS VSS gf180mcu_fd_sc_mcu9t5v0__filltie
XTAP_TAPCELL_ROW_129_4539 VSS VSS gf180mcu_fd_sc_mcu9t5v0__filltie
XTAP_TAPCELL_ROW_129_4528 VSS VSS gf180mcu_fd_sc_mcu9t5v0__filltie
XTAP_TAPCELL_ROW_129_4517 VSS VSS gf180mcu_fd_sc_mcu9t5v0__filltie
XPHY_EDGE_ROW_16_Left_340 VSS VSS gf180mcu_fd_sc_mcu9t5v0__endcap
XTAP_TAPCELL_ROW_274_6597 VSS VSS gf180mcu_fd_sc_mcu9t5v0__filltie
XTAP_TAPCELL_ROW_105_3882 VSS VSS gf180mcu_fd_sc_mcu9t5v0__filltie
XTAP_TAPCELL_ROW_105_3871 VSS VSS gf180mcu_fd_sc_mcu9t5v0__filltie
XTAP_TAPCELL_ROW_0_941 VSS VSS gf180mcu_fd_sc_mcu9t5v0__filltie
XTAP_TAPCELL_ROW_105_3860 VSS VSS gf180mcu_fd_sc_mcu9t5v0__filltie
X_09527_ _18561_/Q _15505_/A1 _09528_/B2 VSS _15509_/VNW VSS VSS gf180mcu_fd_sc_mcu9t5v0__nand2_1
XTAP_TAPCELL_ROW_101_3757 VSS VSS gf180mcu_fd_sc_mcu9t5v0__filltie
XTAP_TAPCELL_ROW_0_952 VSS VSS gf180mcu_fd_sc_mcu9t5v0__filltie
XTAP_TAPCELL_ROW_0_963 VSS VSS gf180mcu_fd_sc_mcu9t5v0__filltie
XTAP_TAPCELL_ROW_0_974 VSS VSS gf180mcu_fd_sc_mcu9t5v0__filltie
XTAP_TAPCELL_ROW_101_3768 VSS VSS gf180mcu_fd_sc_mcu9t5v0__filltie
XTAP_TAPCELL_ROW_0_985 VSS VSS gf180mcu_fd_sc_mcu9t5v0__filltie
XTAP_TAPCELL_ROW_0_996 VSS VSS gf180mcu_fd_sc_mcu9t5v0__filltie
XTAP_TAPCELL_ROW_43_2152 VSS VSS gf180mcu_fd_sc_mcu9t5v0__filltie
X_09458_ _20038_/Q _19192_/Q _09458_/Z VSS VSS VSS VSS gf180mcu_fd_sc_mcu9t5v0__and2_1
XTAP_TAPCELL_ROW_43_2163 VSS VSS gf180mcu_fd_sc_mcu9t5v0__filltie
XTAP_TAPCELL_ROW_287_6969 VSS VSS gf180mcu_fd_sc_mcu9t5v0__filltie
XTAP_TAPCELL_ROW_287_6958 VSS VSS gf180mcu_fd_sc_mcu9t5v0__filltie
X_09389_ _19188_/Q _12714_/A1 VSS _12708_/VNW VSS VSS gf180mcu_fd_sc_mcu9t5v0__clkinv_1
XTAP_TAPCELL_ROW_43_2174 VSS VSS gf180mcu_fd_sc_mcu9t5v0__filltie
X_11420_ _11526_/B _11420_/A2 _11420_/B1 _11420_/B2 _11422_/B2 VSS VSS VSS VSS gf180mcu_fd_sc_mcu9t5v0__aoi22_1
X_11351_ wire283/I _11351_/A2 _11351_/B1 _11351_/B2 _11353_/B2 VSS VSS VSS VSS gf180mcu_fd_sc_mcu9t5v0__aoi22_1
X_10302_ _20095_/Q _17326_/A1 wire168/I _10302_/C _10304_/A2 VSS VSS VSS VSS gf180mcu_fd_sc_mcu9t5v0__oai211_1
XTAP_TAPCELL_ROW_227_5320 VSS VSS gf180mcu_fd_sc_mcu9t5v0__filltie
XTAP_TAPCELL_ROW_56_2513 VSS VSS gf180mcu_fd_sc_mcu9t5v0__filltie
XTAP_TAPCELL_ROW_56_2524 VSS VSS gf180mcu_fd_sc_mcu9t5v0__filltie
XTAP_TAPCELL_ROW_56_2535 VSS VSS gf180mcu_fd_sc_mcu9t5v0__filltie
Xeco12_buf_15937 _15937_/ZN _15954_/B VSS VSS VSS VSS gf180mcu_fd_sc_mcu9t5v0__clkbuf_16
X_11282_ _19085_/Q _11321_/A2 _11283_/A2 VSS _11283_/VNW VSS VSS gf180mcu_fd_sc_mcu9t5v0__nand2_1
X_14070_ _14070_/I _14103_/A1 VSS _14137_/VNW VSS VSS gf180mcu_fd_sc_mcu9t5v0__clkinv_1
X_10233_ _10643_/B2 _10233_/A2 _10233_/B1 _19828_/Q _10234_/C VSS _16689_/VNW VSS
+ VSS gf180mcu_fd_sc_mcu9t5v0__aoi22_1
XTAP_TAPCELL_ROW_223_5206 VSS VSS gf180mcu_fd_sc_mcu9t5v0__filltie
X_13021_ _13022_/A1 _13022_/A2 _13516_/B _13024_/A1 VSS _13022_/VNW VSS VSS gf180mcu_fd_sc_mcu9t5v0__nand3_1
X_10164_ _10164_/A1 _10164_/A2 _10164_/B _10164_/C _10176_/A2 VSS _10164_/VNW VSS
+ VSS gf180mcu_fd_sc_mcu9t5v0__oai211_1
X_10095_ _19225_/Q _09898_/C wire297/Z _19249_/Q _10097_/A1 VSS VSS VSS VSS gf180mcu_fd_sc_mcu9t5v0__aoi22_1
X_17760_ _17760_/A1 _17758_/Z _18755_/D VSS VSS VSS VSS gf180mcu_fd_sc_mcu9t5v0__nand2_1
X_14972_ _19428_/Q _19373_/Q _14976_/B VSS _14976_/VNW VSS VSS gf180mcu_fd_sc_mcu9t5v0__and2_1
X_16711_ _19283_/Q _16695_/B _16712_/A3 VSS VSS VSS VSS gf180mcu_fd_sc_mcu9t5v0__nor2_1
X_17691_ _18724_/Q _17673_/S _17692_/C VSS _17691_/VNW VSS VSS gf180mcu_fd_sc_mcu9t5v0__nand2_1
X_13923_ _19320_/Q _19297_/Q _13995_/A1 VSS VSS VSS VSS gf180mcu_fd_sc_mcu9t5v0__nand2_1
X_16642_ _16675_/A1 _16642_/A2 _16642_/A3 _16642_/B _16643_/I1 VSS VSS VSS VSS gf180mcu_fd_sc_mcu9t5v0__oai31_1
X_13854_ _19293_/Q _19322_/Q _13892_/A1 VSS _13854_/VNW VSS VSS gf180mcu_fd_sc_mcu9t5v0__nand2_1
X_19430_ _19430_/D _20070_/RN _19633_/CLK _19430_/Q VSS VSS VSS VSS gf180mcu_fd_sc_mcu9t5v0__dffrnq_1
X_16573_ wire301/Z _18779_/Q _16619_/S _16573_/Z VSS VSS VSS VSS gf180mcu_fd_sc_mcu9t5v0__mux2_1
X_12805_ _12805_/I0 _19205_/Q _13497_/B _19205_/D VSS VSS VSS VSS gf180mcu_fd_sc_mcu9t5v0__mux2_1
X_19361_ _19361_/D _20065_/RN clkload21/I _19361_/Q VSS VSS VSS VSS gf180mcu_fd_sc_mcu9t5v0__dffrnq_1
X_18312_ _18312_/D clkload81/I _18312_/Q VSS VSS VSS VSS gf180mcu_fd_sc_mcu9t5v0__dffq_1
X_15524_ _19845_/Q _15521_/Z _15524_/B _19845_/D VSS _15524_/VNW VSS VSS gf180mcu_fd_sc_mcu9t5v0__aoi21_1
X_10997_ _19017_/Q _18102_/B _11010_/B VSS VSS VSS VSS gf180mcu_fd_sc_mcu9t5v0__nand2_1
X_13785_ _13785_/A1 _13785_/A2 _13784_/B _13785_/Z VSS _13785_/VNW VSS VSS gf180mcu_fd_sc_mcu9t5v0__and3_1
X_19292_ _19292_/D _20060_/RN clkload15/I _19292_/Q VSS VSS VSS VSS gf180mcu_fd_sc_mcu9t5v0__dffrnq_1
X_12736_ _19782_/Q _12734_/Z _12736_/B _12738_/A2 VSS VSS VSS VSS gf180mcu_fd_sc_mcu9t5v0__oai21_1
X_18243_ _18243_/D _18324_/CLK _18243_/Q VSS VSS VSS VSS gf180mcu_fd_sc_mcu9t5v0__dffq_4
X_15455_ _19821_/Q _15436_/Z _15456_/A3 VSS _16413_/VNW VSS VSS gf180mcu_fd_sc_mcu9t5v0__nor2_1
XTAP_TAPCELL_ROW_212_4910 VSS VSS gf180mcu_fd_sc_mcu9t5v0__filltie
X_12667_ _12710_/A2 _12711_/A2 _12716_/S _12667_/Z VSS VSS VSS VSS gf180mcu_fd_sc_mcu9t5v0__mux2_1
X_18174_ _18174_/D clkload72/I _18174_/Q VSS VSS VSS VSS gf180mcu_fd_sc_mcu9t5v0__dffq_4
X_15386_ _19671_/Q _19771_/Q _15420_/S _19771_/D VSS VSS VSS VSS gf180mcu_fd_sc_mcu9t5v0__mux2_1
XTAP_TAPCELL_ROW_26_1693 VSS VSS gf180mcu_fd_sc_mcu9t5v0__filltie
X_11618_ _11590_/Z _12634_/A2 _12632_/A1 VSS _11621_/VNW VSS VSS gf180mcu_fd_sc_mcu9t5v0__nand2_1
X_14406_ _14406_/A1 _14406_/A2 _19450_/D VSS VSS VSS VSS gf180mcu_fd_sc_mcu9t5v0__nand2_1
X_17125_ _17198_/A1 _17125_/A2 _17125_/A3 _17125_/B _17134_/C2 VSS _17134_/VNW VSS
+ VSS gf180mcu_fd_sc_mcu9t5v0__oai31_1
X_12598_ _18406_/Q wire163/Z _12601_/A3 VSS VSS VSS VSS gf180mcu_fd_sc_mcu9t5v0__nor2_1
XTAP_TAPCELL_ROW_111_4031 VSS VSS gf180mcu_fd_sc_mcu9t5v0__filltie
XTAP_TAPCELL_ROW_22_1579 VSS VSS gf180mcu_fd_sc_mcu9t5v0__filltie
X_14337_ _14367_/I0 _19409_/Q _14337_/S _19409_/D VSS VSS VSS VSS gf180mcu_fd_sc_mcu9t5v0__mux2_1
XTAP_TAPCELL_ROW_305_7464 VSS VSS gf180mcu_fd_sc_mcu9t5v0__filltie
XTAP_TAPCELL_ROW_305_7453 VSS VSS gf180mcu_fd_sc_mcu9t5v0__filltie
X_11549_ _18568_/Q _18567_/Q _17430_/A2 VSS VSS VSS VSS gf180mcu_fd_sc_mcu9t5v0__nand2_1
XTAP_TAPCELL_ROW_111_4042 VSS VSS gf180mcu_fd_sc_mcu9t5v0__filltie
Xmax_cap215 _12686_/C wire213/I VSS max_cap215/VNW VSS VSS gf180mcu_fd_sc_mcu9t5v0__clkbuf_8
X_17056_ _17055_/Z _18519_/Q _17056_/S _18519_/D VSS VSS VSS VSS gf180mcu_fd_sc_mcu9t5v0__mux2_1
X_14268_ _13757_/Z _19342_/Q _14285_/S _19342_/D VSS VSS VSS VSS gf180mcu_fd_sc_mcu9t5v0__mux2_1
XTAP_TAPCELL_ROW_297_7243 VSS VSS gf180mcu_fd_sc_mcu9t5v0__filltie
XTAP_TAPCELL_ROW_301_7339 VSS VSS gf180mcu_fd_sc_mcu9t5v0__filltie
XTAP_TAPCELL_ROW_297_7232 VSS VSS gf180mcu_fd_sc_mcu9t5v0__filltie
X_16007_ _18674_/Q _18771_/Q _16597_/S _16007_/Z VSS VSS VSS VSS gf180mcu_fd_sc_mcu9t5v0__mux2_1
X_13219_ _19733_/Q _19765_/Q _13225_/A1 VSS VSS VSS VSS gf180mcu_fd_sc_mcu9t5v0__xnor2_1
X_14199_ _14245_/B _14198_/Z _14201_/A2 VSS _14199_/VNW VSS VSS gf180mcu_fd_sc_mcu9t5v0__xnor2_1
XTAP_TAPCELL_ROW_318_7803 VSS VSS gf180mcu_fd_sc_mcu9t5v0__filltie
XTAP_TAPCELL_ROW_293_7118 VSS VSS gf180mcu_fd_sc_mcu9t5v0__filltie
XTAP_TAPCELL_ROW_124_4403 VSS VSS gf180mcu_fd_sc_mcu9t5v0__filltie
XTAP_TAPCELL_ROW_318_7825 VSS VSS gf180mcu_fd_sc_mcu9t5v0__filltie
XTAP_TAPCELL_ROW_318_7814 VSS VSS gf180mcu_fd_sc_mcu9t5v0__filltie
XTAP_TAPCELL_ROW_293_7129 VSS VSS gf180mcu_fd_sc_mcu9t5v0__filltie
X_17958_ _18856_/Q _17958_/A2 _17959_/A2 VSS _17959_/VNW VSS VSS gf180mcu_fd_sc_mcu9t5v0__nand2_1
X_16909_ _16614_/B _19250_/Q _16925_/S _16909_/Z VSS _16909_/VNW VSS VSS gf180mcu_fd_sc_mcu9t5v0__mux2_1
X_17889_ _17889_/I _17957_/A2 VSS VSS VSS VSS gf180mcu_fd_sc_mcu9t5v0__clkinv_1
X_19628_ _19628_/D _20140_/RN _19633_/CLK _19628_/Q VSS VSS VSS VSS gf180mcu_fd_sc_mcu9t5v0__dffrnq_1
XTAP_TAPCELL_ROW_192_1_4766 VSS VSS gf180mcu_fd_sc_mcu9t5v0__filltie
X_09312_ _19994_/Q _15832_/A1 VSS VSS VSS VSS gf180mcu_fd_sc_mcu9t5v0__clkinv_1
XTAP_TAPCELL_ROW_118_4229 VSS VSS gf180mcu_fd_sc_mcu9t5v0__filltie
XTAP_TAPCELL_ROW_118_4218 VSS VSS gf180mcu_fd_sc_mcu9t5v0__filltie
X_19559_ _19559_/D _20071_/RN clkload19/I _19559_/Q VSS VSS VSS VSS gf180mcu_fd_sc_mcu9t5v0__dffrnq_1
X_09243_ _20069_/Q _10835_/B2 VSS VSS VSS VSS gf180mcu_fd_sc_mcu9t5v0__clkinv_1
X_09174_ _19147_/Q _13737_/A1 VSS VSS VSS VSS gf180mcu_fd_sc_mcu9t5v0__clkinv_1
XTAP_TAPCELL_ROW_282_6833 VSS VSS gf180mcu_fd_sc_mcu9t5v0__filltie
XTAP_TAPCELL_ROW_282_6822 VSS VSS gf180mcu_fd_sc_mcu9t5v0__filltie
Xoutput16 output16/I dout[5] VSS VSS VSS VSS gf180mcu_fd_sc_mcu9t5v0__dlyd_1
XTAP_TAPCELL_ROW_263_6298 VSS VSS gf180mcu_fd_sc_mcu9t5v0__filltie
XTAP_TAPCELL_ROW_276_6659 VSS VSS gf180mcu_fd_sc_mcu9t5v0__filltie
XTAP_TAPCELL_ROW_276_6648 VSS VSS gf180mcu_fd_sc_mcu9t5v0__filltie
XTAP_TAPCELL_ROW_107_3933 VSS VSS gf180mcu_fd_sc_mcu9t5v0__filltie
XTAP_TAPCELL_ROW_107_3922 VSS VSS gf180mcu_fd_sc_mcu9t5v0__filltie
XTAP_TAPCELL_ROW_103_3808 VSS VSS gf180mcu_fd_sc_mcu9t5v0__filltie
X_10920_ _16734_/A1 _18147_/S _10924_/B _10921_/I0 VSS _10920_/VNW VSS VSS gf180mcu_fd_sc_mcu9t5v0__oai21_1
XTAP_TAPCELL_ROW_103_3819 VSS VSS gf180mcu_fd_sc_mcu9t5v0__filltie
XTAP_TAPCELL_ROW_216_5010 VSS VSS gf180mcu_fd_sc_mcu9t5v0__filltie
XTAP_TAPCELL_ROW_45_2214 VSS VSS gf180mcu_fd_sc_mcu9t5v0__filltie
XTAP_TAPCELL_ROW_45_2225 VSS VSS gf180mcu_fd_sc_mcu9t5v0__filltie
XTAP_TAPCELL_ROW_216_5021 VSS VSS gf180mcu_fd_sc_mcu9t5v0__filltie
X_10851_ _10851_/I0 _18964_/Q _18152_/S _18964_/D VSS _10851_/VNW VSS VSS gf180mcu_fd_sc_mcu9t5v0__mux2_1
X_13570_ _13571_/A1 _13571_/A3 _13570_/B _13572_/A2 VSS _13572_/VNW VSS VSS gf180mcu_fd_sc_mcu9t5v0__aoi21_1
X_10782_ _09818_/I _10785_/A2 _10799_/A2 VSS VSS VSS VSS gf180mcu_fd_sc_mcu9t5v0__nand2_1
XTAP_TAPCELL_ROW_252_5991 VSS VSS gf180mcu_fd_sc_mcu9t5v0__filltie
X_12521_ _12686_/C _12488_/I _12521_/A3 _12521_/B _19161_/D VSS VSS VSS VSS gf180mcu_fd_sc_mcu9t5v0__oai31_1
Xclkbuf_leaf_5_clk_regs clkload0/I clkload21/I VSS clkbuf_leaf_5_clk_regs/VNW VSS
+ VSS gf180mcu_fd_sc_mcu9t5v0__clkbuf_8
X_15240_ _19727_/Q _15417_/S _15241_/B VSS _15240_/VNW VSS VSS gf180mcu_fd_sc_mcu9t5v0__nand2_1
X_12452_ _19152_/Q _12355_/I _12453_/B VSS VSS VSS VSS gf180mcu_fd_sc_mcu9t5v0__nand2_1
X_11403_ _18398_/Q _18382_/Q _11403_/S _11403_/Z VSS VSS VSS VSS gf180mcu_fd_sc_mcu9t5v0__mux2_1
X_12383_ _18300_/Q _18252_/Q _12383_/S _12383_/Z VSS VSS VSS VSS gf180mcu_fd_sc_mcu9t5v0__mux2_1
X_15171_ _19713_/Q _19553_/Q wire108/Z _19713_/D VSS _15171_/VNW VSS VSS gf180mcu_fd_sc_mcu9t5v0__mux2_1
X_11334_ _18393_/Q _11334_/A2 _11335_/C VSS VSS VSS VSS gf180mcu_fd_sc_mcu9t5v0__or2_1
X_14122_ _19321_/Q _19300_/Q _14121_/Z _14192_/B VSS VSS VSS VSS gf180mcu_fd_sc_mcu9t5v0__nand3_1
X_11265_ _11265_/A1 _11265_/A2 _11265_/B wire136/Z _11266_/B VSS VSS VSS VSS gf180mcu_fd_sc_mcu9t5v0__oai211_1
X_18930_ _18930_/D _20018_/RN clkload39/I _18930_/Q VSS VSS VSS VSS gf180mcu_fd_sc_mcu9t5v0__dffrnq_1
X_14053_ _14053_/A1 _14053_/A2 _14053_/Z VSS _14053_/VNW VSS VSS gf180mcu_fd_sc_mcu9t5v0__xor2_1
X_10216_ _10543_/C _17401_/C _10216_/ZN VSS VSS VSS VSS gf180mcu_fd_sc_mcu9t5v0__nor2_1
X_13004_ _13244_/B _13022_/A2 _13010_/A2 VSS VSS VSS VSS gf180mcu_fd_sc_mcu9t5v0__nand2_1
X_11196_ wire283/Z _11196_/A2 _11196_/B1 _11196_/B2 _11198_/B2 VSS VSS VSS VSS gf180mcu_fd_sc_mcu9t5v0__aoi22_1
X_18861_ _18861_/D _20141_/RN clkload23/I _18861_/Q VSS VSS VSS VSS gf180mcu_fd_sc_mcu9t5v0__dffrnq_1
X_10147_ _10164_/A2 _10175_/A2 _10164_/B _10152_/A2 VSS _10147_/VNW VSS VSS gf180mcu_fd_sc_mcu9t5v0__nand3_1
X_17812_ _15936_/B _18769_/D _18790_/Q _17813_/A2 VSS VSS VSS VSS gf180mcu_fd_sc_mcu9t5v0__oai21_1
XTAP_TAPCELL_ROW_30_1804 VSS VSS gf180mcu_fd_sc_mcu9t5v0__filltie
X_18792_ _18792_/D _20072_/RN _19806_/CLK _18792_/Q VSS VSS VSS VSS gf180mcu_fd_sc_mcu9t5v0__dffrnq_1
X_10078_ _10078_/A1 _10078_/A2 _10079_/C VSS _10078_/VNW VSS VSS gf180mcu_fd_sc_mcu9t5v0__nand2_1
X_17743_ _18748_/Q _17742_/S _17743_/B _17744_/I VSS _17743_/VNW VSS VSS gf180mcu_fd_sc_mcu9t5v0__aoi21_1
X_14955_ _19614_/Q _14955_/I1 _20039_/D _19614_/D VSS VSS VSS VSS gf180mcu_fd_sc_mcu9t5v0__mux2_1
XTAP_TAPCELL_ROW_15_1383 VSS VSS gf180mcu_fd_sc_mcu9t5v0__filltie
XTAP_TAPCELL_ROW_30_1815 VSS VSS gf180mcu_fd_sc_mcu9t5v0__filltie
X_13906_ _13906_/A1 _13906_/A2 _13906_/B _13948_/A1 VSS VSS VSS VSS gf180mcu_fd_sc_mcu9t5v0__oai21_1
XTAP_TAPCELL_ROW_15_1394 VSS VSS gf180mcu_fd_sc_mcu9t5v0__filltie
X_17674_ _18637_/Q _18713_/Q _17685_/S _18713_/D VSS VSS VSS VSS gf180mcu_fd_sc_mcu9t5v0__mux2_1
XPHY_EDGE_ROW_188_2_Left_700 VSS VSS gf180mcu_fd_sc_mcu9t5v0__endcap
X_19413_ _19413_/D _20053_/RN clkload18/I _19413_/Q VSS VSS VSS VSS gf180mcu_fd_sc_mcu9t5v0__dffrnq_1
X_14886_ _14886_/A1 _14886_/A2 _14891_/A1 VSS _14886_/VNW VSS VSS gf180mcu_fd_sc_mcu9t5v0__nand2_1
X_16625_ _18352_/Q _16625_/I1 _16643_/S _18352_/D VSS _16625_/VNW VSS VSS gf180mcu_fd_sc_mcu9t5v0__mux2_4
Xmax_cap91 _16675_/A1 _15996_/B VSS VSS VSS VSS gf180mcu_fd_sc_mcu9t5v0__clkbuf_16
X_13837_ _13837_/A1 _13837_/A2 _13837_/B _13866_/A1 VSS VSS VSS VSS gf180mcu_fd_sc_mcu9t5v0__aoi21_1
X_16556_ _18339_/Q _16167_/B _17073_/S _18339_/D VSS VSS VSS VSS gf180mcu_fd_sc_mcu9t5v0__mux2_4
X_13768_ _19316_/Q _19292_/Q _13970_/A1 _13767_/B _13785_/A1 VSS VSS VSS VSS gf180mcu_fd_sc_mcu9t5v0__nand4_1
X_19344_ _19344_/D _20048_/RN clkload19/I _19344_/Q VSS VSS VSS VSS gf180mcu_fd_sc_mcu9t5v0__dffrnq_1
XTAP_TAPCELL_ROW_28_1744 VSS VSS gf180mcu_fd_sc_mcu9t5v0__filltie
XTAP_TAPCELL_ROW_28_1755 VSS VSS gf180mcu_fd_sc_mcu9t5v0__filltie
X_16487_ _19232_/Q _16137_/C _17023_/S _16487_/Z VSS _16487_/VNW VSS VSS gf180mcu_fd_sc_mcu9t5v0__mux2_1
X_15507_ _19840_/Q _15507_/A2 _15507_/Z VSS _15507_/VNW VSS VSS gf180mcu_fd_sc_mcu9t5v0__xor2_1
X_19275_ _19275_/D _20043_/RN _19680_/CLK _19275_/Q VSS VSS VSS VSS gf180mcu_fd_sc_mcu9t5v0__dffrnq_2
Xclkbuf_0_clk clkbuf_0_clk/I clkbuf_0_clk/Z VSS VSS VSS VSS gf180mcu_fd_sc_mcu9t5v0__clkbuf_16
X_12719_ _19190_/Q _12724_/C _12722_/B VSS VSS VSS VSS gf180mcu_fd_sc_mcu9t5v0__nand2_1
XTAP_TAPCELL_ROW_28_1766 VSS VSS gf180mcu_fd_sc_mcu9t5v0__filltie
XTAP_TAPCELL_ROW_307_7515 VSS VSS gf180mcu_fd_sc_mcu9t5v0__filltie
X_18226_ _18226_/D clkload80/I _18226_/Q VSS VSS VSS VSS gf180mcu_fd_sc_mcu9t5v0__dffq_4
XTAP_TAPCELL_ROW_307_7504 VSS VSS gf180mcu_fd_sc_mcu9t5v0__filltie
X_15438_ _19822_/Q _15437_/Z _15438_/Z VSS _15446_/VNW VSS VSS gf180mcu_fd_sc_mcu9t5v0__and2_1
X_13699_ _19145_/Q _19111_/Q _13700_/I VSS VSS VSS VSS gf180mcu_fd_sc_mcu9t5v0__xor2_1
XTAP_TAPCELL_ROW_307_7526 VSS VSS gf180mcu_fd_sc_mcu9t5v0__filltie
XTAP_TAPCELL_ROW_299_7305 VSS VSS gf180mcu_fd_sc_mcu9t5v0__filltie
X_18157_ _18157_/D clkload72/I _18157_/Q VSS VSS VSS VSS gf180mcu_fd_sc_mcu9t5v0__dffq_1
X_15369_ _19654_/Q _19754_/Q _15430_/S _19754_/D VSS VSS VSS VSS gf180mcu_fd_sc_mcu9t5v0__mux2_1
X_17108_ _17195_/A1 _18378_/Q _17111_/A2 VSS VSS VSS VSS gf180mcu_fd_sc_mcu9t5v0__nor2_1
X_18088_ _18933_/Q _18932_/Q _18934_/Q _18090_/A2 VSS _18088_/VNW VSS VSS gf180mcu_fd_sc_mcu9t5v0__aoi21_1
X_17039_ _16614_/B _19250_/Q _17055_/S _17039_/Z VSS VSS VSS VSS gf180mcu_fd_sc_mcu9t5v0__mux2_1
X_09930_ _10138_/B1 _09930_/A2 _10165_/B1 _19276_/Q _09930_/C _09931_/B VSS _09930_/VNW
+ VSS VSS gf180mcu_fd_sc_mcu9t5v0__aoi221_1
XTAP_TAPCELL_ROW_91_3491 VSS VSS gf180mcu_fd_sc_mcu9t5v0__filltie
XTAP_TAPCELL_ROW_91_3480 VSS VSS gf180mcu_fd_sc_mcu9t5v0__filltie
X_20050_ _20050_/D _20050_/RN clkload59/I _20050_/Q VSS VSS VSS VSS gf180mcu_fd_sc_mcu9t5v0__dffrnq_1
XPHY_EDGE_ROW_15_Right_15 VSS VSS gf180mcu_fd_sc_mcu9t5v0__endcap
X_09861_ _17075_/A2 _11067_/S _20033_/D VSS _09861_/VNW VSS VSS gf180mcu_fd_sc_mcu9t5v0__nand2_1
Xclkbuf_leaf_75_clk_regs clkbuf_3_0_0_clk_regs/Z clkload10/I VSS VSS VSS VSS gf180mcu_fd_sc_mcu9t5v0__clkbuf_8
X_09792_ _18847_/Q _17902_/A1 _09792_/B _09792_/C _09793_/C VSS VSS VSS VSS gf180mcu_fd_sc_mcu9t5v0__oai211_1
Xload_slew284 _11091_/B _12383_/S VSS VSS VSS VSS gf180mcu_fd_sc_mcu9t5v0__clkbuf_3
Xload_slew295 _10136_/B1 _10169_/B1 VSS max_cap171/VNW VSS VSS gf180mcu_fd_sc_mcu9t5v0__clkbuf_4
XTAP_TAPCELL_ROW_271_6523 VSS VSS gf180mcu_fd_sc_mcu9t5v0__filltie
XTAP_TAPCELL_ROW_271_6512 VSS VSS gf180mcu_fd_sc_mcu9t5v0__filltie
XTAP_TAPCELL_ROW_271_6534 VSS VSS gf180mcu_fd_sc_mcu9t5v0__filltie
XPHY_EDGE_ROW_172_2_Left_684 VSS VSS gf180mcu_fd_sc_mcu9t5v0__endcap
XPHY_EDGE_ROW_24_Right_24 VSS VSS gf180mcu_fd_sc_mcu9t5v0__endcap
XTAP_TAPCELL_ROW_269_6474 VSS VSS gf180mcu_fd_sc_mcu9t5v0__filltie
XTAP_TAPCELL_ROW_269_6463 VSS VSS gf180mcu_fd_sc_mcu9t5v0__filltie
XTAP_TAPCELL_ROW_98_3689 VSS VSS gf180mcu_fd_sc_mcu9t5v0__filltie
X_09226_ _18925_/Q _18060_/A1 VSS _10980_/VNW VSS VSS gf180mcu_fd_sc_mcu9t5v0__clkinv_1
XTAP_TAPCELL_ROW_98_3678 VSS VSS gf180mcu_fd_sc_mcu9t5v0__filltie
XTAP_TAPCELL_ROW_98_3667 VSS VSS gf180mcu_fd_sc_mcu9t5v0__filltie
XTAP_TAPCELL_ROW_265_6349 VSS VSS gf180mcu_fd_sc_mcu9t5v0__filltie
X_09157_ _19743_/Q _13416_/A1 VSS _13618_/VNW VSS VSS gf180mcu_fd_sc_mcu9t5v0__clkinv_1
XPHY_EDGE_ROW_292_Right_219 VSS VSS gf180mcu_fd_sc_mcu9t5v0__endcap
X_09088_ _20005_/Q _15820_/A2 VSS _09088_/VNW VSS VSS gf180mcu_fd_sc_mcu9t5v0__clkinv_1
XPHY_EDGE_ROW_33_Right_33 VSS VSS gf180mcu_fd_sc_mcu9t5v0__endcap
XTAP_TAPCELL_ROW_38_2040 VSS VSS gf180mcu_fd_sc_mcu9t5v0__filltie
X_11050_ _18036_/I0 _19051_/Q wire174/Z _19051_/D VSS VSS VSS VSS gf180mcu_fd_sc_mcu9t5v0__mux2_1
X_10001_ _10001_/A1 _10001_/A2 _10003_/A2 VSS VSS VSS VSS gf180mcu_fd_sc_mcu9t5v0__nand2_1
XTAP_TAPCELL_ROW_241_5692 VSS VSS gf180mcu_fd_sc_mcu9t5v0__filltie
XTAP_TAPCELL_ROW_70_2896 VSS VSS gf180mcu_fd_sc_mcu9t5v0__filltie
X_14740_ _19548_/Q _14739_/Z _14764_/B _19548_/D VSS _14740_/VNW VSS VSS gf180mcu_fd_sc_mcu9t5v0__mux2_1
X_11952_ _18198_/Q _12299_/S _12342_/C _11952_/C _11958_/A1 VSS _16226_/VNW VSS VSS
+ gf180mcu_fd_sc_mcu9t5v0__oai211_1
XPHY_EDGE_ROW_42_Right_42 VSS VSS gf180mcu_fd_sc_mcu9t5v0__endcap
X_10903_ _19248_/Q _19254_/Q _18151_/S _10903_/Z VSS VSS VSS VSS gf180mcu_fd_sc_mcu9t5v0__mux2_1
X_11883_ _18901_/Q _11907_/A2 _11903_/A2 VSS _12427_/VNW VSS VSS gf180mcu_fd_sc_mcu9t5v0__xnor2_1
X_14671_ _14671_/A1 _14671_/A2 _14671_/B _14675_/A2 VSS _14671_/VNW VSS VSS gf180mcu_fd_sc_mcu9t5v0__aoi21_1
X_17390_ _18617_/Q _17306_/C _17391_/A3 VSS VSS VSS VSS gf180mcu_fd_sc_mcu9t5v0__nand2_1
Xeco15_sk1_6 clkload80/I eco15_sk2_6/I VSS VSS VSS VSS gf180mcu_fd_sc_mcu9t5v0__clkbuf_16
X_16410_ _19230_/Q _16932_/A2 _16411_/A2 VSS VSS VSS VSS gf180mcu_fd_sc_mcu9t5v0__nand2_1
X_10834_ _20068_/Q _10834_/A2 _20069_/Q _10835_/A3 VSS VSS VSS VSS gf180mcu_fd_sc_mcu9t5v0__aoi21_1
X_13622_ _13622_/A1 _13622_/A2 _13622_/B _19286_/D VSS _13622_/VNW VSS VSS gf180mcu_fd_sc_mcu9t5v0__oai21_1
X_16341_ _19230_/Q _16016_/B _16871_/S _16341_/Z VSS VSS VSS VSS gf180mcu_fd_sc_mcu9t5v0__mux2_1
XTAP_TAPCELL_ROW_250_5939 VSS VSS gf180mcu_fd_sc_mcu9t5v0__filltie
X_13553_ _19272_/Q _13419_/B _13558_/B VSS VSS VSS VSS gf180mcu_fd_sc_mcu9t5v0__nand2_1
X_10765_ _19007_/Q _18831_/Q _10766_/A3 VSS VSS VSS VSS gf180mcu_fd_sc_mcu9t5v0__nor2_1
X_19060_ _19060_/D _20020_/RN clkload36/I _19060_/Q VSS VSS VSS VSS gf180mcu_fd_sc_mcu9t5v0__dffrnq_1
X_12504_ _19159_/Q _12488_/I _12505_/B VSS _12505_/VNW VSS VSS gf180mcu_fd_sc_mcu9t5v0__nand2_1
X_16272_ _18210_/Q _16272_/I1 _16824_/S _18210_/D VSS VSS VSS VSS gf180mcu_fd_sc_mcu9t5v0__mux2_4
X_10696_ _10718_/C _10696_/A2 _10696_/B1 _10696_/B2 _10696_/ZN VSS VSS VSS VSS gf180mcu_fd_sc_mcu9t5v0__aoi22_4
X_13484_ _13486_/A1 _19780_/Q _13495_/A1 VSS VSS VSS VSS gf180mcu_fd_sc_mcu9t5v0__nor2_1
X_12435_ wire175/Z wire124/Z _12618_/B _12437_/A3 VSS _12435_/VNW VSS VSS gf180mcu_fd_sc_mcu9t5v0__aoi21_1
X_15223_ _15224_/A1 _19572_/Q _15229_/B VSS _15223_/VNW VSS VSS gf180mcu_fd_sc_mcu9t5v0__nand2_1
X_18011_ _18027_/I0 _18896_/Q _18021_/S _18896_/D VSS VSS VSS VSS gf180mcu_fd_sc_mcu9t5v0__mux2_1
XPHY_EDGE_ROW_51_Right_51 VSS VSS gf180mcu_fd_sc_mcu9t5v0__endcap
X_12366_ _18154_/Q _12382_/S _12370_/A2 VSS VSS VSS VSS gf180mcu_fd_sc_mcu9t5v0__nor2_1
XTAP_TAPCELL_ROW_248_5879 VSS VSS gf180mcu_fd_sc_mcu9t5v0__filltie
X_15154_ _19696_/Q _19536_/Q wire108/Z _19696_/D VSS VSS VSS VSS gf180mcu_fd_sc_mcu9t5v0__mux2_1
X_11317_ _11317_/A1 _11317_/A2 _11317_/B wire136/Z _11318_/B VSS _11317_/VNW VSS VSS
+ gf180mcu_fd_sc_mcu9t5v0__oai211_1
X_14105_ _14105_/I _14131_/A1 VSS _14127_/VNW VSS VSS gf180mcu_fd_sc_mcu9t5v0__clkinv_1
X_19962_ _19962_/D _20026_/RN clkload45/I _19962_/Q VSS VSS VSS VSS gf180mcu_fd_sc_mcu9t5v0__dffrnq_1
X_15085_ _19395_/Q _19312_/Q _15089_/B VSS VSS VSS VSS gf180mcu_fd_sc_mcu9t5v0__xor2_1
X_12297_ _19136_/Q _12297_/I1 _12333_/B _19136_/D VSS _12297_/VNW VSS VSS gf180mcu_fd_sc_mcu9t5v0__mux2_1
X_11248_ _18339_/Q _18323_/Q _18307_/Q _18291_/Q _11524_/S _11485_/C _11248_/Z VSS
+ VSS VSS VSS gf180mcu_fd_sc_mcu9t5v0__mux4_1
X_19893_ _19893_/D _20021_/RN clkload71/I _19893_/Q VSS VSS VSS VSS gf180mcu_fd_sc_mcu9t5v0__dffrnq_1
XTAP_TAPCELL_ROW_17_1445 VSS VSS gf180mcu_fd_sc_mcu9t5v0__filltie
X_14036_ _14034_/B _14036_/A2 _14036_/A3 _14037_/A2 VSS _14036_/VNW VSS VSS gf180mcu_fd_sc_mcu9t5v0__nor3_1
X_18913_ _18913_/D _20065_/RN clkload11/I _18913_/Q VSS VSS VSS VSS gf180mcu_fd_sc_mcu9t5v0__dffrnq_1
X_11179_ _18566_/Q _18174_/Q _11181_/A1 VSS VSS VSS VSS gf180mcu_fd_sc_mcu9t5v0__nand2_1
X_18844_ _18844_/D _20060_/RN clkload33/I _18844_/Q VSS VSS VSS VSS gf180mcu_fd_sc_mcu9t5v0__dffrnq_1
XTAP_TAPCELL_ROW_17_1456 VSS VSS gf180mcu_fd_sc_mcu9t5v0__filltie
X_18775_ _18775_/D _20055_/RN clkload55/I _18775_/Q VSS VSS VSS VSS gf180mcu_fd_sc_mcu9t5v0__dffrnq_1
X_15987_ _15954_/B _16234_/A2 _15985_/C _16106_/B VSS VSS VSS VSS gf180mcu_fd_sc_mcu9t5v0__nor3_4
XPHY_EDGE_ROW_60_Right_60 VSS VSS gf180mcu_fd_sc_mcu9t5v0__endcap
X_17726_ _18739_/Q _17685_/S _17743_/B _09065_/I _17727_/I VSS VSS VSS VSS gf180mcu_fd_sc_mcu9t5v0__aoi22_1
X_14938_ _19423_/Q _14937_/Z _14939_/I1 VSS VSS VSS VSS gf180mcu_fd_sc_mcu9t5v0__xnor2_1
X_17657_ _18620_/Q _18696_/Q _17685_/S _18696_/D VSS VSS VSS VSS gf180mcu_fd_sc_mcu9t5v0__mux2_1
X_14869_ _19411_/Q _19352_/Q _14872_/A1 _14870_/I1 VSS VSS VSS VSS gf180mcu_fd_sc_mcu9t5v0__xnor3_1
X_16608_ _15996_/B _16608_/A2 _16608_/A3 _16608_/B _16609_/I1 VSS VSS VSS VSS gf180mcu_fd_sc_mcu9t5v0__oai31_1
XTAP_TAPCELL_ROW_80_3170 VSS VSS gf180mcu_fd_sc_mcu9t5v0__filltie
X_17588_ _18654_/Q _17577_/S _17589_/A2 VSS VSS VSS VSS gf180mcu_fd_sc_mcu9t5v0__nand2_1
XTAP_TAPCELL_ROW_80_3192 VSS VSS gf180mcu_fd_sc_mcu9t5v0__filltie
XTAP_TAPCELL_ROW_80_3181 VSS VSS gf180mcu_fd_sc_mcu9t5v0__filltie
X_19327_ _19327_/D _20031_/RN clkload19/I _19327_/Q VSS VSS VSS VSS gf180mcu_fd_sc_mcu9t5v0__dffrnq_1
X_16539_ _16182_/B _19241_/Q _17057_/S _16539_/Z VSS _16539_/VNW VSS VSS gf180mcu_fd_sc_mcu9t5v0__mux2_1
X_19258_ _19258_/D _20026_/RN _19680_/CLK _19258_/Q VSS VSS VSS VSS gf180mcu_fd_sc_mcu9t5v0__dffrnq_2
X_18209_ _18209_/D clkload68/I _18209_/Q VSS VSS VSS VSS gf180mcu_fd_sc_mcu9t5v0__dffq_1
XTAP_TAPCELL_ROW_93_3542 VSS VSS gf180mcu_fd_sc_mcu9t5v0__filltie
X_19189_ _19189_/D _20021_/RN clkload13/I _19189_/Q VSS VSS VSS VSS gf180mcu_fd_sc_mcu9t5v0__dffrnq_1
XTAP_TAPCELL_ROW_93_3531 VSS VSS gf180mcu_fd_sc_mcu9t5v0__filltie
XTAP_TAPCELL_ROW_93_3553 VSS VSS gf180mcu_fd_sc_mcu9t5v0__filltie
XTAP_TAPCELL_ROW_260_6224 VSS VSS gf180mcu_fd_sc_mcu9t5v0__filltie
XTAP_TAPCELL_ROW_260_6213 VSS VSS gf180mcu_fd_sc_mcu9t5v0__filltie
XPHY_EDGE_ROW_103_Right_103 VSS VSS gf180mcu_fd_sc_mcu9t5v0__endcap
X_20102_ _20102_/D clkload78/I _20102_/Q VSS VSS VSS VSS gf180mcu_fd_sc_mcu9t5v0__dffq_1
X_09913_ _19229_/Q _09998_/C _10169_/B1 _19237_/Q _10168_/B1 _19205_/Q _09914_/A2
+ VSS VSS VSS VSS gf180mcu_fd_sc_mcu9t5v0__aoi222_1
X_09844_ _20030_/Q _17412_/B _10794_/A2 VSS VSS VSS VSS gf180mcu_fd_sc_mcu9t5v0__nor2_1
X_20033_ _20033_/D _20033_/RN _20054_/CLK _20033_/Q VSS VSS VSS VSS gf180mcu_fd_sc_mcu9t5v0__dffrnq_1
XTAP_TAPCELL_ROW_258_6153 VSS VSS gf180mcu_fd_sc_mcu9t5v0__filltie
XTAP_TAPCELL_ROW_87_3368 VSS VSS gf180mcu_fd_sc_mcu9t5v0__filltie
XTAP_TAPCELL_ROW_258_6175 VSS VSS gf180mcu_fd_sc_mcu9t5v0__filltie
XTAP_TAPCELL_ROW_258_6164 VSS VSS gf180mcu_fd_sc_mcu9t5v0__filltie
X_09775_ _20026_/Q _18060_/B _09775_/B _09827_/A1 VSS VSS VSS VSS gf180mcu_fd_sc_mcu9t5v0__oai21_1
XTAP_TAPCELL_ROW_87_3379 VSS VSS gf180mcu_fd_sc_mcu9t5v0__filltie
XTAP_TAPCELL_ROW_3_1054 VSS VSS gf180mcu_fd_sc_mcu9t5v0__filltie
XTAP_TAPCELL_ROW_3_1065 VSS VSS gf180mcu_fd_sc_mcu9t5v0__filltie
XTAP_TAPCELL_ROW_3_1076 VSS VSS gf180mcu_fd_sc_mcu9t5v0__filltie
X_10550_ _10389_/C _10649_/A2 _10550_/A3 _17161_/C _10551_/B2 VSS VSS VSS VSS gf180mcu_fd_sc_mcu9t5v0__oai31_1
X_10481_ _18996_/Q _10654_/A2 _10481_/B wire160/Z _10503_/A1 VSS VSS VSS VSS gf180mcu_fd_sc_mcu9t5v0__oai211_1
XTAP_TAPCELL_ROW_230_5393 VSS VSS gf180mcu_fd_sc_mcu9t5v0__filltie
XTAP_TAPCELL_ROW_230_5382 VSS VSS gf180mcu_fd_sc_mcu9t5v0__filltie
X_09209_ _19560_/Q _15182_/A2 VSS VSS VSS VSS gf180mcu_fd_sc_mcu9t5v0__clkinv_1
Xrebuffer231 _09472_/ZN _14624_/S VSS VSS VSS VSS gf180mcu_fd_sc_mcu9t5v0__buf_12
X_12220_ _18370_/Q _18354_/Q _12340_/S _12220_/Z VSS _12220_/VNW VSS VSS gf180mcu_fd_sc_mcu9t5v0__mux2_1
Xclkbuf_3_5_0_clk_regs clkbuf_0_clk_regs/Z clkload4/I VSS VSS VSS VSS gf180mcu_fd_sc_mcu9t5v0__clkbuf_8
Xrebuffer264 _15855_/A2 _09700_/A1 VSS VSS VSS VSS gf180mcu_fd_sc_mcu9t5v0__buf_8
X_12151_ _18367_/Q _18351_/Q _12315_/S _12151_/Z VSS _16975_/VNW VSS VSS gf180mcu_fd_sc_mcu9t5v0__mux2_1
XTAP_TAPCELL_ROW_243_5743 VSS VSS gf180mcu_fd_sc_mcu9t5v0__filltie
XTAP_TAPCELL_ROW_72_2958 VSS VSS gf180mcu_fd_sc_mcu9t5v0__filltie
X_12082_ _12090_/B _12082_/A2 _12082_/A3 _12094_/B1 VSS VSS VSS VSS gf180mcu_fd_sc_mcu9t5v0__nor3_1
X_11102_ _18265_/Q _11403_/S _11428_/B _11103_/A2 VSS VSS VSS VSS gf180mcu_fd_sc_mcu9t5v0__oai21_1
XTAP_TAPCELL_ROW_243_5765 VSS VSS gf180mcu_fd_sc_mcu9t5v0__filltie
XTAP_TAPCELL_ROW_243_5754 VSS VSS gf180mcu_fd_sc_mcu9t5v0__filltie
XTAP_TAPCELL_ROW_72_2969 VSS VSS gf180mcu_fd_sc_mcu9t5v0__filltie
XPHY_EDGE_ROW_8_Left_332 VSS VSS gf180mcu_fd_sc_mcu9t5v0__endcap
X_15910_ _20119_/Q _19255_/Q wire79/Z _20119_/D VSS VSS VSS VSS gf180mcu_fd_sc_mcu9t5v0__mux2_1
X_11033_ _19066_/Q _19034_/Q _11051_/S _19034_/D VSS VSS VSS VSS gf180mcu_fd_sc_mcu9t5v0__mux2_1
X_16890_ _18437_/Q _16889_/Z wire38/Z _18437_/D VSS VSS VSS VSS gf180mcu_fd_sc_mcu9t5v0__mux2_1
X_15841_ _20139_/Q _09758_/B _17571_/S VSS VSS VSS VSS gf180mcu_fd_sc_mcu9t5v0__nand2_1
XTAP_TAPCELL_ROW_12_1320 VSS VSS gf180mcu_fd_sc_mcu9t5v0__filltie
X_15772_ wire301/Z _19942_/Q _15786_/S _19942_/D VSS VSS VSS VSS gf180mcu_fd_sc_mcu9t5v0__mux2_1
X_18560_ _18560_/D _20060_/RN clkload25/I _18560_/Q VSS VSS VSS VSS gf180mcu_fd_sc_mcu9t5v0__dffrnq_1
X_12984_ _12984_/A1 _12983_/B _12987_/A2 VSS VSS VSS VSS gf180mcu_fd_sc_mcu9t5v0__xnor2_1
X_17511_ _18616_/Q _19257_/Q _17511_/S _18616_/D VSS VSS VSS VSS gf180mcu_fd_sc_mcu9t5v0__mux2_1
X_18491_ _18491_/D _18509_/CLK _18491_/Q VSS VSS VSS VSS gf180mcu_fd_sc_mcu9t5v0__dffq_4
X_11935_ _18277_/Q _12345_/A2 _12299_/S _11936_/B2 VSS VSS VSS VSS gf180mcu_fd_sc_mcu9t5v0__aoi21_1
X_14723_ _19543_/Q _14730_/S _14724_/B VSS VSS VSS VSS gf180mcu_fd_sc_mcu9t5v0__nand2_1
X_17442_ _11095_/S _17443_/A2 _17442_/B _18567_/D VSS VSS VSS VSS gf180mcu_fd_sc_mcu9t5v0__oai21_1
XPHY_EDGE_ROW_183_1_Left_506 VSS VSS gf180mcu_fd_sc_mcu9t5v0__endcap
X_14654_ _19525_/Q _14715_/S _14655_/B VSS _14654_/VNW VSS VSS gf180mcu_fd_sc_mcu9t5v0__nand2_1
X_11866_ _12299_/S _11866_/A2 _11866_/A3 _11867_/B VSS VSS VSS VSS gf180mcu_fd_sc_mcu9t5v0__nand3_1
XPHY_EDGE_ROW_254_Right_181 VSS VSS gf180mcu_fd_sc_mcu9t5v0__endcap
X_13605_ _13608_/A1 _13608_/A2 _13605_/Z VSS VSS VSS VSS gf180mcu_fd_sc_mcu9t5v0__and2_1
X_17373_ _18551_/Q _17394_/A2 _17393_/B VSS _17410_/VNW VSS VSS gf180mcu_fd_sc_mcu9t5v0__nand2_1
X_10817_ _20061_/Q _10817_/A2 _10818_/B VSS _10817_/VNW VSS VSS gf180mcu_fd_sc_mcu9t5v0__nand2_1
X_11797_ _18175_/Q _18159_/Q _12340_/S _11797_/Z VSS VSS VSS VSS gf180mcu_fd_sc_mcu9t5v0__mux2_1
X_14585_ _19138_/Q _14590_/B _14624_/S _14586_/B2 VSS _14585_/VNW VSS VSS gf180mcu_fd_sc_mcu9t5v0__aoi21_1
X_16324_ _18227_/Q _16323_/Z _16862_/S _18227_/D VSS VSS VSS VSS gf180mcu_fd_sc_mcu9t5v0__mux2_4
X_10748_ _19865_/Q _10724_/C _10748_/B _10749_/A2 VSS VSS VSS VSS gf180mcu_fd_sc_mcu9t5v0__oai21_4
X_13536_ _13536_/A1 _13536_/A2 _13536_/Z VSS _13536_/VNW VSS VSS gf180mcu_fd_sc_mcu9t5v0__or2_1
X_19112_ _19112_/D _20072_/RN clkload11/I _19112_/Q VSS VSS VSS VSS gf180mcu_fd_sc_mcu9t5v0__dffrnq_1
X_16255_ _19265_/Q _16142_/C _16955_/S _16255_/Z VSS _16255_/VNW VSS VSS gf180mcu_fd_sc_mcu9t5v0__mux2_1
X_13467_ _19747_/Q _13469_/A2 _13485_/A2 VSS _13485_/VNW VSS VSS gf180mcu_fd_sc_mcu9t5v0__nand2_1
X_19043_ _19043_/D _20067_/RN clkload34/I _19043_/Q VSS VSS VSS VSS gf180mcu_fd_sc_mcu9t5v0__dffrnq_1
X_12418_ _18304_/Q _12608_/A2 wire146/Z _12419_/B2 VSS _12418_/VNW VSS VSS gf180mcu_fd_sc_mcu9t5v0__oai21_1
X_10679_ _15470_/A1 _19819_/Q _10679_/B _17411_/C _10680_/B VSS VSS VSS VSS gf180mcu_fd_sc_mcu9t5v0__oai211_1
X_15206_ _15206_/A1 _19568_/Q _15206_/A3 _15208_/A2 VSS VSS VSS VSS gf180mcu_fd_sc_mcu9t5v0__xnor3_1
X_16186_ _19242_/Q _16751_/B _16189_/A2 VSS VSS VSS VSS gf180mcu_fd_sc_mcu9t5v0__nand2_1
XTAP_TAPCELL_ROW_131_4590 VSS VSS gf180mcu_fd_sc_mcu9t5v0__filltie
X_13398_ _13416_/A1 _19775_/Q _13398_/A3 _13399_/A2 VSS VSS VSS VSS gf180mcu_fd_sc_mcu9t5v0__xnor3_1
X_12349_ _12349_/A1 _12349_/A2 _12350_/A2 VSS VSS VSS VSS gf180mcu_fd_sc_mcu9t5v0__nand2_1
X_15137_ _19679_/Q _19519_/Q wire108/Z _19679_/D VSS VSS VSS VSS gf180mcu_fd_sc_mcu9t5v0__mux2_1
Xdelaybuf_3_core_clk delaybuf_3_core_clk/I clkbuf_0_clk/I VSS VSS VSS VSS gf180mcu_fd_sc_mcu9t5v0__clkbuf_16
XTAP_TAPCELL_ROW_19_1507 VSS VSS gf180mcu_fd_sc_mcu9t5v0__filltie
XTAP_TAPCELL_ROW_19_1518 VSS VSS gf180mcu_fd_sc_mcu9t5v0__filltie
XTAP_TAPCELL_ROW_321_7898 VSS VSS gf180mcu_fd_sc_mcu9t5v0__filltie
XTAP_TAPCELL_ROW_321_7887 VSS VSS gf180mcu_fd_sc_mcu9t5v0__filltie
X_19945_ _19945_/D _20073_/RN clkload50/I _19945_/Q VSS VSS VSS VSS gf180mcu_fd_sc_mcu9t5v0__dffrnq_1
X_15068_ _19308_/Q _19393_/Q _15068_/B _15073_/A1 VSS _15068_/VNW VSS VSS gf180mcu_fd_sc_mcu9t5v0__aoi21_1
X_14019_ _14033_/A1 _14033_/A2 _14020_/I VSS VSS VSS VSS gf180mcu_fd_sc_mcu9t5v0__xnor2_1
X_19876_ _19876_/D _20068_/RN clkload56/I _19876_/Q VSS VSS VSS VSS gf180mcu_fd_sc_mcu9t5v0__dffrnq_1
XPHY_EDGE_ROW_171_3_Left_829 VSS VSS gf180mcu_fd_sc_mcu9t5v0__endcap
XPHY_EDGE_ROW_308_Left_631 VSS VSS gf180mcu_fd_sc_mcu9t5v0__endcap
X_18827_ _18827_/D _20043_/RN clkload55/I _18827_/Q VSS VSS VSS VSS gf180mcu_fd_sc_mcu9t5v0__dffrnq_1
X_18758_ _18758_/D _20038_/RN _20049_/CLK _18758_/Q VSS VSS VSS VSS gf180mcu_fd_sc_mcu9t5v0__dffrnq_1
X_09560_ _20028_/Q _20031_/Q _20042_/Q _09974_/C VSS VSS VSS VSS gf180mcu_fd_sc_mcu9t5v0__nor3_1
X_17709_ _17709_/A1 _17709_/A2 _18730_/D VSS _17709_/VNW VSS VSS gf180mcu_fd_sc_mcu9t5v0__nand2_1
XTAP_TAPCELL_ROW_82_3243 VSS VSS gf180mcu_fd_sc_mcu9t5v0__filltie
X_09491_ _19140_/Q _14370_/A1 _12356_/A1 VSS VSS VSS VSS gf180mcu_fd_sc_mcu9t5v0__nand2_1
XTAP_TAPCELL_ROW_82_3232 VSS VSS gf180mcu_fd_sc_mcu9t5v0__filltie
X_18689_ _18689_/D _20029_/RN clkload24/I _18689_/Q VSS VSS VSS VSS gf180mcu_fd_sc_mcu9t5v0__dffrnq_1
XTAP_TAPCELL_ROW_95_3604 VSS VSS gf180mcu_fd_sc_mcu9t5v0__filltie
XPHY_EDGE_ROW_317_Left_640 VSS VSS gf180mcu_fd_sc_mcu9t5v0__endcap
XTAP_TAPCELL_ROW_76_3069 VSS VSS gf180mcu_fd_sc_mcu9t5v0__filltie
XTAP_TAPCELL_ROW_89_3419 VSS VSS gf180mcu_fd_sc_mcu9t5v0__filltie
XTAP_TAPCELL_ROW_110_3995 VSS VSS gf180mcu_fd_sc_mcu9t5v0__filltie
XTAP_TAPCELL_ROW_9_1230 VSS VSS gf180mcu_fd_sc_mcu9t5v0__filltie
X_20016_ _20016_/D _20144_/RN _20049_/CLK _20016_/Q VSS VSS VSS VSS gf180mcu_fd_sc_mcu9t5v0__dffrnq_1
XPHY_EDGE_ROW_202_2_Left_714 VSS VSS gf180mcu_fd_sc_mcu9t5v0__endcap
X_09827_ _09827_/A1 _09827_/A2 _20026_/D VSS _09829_/VNW VSS VSS gf180mcu_fd_sc_mcu9t5v0__nand2_1
XTAP_TAPCELL_ROW_9_1241 VSS VSS gf180mcu_fd_sc_mcu9t5v0__filltie
X_09758_ _20140_/Q _09758_/A2 _09758_/B _17627_/A1 VSS VSS VSS VSS gf180mcu_fd_sc_mcu9t5v0__oai21_1
XTAP_TAPCELL_ROW_5_1116 VSS VSS gf180mcu_fd_sc_mcu9t5v0__filltie
XTAP_TAPCELL_ROW_5_1127 VSS VSS gf180mcu_fd_sc_mcu9t5v0__filltie
X_11720_ _11720_/A1 _11748_/A2 _11720_/B _11721_/A2 VSS VSS VSS VSS gf180mcu_fd_sc_mcu9t5v0__oai21_1
X_09689_ _09695_/A3 _09689_/A2 _20012_/D VSS _09689_/VNW VSS VSS gf180mcu_fd_sc_mcu9t5v0__nand2_1
XTAP_TAPCELL_ROW_65_2762 VSS VSS gf180mcu_fd_sc_mcu9t5v0__filltie
XTAP_TAPCELL_ROW_65_2773 VSS VSS gf180mcu_fd_sc_mcu9t5v0__filltie
XTAP_TAPCELL_ROW_232_5455 VSS VSS gf180mcu_fd_sc_mcu9t5v0__filltie
XTAP_TAPCELL_ROW_232_5444 VSS VSS gf180mcu_fd_sc_mcu9t5v0__filltie
XTAP_TAPCELL_ROW_61_2648 VSS VSS gf180mcu_fd_sc_mcu9t5v0__filltie
X_11651_ _12632_/C _11659_/A2 _12632_/B _11652_/B1 VSS _12635_/VNW VSS VSS gf180mcu_fd_sc_mcu9t5v0__nor3_1
XTAP_TAPCELL_ROW_61_2659 VSS VSS gf180mcu_fd_sc_mcu9t5v0__filltie
X_10602_ _19000_/Q _10654_/A2 _10602_/B wire160/Z _10604_/B1 VSS _10602_/VNW VSS VSS
+ gf180mcu_fd_sc_mcu9t5v0__oai211_1
X_11582_ _11610_/A1 _11581_/Z _11610_/B _11589_/A1 VSS _11582_/VNW VSS VSS gf180mcu_fd_sc_mcu9t5v0__aoi21_1
X_14370_ _14370_/A1 _14370_/A2 _19439_/D VSS VSS VSS VSS gf180mcu_fd_sc_mcu9t5v0__nand2_1
X_10533_ _18340_/Q _18324_/Q _17404_/S _10533_/Z VSS VSS VSS VSS gf180mcu_fd_sc_mcu9t5v0__mux2_1
XTAP_TAPCELL_ROW_249_5930 VSS VSS gf180mcu_fd_sc_mcu9t5v0__filltie
X_13321_ _16700_/A1 _13320_/B _13321_/B1 _13321_/B2 _19249_/D VSS _13321_/VNW VSS
+ VSS gf180mcu_fd_sc_mcu9t5v0__aoi22_1
X_16040_ _18158_/Q _16040_/I1 _16602_/S _18158_/D VSS VSS VSS VSS gf180mcu_fd_sc_mcu9t5v0__mux2_4
XTAP_TAPCELL_ROW_245_5816 VSS VSS gf180mcu_fd_sc_mcu9t5v0__filltie
XTAP_TAPCELL_ROW_245_5805 VSS VSS gf180mcu_fd_sc_mcu9t5v0__filltie
X_10464_ _10459_/C _10464_/A2 _10464_/A3 _10464_/B _10465_/B1 VSS VSS VSS VSS gf180mcu_fd_sc_mcu9t5v0__oai31_1
X_13252_ _13255_/A1 _13255_/A2 _13256_/A1 VSS VSS VSS VSS gf180mcu_fd_sc_mcu9t5v0__nand2_1
X_12203_ _18497_/Q _12203_/A2 _12205_/A2 VSS VSS VSS VSS gf180mcu_fd_sc_mcu9t5v0__nand2_1
X_10395_ _18992_/Q _10654_/A2 _10395_/B wire160/Z _10397_/B1 VSS _10395_/VNW VSS VSS
+ gf180mcu_fd_sc_mcu9t5v0__oai211_1
X_13183_ _13183_/A1 _19762_/Q _13195_/A2 _13184_/A2 VSS VSS VSS VSS gf180mcu_fd_sc_mcu9t5v0__xnor3_1
XTAP_TAPCELL_ROW_59_2599 VSS VSS gf180mcu_fd_sc_mcu9t5v0__filltie
X_12134_ _18414_/Q _12315_/S _12137_/A2 VSS _17129_/VNW VSS VSS gf180mcu_fd_sc_mcu9t5v0__nand2_1
X_17991_ _18877_/Q _18024_/I0 _17997_/S _18877_/D VSS VSS VSS VSS gf180mcu_fd_sc_mcu9t5v0__mux2_1
X_19730_ _19730_/D _20050_/RN clkload10/I _19730_/Q VSS VSS VSS VSS gf180mcu_fd_sc_mcu9t5v0__dffrnq_1
X_12065_ _18459_/Q _12203_/A2 _12159_/B _12066_/B2 VSS VSS VSS VSS gf180mcu_fd_sc_mcu9t5v0__aoi21_1
X_16942_ _16941_/Z _18462_/Q wire33/Z _18462_/D VSS VSS VSS VSS gf180mcu_fd_sc_mcu9t5v0__mux2_1
XPHY_EDGE_ROW_323_Right_250 VSS VSS gf180mcu_fd_sc_mcu9t5v0__endcap
X_16873_ _19248_/Q _16599_/B _16881_/S _16873_/Z VSS VSS VSS VSS gf180mcu_fd_sc_mcu9t5v0__mux2_4
X_11016_ _11018_/A1 _11016_/A2 _11019_/A1 VSS VSS VSS VSS gf180mcu_fd_sc_mcu9t5v0__nand2_1
X_19661_ _19661_/D _20045_/RN clkload42/I _19661_/Q VSS VSS VSS VSS gf180mcu_fd_sc_mcu9t5v0__dffrnq_1
X_18612_ _18612_/D clkload76/I _18612_/Q VSS VSS VSS VSS gf180mcu_fd_sc_mcu9t5v0__dffq_1
X_15824_ _15824_/A1 _15825_/A1 _15824_/A3 _15823_/B _15824_/B2 _19990_/D VSS _15824_/VNW
+ VSS VSS gf180mcu_fd_sc_mcu9t5v0__oai32_1
X_19592_ _19592_/D _20040_/RN clkload17/I _19592_/Q VSS VSS VSS VSS gf180mcu_fd_sc_mcu9t5v0__dffrnq_1
X_18543_ _18543_/D _20043_/RN clkload52/I _18543_/Q VSS VSS VSS VSS gf180mcu_fd_sc_mcu9t5v0__dffrnq_1
X_15755_ _19930_/Q _19928_/Q _19929_/Q _15740_/Z _15759_/A3 VSS _15755_/VNW VSS VSS
+ gf180mcu_fd_sc_mcu9t5v0__nor4_1
XTAP_TAPCELL_ROW_120_4291 VSS VSS gf180mcu_fd_sc_mcu9t5v0__filltie
XTAP_TAPCELL_ROW_120_4280 VSS VSS gf180mcu_fd_sc_mcu9t5v0__filltie
X_12967_ _12734_/Z _12967_/A2 _12973_/A2 VSS _12967_/VNW VSS VSS gf180mcu_fd_sc_mcu9t5v0__nor2_1
X_11918_ _18228_/Q _12340_/S _12347_/C _11921_/A2 VSS VSS VSS VSS gf180mcu_fd_sc_mcu9t5v0__aoi21_1
X_18474_ _18474_/D _20129_/CLK _18474_/Q VSS VSS VSS VSS gf180mcu_fd_sc_mcu9t5v0__dffq_1
X_15686_ _15686_/A1 _09676_/B _15686_/B _15689_/S VSS VSS VSS VSS gf180mcu_fd_sc_mcu9t5v0__oai21_1
X_12898_ _12898_/A1 _12891_/Z _12898_/B _12901_/A2 VSS VSS VSS VSS gf180mcu_fd_sc_mcu9t5v0__aoi21_1
X_14706_ _19156_/Q _19122_/Q _14706_/B _14707_/A3 VSS VSS VSS VSS gf180mcu_fd_sc_mcu9t5v0__aoi21_1
XTAP_TAPCELL_ROW_310_7599 VSS VSS gf180mcu_fd_sc_mcu9t5v0__filltie
XTAP_TAPCELL_ROW_310_7588 VSS VSS gf180mcu_fd_sc_mcu9t5v0__filltie
X_11849_ _11849_/A1 _11849_/A2 _11850_/B VSS _11849_/VNW VSS VSS gf180mcu_fd_sc_mcu9t5v0__nor2_1
X_17425_ _20012_/Q _17425_/A2 _17427_/A1 VSS _17426_/VNW VSS VSS gf180mcu_fd_sc_mcu9t5v0__nand2_1
X_14637_ _19099_/Q _19515_/Q _14730_/S _19515_/D VSS VSS VSS VSS gf180mcu_fd_sc_mcu9t5v0__mux2_1
X_17356_ _18422_/Q _17406_/A2 _17405_/A2 _18438_/Q _17401_/C _17357_/B VSS VSS VSS
+ VSS gf180mcu_fd_sc_mcu9t5v0__aoi221_1
XTAP_TAPCELL_ROW_133_4630 VSS VSS gf180mcu_fd_sc_mcu9t5v0__filltie
X_14568_ _19171_/Q _19137_/Q _14758_/A1 VSS _14568_/VNW VSS VSS gf180mcu_fd_sc_mcu9t5v0__nand2_1
X_16307_ _19230_/Q _16016_/B _16861_/S _16307_/Z VSS _17004_/VNW VSS VSS gf180mcu_fd_sc_mcu9t5v0__mux2_1
XTAP_TAPCELL_ROW_215_4996 VSS VSS gf180mcu_fd_sc_mcu9t5v0__filltie
XTAP_TAPCELL_ROW_215_4985 VSS VSS gf180mcu_fd_sc_mcu9t5v0__filltie
XTAP_TAPCELL_ROW_215_4974 VSS VSS gf180mcu_fd_sc_mcu9t5v0__filltie
XTAP_TAPCELL_ROW_133_4652 VSS VSS gf180mcu_fd_sc_mcu9t5v0__filltie
XTAP_TAPCELL_ROW_133_4641 VSS VSS gf180mcu_fd_sc_mcu9t5v0__filltie
X_17287_ _20117_/Q wire168/Z _17409_/B _17287_/C _17289_/A2 VSS VSS VSS VSS gf180mcu_fd_sc_mcu9t5v0__oai211_1
X_13519_ _19265_/Q _13320_/B _13522_/B VSS VSS VSS VSS gf180mcu_fd_sc_mcu9t5v0__nand2_1
Xclkload10 clkload10/I clkload10/ZN VSS VSS VSS VSS gf180mcu_fd_sc_mcu9t5v0__clkinv_1
X_14499_ _19163_/Q _19129_/Q _14726_/A1 VSS _14500_/VNW VSS VSS gf180mcu_fd_sc_mcu9t5v0__xnor2_1
XTAP_TAPCELL_ROW_323_7949 VSS VSS gf180mcu_fd_sc_mcu9t5v0__filltie
X_16238_ _16117_/C _16787_/S _16406_/A1 VSS VSS VSS VSS gf180mcu_fd_sc_mcu9t5v0__nand2_4
Xclkload43 clkload43/I clkload43/ZN VSS VSS VSS VSS gf180mcu_fd_sc_mcu9t5v0__inv_4
X_19026_ _19026_/D _20050_/RN clkload33/I _19026_/Q VSS VSS VSS VSS gf180mcu_fd_sc_mcu9t5v0__dffrnq_1
Xclkload32 clkload32/I clkload32/Z VSS VSS VSS VSS gf180mcu_fd_sc_mcu9t5v0__clkbuf_4
Xclkload21 clkload21/I clkload21/ZN VSS VSS VSS VSS gf180mcu_fd_sc_mcu9t5v0__clkinv_1
X_16169_ _16169_/A1 _16169_/A2 _16169_/B _16170_/I1 VSS VSS VSS VSS gf180mcu_fd_sc_mcu9t5v0__oai21_1
Xclkload76 clkload76/I clkload76/ZN VSS _17410_/VNW VSS VSS gf180mcu_fd_sc_mcu9t5v0__inv_2
Xclkload65 clkload65/I clkload65/ZN VSS VSS VSS VSS gf180mcu_fd_sc_mcu9t5v0__inv_2
Xclkload54 clkload54/I clkload54/ZN VSS VSS VSS VSS gf180mcu_fd_sc_mcu9t5v0__inv_8
XPHY_EDGE_ROW_181_2_Left_693 VSS VSS gf180mcu_fd_sc_mcu9t5v0__endcap
XTAP_TAPCELL_ROW_209_4789 VSS VSS gf180mcu_fd_sc_mcu9t5v0__filltie
XTAP_TAPCELL_ROW_209_4778 VSS VSS gf180mcu_fd_sc_mcu9t5v0__filltie
X_19928_ _19928_/D _19992_/RN clkload49/I _19928_/Q VSS VSS VSS VSS gf180mcu_fd_sc_mcu9t5v0__dffrnq_1
XTAP_TAPCELL_ROW_127_4478 VSS VSS gf180mcu_fd_sc_mcu9t5v0__filltie
XTAP_TAPCELL_ROW_127_4467 VSS VSS gf180mcu_fd_sc_mcu9t5v0__filltie
X_19859_ _19859_/D _20051_/RN clkload58/I _19859_/Q VSS VSS VSS VSS gf180mcu_fd_sc_mcu9t5v0__dffrnq_1
XTAP_TAPCELL_ROW_84_3305 VSS VSS gf180mcu_fd_sc_mcu9t5v0__filltie
X_09612_ _12028_/A1 _17444_/A2 _17461_/A1 VSS VSS VSS VSS gf180mcu_fd_sc_mcu9t5v0__nand2_1
X_09543_ _20003_/Q _19996_/Q _09547_/A2 VSS _09548_/VNW VSS VSS gf180mcu_fd_sc_mcu9t5v0__nor2_1
X_09474_ _19157_/Q _14370_/A1 _12489_/A1 VSS _18023_/VNW VSS VSS gf180mcu_fd_sc_mcu9t5v0__nand2_1
Xwire119 wire119/I wire119/Z VSS wire119/VNW VSS VSS gf180mcu_fd_sc_mcu9t5v0__clkbuf_4
Xclkload4 clkload4/I clkload4/ZN VSS VSS VSS VSS gf180mcu_fd_sc_mcu9t5v0__clkinv_12
Xwire108 wire108/I wire108/Z VSS VSS VSS VSS gf180mcu_fd_sc_mcu9t5v0__buf_12
XTAP_TAPCELL_ROW_285_6897 VSS VSS gf180mcu_fd_sc_mcu9t5v0__filltie
XPHY_EDGE_ROW_89_Left_413 VSS VSS gf180mcu_fd_sc_mcu9t5v0__endcap
XTAP_TAPCELL_ROW_225_5270 VSS VSS gf180mcu_fd_sc_mcu9t5v0__filltie
X_10180_ _20042_/Q _10180_/A2 _10180_/B1 _10180_/B2 _20072_/Q _10181_/A2 VSS _10181_/VNW
+ VSS VSS gf180mcu_fd_sc_mcu9t5v0__aoi221_1
XTAP_TAPCELL_ROW_54_2463 VSS VSS gf180mcu_fd_sc_mcu9t5v0__filltie
XTAP_TAPCELL_ROW_54_2474 VSS VSS gf180mcu_fd_sc_mcu9t5v0__filltie
Xfanout241 _16862_/S _16850_/S VSS VSS VSS VSS gf180mcu_fd_sc_mcu9t5v0__clkbuf_16
XTAP_TAPCELL_ROW_50_2349 VSS VSS gf180mcu_fd_sc_mcu9t5v0__filltie
Xfanout252 _16893_/S _16881_/S VSS VSS VSS VSS gf180mcu_fd_sc_mcu9t5v0__clkbuf_16
XTAP_TAPCELL_ROW_221_5156 VSS VSS gf180mcu_fd_sc_mcu9t5v0__filltie
XTAP_TAPCELL_ROW_221_5145 VSS VSS gf180mcu_fd_sc_mcu9t5v0__filltie
X_13870_ _13870_/A1 _13870_/A2 _13870_/B _13903_/A1 VSS VSS VSS VSS gf180mcu_fd_sc_mcu9t5v0__oai21_1
XTAP_TAPCELL_ROW_67_2813 VSS VSS gf180mcu_fd_sc_mcu9t5v0__filltie
XPHY_EDGE_ROW_98_Left_422 VSS VSS gf180mcu_fd_sc_mcu9t5v0__endcap
XTAP_TAPCELL_ROW_238_5620 VSS VSS gf180mcu_fd_sc_mcu9t5v0__filltie
X_12821_ _19762_/Q _12820_/Z _12824_/B VSS _12826_/VNW VSS VSS gf180mcu_fd_sc_mcu9t5v0__xor2_1
XTAP_TAPCELL_ROW_67_2824 VSS VSS gf180mcu_fd_sc_mcu9t5v0__filltie
XTAP_TAPCELL_ROW_67_2835 VSS VSS gf180mcu_fd_sc_mcu9t5v0__filltie
XTAP_TAPCELL_ROW_234_5506 VSS VSS gf180mcu_fd_sc_mcu9t5v0__filltie
XTAP_TAPCELL_ROW_234_5517 VSS VSS gf180mcu_fd_sc_mcu9t5v0__filltie
XTAP_TAPCELL_ROW_219_5096 VSS VSS gf180mcu_fd_sc_mcu9t5v0__filltie
X_15540_ _19858_/Q wire300/Z _15544_/S _19858_/D VSS VSS VSS VSS gf180mcu_fd_sc_mcu9t5v0__mux2_1
XTAP_TAPCELL_ROW_219_5085 VSS VSS gf180mcu_fd_sc_mcu9t5v0__filltie
XTAP_TAPCELL_ROW_48_2289 VSS VSS gf180mcu_fd_sc_mcu9t5v0__filltie
X_12752_ _13304_/B _12752_/A2 _12752_/B _19198_/D VSS VSS VSS VSS gf180mcu_fd_sc_mcu9t5v0__oai21_1
X_15471_ _19826_/Q _15470_/Z _15471_/S _19826_/D VSS VSS VSS VSS gf180mcu_fd_sc_mcu9t5v0__mux2_1
X_12683_ _19181_/Q _12655_/S _12684_/B VSS VSS VSS VSS gf180mcu_fd_sc_mcu9t5v0__nand2_1
X_11703_ _18893_/Q _11703_/A2 _11722_/A2 VSS VSS VSS VSS gf180mcu_fd_sc_mcu9t5v0__xnor2_1
X_17210_ _18527_/Q _18511_/Q _17404_/S _17210_/Z VSS VSS VSS VSS gf180mcu_fd_sc_mcu9t5v0__mux2_1
X_11634_ _11590_/Z _11604_/Z _12658_/A2 VSS VSS VSS VSS gf180mcu_fd_sc_mcu9t5v0__nand2_1
X_14422_ _19152_/Q _14422_/A2 _14422_/B _14428_/A2 VSS VSS VSS VSS gf180mcu_fd_sc_mcu9t5v0__oai21_1
X_18190_ _18190_/D clkload72/I _18190_/Q VSS VSS VSS VSS gf180mcu_fd_sc_mcu9t5v0__dffq_1
X_11565_ _18313_/Q _12092_/B _12116_/C _11568_/A1 VSS VSS VSS VSS gf180mcu_fd_sc_mcu9t5v0__oai21_1
X_17141_ _19858_/Q _10724_/C _17141_/B _17143_/A3 VSS VSS VSS VSS gf180mcu_fd_sc_mcu9t5v0__oai21_1
X_14353_ _14353_/A1 _20037_/Q _09458_/Z _14367_/S VSS VSS VSS VSS gf180mcu_fd_sc_mcu9t5v0__nand3_2
X_10516_ _10516_/A1 _10516_/A2 _10516_/B _10516_/C _10521_/A3 VSS VSS VSS VSS gf180mcu_fd_sc_mcu9t5v0__oai211_1
X_11496_ _11521_/B _11494_/Z _11496_/B _11500_/A2 VSS VSS VSS VSS gf180mcu_fd_sc_mcu9t5v0__oai21_1
X_17072_ _18534_/Q _16660_/B _17074_/S _18534_/D VSS VSS VSS VSS gf180mcu_fd_sc_mcu9t5v0__mux2_1
X_13304_ _12734_/Z _13303_/Z _13304_/B _13305_/B2 VSS VSS VSS VSS gf180mcu_fd_sc_mcu9t5v0__aoi21_1
X_14284_ _14259_/Z _19358_/Q _14285_/S _19358_/D VSS _14871_/VNW VSS VSS gf180mcu_fd_sc_mcu9t5v0__mux2_1
X_10447_ _18946_/Q wire166/Z _10449_/A2 VSS VSS VSS VSS gf180mcu_fd_sc_mcu9t5v0__nand2_1
X_16023_ _19263_/Q _15996_/B _16025_/B VSS _17095_/VNW VSS VSS gf180mcu_fd_sc_mcu9t5v0__nand2_1
X_13235_ _19767_/Q _13235_/A2 _13255_/A1 VSS VSS VSS VSS gf180mcu_fd_sc_mcu9t5v0__nand2_1
X_10378_ _17378_/A1 _18318_/Q _10381_/A2 VSS VSS VSS VSS gf180mcu_fd_sc_mcu9t5v0__nor2_1
XTAP_TAPCELL_ROW_303_7392 VSS VSS gf180mcu_fd_sc_mcu9t5v0__filltie
X_13166_ _13184_/A1 _13166_/A2 _13419_/B _13167_/B2 VSS _13166_/VNW VSS VSS gf180mcu_fd_sc_mcu9t5v0__aoi21_1
X_12117_ _11736_/C _12117_/A2 _12120_/A2 VSS VSS VSS VSS gf180mcu_fd_sc_mcu9t5v0__nor2_1
X_13097_ _19726_/Q _13096_/Z _13098_/I VSS _13097_/VNW VSS VSS gf180mcu_fd_sc_mcu9t5v0__nor2_1
X_17974_ _18861_/Q _18024_/I0 _17978_/S _18861_/D VSS _17974_/VNW VSS VSS gf180mcu_fd_sc_mcu9t5v0__mux2_1
XTAP_TAPCELL_ROW_295_7193 VSS VSS gf180mcu_fd_sc_mcu9t5v0__filltie
X_16925_ _16668_/B _19258_/Q _16925_/S _16925_/Z VSS VSS VSS VSS gf180mcu_fd_sc_mcu9t5v0__mux2_1
XTAP_TAPCELL_ROW_295_7182 VSS VSS gf180mcu_fd_sc_mcu9t5v0__filltie
XTAP_TAPCELL_ROW_295_7171 VSS VSS gf180mcu_fd_sc_mcu9t5v0__filltie
X_12048_ _12092_/B _12046_/Z _12048_/B _12208_/C _12049_/A3 VSS VSS VSS VSS gf180mcu_fd_sc_mcu9t5v0__aoi211_1
XTAP_TAPCELL_ROW_37_1993 VSS VSS gf180mcu_fd_sc_mcu9t5v0__filltie
X_19713_ _19713_/D _20033_/RN clkload30/I _19713_/Q VSS VSS VSS VSS gf180mcu_fd_sc_mcu9t5v0__dffrnq_1
XTAP_TAPCELL_ROW_291_7068 VSS VSS gf180mcu_fd_sc_mcu9t5v0__filltie
XTAP_TAPCELL_ROW_122_4342 VSS VSS gf180mcu_fd_sc_mcu9t5v0__filltie
XTAP_TAPCELL_ROW_122_4331 VSS VSS gf180mcu_fd_sc_mcu9t5v0__filltie
XTAP_TAPCELL_ROW_33_1879 VSS VSS gf180mcu_fd_sc_mcu9t5v0__filltie
X_19644_ _19644_/D _20028_/RN clkload9/I _19644_/Q VSS VSS VSS VSS gf180mcu_fd_sc_mcu9t5v0__dffrnq_1
X_16856_ _18420_/Q _16855_/Z _16862_/S _18420_/D VSS VSS VSS VSS gf180mcu_fd_sc_mcu9t5v0__mux2_1
XTAP_TAPCELL_ROW_316_7764 VSS VSS gf180mcu_fd_sc_mcu9t5v0__filltie
XTAP_TAPCELL_ROW_291_7079 VSS VSS gf180mcu_fd_sc_mcu9t5v0__filltie
XTAP_TAPCELL_ROW_316_7753 VSS VSS gf180mcu_fd_sc_mcu9t5v0__filltie
XTAP_TAPCELL_ROW_312_7639 VSS VSS gf180mcu_fd_sc_mcu9t5v0__filltie
X_15807_ input4/Z _19976_/Q _15811_/S _19976_/D VSS VSS VSS VSS gf180mcu_fd_sc_mcu9t5v0__mux2_1
X_16787_ _19276_/Q _17059_/I1 _16787_/S _16787_/Z VSS VSS VSS VSS gf180mcu_fd_sc_mcu9t5v0__mux2_1
X_13999_ _13966_/Z _13999_/A2 _13999_/B _14018_/A1 VSS _13999_/VNW VSS VSS gf180mcu_fd_sc_mcu9t5v0__oai21_1
X_19575_ _19575_/D _20023_/RN clkload17/I _19575_/Q VSS VSS VSS VSS gf180mcu_fd_sc_mcu9t5v0__dffrnq_1
X_18526_ _18526_/D clkload62/I _18526_/Q VSS VSS VSS VSS gf180mcu_fd_sc_mcu9t5v0__dffq_1
X_15738_ _19926_/Q _15738_/A2 _15739_/A2 VSS VSS VSS VSS gf180mcu_fd_sc_mcu9t5v0__xnor2_1
X_18457_ _18457_/D clkload53/I _18457_/Q VSS VSS VSS VSS gf180mcu_fd_sc_mcu9t5v0__dffq_1
XTAP_TAPCELL_ROW_135_4714 VSS VSS gf180mcu_fd_sc_mcu9t5v0__filltie
XTAP_TAPCELL_ROW_135_4703 VSS VSS gf180mcu_fd_sc_mcu9t5v0__filltie
X_17408_ _20077_/Q _17407_/C _17408_/B _17408_/C _17411_/A1 VSS VSS VSS VSS gf180mcu_fd_sc_mcu9t5v0__aoi211_1
XTAP_TAPCELL_ROW_135_4736 VSS VSS gf180mcu_fd_sc_mcu9t5v0__filltie
XTAP_TAPCELL_ROW_135_4725 VSS VSS gf180mcu_fd_sc_mcu9t5v0__filltie
X_15669_ _15669_/A1 _15668_/Z _15672_/B _19909_/D VSS VSS VSS VSS gf180mcu_fd_sc_mcu9t5v0__aoi21_1
X_18388_ _18388_/D clkload75/I _18388_/Q VSS VSS VSS VSS gf180mcu_fd_sc_mcu9t5v0__dffq_1
Xclkbuf_leaf_29_clk_regs clkload3/I clkload54/I VSS VSS VSS VSS gf180mcu_fd_sc_mcu9t5v0__clkbuf_8
XTAP_TAPCELL_ROW_116_4168 VSS VSS gf180mcu_fd_sc_mcu9t5v0__filltie
X_09190_ _19128_/Q _14495_/A2 VSS _12103_/VNW VSS VSS gf180mcu_fd_sc_mcu9t5v0__clkinv_1
X_17339_ _18357_/Q _17406_/A2 _17405_/A2 _18373_/Q _17340_/B VSS _17339_/VNW VSS VSS
+ gf180mcu_fd_sc_mcu9t5v0__aoi22_1
XTAP_TAPCELL_ROW_116_4179 VSS VSS gf180mcu_fd_sc_mcu9t5v0__filltie
X_19009_ _19009_/D _20033_/RN clkload38/I _19009_/Q VSS VSS VSS VSS gf180mcu_fd_sc_mcu9t5v0__dffrnq_1
XTAP_TAPCELL_ROW_280_6783 VSS VSS gf180mcu_fd_sc_mcu9t5v0__filltie
XTAP_TAPCELL_ROW_280_6772 VSS VSS gf180mcu_fd_sc_mcu9t5v0__filltie
XTAP_TAPCELL_ROW_280_6761 VSS VSS gf180mcu_fd_sc_mcu9t5v0__filltie
XTAP_TAPCELL_ROW_129_4529 VSS VSS gf180mcu_fd_sc_mcu9t5v0__filltie
XTAP_TAPCELL_ROW_129_4518 VSS VSS gf180mcu_fd_sc_mcu9t5v0__filltie
XPHY_EDGE_ROW_259_Left_582 VSS VSS gf180mcu_fd_sc_mcu9t5v0__endcap
XPHY_EDGE_ROW_89_Right_89 VSS VSS gf180mcu_fd_sc_mcu9t5v0__endcap
XTAP_TAPCELL_ROW_274_6598 VSS VSS gf180mcu_fd_sc_mcu9t5v0__filltie
XTAP_TAPCELL_ROW_105_3883 VSS VSS gf180mcu_fd_sc_mcu9t5v0__filltie
XTAP_TAPCELL_ROW_105_3872 VSS VSS gf180mcu_fd_sc_mcu9t5v0__filltie
XTAP_TAPCELL_ROW_105_3861 VSS VSS gf180mcu_fd_sc_mcu9t5v0__filltie
X_09526_ _19847_/Q _09848_/B _09533_/A1 VSS VSS VSS VSS gf180mcu_fd_sc_mcu9t5v0__nand2_1
XTAP_TAPCELL_ROW_101_3758 VSS VSS gf180mcu_fd_sc_mcu9t5v0__filltie
XTAP_TAPCELL_ROW_0_953 VSS VSS gf180mcu_fd_sc_mcu9t5v0__filltie
XTAP_TAPCELL_ROW_0_942 VSS VSS gf180mcu_fd_sc_mcu9t5v0__filltie
XTAP_TAPCELL_ROW_0_964 VSS VSS gf180mcu_fd_sc_mcu9t5v0__filltie
XTAP_TAPCELL_ROW_101_3747 VSS VSS gf180mcu_fd_sc_mcu9t5v0__filltie
XTAP_TAPCELL_ROW_101_3769 VSS VSS gf180mcu_fd_sc_mcu9t5v0__filltie
X_09457_ _14353_/A1 _13656_/A1 _10189_/S VSS VSS VSS VSS gf180mcu_fd_sc_mcu9t5v0__nor2_4
XTAP_TAPCELL_ROW_0_975 VSS VSS gf180mcu_fd_sc_mcu9t5v0__filltie
XTAP_TAPCELL_ROW_0_986 VSS VSS gf180mcu_fd_sc_mcu9t5v0__filltie
XPHY_EDGE_ROW_98_Right_98 VSS VSS gf180mcu_fd_sc_mcu9t5v0__endcap
XTAP_TAPCELL_ROW_43_2153 VSS VSS gf180mcu_fd_sc_mcu9t5v0__filltie
XTAP_TAPCELL_ROW_43_2164 VSS VSS gf180mcu_fd_sc_mcu9t5v0__filltie
XTAP_TAPCELL_ROW_287_6959 VSS VSS gf180mcu_fd_sc_mcu9t5v0__filltie
XPHY_EDGE_ROW_268_Left_591 VSS VSS gf180mcu_fd_sc_mcu9t5v0__endcap
X_09388_ _19184_/Q _12695_/A1 VSS _13745_/VNW VSS VSS gf180mcu_fd_sc_mcu9t5v0__clkinv_1
XTAP_TAPCELL_ROW_43_2175 VSS VSS gf180mcu_fd_sc_mcu9t5v0__filltie
X_11350_ _18362_/Q _11098_/B wire283/I _11351_/B2 VSS VSS VSS VSS gf180mcu_fd_sc_mcu9t5v0__aoi21_1
X_10301_ _17326_/A1 _10301_/A2 _10302_/C VSS _17178_/VNW VSS VSS gf180mcu_fd_sc_mcu9t5v0__nand2_1
XTAP_TAPCELL_ROW_227_5321 VSS VSS gf180mcu_fd_sc_mcu9t5v0__filltie
XTAP_TAPCELL_ROW_227_5310 VSS VSS gf180mcu_fd_sc_mcu9t5v0__filltie
XTAP_TAPCELL_ROW_56_2514 VSS VSS gf180mcu_fd_sc_mcu9t5v0__filltie
XTAP_TAPCELL_ROW_56_2525 VSS VSS gf180mcu_fd_sc_mcu9t5v0__filltie
XTAP_TAPCELL_ROW_56_2536 VSS VSS gf180mcu_fd_sc_mcu9t5v0__filltie
X_11281_ _18871_/Q _11878_/A1 _11320_/B1 _11281_/B2 _11320_/C _11283_/A1 VSS _11281_/VNW
+ VSS VSS gf180mcu_fd_sc_mcu9t5v0__oai221_1
X_13020_ _19722_/Q _13020_/A2 _13516_/B VSS VSS VSS VSS gf180mcu_fd_sc_mcu9t5v0__xnor2_1
X_10232_ _10459_/C _10232_/A2 _10232_/A3 _10232_/B _10233_/B1 VSS VSS VSS VSS gf180mcu_fd_sc_mcu9t5v0__oai31_1
XTAP_TAPCELL_ROW_223_5207 VSS VSS gf180mcu_fd_sc_mcu9t5v0__filltie
X_10163_ _10164_/A1 _10163_/A2 _10164_/C VSS _10163_/VNW VSS VSS gf180mcu_fd_sc_mcu9t5v0__nand2_1
XPHY_EDGE_ROW_192_1_Left_515 VSS VSS gf180mcu_fd_sc_mcu9t5v0__endcap
X_16710_ _16730_/A1 _16622_/B _16710_/B _16730_/C _16712_/A2 VSS VSS VSS VSS gf180mcu_fd_sc_mcu9t5v0__aoi211_4
X_10094_ _10094_/A1 _10094_/A2 _10096_/C VSS VSS VSS VSS gf180mcu_fd_sc_mcu9t5v0__nand2_1
X_14971_ _14971_/A1 _14971_/A2 _14976_/A1 VSS _14971_/VNW VSS VSS gf180mcu_fd_sc_mcu9t5v0__nand2_1
X_17690_ _18648_/Q _17743_/B _17692_/B VSS VSS VSS VSS gf180mcu_fd_sc_mcu9t5v0__nand2_1
X_13922_ _19318_/Q _19298_/Q _13927_/A1 VSS _13922_/VNW VSS VSS gf180mcu_fd_sc_mcu9t5v0__nand2_1
X_16641_ _16750_/A1 _16674_/A2 _16641_/B _16642_/A3 VSS VSS VSS VSS gf180mcu_fd_sc_mcu9t5v0__aoi21_1
X_13853_ _19321_/Q _19293_/Q _19322_/Q _19292_/Q _13856_/A1 VSS _13855_/VNW VSS VSS
+ gf180mcu_fd_sc_mcu9t5v0__aoi22_1
X_16572_ _19277_/Q _15996_/B _16578_/B VSS _17034_/VNW VSS VSS gf180mcu_fd_sc_mcu9t5v0__nand2_1
X_12804_ _19759_/Q _12810_/A1 _12801_/Z _12805_/I0 VSS VSS VSS VSS gf180mcu_fd_sc_mcu9t5v0__xnor3_1
X_19360_ _19360_/D _20064_/RN clkload21/I _19360_/Q VSS VSS VSS VSS gf180mcu_fd_sc_mcu9t5v0__dffrnq_1
X_18311_ _18311_/D clkload81/I _18311_/Q VSS VSS VSS VSS gf180mcu_fd_sc_mcu9t5v0__dffq_1
X_15523_ _19829_/Q _19870_/Q _09726_/B _15521_/Z _19845_/Q _15524_/B VSS VSS VSS VSS
+ gf180mcu_fd_sc_mcu9t5v0__oai32_1
X_10996_ _19016_/Q _10995_/Z _10996_/S _19016_/D VSS VSS VSS VSS gf180mcu_fd_sc_mcu9t5v0__mux2_1
X_13784_ _13785_/A1 _13785_/A2 _13784_/B _13807_/A1 VSS _15240_/VNW VSS VSS gf180mcu_fd_sc_mcu9t5v0__aoi21_1
X_19291_ _19291_/D _20059_/RN _19680_/CLK _19291_/Q VSS VSS VSS VSS gf180mcu_fd_sc_mcu9t5v0__dffrnq_1
X_12735_ _12843_/A1 _19716_/Q _12735_/B _12736_/B VSS _12735_/VNW VSS VSS gf180mcu_fd_sc_mcu9t5v0__oai21_1
X_18242_ _18242_/D clkload80/I _18242_/Q VSS VSS VSS VSS gf180mcu_fd_sc_mcu9t5v0__dffq_1
X_15454_ _19821_/Q _15445_/B _15456_/B VSS VSS VSS VSS gf180mcu_fd_sc_mcu9t5v0__nand2_1
XTAP_TAPCELL_ROW_212_4911 VSS VSS gf180mcu_fd_sc_mcu9t5v0__filltie
XTAP_TAPCELL_ROW_212_4900 VSS VSS gf180mcu_fd_sc_mcu9t5v0__filltie
X_12666_ _12666_/A1 _12666_/A2 _12711_/A2 VSS _12666_/VNW VSS VSS gf180mcu_fd_sc_mcu9t5v0__nand2_1
X_18173_ _18173_/D _18496_/CLK _18173_/Q VSS VSS VSS VSS gf180mcu_fd_sc_mcu9t5v0__dffq_4
X_12597_ _18358_/Q _12613_/A2 _12601_/A2 VSS VSS VSS VSS gf180mcu_fd_sc_mcu9t5v0__nor2_1
XPHY_EDGE_ROW_180_3_Left_838 VSS VSS gf180mcu_fd_sc_mcu9t5v0__endcap
XTAP_TAPCELL_ROW_26_1694 VSS VSS gf180mcu_fd_sc_mcu9t5v0__filltie
X_11617_ _11656_/A1 _11604_/Z _11631_/C VSS VSS VSS VSS gf180mcu_fd_sc_mcu9t5v0__nor2_1
X_14405_ _19117_/Q wire199/Z _14704_/S _14405_/C _14406_/A2 VSS VSS VSS VSS gf180mcu_fd_sc_mcu9t5v0__oai211_1
X_15385_ _19670_/Q _19770_/Q _15420_/S _19770_/D VSS VSS VSS VSS gf180mcu_fd_sc_mcu9t5v0__mux2_1
X_17124_ _18475_/Q _17380_/A2 _17380_/B1 _18491_/Q _17125_/B VSS _17135_/VNW VSS VSS
+ gf180mcu_fd_sc_mcu9t5v0__aoi22_1
X_11548_ _11095_/S _18564_/Q _11548_/B _11548_/ZN VSS VSS VSS VSS gf180mcu_fd_sc_mcu9t5v0__oai21_4
X_14336_ _14366_/I0 _19408_/Q _14337_/S _19408_/D VSS VSS VSS VSS gf180mcu_fd_sc_mcu9t5v0__mux2_1
XTAP_TAPCELL_ROW_305_7454 VSS VSS gf180mcu_fd_sc_mcu9t5v0__filltie
XTAP_TAPCELL_ROW_111_4043 VSS VSS gf180mcu_fd_sc_mcu9t5v0__filltie
XTAP_TAPCELL_ROW_111_4032 VSS VSS gf180mcu_fd_sc_mcu9t5v0__filltie
X_17055_ _16668_/B _19258_/Q _17055_/S _17055_/Z VSS VSS VSS VSS gf180mcu_fd_sc_mcu9t5v0__mux2_1
XTAP_TAPCELL_ROW_305_7465 VSS VSS gf180mcu_fd_sc_mcu9t5v0__filltie
X_11479_ _18404_/Q _18388_/Q _11524_/S _11479_/Z VSS _17315_/VNW VSS VSS gf180mcu_fd_sc_mcu9t5v0__mux2_1
X_14267_ _14338_/A2 _14267_/A2 _14285_/S VSS VSS VSS VSS gf180mcu_fd_sc_mcu9t5v0__nand2_2
XTAP_TAPCELL_ROW_297_7244 VSS VSS gf180mcu_fd_sc_mcu9t5v0__filltie
XTAP_TAPCELL_ROW_297_7233 VSS VSS gf180mcu_fd_sc_mcu9t5v0__filltie
X_16006_ _19261_/Q _16569_/A1 _16011_/B VSS _16564_/VNW VSS VSS gf180mcu_fd_sc_mcu9t5v0__nand2_1
X_13218_ _13218_/A1 _13218_/A2 _13218_/B _13220_/A2 VSS _13218_/VNW VSS VSS gf180mcu_fd_sc_mcu9t5v0__oai21_1
X_14198_ _14198_/A1 _14198_/A2 _14198_/Z VSS VSS VSS VSS gf180mcu_fd_sc_mcu9t5v0__xor2_1
XTAP_TAPCELL_ROW_293_7119 VSS VSS gf180mcu_fd_sc_mcu9t5v0__filltie
X_13149_ _16428_/A1 _13419_/B _13149_/B1 _13149_/B2 _19238_/D VSS _13149_/VNW VSS
+ VSS gf180mcu_fd_sc_mcu9t5v0__aoi22_2
XTAP_TAPCELL_ROW_318_7826 VSS VSS gf180mcu_fd_sc_mcu9t5v0__filltie
XTAP_TAPCELL_ROW_318_7815 VSS VSS gf180mcu_fd_sc_mcu9t5v0__filltie
XTAP_TAPCELL_ROW_318_7804 VSS VSS gf180mcu_fd_sc_mcu9t5v0__filltie
XTAP_TAPCELL_ROW_124_4404 VSS VSS gf180mcu_fd_sc_mcu9t5v0__filltie
X_17957_ _18855_/Q _17957_/A2 _17951_/Z _17959_/A1 VSS _18005_/VNW VSS VSS gf180mcu_fd_sc_mcu9t5v0__nand3_1
X_16908_ _16907_/Z _18446_/Q _16928_/S _18446_/D VSS VSS VSS VSS gf180mcu_fd_sc_mcu9t5v0__mux2_1
X_17888_ _19019_/Q _17888_/A2 _17888_/B _17889_/I VSS VSS VSS VSS gf180mcu_fd_sc_mcu9t5v0__oai21_1
X_16839_ _19247_/Q _16592_/B _16863_/S _16839_/Z VSS VSS VSS VSS gf180mcu_fd_sc_mcu9t5v0__mux2_1
X_19627_ _19627_/D _20139_/RN clkload21/I _19627_/Q VSS VSS VSS VSS gf180mcu_fd_sc_mcu9t5v0__dffrnq_1
X_19558_ _19558_/D _20070_/RN clkload7/I _19558_/Q VSS VSS VSS VSS gf180mcu_fd_sc_mcu9t5v0__dffrnq_1
X_18509_ _18509_/D _18509_/CLK _18509_/Q VSS VSS VSS VSS gf180mcu_fd_sc_mcu9t5v0__dffq_4
X_09311_ _19995_/Q _15834_/A1 VSS VSS VSS VSS gf180mcu_fd_sc_mcu9t5v0__clkinv_1
XTAP_TAPCELL_ROW_118_4219 VSS VSS gf180mcu_fd_sc_mcu9t5v0__filltie
X_19489_ _19489_/D _20065_/RN clkload14/I _19489_/Q VSS VSS VSS VSS gf180mcu_fd_sc_mcu9t5v0__dffrnq_1
X_09242_ _20068_/Q _15952_/I0 VSS VSS VSS VSS gf180mcu_fd_sc_mcu9t5v0__clkinv_1
X_09173_ _19146_/Q _13724_/A1 VSS VSS VSS VSS gf180mcu_fd_sc_mcu9t5v0__clkinv_1
XTAP_TAPCELL_ROW_282_6834 VSS VSS gf180mcu_fd_sc_mcu9t5v0__filltie
XTAP_TAPCELL_ROW_282_6823 VSS VSS gf180mcu_fd_sc_mcu9t5v0__filltie
XTAP_TAPCELL_ROW_282_6812 VSS VSS gf180mcu_fd_sc_mcu9t5v0__filltie
Xoutput17 output17/I dout[6] VSS VSS VSS VSS gf180mcu_fd_sc_mcu9t5v0__dlyd_1
XTAP_TAPCELL_ROW_263_6299 VSS VSS gf180mcu_fd_sc_mcu9t5v0__filltie
XTAP_TAPCELL_ROW_276_6649 VSS VSS gf180mcu_fd_sc_mcu9t5v0__filltie
XPHY_EDGE_ROW_144_2_Left_656 VSS VSS gf180mcu_fd_sc_mcu9t5v0__endcap
XTAP_TAPCELL_ROW_107_3934 VSS VSS gf180mcu_fd_sc_mcu9t5v0__filltie
XTAP_TAPCELL_ROW_107_3923 VSS VSS gf180mcu_fd_sc_mcu9t5v0__filltie
XTAP_TAPCELL_ROW_107_3912 VSS VSS gf180mcu_fd_sc_mcu9t5v0__filltie
XTAP_TAPCELL_ROW_103_3809 VSS VSS gf180mcu_fd_sc_mcu9t5v0__filltie
XPHY_EDGE_ROW_150_2_Right_881 VSS VSS gf180mcu_fd_sc_mcu9t5v0__endcap
XTAP_TAPCELL_ROW_49_2340 VSS VSS gf180mcu_fd_sc_mcu9t5v0__filltie
X_10850_ _16633_/A1 _18151_/S _10860_/B _10851_/I0 VSS VSS VSS VSS gf180mcu_fd_sc_mcu9t5v0__oai21_1
XTAP_TAPCELL_ROW_216_5000 VSS VSS gf180mcu_fd_sc_mcu9t5v0__filltie
XTAP_TAPCELL_ROW_45_2215 VSS VSS gf180mcu_fd_sc_mcu9t5v0__filltie
XTAP_TAPCELL_ROW_216_5022 VSS VSS gf180mcu_fd_sc_mcu9t5v0__filltie
XTAP_TAPCELL_ROW_216_5011 VSS VSS gf180mcu_fd_sc_mcu9t5v0__filltie
XTAP_TAPCELL_ROW_45_2226 VSS VSS gf180mcu_fd_sc_mcu9t5v0__filltie
X_10781_ _09818_/I _10785_/A2 _10799_/B VSS VSS VSS VSS gf180mcu_fd_sc_mcu9t5v0__nor2_1
X_09509_ _18580_/Q _11325_/A1 _12010_/A1 _18582_/Q _09515_/A2 VSS VSS VSS VSS gf180mcu_fd_sc_mcu9t5v0__oai22_4
XTAP_TAPCELL_ROW_252_5992 VSS VSS gf180mcu_fd_sc_mcu9t5v0__filltie
X_12520_ _19161_/Q _12488_/I _12521_/B VSS VSS VSS VSS gf180mcu_fd_sc_mcu9t5v0__nand2_1
XPHY_EDGE_ROW_117_Right_117 VSS VSS gf180mcu_fd_sc_mcu9t5v0__endcap
X_12451_ wire175/Z wire280/Z _12618_/B _12453_/A3 VSS VSS VSS VSS gf180mcu_fd_sc_mcu9t5v0__aoi21_1
X_11402_ _11521_/B _11400_/Z _11402_/B _11406_/A2 VSS VSS VSS VSS gf180mcu_fd_sc_mcu9t5v0__oai21_1
X_15170_ _19712_/Q _19552_/Q wire108/Z _19712_/D VSS _15170_/VNW VSS VSS gf180mcu_fd_sc_mcu9t5v0__mux2_1
X_12382_ _18156_/Q _18204_/Q _12382_/S _12382_/Z VSS VSS VSS VSS gf180mcu_fd_sc_mcu9t5v0__mux2_1
X_14121_ _14192_/A1 _14192_/A2 _14121_/Z VSS VSS VSS VSS gf180mcu_fd_sc_mcu9t5v0__xor2_1
X_11333_ _11429_/B _11332_/Z _11333_/B _11337_/A2 VSS VSS VSS VSS gf180mcu_fd_sc_mcu9t5v0__oai21_1
X_11264_ _18244_/Q _11469_/B _11265_/B VSS _11264_/VNW VSS VSS gf180mcu_fd_sc_mcu9t5v0__nand2_1
X_14052_ _14053_/A1 _14053_/A2 _14075_/A1 VSS _14052_/VNW VSS VSS gf180mcu_fd_sc_mcu9t5v0__nand2_1
X_10215_ _10648_/C _18665_/Q _10821_/B _10246_/A2 VSS VSS VSS VSS gf180mcu_fd_sc_mcu9t5v0__nand3_1
X_13003_ _12985_/Z _13003_/A2 _13511_/B _13022_/A2 VSS _13010_/VNW VSS VSS gf180mcu_fd_sc_mcu9t5v0__oai21_1
X_18860_ _18860_/D _20140_/RN clkload27/I _18860_/Q VSS VSS VSS VSS gf180mcu_fd_sc_mcu9t5v0__dffrnq_1
X_11195_ _18175_/Q wire136/I _11526_/B _11196_/B2 VSS VSS VSS VSS gf180mcu_fd_sc_mcu9t5v0__aoi21_1
X_17811_ _18789_/Q _18768_/Q _18769_/D _18789_/D VSS _17811_/VNW VSS VSS gf180mcu_fd_sc_mcu9t5v0__mux2_1
XTAP_TAPCELL_ROW_34_1930 VSS VSS gf180mcu_fd_sc_mcu9t5v0__filltie
X_10146_ _19227_/Q _09898_/C _10168_/B1 _19211_/Q _10164_/B VSS _10146_/VNW VSS VSS
+ gf180mcu_fd_sc_mcu9t5v0__aoi22_1
XTAP_TAPCELL_ROW_30_1805 VSS VSS gf180mcu_fd_sc_mcu9t5v0__filltie
X_18791_ _18791_/D _20071_/RN _19806_/CLK _18791_/Q VSS VSS VSS VSS gf180mcu_fd_sc_mcu9t5v0__dffrnq_1
X_10077_ _19216_/Q wire172/Z wire285/Z _19256_/Q _10078_/A2 VSS _10078_/VNW VSS VSS
+ gf180mcu_fd_sc_mcu9t5v0__aoi22_1
X_17742_ _18663_/Q _18747_/Q _17742_/S _18747_/D VSS VSS VSS VSS gf180mcu_fd_sc_mcu9t5v0__mux2_1
XTAP_TAPCELL_ROW_15_1384 VSS VSS gf180mcu_fd_sc_mcu9t5v0__filltie
XTAP_TAPCELL_ROW_30_1816 VSS VSS gf180mcu_fd_sc_mcu9t5v0__filltie
X_14954_ _19425_/Q _19370_/Q _14957_/A1 _14955_/I1 VSS VSS VSS VSS gf180mcu_fd_sc_mcu9t5v0__xnor3_1
X_17673_ _18636_/Q _18712_/Q _17673_/S _18712_/D VSS VSS VSS VSS gf180mcu_fd_sc_mcu9t5v0__mux2_1
XTAP_TAPCELL_ROW_15_1395 VSS VSS gf180mcu_fd_sc_mcu9t5v0__filltie
X_13905_ _19309_/Q _13904_/Z _14139_/S _19309_/D VSS _13905_/VNW VSS VSS gf180mcu_fd_sc_mcu9t5v0__mux2_1
X_16624_ _16675_/A1 _16624_/A2 _16624_/A3 _16624_/B _16625_/I1 VSS _16714_/VNW VSS
+ VSS gf180mcu_fd_sc_mcu9t5v0__oai31_1
X_19412_ _19412_/D _20052_/RN clkload7/I _19412_/Q VSS VSS VSS VSS gf180mcu_fd_sc_mcu9t5v0__dffrnq_1
X_14885_ _19594_/Q _14900_/S _14890_/B VSS VSS VSS VSS gf180mcu_fd_sc_mcu9t5v0__nor2_1
Xmax_cap70 _16477_/A2 _16686_/A3 VSS _16335_/VNW VSS VSS gf180mcu_fd_sc_mcu9t5v0__clkbuf_4
X_13836_ _13836_/A1 _13833_/Z _13836_/B _13869_/A1 VSS VSS VSS VSS gf180mcu_fd_sc_mcu9t5v0__oai21_1
XPHY_EDGE_ROW_35_Left_359 VSS VSS gf180mcu_fd_sc_mcu9t5v0__endcap
X_16555_ _18338_/Q _16162_/B _17073_/S _18338_/D VSS _16555_/VNW VSS VSS gf180mcu_fd_sc_mcu9t5v0__mux2_4
Xmax_cap92 _16569_/A1 _16675_/A1 VSS VSS VSS VSS gf180mcu_fd_sc_mcu9t5v0__buf_8
X_10979_ _10979_/A1 _10979_/A2 _10979_/B _10984_/A1 VSS VSS VSS VSS gf180mcu_fd_sc_mcu9t5v0__oai21_1
X_13767_ _19316_/Q _19294_/Q _13767_/B _13769_/B2 VSS VSS VSS VSS gf180mcu_fd_sc_mcu9t5v0__aoi21_1
XTAP_TAPCELL_ROW_28_1745 VSS VSS gf180mcu_fd_sc_mcu9t5v0__filltie
X_19343_ _19343_/D _20047_/RN clkload7/I _19343_/Q VSS VSS VSS VSS gf180mcu_fd_sc_mcu9t5v0__dffrnq_1
XTAP_TAPCELL_ROW_28_1756 VSS VSS gf180mcu_fd_sc_mcu9t5v0__filltie
X_16486_ _18300_/Q _16485_/Z _16996_/S _18300_/D VSS VSS VSS VSS gf180mcu_fd_sc_mcu9t5v0__mux2_1
X_15506_ _17422_/S _15507_/A2 _15506_/A3 _19839_/D VSS _15506_/VNW VSS VSS gf180mcu_fd_sc_mcu9t5v0__and3_1
X_19274_ _19274_/D _20042_/RN clkload42/I _19274_/Q VSS VSS VSS VSS gf180mcu_fd_sc_mcu9t5v0__dffrnq_1
X_12718_ _12722_/A1 _12718_/A2 _12718_/B _19189_/D VSS VSS VSS VSS gf180mcu_fd_sc_mcu9t5v0__oai21_1
XTAP_TAPCELL_ROW_307_7505 VSS VSS gf180mcu_fd_sc_mcu9t5v0__filltie
X_15437_ _19821_/Q _15436_/Z _15437_/Z VSS VSS VSS VSS gf180mcu_fd_sc_mcu9t5v0__and2_1
X_18225_ _18225_/D clkload68/I _18225_/Q VSS VSS VSS VSS gf180mcu_fd_sc_mcu9t5v0__dffq_4
X_13698_ _19144_/Q _13698_/A2 _13698_/B _13724_/B1 VSS VSS VSS VSS gf180mcu_fd_sc_mcu9t5v0__oai21_1
XTAP_TAPCELL_ROW_307_7516 VSS VSS gf180mcu_fd_sc_mcu9t5v0__filltie
X_12649_ _12664_/C _12649_/A2 _12649_/A3 _12649_/A4 _12650_/B VSS _12649_/VNW VSS
+ VSS gf180mcu_fd_sc_mcu9t5v0__nand4_1
XTAP_TAPCELL_ROW_299_7306 VSS VSS gf180mcu_fd_sc_mcu9t5v0__filltie
X_18156_ _18156_/D clkload64/I _18156_/Q VSS VSS VSS VSS gf180mcu_fd_sc_mcu9t5v0__dffq_1
X_15368_ _19653_/Q _19753_/Q _15420_/S _19753_/D VSS VSS VSS VSS gf180mcu_fd_sc_mcu9t5v0__mux2_1
X_17107_ _19826_/Q _17107_/A2 _17107_/A3 _17107_/B _17112_/A2 VSS VSS VSS VSS gf180mcu_fd_sc_mcu9t5v0__oai31_1
Xwire291 wire291/I wire291/Z VSS VSS VSS VSS gf180mcu_fd_sc_mcu9t5v0__clkbuf_2
Xwire280 wire281/Z wire280/Z VSS VSS VSS VSS gf180mcu_fd_sc_mcu9t5v0__buf_2
X_18087_ _18934_/Q _11018_/B _18090_/B VSS _18088_/VNW VSS VSS gf180mcu_fd_sc_mcu9t5v0__nand2_1
X_15299_ _19637_/Q _19614_/Q _15304_/A2 VSS VSS VSS VSS gf180mcu_fd_sc_mcu9t5v0__nor2_1
X_14319_ _14214_/Z _19392_/Q _14322_/S _19392_/D VSS VSS VSS VSS gf180mcu_fd_sc_mcu9t5v0__mux2_1
X_17038_ _17037_/Z _18510_/Q _17050_/S _18510_/D VSS VSS VSS VSS gf180mcu_fd_sc_mcu9t5v0__mux2_4
XTAP_TAPCELL_ROW_91_3492 VSS VSS gf180mcu_fd_sc_mcu9t5v0__filltie
XPHY_EDGE_ROW_44_Left_368 VSS VSS gf180mcu_fd_sc_mcu9t5v0__endcap
XTAP_TAPCELL_ROW_91_3481 VSS VSS gf180mcu_fd_sc_mcu9t5v0__filltie
XPHY_EDGE_ROW_189_2_Right_920 VSS VSS gf180mcu_fd_sc_mcu9t5v0__endcap
X_09860_ _20054_/Q _20034_/Q _09399_/Z _11067_/S VSS VSS VSS VSS gf180mcu_fd_sc_mcu9t5v0__nand3_2
X_18989_ _18989_/D _20141_/RN clkload67/I _18989_/Q VSS VSS VSS VSS gf180mcu_fd_sc_mcu9t5v0__dffrnq_1
X_09791_ _18838_/Q _17933_/B2 _18850_/Q _10800_/A1 _09791_/C _09792_/C VSS VSS VSS
+ VSS gf180mcu_fd_sc_mcu9t5v0__aoi221_1
XPHY_EDGE_ROW_268_Right_195 VSS VSS gf180mcu_fd_sc_mcu9t5v0__endcap
Xload_slew296 _10138_/A2 _09998_/C VSS VSS VSS VSS gf180mcu_fd_sc_mcu9t5v0__clkbuf_4
XTAP_TAPCELL_ROW_271_6513 VSS VSS gf180mcu_fd_sc_mcu9t5v0__filltie
XTAP_TAPCELL_ROW_137_3_8002 VSS VSS gf180mcu_fd_sc_mcu9t5v0__filltie
XTAP_TAPCELL_ROW_271_6535 VSS VSS gf180mcu_fd_sc_mcu9t5v0__filltie
XTAP_TAPCELL_ROW_271_6524 VSS VSS gf180mcu_fd_sc_mcu9t5v0__filltie
XPHY_EDGE_ROW_53_Left_377 VSS VSS gf180mcu_fd_sc_mcu9t5v0__endcap
Xclkbuf_leaf_44_clk_regs clkload6/I clkload81/I VSS clkbuf_leaf_44_clk_regs/VNW VSS
+ VSS gf180mcu_fd_sc_mcu9t5v0__clkbuf_8
XTAP_TAPCELL_ROW_269_6475 VSS VSS gf180mcu_fd_sc_mcu9t5v0__filltie
XTAP_TAPCELL_ROW_269_6464 VSS VSS gf180mcu_fd_sc_mcu9t5v0__filltie
XTAP_TAPCELL_ROW_98_3679 VSS VSS gf180mcu_fd_sc_mcu9t5v0__filltie
X_09225_ _19602_/Q _15266_/A1 VSS VSS VSS VSS gf180mcu_fd_sc_mcu9t5v0__clkinv_1
XTAP_TAPCELL_ROW_98_3668 VSS VSS gf180mcu_fd_sc_mcu9t5v0__filltie
X_09156_ _19774_/Q _13378_/A2 VSS VSS VSS VSS gf180mcu_fd_sc_mcu9t5v0__clkinv_1
X_09087_ _20028_/Q _10179_/A1 VSS VSS VSS VSS gf180mcu_fd_sc_mcu9t5v0__inv_2
XPHY_EDGE_ROW_62_Left_386 VSS VSS gf180mcu_fd_sc_mcu9t5v0__endcap
XTAP_TAPCELL_ROW_38_2030 VSS VSS gf180mcu_fd_sc_mcu9t5v0__filltie
XTAP_TAPCELL_ROW_38_2041 VSS VSS gf180mcu_fd_sc_mcu9t5v0__filltie
X_10000_ _18956_/Q wire172/Z _10172_/A2 _18940_/Q _10001_/A2 VSS _10870_/VNW VSS VSS
+ gf180mcu_fd_sc_mcu9t5v0__aoi22_1
X_09989_ _09916_/B _18948_/Q _10168_/B1 _09991_/A2 VSS VSS VSS VSS gf180mcu_fd_sc_mcu9t5v0__nand3_1
XTAP_TAPCELL_ROW_70_2897 VSS VSS gf180mcu_fd_sc_mcu9t5v0__filltie
XTAP_TAPCELL_ROW_241_5693 VSS VSS gf180mcu_fd_sc_mcu9t5v0__filltie
XPHY_EDGE_ROW_235_Right_162 VSS VSS gf180mcu_fd_sc_mcu9t5v0__endcap
XPHY_EDGE_ROW_71_Left_395 VSS VSS gf180mcu_fd_sc_mcu9t5v0__endcap
X_11951_ _12299_/S _11951_/A2 _11951_/A3 _11952_/C VSS VSS VSS VSS gf180mcu_fd_sc_mcu9t5v0__nand3_1
XPHY_EDGE_ROW_151_2_Right_882 VSS VSS gf180mcu_fd_sc_mcu9t5v0__endcap
X_10902_ _10901_/Z _18990_/Q _18152_/S _18990_/D VSS VSS VSS VSS gf180mcu_fd_sc_mcu9t5v0__mux2_1
X_14670_ _14670_/I0 _19529_/Q _14670_/S _19529_/D VSS _14670_/VNW VSS VSS gf180mcu_fd_sc_mcu9t5v0__mux2_1
X_11882_ _18899_/Q _18900_/Q _11882_/A3 _12336_/B _11907_/A2 VSS VSS VSS VSS gf180mcu_fd_sc_mcu9t5v0__oai31_1
XTAP_TAPCELL_ROW_10_1270 VSS VSS gf180mcu_fd_sc_mcu9t5v0__filltie
Xeco15_sk1_7 clkload63/I eco15_sk2_7/I VSS VSS VSS VSS gf180mcu_fd_sc_mcu9t5v0__clkbuf_16
X_10833_ _15952_/I0 _09749_/B _10833_/B1 _09748_/B _20068_/D VSS _10833_/VNW VSS VSS
+ gf180mcu_fd_sc_mcu9t5v0__oai22_1
X_13621_ _13615_/B _13625_/A2 _13622_/A2 VSS _13622_/VNW VSS VSS gf180mcu_fd_sc_mcu9t5v0__nand2_1
X_16340_ _18234_/Q _16339_/Z wire38/I _18234_/D VSS _16519_/VNW VSS VSS gf180mcu_fd_sc_mcu9t5v0__mux2_1
X_10764_ _19014_/Q _10786_/A2 _10766_/A2 VSS VSS VSS VSS gf180mcu_fd_sc_mcu9t5v0__nor2_1
X_13552_ _13043_/I _13550_/Z _13556_/A1 _13552_/B _19271_/D VSS VSS VSS VSS gf180mcu_fd_sc_mcu9t5v0__oai31_1
X_12503_ _18740_/Q _12527_/A2 _12543_/B1 _12503_/B2 _12505_/A3 VSS VSS VSS VSS gf180mcu_fd_sc_mcu9t5v0__aoi22_4
X_16271_ _16271_/A1 _16426_/B _16272_/I1 VSS VSS VSS VSS gf180mcu_fd_sc_mcu9t5v0__nand2_4
X_10695_ _10659_/C _10694_/Z _10718_/C _10696_/B2 VSS VSS VSS VSS gf180mcu_fd_sc_mcu9t5v0__aoi21_1
X_13483_ _13486_/A1 _19780_/Q _13495_/B VSS VSS VSS VSS gf180mcu_fd_sc_mcu9t5v0__nand2_1
X_18010_ _18026_/I0 _18895_/Q _18021_/S _18895_/D VSS VSS VSS VSS gf180mcu_fd_sc_mcu9t5v0__mux2_1
XTAP_TAPCELL_ROW_23_1620 VSS VSS gf180mcu_fd_sc_mcu9t5v0__filltie
X_12434_ _12616_/B _12434_/A2 _12434_/A3 _12434_/B1 _12434_/B2 wire124/I VSS VSS VSS
+ VSS gf180mcu_fd_sc_mcu9t5v0__oai32_1
X_15222_ _15222_/I0 _19724_/Q _15430_/S _19724_/D VSS VSS VSS VSS gf180mcu_fd_sc_mcu9t5v0__mux2_1
X_12365_ _19142_/Q _12355_/I _12372_/B VSS _14654_/VNW VSS VSS gf180mcu_fd_sc_mcu9t5v0__nand2_1
X_15153_ _19695_/Q _19535_/Q wire108/Z _19695_/D VSS _15410_/VNW VSS VSS gf180mcu_fd_sc_mcu9t5v0__mux2_1
X_11316_ _18248_/Q _11469_/B _11317_/B VSS VSS VSS VSS gf180mcu_fd_sc_mcu9t5v0__nand2_1
X_19961_ _19961_/D _20025_/RN clkload46/I _19961_/Q VSS VSS VSS VSS gf180mcu_fd_sc_mcu9t5v0__dffrnq_1
X_15084_ _19395_/Q _19312_/Q _15099_/A3 VSS VSS VSS VSS gf180mcu_fd_sc_mcu9t5v0__nand2_1
X_14104_ _14104_/A1 _14090_/Z _14104_/B _14105_/I VSS VSS VSS VSS gf180mcu_fd_sc_mcu9t5v0__aoi21_1
XTAP_TAPCELL_ROW_143_3_8023 VSS VSS gf180mcu_fd_sc_mcu9t5v0__filltie
X_14035_ _14035_/I _14096_/A1 VSS VSS VSS VSS gf180mcu_fd_sc_mcu9t5v0__clkinv_1
X_18912_ _18912_/D _20064_/RN clkload11/I _18912_/Q VSS VSS VSS VSS gf180mcu_fd_sc_mcu9t5v0__dffrnq_1
X_12296_ wire213/I _12296_/A2 _12296_/B1 _12296_/B2 _12297_/I1 VSS VSS VSS VSS gf180mcu_fd_sc_mcu9t5v0__aoi22_1
X_11247_ _18275_/Q _11524_/S _11520_/B _11249_/A2 VSS VSS VSS VSS gf180mcu_fd_sc_mcu9t5v0__oai21_1
X_19892_ _19892_/D _20020_/RN clkload71/I _19892_/Q VSS VSS VSS VSS gf180mcu_fd_sc_mcu9t5v0__dffrnq_1
X_11178_ _18206_/Q _18190_/Q _11524_/S _11178_/Z VSS _16255_/VNW VSS VSS gf180mcu_fd_sc_mcu9t5v0__mux2_1
XTAP_TAPCELL_ROW_17_1446 VSS VSS gf180mcu_fd_sc_mcu9t5v0__filltie
XTAP_TAPCELL_ROW_17_1457 VSS VSS gf180mcu_fd_sc_mcu9t5v0__filltie
X_18843_ _18843_/D _20059_/RN clkload33/I _18843_/Q VSS VSS VSS VSS gf180mcu_fd_sc_mcu9t5v0__dffrnq_1
X_10129_ _19281_/Q _10165_/B1 _10166_/B1 _19289_/Q _19273_/Q _10166_/A2 _10130_/A3
+ VSS VSS VSS VSS gf180mcu_fd_sc_mcu9t5v0__aoi222_1
X_18774_ _18774_/D _20054_/RN _20049_/CLK _18774_/Q VSS VSS VSS VSS gf180mcu_fd_sc_mcu9t5v0__dffrnq_1
X_15986_ _11095_/S _15986_/A2 _15988_/A2 _15973_/B _15986_/C _16511_/A1 VSS VSS VSS
+ VSS gf180mcu_fd_sc_mcu9t5v0__oai221_4
X_17725_ _17725_/I _18738_/D VSS VSS VSS VSS gf180mcu_fd_sc_mcu9t5v0__clkinv_1
X_14937_ _14937_/I0 _14934_/Z _14937_/S _14937_/Z VSS VSS VSS VSS gf180mcu_fd_sc_mcu9t5v0__mux2_1
X_17656_ _18619_/Q _18695_/Q _17685_/S _18695_/D VSS VSS VSS VSS gf180mcu_fd_sc_mcu9t5v0__mux2_1
X_14868_ _19411_/Q _19352_/Q _14872_/A2 VSS VSS VSS VSS gf180mcu_fd_sc_mcu9t5v0__nor2_1
X_16607_ _19249_/Q _16700_/A2 wire71/I _16608_/A3 VSS _16607_/VNW VSS VSS gf180mcu_fd_sc_mcu9t5v0__nor3_1
X_17587_ _17587_/A1 _17589_/A1 _18653_/D VSS _17587_/VNW VSS VSS gf180mcu_fd_sc_mcu9t5v0__nand2_1
X_13819_ _19316_/Q _19317_/Q _19296_/Q _19297_/Q _13820_/I VSS _13854_/VNW VSS VSS
+ gf180mcu_fd_sc_mcu9t5v0__and4_1
XTAP_TAPCELL_ROW_80_3171 VSS VSS gf180mcu_fd_sc_mcu9t5v0__filltie
X_16538_ _16537_/Z _18325_/Q _17054_/S _18325_/D VSS VSS VSS VSS gf180mcu_fd_sc_mcu9t5v0__mux2_4
XTAP_TAPCELL_ROW_80_3193 VSS VSS gf180mcu_fd_sc_mcu9t5v0__filltie
XTAP_TAPCELL_ROW_80_3182 VSS VSS gf180mcu_fd_sc_mcu9t5v0__filltie
X_19326_ _19326_/D _20030_/RN clkload19/I _19326_/Q VSS VSS VSS VSS gf180mcu_fd_sc_mcu9t5v0__dffrnq_1
X_14799_ _09462_/I _14799_/A2 _14799_/B _19570_/D VSS VSS VSS VSS gf180mcu_fd_sc_mcu9t5v0__oai21_1
X_16469_ _19240_/Q _16177_/C _16993_/S _16469_/Z VSS VSS VSS VSS gf180mcu_fd_sc_mcu9t5v0__mux2_1
X_19257_ _19257_/D _20025_/RN _19680_/CLK _19257_/Q VSS VSS VSS VSS gf180mcu_fd_sc_mcu9t5v0__dffrnq_1
X_18208_ _18208_/D clkload75/I _18208_/Q VSS VSS VSS VSS gf180mcu_fd_sc_mcu9t5v0__dffq_4
XTAP_TAPCELL_ROW_93_3543 VSS VSS gf180mcu_fd_sc_mcu9t5v0__filltie
X_19188_ _19188_/D _20020_/RN clkload13/I _19188_/Q VSS VSS VSS VSS gf180mcu_fd_sc_mcu9t5v0__dffrnq_1
XTAP_TAPCELL_ROW_93_3532 VSS VSS gf180mcu_fd_sc_mcu9t5v0__filltie
X_18139_ _19214_/Q _19220_/Q _18151_/S _18139_/Z VSS VSS VSS VSS gf180mcu_fd_sc_mcu9t5v0__mux2_1
XTAP_TAPCELL_ROW_260_6225 VSS VSS gf180mcu_fd_sc_mcu9t5v0__filltie
XTAP_TAPCELL_ROW_260_6214 VSS VSS gf180mcu_fd_sc_mcu9t5v0__filltie
X_20101_ _20101_/D clkload77/I _20101_/Q VSS VSS VSS VSS gf180mcu_fd_sc_mcu9t5v0__dffq_1
XTAP_TAPCELL_ROW_277_6700 VSS VSS gf180mcu_fd_sc_mcu9t5v0__filltie
X_09912_ _10057_/A1 _10057_/A2 _10026_/B1 VSS VSS VSS VSS gf180mcu_fd_sc_mcu9t5v0__nor2_2
X_09843_ _19847_/Q _09849_/B _10724_/C VSS _10773_/VNW VSS VSS gf180mcu_fd_sc_mcu9t5v0__nand2_2
X_20032_ _20032_/D _09246_/I _20054_/CLK _20032_/Q VSS VSS VSS VSS gf180mcu_fd_sc_mcu9t5v0__dffsnq_1
XTAP_TAPCELL_ROW_258_6154 VSS VSS gf180mcu_fd_sc_mcu9t5v0__filltie
XTAP_TAPCELL_ROW_258_6176 VSS VSS gf180mcu_fd_sc_mcu9t5v0__filltie
XTAP_TAPCELL_ROW_258_6165 VSS VSS gf180mcu_fd_sc_mcu9t5v0__filltie
X_09774_ _17888_/B _09829_/A1 _09775_/B VSS _09774_/VNW VSS VSS gf180mcu_fd_sc_mcu9t5v0__nand2_1
XTAP_TAPCELL_ROW_87_3369 VSS VSS gf180mcu_fd_sc_mcu9t5v0__filltie
XTAP_TAPCELL_ROW_7_1180 VSS VSS gf180mcu_fd_sc_mcu9t5v0__filltie
XPHY_EDGE_ROW_150_1_Right_734 VSS VSS gf180mcu_fd_sc_mcu9t5v0__endcap
XTAP_TAPCELL_ROW_3_1055 VSS VSS gf180mcu_fd_sc_mcu9t5v0__filltie
XTAP_TAPCELL_ROW_3_1066 VSS VSS gf180mcu_fd_sc_mcu9t5v0__filltie
XTAP_TAPCELL_ROW_3_1077 VSS VSS gf180mcu_fd_sc_mcu9t5v0__filltie
XTAP_TAPCELL_ROW_230_5394 VSS VSS gf180mcu_fd_sc_mcu9t5v0__filltie
X_10480_ _10654_/A2 _10480_/A2 _10480_/A3 _10481_/B VSS _10480_/VNW VSS VSS gf180mcu_fd_sc_mcu9t5v0__nand3_1
Xrebuffer232 rebuffer266/Z _17062_/S VSS VSS VSS VSS gf180mcu_fd_sc_mcu9t5v0__buf_12
XTAP_TAPCELL_ROW_230_5383 VSS VSS gf180mcu_fd_sc_mcu9t5v0__filltie
X_09208_ _19584_/Q _15184_/B2 VSS VSS VSS VSS gf180mcu_fd_sc_mcu9t5v0__clkinv_1
X_09139_ _19735_/Q _13245_/A1 VSS _12851_/VNW VSS VSS gf180mcu_fd_sc_mcu9t5v0__clkinv_1
Xrebuffer265 _09519_/ZN _17628_/A1 VSS VSS VSS VSS gf180mcu_fd_sc_mcu9t5v0__buf_8
XPHY_EDGE_ROW_304_Right_231 VSS VSS gf180mcu_fd_sc_mcu9t5v0__endcap
X_12150_ _18913_/Q _12150_/A2 _12170_/A2 VSS VSS VSS VSS gf180mcu_fd_sc_mcu9t5v0__xnor2_1
X_11101_ _18233_/Q _11098_/B _11103_/B VSS VSS VSS VSS gf180mcu_fd_sc_mcu9t5v0__nand2_1
X_12081_ _18348_/Q _12203_/A2 _12082_/A3 VSS _17153_/VNW VSS VSS gf180mcu_fd_sc_mcu9t5v0__nor2_1
XTAP_TAPCELL_ROW_243_5766 VSS VSS gf180mcu_fd_sc_mcu9t5v0__filltie
XTAP_TAPCELL_ROW_243_5755 VSS VSS gf180mcu_fd_sc_mcu9t5v0__filltie
XTAP_TAPCELL_ROW_243_5744 VSS VSS gf180mcu_fd_sc_mcu9t5v0__filltie
XTAP_TAPCELL_ROW_72_2959 VSS VSS gf180mcu_fd_sc_mcu9t5v0__filltie
X_11032_ _19065_/Q _19033_/Q _11051_/S _19033_/D VSS VSS VSS VSS gf180mcu_fd_sc_mcu9t5v0__mux2_1
X_15840_ _17609_/S _15840_/A2 _20143_/D VSS _15840_/VNW VSS VSS gf180mcu_fd_sc_mcu9t5v0__nand2_1
XTAP_TAPCELL_ROW_12_1310 VSS VSS gf180mcu_fd_sc_mcu9t5v0__filltie
XTAP_TAPCELL_ROW_12_1321 VSS VSS gf180mcu_fd_sc_mcu9t5v0__filltie
X_15771_ _09065_/I _19941_/Q _15786_/S _19941_/D VSS VSS VSS VSS gf180mcu_fd_sc_mcu9t5v0__mux2_1
X_12983_ _12983_/A1 _12983_/A2 _12983_/B _12996_/A2 VSS VSS VSS VSS gf180mcu_fd_sc_mcu9t5v0__aoi21_1
X_17510_ _18615_/Q _19256_/Q _17513_/S _18615_/D VSS VSS VSS VSS gf180mcu_fd_sc_mcu9t5v0__mux2_1
X_18490_ _18490_/D _20129_/CLK _18490_/Q VSS VSS VSS VSS gf180mcu_fd_sc_mcu9t5v0__dffq_1
X_11934_ _18261_/Q _12340_/S _11936_/B1 VSS VSS VSS VSS gf180mcu_fd_sc_mcu9t5v0__nand2_1
X_14722_ _14722_/A1 _14722_/A2 _14725_/B VSS _14722_/VNW VSS VSS gf180mcu_fd_sc_mcu9t5v0__nor2_1
X_17441_ _11095_/S _09688_/B _17443_/A2 _17442_/B VSS VSS VSS VSS gf180mcu_fd_sc_mcu9t5v0__nand3_1
XPHY_EDGE_ROW_152_2_Right_883 VSS VSS gf180mcu_fd_sc_mcu9t5v0__endcap
X_14653_ _13675_/B _14653_/A2 _14655_/A2 VSS VSS VSS VSS gf180mcu_fd_sc_mcu9t5v0__xnor2_1
X_11865_ _18306_/Q _12345_/A2 _11866_/A3 VSS _11865_/VNW VSS VSS gf180mcu_fd_sc_mcu9t5v0__nand2_1
X_13604_ _13608_/A1 _13608_/A2 _13606_/A2 VSS VSS VSS VSS gf180mcu_fd_sc_mcu9t5v0__nor2_1
X_10816_ _10816_/A1 _10816_/A2 _10816_/B1 _09721_/B _20060_/D VSS _10817_/VNW VSS
+ VSS gf180mcu_fd_sc_mcu9t5v0__aoi22_1
X_17372_ _17250_/Z _17372_/A2 _17372_/B _18550_/D VSS VSS VSS VSS gf180mcu_fd_sc_mcu9t5v0__oai21_4
X_19111_ _19111_/D _20071_/RN clkload12/I _19111_/Q VSS VSS VSS VSS gf180mcu_fd_sc_mcu9t5v0__dffrnq_1
X_11796_ _12147_/S _11796_/A2 _11813_/A2 VSS _11796_/VNW VSS VSS gf180mcu_fd_sc_mcu9t5v0__nor2_1
X_14584_ wire199/Z _14582_/Z _14587_/B _14586_/B1 VSS VSS VSS VSS gf180mcu_fd_sc_mcu9t5v0__nand3_1
XPHY_EDGE_ROW_109_Left_433 VSS VSS gf180mcu_fd_sc_mcu9t5v0__endcap
X_16323_ _19238_/Q _16167_/B _16861_/S _16323_/Z VSS VSS VSS VSS gf180mcu_fd_sc_mcu9t5v0__mux2_1
X_10747_ _17411_/C _10816_/A1 _17231_/A3 _10747_/B _10748_/B VSS VSS VSS VSS gf180mcu_fd_sc_mcu9t5v0__oai31_4
X_13535_ _13536_/A1 _13536_/A2 _13541_/A3 VSS VSS VSS VSS gf180mcu_fd_sc_mcu9t5v0__nor2_1
X_16254_ _18205_/Q _16253_/Z _16818_/S _18205_/D VSS _17198_/VNW VSS VSS gf180mcu_fd_sc_mcu9t5v0__mux2_4
X_10678_ _15470_/A1 _10678_/A2 _10679_/B VSS _15467_/VNW VSS VSS gf180mcu_fd_sc_mcu9t5v0__nand2_1
XPHY_EDGE_ROW_213_Left_536 VSS VSS gf180mcu_fd_sc_mcu9t5v0__endcap
X_13466_ _13466_/A1 _13466_/A2 _13466_/B _13485_/A1 VSS _13466_/VNW VSS VSS gf180mcu_fd_sc_mcu9t5v0__oai21_1
X_19042_ _19042_/D _20066_/RN clkload33/I _19042_/Q VSS VSS VSS VSS gf180mcu_fd_sc_mcu9t5v0__dffrnq_1
X_12417_ _18256_/Q _12607_/A2 _12419_/B1 VSS VSS VSS VSS gf180mcu_fd_sc_mcu9t5v0__nor2_1
X_15205_ _15209_/A1 _15209_/A3 _15206_/A3 VSS VSS VSS VSS gf180mcu_fd_sc_mcu9t5v0__nor2_1
X_16185_ _18182_/Q _16185_/I1 _16753_/S _18182_/D VSS VSS VSS VSS gf180mcu_fd_sc_mcu9t5v0__mux2_4
XTAP_TAPCELL_ROW_131_4591 VSS VSS gf180mcu_fd_sc_mcu9t5v0__filltie
X_13397_ _13416_/A1 _19775_/Q _13433_/A1 VSS VSS VSS VSS gf180mcu_fd_sc_mcu9t5v0__nor2_1
XTAP_TAPCELL_ROW_131_4580 VSS VSS gf180mcu_fd_sc_mcu9t5v0__filltie
X_12348_ _12347_/C _12343_/Z _12348_/B _12348_/C _12349_/A2 VSS _12348_/VNW VSS VSS
+ gf180mcu_fd_sc_mcu9t5v0__oai211_1
X_15136_ _19678_/Q _19518_/Q wire108/Z _19678_/D VSS VSS VSS VSS gf180mcu_fd_sc_mcu9t5v0__mux2_1
XTAP_TAPCELL_ROW_19_1508 VSS VSS gf180mcu_fd_sc_mcu9t5v0__filltie
XTAP_TAPCELL_ROW_321_7899 VSS VSS gf180mcu_fd_sc_mcu9t5v0__filltie
XTAP_TAPCELL_ROW_321_7888 VSS VSS gf180mcu_fd_sc_mcu9t5v0__filltie
X_19944_ _19944_/D _20072_/RN clkload50/I _19944_/Q VSS VSS VSS VSS gf180mcu_fd_sc_mcu9t5v0__dffrnq_1
X_12279_ _12279_/A1 _12279_/A2 _12296_/A2 VSS _12297_/VNW VSS VSS gf180mcu_fd_sc_mcu9t5v0__xnor2_1
X_15067_ _19642_/Q _15066_/Z _20039_/Q _19642_/D VSS VSS VSS VSS gf180mcu_fd_sc_mcu9t5v0__mux2_1
XPHY_EDGE_ROW_118_Left_442 VSS VSS gf180mcu_fd_sc_mcu9t5v0__endcap
X_14018_ _14018_/A1 _14016_/Z _14033_/A2 VSS VSS VSS VSS gf180mcu_fd_sc_mcu9t5v0__xnor2_1
X_19875_ _19875_/D _20067_/RN clkload56/I _19875_/Q VSS VSS VSS VSS gf180mcu_fd_sc_mcu9t5v0__dffrnq_1
XPHY_EDGE_ROW_222_Left_545 VSS VSS gf180mcu_fd_sc_mcu9t5v0__endcap
XTAP_TAPCELL_ROW_164_1_4752 VSS VSS gf180mcu_fd_sc_mcu9t5v0__filltie
X_18826_ _18826_/D _20042_/RN clkload55/I _18826_/Q VSS VSS VSS VSS gf180mcu_fd_sc_mcu9t5v0__dffrnq_1
X_15969_ _10064_/S _16198_/A2 _15938_/Z _15969_/B2 _16545_/A3 VSS VSS VSS VSS gf180mcu_fd_sc_mcu9t5v0__aoi22_4
X_18757_ _18757_/D _20037_/RN clkload51/I _18757_/Q VSS VSS VSS VSS gf180mcu_fd_sc_mcu9t5v0__dffrnq_1
XTAP_TAPCELL_ROW_253_6040 VSS VSS gf180mcu_fd_sc_mcu9t5v0__filltie
X_17708_ _18730_/Q _17742_/S _17743_/B _18654_/Q _17709_/A2 VSS _17708_/VNW VSS VSS
+ gf180mcu_fd_sc_mcu9t5v0__aoi22_1
XTAP_TAPCELL_ROW_82_3244 VSS VSS gf180mcu_fd_sc_mcu9t5v0__filltie
X_18688_ _18688_/D _20028_/RN _20054_/CLK _18688_/Q VSS VSS VSS VSS gf180mcu_fd_sc_mcu9t5v0__dffrnq_1
X_09490_ _19157_/Q _14370_/A1 _09492_/B _12487_/A1 VSS _09681_/VNW VSS VSS gf180mcu_fd_sc_mcu9t5v0__aoi21_4
XTAP_TAPCELL_ROW_82_3233 VSS VSS gf180mcu_fd_sc_mcu9t5v0__filltie
X_17639_ _18687_/Q _17639_/A2 _17639_/B _17640_/A2 VSS VSS VSS VSS gf180mcu_fd_sc_mcu9t5v0__oai21_1
XPHY_EDGE_ROW_127_Left_451 VSS VSS gf180mcu_fd_sc_mcu9t5v0__endcap
XPHY_EDGE_ROW_231_Left_554 VSS VSS gf180mcu_fd_sc_mcu9t5v0__endcap
XPHY_EDGE_ROW_140_3_Right_255 VSS VSS gf180mcu_fd_sc_mcu9t5v0__endcap
XTAP_TAPCELL_ROW_95_3605 VSS VSS gf180mcu_fd_sc_mcu9t5v0__filltie
X_19309_ _19309_/D _20141_/RN clkload8/I _19309_/Q VSS VSS VSS VSS gf180mcu_fd_sc_mcu9t5v0__dffrnq_1
XPHY_EDGE_ROW_153_2_Left_665 VSS VSS gf180mcu_fd_sc_mcu9t5v0__endcap
XTAP_TAPCELL_ROW_76_3059 VSS VSS gf180mcu_fd_sc_mcu9t5v0__filltie
XPHY_EDGE_ROW_240_Left_563 VSS VSS gf180mcu_fd_sc_mcu9t5v0__endcap
XTAP_TAPCELL_ROW_110_3996 VSS VSS gf180mcu_fd_sc_mcu9t5v0__filltie
X_20015_ _20015_/D _20143_/RN clkload48/I _20015_/Q VSS VSS VSS VSS gf180mcu_fd_sc_mcu9t5v0__dffrnq_1
XTAP_TAPCELL_ROW_9_1220 VSS VSS gf180mcu_fd_sc_mcu9t5v0__filltie
XTAP_TAPCELL_ROW_9_1231 VSS VSS gf180mcu_fd_sc_mcu9t5v0__filltie
X_09826_ _17869_/A2 _09835_/B _09826_/B _09826_/C _09827_/A2 VSS VSS VSS VSS gf180mcu_fd_sc_mcu9t5v0__aoi211_1
XTAP_TAPCELL_ROW_9_1242 VSS VSS gf180mcu_fd_sc_mcu9t5v0__filltie
X_09757_ _18664_/Q _15842_/A1 _09758_/A2 VSS VSS VSS VSS gf180mcu_fd_sc_mcu9t5v0__nor2_1
XTAP_TAPCELL_ROW_5_1117 VSS VSS gf180mcu_fd_sc_mcu9t5v0__filltie
XTAP_TAPCELL_ROW_5_1128 VSS VSS gf180mcu_fd_sc_mcu9t5v0__filltie
X_09688_ _17426_/A1 _09604_/I _09688_/B _20012_/Q _09689_/A2 VSS VSS VSS VSS gf180mcu_fd_sc_mcu9t5v0__oai211_1
XTAP_TAPCELL_ROW_65_2763 VSS VSS gf180mcu_fd_sc_mcu9t5v0__filltie
XTAP_TAPCELL_ROW_236_5570 VSS VSS gf180mcu_fd_sc_mcu9t5v0__filltie
XPHY_EDGE_ROW_151_1_Right_735 VSS VSS gf180mcu_fd_sc_mcu9t5v0__endcap
XTAP_TAPCELL_ROW_65_2774 VSS VSS gf180mcu_fd_sc_mcu9t5v0__filltie
XTAP_TAPCELL_ROW_232_5456 VSS VSS gf180mcu_fd_sc_mcu9t5v0__filltie
XTAP_TAPCELL_ROW_232_5445 VSS VSS gf180mcu_fd_sc_mcu9t5v0__filltie
XTAP_TAPCELL_ROW_61_2649 VSS VSS gf180mcu_fd_sc_mcu9t5v0__filltie
X_11650_ _12664_/C _11654_/C _12671_/B2 VSS _12639_/VNW VSS VSS gf180mcu_fd_sc_mcu9t5v0__nand2_1
X_10601_ _10654_/A2 _10601_/A2 _10601_/A3 _10602_/B VSS VSS VSS VSS gf180mcu_fd_sc_mcu9t5v0__nand3_1
X_11581_ _18847_/Q _18846_/Q _18836_/Q _11581_/Z VSS _11592_/VNW VSS VSS gf180mcu_fd_sc_mcu9t5v0__mux2_1
XTAP_TAPCELL_ROW_249_5920 VSS VSS gf180mcu_fd_sc_mcu9t5v0__filltie
X_10532_ _19952_/Q wire216/Z _10655_/B _10552_/A2 VSS VSS VSS VSS gf180mcu_fd_sc_mcu9t5v0__aoi21_1
X_13320_ _12734_/Z _13320_/A2 _13320_/B _13321_/B2 VSS VSS VSS VSS gf180mcu_fd_sc_mcu9t5v0__aoi21_1
XTAP_TAPCELL_ROW_249_5931 VSS VSS gf180mcu_fd_sc_mcu9t5v0__filltie
XTAP_TAPCELL_ROW_245_5817 VSS VSS gf180mcu_fd_sc_mcu9t5v0__filltie
XTAP_TAPCELL_ROW_245_5806 VSS VSS gf180mcu_fd_sc_mcu9t5v0__filltie
X_10463_ _18161_/Q _17406_/A2 _17405_/A2 _18177_/Q _10464_/B VSS VSS VSS VSS gf180mcu_fd_sc_mcu9t5v0__aoi22_1
X_13251_ _13251_/I0 _19245_/Q _13304_/B _19245_/D VSS VSS VSS VSS gf180mcu_fd_sc_mcu9t5v0__mux2_1
X_12202_ _18417_/Q _12315_/S _12207_/A3 VSS VSS VSS VSS gf180mcu_fd_sc_mcu9t5v0__nand2_1
X_10394_ _10654_/A2 _10394_/A2 _10394_/A3 _10395_/B VSS VSS VSS VSS gf180mcu_fd_sc_mcu9t5v0__nand3_1
X_13182_ _13182_/A1 _13182_/A2 _13182_/B _13195_/A2 VSS _13182_/VNW VSS VSS gf180mcu_fd_sc_mcu9t5v0__aoi21_1
X_12133_ _18462_/Q _18446_/Q _12315_/S _12133_/Z VSS VSS VSS VSS gf180mcu_fd_sc_mcu9t5v0__mux2_1
X_17990_ _18876_/Q _18023_/I0 _17997_/S _18876_/D VSS _17990_/VNW VSS VSS gf180mcu_fd_sc_mcu9t5v0__mux2_1
X_12064_ _18443_/Q _12315_/S _12066_/B1 VSS VSS VSS VSS gf180mcu_fd_sc_mcu9t5v0__nand2_1
X_16941_ _19249_/Q _16606_/B _16955_/S _16941_/Z VSS VSS VSS VSS gf180mcu_fd_sc_mcu9t5v0__mux2_1
X_11015_ _18102_/A1 _11015_/A2 _19019_/D VSS _11015_/VNW VSS VSS gf180mcu_fd_sc_mcu9t5v0__nor2_1
X_16872_ _18428_/Q _16871_/Z wire38/I _18428_/D VSS _16872_/VNW VSS VSS gf180mcu_fd_sc_mcu9t5v0__mux2_1
X_19660_ _19660_/D _20044_/RN clkload42/I _19660_/Q VSS VSS VSS VSS gf180mcu_fd_sc_mcu9t5v0__dffrnq_1
X_18611_ _18611_/D clkload74/I _18611_/Q VSS VSS VSS VSS gf180mcu_fd_sc_mcu9t5v0__dffq_1
X_15823_ _15824_/A1 _15824_/A3 _15823_/B _19989_/D VSS VSS VSS VSS gf180mcu_fd_sc_mcu9t5v0__aoi21_1
X_19591_ _19591_/D _20039_/RN clkload7/I _19591_/Q VSS VSS VSS VSS gf180mcu_fd_sc_mcu9t5v0__dffrnq_1
X_18542_ _18542_/D _20042_/RN clkload58/I _18542_/Q VSS VSS VSS VSS gf180mcu_fd_sc_mcu9t5v0__dffrnq_1
X_15754_ _15761_/A1 _15754_/A2 _19930_/D VSS VSS VSS VSS gf180mcu_fd_sc_mcu9t5v0__nor2_1
XTAP_TAPCELL_ROW_120_4292 VSS VSS gf180mcu_fd_sc_mcu9t5v0__filltie
XTAP_TAPCELL_ROW_120_4281 VSS VSS gf180mcu_fd_sc_mcu9t5v0__filltie
XTAP_TAPCELL_ROW_120_4270 VSS VSS gf180mcu_fd_sc_mcu9t5v0__filltie
X_14705_ _19539_/Q _14670_/S _14707_/B VSS VSS VSS VSS gf180mcu_fd_sc_mcu9t5v0__nand2_1
X_12966_ _13500_/A1 _13502_/B _12989_/A2 VSS _12967_/VNW VSS VSS gf180mcu_fd_sc_mcu9t5v0__nand2_1
X_11917_ _12299_/S _11917_/A2 _11917_/B _12345_/B _11922_/A2 VSS VSS VSS VSS gf180mcu_fd_sc_mcu9t5v0__aoi211_1
XTAP_TAPCELL_ROW_314_7692 VSS VSS gf180mcu_fd_sc_mcu9t5v0__filltie
X_18473_ _18473_/D clkload52/I _18473_/Q VSS VSS VSS VSS gf180mcu_fd_sc_mcu9t5v0__dffq_1
X_15685_ _15685_/I _15737_/A3 VSS VSS VSS VSS gf180mcu_fd_sc_mcu9t5v0__clkinv_1
XPHY_EDGE_ROW_153_2_Right_884 VSS VSS gf180mcu_fd_sc_mcu9t5v0__endcap
X_12897_ _19773_/Q _12895_/Z _12898_/B VSS VSS VSS VSS gf180mcu_fd_sc_mcu9t5v0__xnor2_1
XTAP_TAPCELL_ROW_310_7589 VSS VSS gf180mcu_fd_sc_mcu9t5v0__filltie
X_11848_ _12299_/S _11844_/Z _11848_/B _12342_/C _11849_/A2 VSS VSS VSS VSS gf180mcu_fd_sc_mcu9t5v0__aoi211_1
X_17424_ _18683_/Q _17438_/C _17429_/A1 VSS VSS VSS VSS gf180mcu_fd_sc_mcu9t5v0__nand2_1
X_14636_ _19098_/Q _19514_/Q _14730_/S _19514_/D VSS VSS VSS VSS gf180mcu_fd_sc_mcu9t5v0__mux2_1
X_17355_ _17404_/S _18470_/Q _17357_/A3 VSS _17357_/VNW VSS VSS gf180mcu_fd_sc_mcu9t5v0__nor2_1
X_14567_ _14567_/A1 _19136_/Q _14567_/B _14581_/A1 VSS VSS VSS VSS gf180mcu_fd_sc_mcu9t5v0__aoi21_1
X_11779_ _11779_/A1 _11779_/A2 _11785_/A2 VSS VSS VSS VSS gf180mcu_fd_sc_mcu9t5v0__nor2_1
XTAP_TAPCELL_ROW_215_4986 VSS VSS gf180mcu_fd_sc_mcu9t5v0__filltie
X_16306_ _18218_/Q _16305_/Z _16840_/S _18218_/D VSS VSS VSS VSS gf180mcu_fd_sc_mcu9t5v0__mux2_1
XTAP_TAPCELL_ROW_215_4975 VSS VSS gf180mcu_fd_sc_mcu9t5v0__filltie
XTAP_TAPCELL_ROW_133_4653 VSS VSS gf180mcu_fd_sc_mcu9t5v0__filltie
XTAP_TAPCELL_ROW_133_4642 VSS VSS gf180mcu_fd_sc_mcu9t5v0__filltie
XTAP_TAPCELL_ROW_133_4631 VSS VSS gf180mcu_fd_sc_mcu9t5v0__filltie
X_13518_ wire277/Z _13517_/Z _13518_/B _19264_/D VSS _13518_/VNW VSS VSS gf180mcu_fd_sc_mcu9t5v0__oai21_1
X_17286_ wire168/Z _17286_/A2 _17286_/A3 _17287_/C VSS _17286_/VNW VSS VSS gf180mcu_fd_sc_mcu9t5v0__nand3_1
X_14498_ _19163_/Q _19129_/Q _14728_/B VSS VSS VSS VSS gf180mcu_fd_sc_mcu9t5v0__nand2_1
X_19025_ _19025_/D _20049_/RN clkload34/I _19025_/Q VSS VSS VSS VSS gf180mcu_fd_sc_mcu9t5v0__dffrnq_1
X_16237_ _19260_/Q _16932_/A2 _16239_/A1 VSS VSS VSS VSS gf180mcu_fd_sc_mcu9t5v0__nand2_1
X_13449_ _13497_/A1 _13465_/A2 _13450_/A2 VSS _13450_/VNW VSS VSS gf180mcu_fd_sc_mcu9t5v0__nor2_1
Xclkload44 clkload44/I clkload44/ZN VSS VSS VSS VSS gf180mcu_fd_sc_mcu9t5v0__inv_3
Xclkload22 clkload22/I clkload22/ZN VSS VSS VSS VSS gf180mcu_fd_sc_mcu9t5v0__clkinv_1
Xclkload11 clkload11/I clkload11/ZN VSS VSS VSS VSS gf180mcu_fd_sc_mcu9t5v0__inv_4
Xclkload33 clkload33/I clkload33/ZN VSS VSS VSS VSS gf180mcu_fd_sc_mcu9t5v0__inv_4
X_16168_ _19238_/Q _16744_/A2 _16751_/A3 _16695_/B _16169_/A2 VSS VSS VSS VSS gf180mcu_fd_sc_mcu9t5v0__oai31_1
Xclkload77 clkload77/I clkload77/ZN VSS VSS VSS VSS gf180mcu_fd_sc_mcu9t5v0__inv_4
Xclkload66 clkload66/I clkload66/ZN VSS VSS VSS VSS gf180mcu_fd_sc_mcu9t5v0__inv_3
Xclkload55 clkload55/I clkload55/Z VSS _17856_/VNW VSS VSS gf180mcu_fd_sc_mcu9t5v0__clkbuf_4
X_15119_ _19661_/Q _19501_/Q wire108/Z _19661_/D VSS VSS VSS VSS gf180mcu_fd_sc_mcu9t5v0__mux2_1
X_16099_ _16750_/A1 _16674_/A2 _16099_/B _16102_/A2 VSS _16099_/VNW VSS VSS gf180mcu_fd_sc_mcu9t5v0__aoi21_1
XTAP_TAPCELL_ROW_209_4779 VSS VSS gf180mcu_fd_sc_mcu9t5v0__filltie
X_19927_ _19927_/D _20055_/RN clkload49/I _19927_/Q VSS VSS VSS VSS gf180mcu_fd_sc_mcu9t5v0__dffrnq_1
XTAP_TAPCELL_ROW_127_4479 VSS VSS gf180mcu_fd_sc_mcu9t5v0__filltie
XTAP_TAPCELL_ROW_127_4468 VSS VSS gf180mcu_fd_sc_mcu9t5v0__filltie
X_19858_ _19858_/D _20050_/RN clkload58/I _19858_/Q VSS VSS VSS VSS gf180mcu_fd_sc_mcu9t5v0__dffrnq_1
XTAP_TAPCELL_ROW_84_3306 VSS VSS gf180mcu_fd_sc_mcu9t5v0__filltie
X_09611_ _20055_/Q _20011_/Q _17444_/A2 VSS _17426_/VNW VSS VSS gf180mcu_fd_sc_mcu9t5v0__nand2_1
X_18809_ _18809_/D _20025_/RN _19806_/CLK _18809_/Q VSS VSS VSS VSS gf180mcu_fd_sc_mcu9t5v0__dffrnq_1
X_09542_ _09542_/A1 _09542_/A2 _09542_/B _09542_/C _15946_/A3 VSS VSS VSS VSS gf180mcu_fd_sc_mcu9t5v0__oai211_4
X_19789_ _19789_/D _20045_/RN _19806_/CLK _19789_/Q VSS VSS VSS VSS gf180mcu_fd_sc_mcu9t5v0__dffrnq_1
X_09473_ _10187_/A2 _15148_/S _09473_/B _14501_/S _14370_/A1 VSS VSS VSS VSS gf180mcu_fd_sc_mcu9t5v0__oai211_4
Xclkload5 clkload5/I clkload5/ZN VSS VSS VSS VSS gf180mcu_fd_sc_mcu9t5v0__inv_20
XPHY_EDGE_ROW_141_3_Right_256 VSS VSS gf180mcu_fd_sc_mcu9t5v0__endcap
XTAP_TAPCELL_ROW_285_6898 VSS VSS gf180mcu_fd_sc_mcu9t5v0__filltie
XTAP_TAPCELL_ROW_225_5260 VSS VSS gf180mcu_fd_sc_mcu9t5v0__filltie
XTAP_TAPCELL_ROW_54_2464 VSS VSS gf180mcu_fd_sc_mcu9t5v0__filltie
XTAP_TAPCELL_ROW_54_2475 VSS VSS gf180mcu_fd_sc_mcu9t5v0__filltie
XTAP_TAPCELL_ROW_225_5271 VSS VSS gf180mcu_fd_sc_mcu9t5v0__filltie
XTAP_TAPCELL_ROW_221_5135 VSS VSS gf180mcu_fd_sc_mcu9t5v0__filltie
XTAP_TAPCELL_ROW_221_5157 VSS VSS gf180mcu_fd_sc_mcu9t5v0__filltie
Xfanout253 _16786_/S _16782_/S VSS VSS VSS VSS gf180mcu_fd_sc_mcu9t5v0__buf_8
Xfanout242 _16962_/S _16958_/S VSS VSS VSS VSS gf180mcu_fd_sc_mcu9t5v0__clkbuf_16
XTAP_TAPCELL_ROW_221_5146 VSS VSS gf180mcu_fd_sc_mcu9t5v0__filltie
XTAP_TAPCELL_ROW_67_2814 VSS VSS gf180mcu_fd_sc_mcu9t5v0__filltie
X_09809_ _11600_/C _09782_/Z _11610_/B VSS _11584_/VNW VSS VSS gf180mcu_fd_sc_mcu9t5v0__and2_1
XTAP_TAPCELL_ROW_238_5621 VSS VSS gf180mcu_fd_sc_mcu9t5v0__filltie
XTAP_TAPCELL_ROW_238_5610 VSS VSS gf180mcu_fd_sc_mcu9t5v0__filltie
X_12820_ _19730_/Q _19795_/Q _12948_/S _12820_/Z VSS _13130_/VNW VSS VSS gf180mcu_fd_sc_mcu9t5v0__mux2_1
XTAP_TAPCELL_ROW_67_2825 VSS VSS gf180mcu_fd_sc_mcu9t5v0__filltie
XTAP_TAPCELL_ROW_67_2836 VSS VSS gf180mcu_fd_sc_mcu9t5v0__filltie
XTAP_TAPCELL_ROW_234_5507 VSS VSS gf180mcu_fd_sc_mcu9t5v0__filltie
XTAP_TAPCELL_ROW_234_5518 VSS VSS gf180mcu_fd_sc_mcu9t5v0__filltie
XTAP_TAPCELL_ROW_219_5086 VSS VSS gf180mcu_fd_sc_mcu9t5v0__filltie
X_12751_ _19198_/Q _13304_/B _12752_/B VSS VSS VSS VSS gf180mcu_fd_sc_mcu9t5v0__nand2_1
X_15470_ _15470_/A1 _10745_/Z _15472_/A2 _15470_/Z VSS VSS VSS VSS gf180mcu_fd_sc_mcu9t5v0__and3_1
XTAP_TAPCELL_ROW_219_5097 VSS VSS gf180mcu_fd_sc_mcu9t5v0__filltie
XPHY_EDGE_ROW_152_1_Right_736 VSS VSS gf180mcu_fd_sc_mcu9t5v0__endcap
X_12682_ _12716_/S _12644_/B _12682_/B _12682_/C _12684_/A2 VSS VSS VSS VSS gf180mcu_fd_sc_mcu9t5v0__oai211_1
X_11702_ _18891_/Q _18892_/Q _12076_/B _11703_/A2 VSS VSS VSS VSS gf180mcu_fd_sc_mcu9t5v0__oai21_1
X_11633_ _12632_/C _11674_/A1 _11633_/B _11643_/A1 VSS _11643_/VNW VSS VSS gf180mcu_fd_sc_mcu9t5v0__oai21_1
X_14421_ _14421_/A1 _14421_/A2 _14422_/B VSS _14421_/VNW VSS VSS gf180mcu_fd_sc_mcu9t5v0__nand2_1
X_17140_ _17769_/A1 _19816_/Q _17231_/A3 _17140_/B _17141_/B VSS VSS VSS VSS gf180mcu_fd_sc_mcu9t5v0__oai31_1
X_11564_ _12090_/B _11564_/A2 _11564_/A3 _11564_/B _11574_/B VSS VSS VSS VSS gf180mcu_fd_sc_mcu9t5v0__oai31_1
X_14352_ _14367_/I0 _19423_/Q _14352_/S _19423_/D VSS VSS VSS VSS gf180mcu_fd_sc_mcu9t5v0__mux2_1
X_10515_ _18227_/Q _17380_/A2 _17380_/B1 _18243_/Q _10516_/B VSS VSS VSS VSS gf180mcu_fd_sc_mcu9t5v0__aoi22_1
X_17071_ _18533_/Q _16654_/B _17073_/S _18533_/D VSS VSS VSS VSS gf180mcu_fd_sc_mcu9t5v0__mux2_4
X_11495_ _11495_/A1 _11495_/A2 _11521_/B _11495_/C _11496_/B VSS VSS VSS VSS gf180mcu_fd_sc_mcu9t5v0__oai211_1
XTAP_TAPCELL_ROW_210_4850 VSS VSS gf180mcu_fd_sc_mcu9t5v0__filltie
X_14283_ _14320_/I0 _19357_/Q _14285_/S _19357_/D VSS VSS VSS VSS gf180mcu_fd_sc_mcu9t5v0__mux2_1
X_13303_ _13303_/A1 _13303_/A2 _13303_/Z VSS VSS VSS VSS gf180mcu_fd_sc_mcu9t5v0__xor2_1
X_10446_ _18544_/Q wire80/Z _10446_/B1 _10650_/B1 _10452_/A2 VSS VSS VSS VSS gf180mcu_fd_sc_mcu9t5v0__aoi22_4
X_16022_ _16750_/A1 _16628_/A2 _16131_/B _16025_/A1 VSS VSS VSS VSS gf180mcu_fd_sc_mcu9t5v0__aoi21_1
X_13234_ _13234_/I0 _19244_/Q _13304_/B _19244_/D VSS VSS VSS VSS gf180mcu_fd_sc_mcu9t5v0__mux2_1
X_10377_ _09261_/I _10377_/A2 _10377_/A3 _10377_/B _10382_/C1 VSS VSS VSS VSS gf180mcu_fd_sc_mcu9t5v0__oai31_1
XTAP_TAPCELL_ROW_303_7393 VSS VSS gf180mcu_fd_sc_mcu9t5v0__filltie
X_13165_ _19729_/Q _19761_/Q _13182_/A1 _13166_/A2 VSS _13166_/VNW VSS VSS gf180mcu_fd_sc_mcu9t5v0__xnor3_1
X_12116_ _18509_/Q _12159_/B _12116_/B _12116_/C _12120_/A1 VSS VSS VSS VSS gf180mcu_fd_sc_mcu9t5v0__oai211_1
X_13096_ _13096_/A1 _13094_/B _13096_/Z VSS _13096_/VNW VSS VSS gf180mcu_fd_sc_mcu9t5v0__xor2_1
X_17973_ _18860_/Q _18023_/I0 _17978_/S _18860_/D VSS VSS VSS VSS gf180mcu_fd_sc_mcu9t5v0__mux2_1
XTAP_TAPCELL_ROW_295_7194 VSS VSS gf180mcu_fd_sc_mcu9t5v0__filltie
XTAP_TAPCELL_ROW_295_7183 VSS VSS gf180mcu_fd_sc_mcu9t5v0__filltie
XTAP_TAPCELL_ROW_295_7172 VSS VSS gf180mcu_fd_sc_mcu9t5v0__filltie
X_12047_ _18506_/Q _12092_/B _12048_/B VSS _12498_/VNW VSS VSS gf180mcu_fd_sc_mcu9t5v0__nor2_1
X_16924_ _16923_/Z _18454_/Q _16924_/S _18454_/D VSS VSS VSS VSS gf180mcu_fd_sc_mcu9t5v0__mux2_1
X_19712_ _19712_/D _09246_/I clkload31/I _19712_/Q VSS VSS VSS VSS gf180mcu_fd_sc_mcu9t5v0__dffrnq_1
XTAP_TAPCELL_ROW_37_1994 VSS VSS gf180mcu_fd_sc_mcu9t5v0__filltie
X_16855_ _19255_/Q _16647_/B _16861_/S _16855_/Z VSS VSS VSS VSS gf180mcu_fd_sc_mcu9t5v0__mux2_1
XTAP_TAPCELL_ROW_122_4343 VSS VSS gf180mcu_fd_sc_mcu9t5v0__filltie
XTAP_TAPCELL_ROW_122_4332 VSS VSS gf180mcu_fd_sc_mcu9t5v0__filltie
X_19643_ _19643_/D _19963_/RN clkload9/I _19643_/Q VSS VSS VSS VSS gf180mcu_fd_sc_mcu9t5v0__dffrnq_1
XTAP_TAPCELL_ROW_316_7765 VSS VSS gf180mcu_fd_sc_mcu9t5v0__filltie
XTAP_TAPCELL_ROW_316_7754 VSS VSS gf180mcu_fd_sc_mcu9t5v0__filltie
XTAP_TAPCELL_ROW_291_7069 VSS VSS gf180mcu_fd_sc_mcu9t5v0__filltie
X_15806_ wire300/Z _19975_/Q _15811_/S _19975_/D VSS VSS VSS VSS gf180mcu_fd_sc_mcu9t5v0__mux2_1
X_16786_ _16785_/Z _18392_/Q _16786_/S _18392_/D VSS VSS VSS VSS gf180mcu_fd_sc_mcu9t5v0__mux2_1
X_19574_ _19574_/D _20022_/RN clkload17/I _19574_/Q VSS VSS VSS VSS gf180mcu_fd_sc_mcu9t5v0__dffrnq_1
X_13998_ _13954_/Z _14032_/A2 _14033_/A1 VSS VSS VSS VSS gf180mcu_fd_sc_mcu9t5v0__xnor2_1
X_18525_ _18525_/D clkload61/I _18525_/Q VSS VSS VSS VSS gf180mcu_fd_sc_mcu9t5v0__dffq_1
X_15737_ _19924_/Q _19925_/Q _15737_/A3 _15738_/A2 VSS _15737_/VNW VSS VSS gf180mcu_fd_sc_mcu9t5v0__nor3_1
X_12949_ _19781_/Q _12949_/A2 _12948_/Z _12950_/I0 VSS VSS VSS VSS gf180mcu_fd_sc_mcu9t5v0__xnor3_1
X_18456_ _18456_/D clkload78/I _18456_/Q VSS VSS VSS VSS gf180mcu_fd_sc_mcu9t5v0__dffq_1
XTAP_TAPCELL_ROW_135_4715 VSS VSS gf180mcu_fd_sc_mcu9t5v0__filltie
XTAP_TAPCELL_ROW_135_4704 VSS VSS gf180mcu_fd_sc_mcu9t5v0__filltie
X_15668_ _19908_/Q _19909_/Q _15668_/A3 _15668_/Z VSS VSS VSS VSS gf180mcu_fd_sc_mcu9t5v0__or3_1
X_17407_ _17406_/C _17407_/A2 _17407_/B1 _17407_/B2 _17407_/C _17408_/C VSS VSS VSS
+ VSS gf180mcu_fd_sc_mcu9t5v0__aoi221_1
XPHY_EDGE_ROW_154_2_Right_885 VSS VSS gf180mcu_fd_sc_mcu9t5v0__endcap
XTAP_TAPCELL_ROW_135_4737 VSS VSS gf180mcu_fd_sc_mcu9t5v0__filltie
XTAP_TAPCELL_ROW_135_4726 VSS VSS gf180mcu_fd_sc_mcu9t5v0__filltie
X_14619_ _19080_/Q _19497_/Q _14730_/S _19497_/D VSS VSS VSS VSS gf180mcu_fd_sc_mcu9t5v0__mux2_1
X_18387_ _18387_/D clkload67/I _18387_/Q VSS VSS VSS VSS gf180mcu_fd_sc_mcu9t5v0__dffq_1
X_15599_ _15629_/A1 _10201_/B _15677_/B _15629_/B VSS VSS VSS VSS gf180mcu_fd_sc_mcu9t5v0__oai21_1
XTAP_TAPCELL_ROW_77_3110 VSS VSS gf180mcu_fd_sc_mcu9t5v0__filltie
X_17338_ _17260_/S _18405_/Q _17340_/A3 VSS _17339_/VNW VSS VSS gf180mcu_fd_sc_mcu9t5v0__nor2_1
XTAP_TAPCELL_ROW_116_4169 VSS VSS gf180mcu_fd_sc_mcu9t5v0__filltie
X_17269_ _17411_/C _17269_/A2 _17269_/A3 _17270_/A2 VSS _17327_/VNW VSS VSS gf180mcu_fd_sc_mcu9t5v0__nand3_1
X_19008_ _19008_/D _09246_/I clkload38/I _19008_/Q VSS VSS VSS VSS gf180mcu_fd_sc_mcu9t5v0__dffrnq_1
Xclkbuf_leaf_69_clk_regs clkload2/I clkload45/I VSS VSS VSS VSS gf180mcu_fd_sc_mcu9t5v0__clkbuf_8
XTAP_TAPCELL_ROW_280_6784 VSS VSS gf180mcu_fd_sc_mcu9t5v0__filltie
XTAP_TAPCELL_ROW_280_6773 VSS VSS gf180mcu_fd_sc_mcu9t5v0__filltie
XTAP_TAPCELL_ROW_280_6762 VSS VSS gf180mcu_fd_sc_mcu9t5v0__filltie
XTAP_TAPCELL_ROW_129_4519 VSS VSS gf180mcu_fd_sc_mcu9t5v0__filltie
Xu_transform_scheduler_core.u_fft_scratch_sram.u_hi.u_sram u_transform_scheduler_core.u_fft_scratch_sram.u_hi.u_sram/A[7]
+ u_transform_scheduler_core.u_fft_scratch_sram.u_hi.u_sram/A[6] u_transform_scheduler_core.u_fft_scratch_sram.u_hi.u_sram/A[5]
+ u_transform_scheduler_core.u_fft_scratch_sram.u_hi.u_sram/A[4] u_transform_scheduler_core.u_fft_scratch_sram.u_hi.u_sram/A[3]
+ u_transform_scheduler_core.u_fft_scratch_sram.u_hi.u_sram/A[2] u_transform_scheduler_core.u_fft_scratch_sram.u_hi.u_sram/A[1]
+ u_transform_scheduler_core.u_fft_scratch_sram.u_hi.u_sram/A[0] u_transform_scheduler_core.u_fft_scratch_sram.u_hi.u_sram/CEN
+ clkbuf_1_1__f_clk/Z u_transform_scheduler_core.u_fft_scratch_sram.u_hi.u_sram/D[7]
+ u_transform_scheduler_core.u_fft_scratch_sram.u_hi.u_sram/D[6] u_transform_scheduler_core.u_fft_scratch_sram.u_hi.u_sram/D[5]
+ u_transform_scheduler_core.u_fft_scratch_sram.u_hi.u_sram/D[4] u_transform_scheduler_core.u_fft_scratch_sram.u_hi.u_sram/D[3]
+ u_transform_scheduler_core.u_fft_scratch_sram.u_hi.u_sram/D[2] u_transform_scheduler_core.u_fft_scratch_sram.u_hi.u_sram/D[1]
+ u_transform_scheduler_core.u_fft_scratch_sram.u_hi.u_sram/D[0] u_transform_scheduler_core.u_fft_scratch_sram.u_hi.u_sram/GWEN
+ _15581_/B _18036_/I0 _18035_/I0 _18034_/I0 _18033_/I0 _18032_/I0 _18031_/I0 _18030_/I0
+ VSS VSS u_transform_scheduler_core.u_fft_scratch_sram.u_hi.u_sram/GWEN u_transform_scheduler_core.u_fft_scratch_sram.u_hi.u_sram/GWEN
+ u_transform_scheduler_core.u_fft_scratch_sram.u_hi.u_sram/GWEN u_transform_scheduler_core.u_fft_scratch_sram.u_hi.u_sram/GWEN
+ u_transform_scheduler_core.u_fft_scratch_sram.u_hi.u_sram/GWEN u_transform_scheduler_core.u_fft_scratch_sram.u_hi.u_sram/GWEN
+ u_transform_scheduler_core.u_fft_scratch_sram.u_hi.u_sram/GWEN u_transform_scheduler_core.u_fft_scratch_sram.u_hi.u_sram/GWEN
+ gf180mcu_fd_ip_sram__sram256x8m8wm1
XTAP_TAPCELL_ROW_274_6599 VSS VSS gf180mcu_fd_sc_mcu9t5v0__filltie
XTAP_TAPCELL_ROW_105_3873 VSS VSS gf180mcu_fd_sc_mcu9t5v0__filltie
XTAP_TAPCELL_ROW_105_3862 VSS VSS gf180mcu_fd_sc_mcu9t5v0__filltie
X_09525_ wire174/I _09525_/A2 _09849_/B VSS VSS VSS VSS gf180mcu_fd_sc_mcu9t5v0__nand2_2
XTAP_TAPCELL_ROW_0_954 VSS VSS gf180mcu_fd_sc_mcu9t5v0__filltie
XTAP_TAPCELL_ROW_0_943 VSS VSS gf180mcu_fd_sc_mcu9t5v0__filltie
XTAP_TAPCELL_ROW_0_965 VSS VSS gf180mcu_fd_sc_mcu9t5v0__filltie
XTAP_TAPCELL_ROW_62_2700 VSS VSS gf180mcu_fd_sc_mcu9t5v0__filltie
XTAP_TAPCELL_ROW_101_3748 VSS VSS gf180mcu_fd_sc_mcu9t5v0__filltie
XTAP_TAPCELL_ROW_101_3759 VSS VSS gf180mcu_fd_sc_mcu9t5v0__filltie
X_09456_ _19193_/Q _09454_/Z _12729_/A2 VSS VSS VSS VSS gf180mcu_fd_sc_mcu9t5v0__nand2_4
XTAP_TAPCELL_ROW_0_976 VSS VSS gf180mcu_fd_sc_mcu9t5v0__filltie
XTAP_TAPCELL_ROW_0_987 VSS VSS gf180mcu_fd_sc_mcu9t5v0__filltie
XTAP_TAPCELL_ROW_43_2154 VSS VSS gf180mcu_fd_sc_mcu9t5v0__filltie
X_09387_ _20118_/Q _17306_/A1 VSS _16646_/VNW VSS VSS gf180mcu_fd_sc_mcu9t5v0__clkinv_1
XTAP_TAPCELL_ROW_43_2165 VSS VSS gf180mcu_fd_sc_mcu9t5v0__filltie
XTAP_TAPCELL_ROW_43_2176 VSS VSS gf180mcu_fd_sc_mcu9t5v0__filltie
XPHY_EDGE_ROW_142_3_Right_257 VSS VSS gf180mcu_fd_sc_mcu9t5v0__endcap
X_10300_ _17278_/C _10300_/A2 _10300_/B _10300_/C _10301_/A2 VSS _11126_/VNW VSS VSS
+ gf180mcu_fd_sc_mcu9t5v0__oai211_1
XTAP_TAPCELL_ROW_227_5322 VSS VSS gf180mcu_fd_sc_mcu9t5v0__filltie
XTAP_TAPCELL_ROW_227_5311 VSS VSS gf180mcu_fd_sc_mcu9t5v0__filltie
X_11280_ wire283/Z _11280_/A2 _11280_/B1 _11280_/B2 _12071_/B _11281_/B2 VSS VSS VSS
+ VSS gf180mcu_fd_sc_mcu9t5v0__aoi221_2
XTAP_TAPCELL_ROW_227_5300 VSS VSS gf180mcu_fd_sc_mcu9t5v0__filltie
XTAP_TAPCELL_ROW_56_2515 VSS VSS gf180mcu_fd_sc_mcu9t5v0__filltie
XTAP_TAPCELL_ROW_56_2526 VSS VSS gf180mcu_fd_sc_mcu9t5v0__filltie
X_10231_ _18153_/Q _17282_/A2 _17282_/B1 _18169_/Q _10232_/B VSS _10231_/VNW VSS VSS
+ gf180mcu_fd_sc_mcu9t5v0__aoi22_1
XTAP_TAPCELL_ROW_223_5208 VSS VSS gf180mcu_fd_sc_mcu9t5v0__filltie
X_10162_ _10162_/A1 _10162_/A2 _10163_/A2 VSS _10162_/VNW VSS VSS gf180mcu_fd_sc_mcu9t5v0__nand2_1
X_10093_ _19217_/Q wire172/Z _09998_/C _19233_/Q _10094_/A2 VSS _10116_/VNW VSS VSS
+ gf180mcu_fd_sc_mcu9t5v0__aoi22_1
X_14970_ _19617_/Q _20039_/D _14975_/B VSS VSS VSS VSS gf180mcu_fd_sc_mcu9t5v0__nor2_1
X_13921_ _13921_/A1 _13921_/A2 _13921_/B _13940_/A2 VSS VSS VSS VSS gf180mcu_fd_sc_mcu9t5v0__oai21_1
X_16640_ _19254_/Q _16751_/A2 wire71/Z _16642_/A2 VSS VSS VSS VSS gf180mcu_fd_sc_mcu9t5v0__nor3_1
X_13852_ _13873_/B2 _13851_/Z _13896_/A1 VSS _15226_/VNW VSS VSS gf180mcu_fd_sc_mcu9t5v0__xnor2_1
X_16571_ _16602_/S _16571_/A2 _16571_/B _18345_/D VSS _16571_/VNW VSS VSS gf180mcu_fd_sc_mcu9t5v0__aoi21_4
X_12803_ _19759_/Q _12801_/Z _12810_/B VSS VSS VSS VSS gf180mcu_fd_sc_mcu9t5v0__nand2_1
X_13783_ _13783_/A1 _13803_/B1 _13784_/B VSS VSS VSS VSS gf180mcu_fd_sc_mcu9t5v0__xor2_1
X_18310_ _18310_/D clkload81/I _18310_/Q VSS VSS VSS VSS gf180mcu_fd_sc_mcu9t5v0__dffq_1
X_15522_ _15566_/A1 _15522_/A2 _15521_/Z _19844_/D VSS VSS VSS VSS gf180mcu_fd_sc_mcu9t5v0__nor3_1
X_10995_ _10953_/Z _10995_/A2 _18049_/B _10995_/Z VSS VSS VSS VSS gf180mcu_fd_sc_mcu9t5v0__xor3_1
X_19290_ _19290_/D _20058_/RN _19680_/CLK _19290_/Q VSS VSS VSS VSS gf180mcu_fd_sc_mcu9t5v0__dffrnq_1
X_12734_ _12843_/A1 _19716_/Q _12734_/Z VSS VSS VSS VSS gf180mcu_fd_sc_mcu9t5v0__or2_1
X_18241_ _18241_/D clkload70/I _18241_/Q VSS VSS VSS VSS gf180mcu_fd_sc_mcu9t5v0__dffq_1
X_15453_ _15436_/Z _15459_/A2 _15453_/A3 _15453_/B _19820_/D VSS _15453_/VNW VSS VSS
+ gf180mcu_fd_sc_mcu9t5v0__oai31_1
XTAP_TAPCELL_ROW_212_4901 VSS VSS gf180mcu_fd_sc_mcu9t5v0__filltie
XPHY_EDGE_ROW_153_1_Right_737 VSS VSS gf180mcu_fd_sc_mcu9t5v0__endcap
X_12665_ _11656_/B _12675_/B _12665_/B _12666_/A2 VSS VSS VSS VSS gf180mcu_fd_sc_mcu9t5v0__oai21_1
XTAP_TAPCELL_ROW_212_4912 VSS VSS gf180mcu_fd_sc_mcu9t5v0__filltie
X_18172_ _18172_/D clkload64/I _18172_/Q VSS VSS VSS VSS gf180mcu_fd_sc_mcu9t5v0__dffq_4
X_12596_ _12620_/A1 _12620_/A2 _12596_/A3 _12596_/B _19170_/D VSS VSS VSS VSS gf180mcu_fd_sc_mcu9t5v0__oai31_1
X_15384_ _19669_/Q _19769_/Q _15417_/S _19769_/D VSS _15384_/VNW VSS VSS gf180mcu_fd_sc_mcu9t5v0__mux2_1
XTAP_TAPCELL_ROW_26_1684 VSS VSS gf180mcu_fd_sc_mcu9t5v0__filltie
X_11616_ _11659_/A1 _12634_/A2 _12661_/A2 VSS VSS VSS VSS gf180mcu_fd_sc_mcu9t5v0__nand2_1
XTAP_TAPCELL_ROW_26_1695 VSS VSS gf180mcu_fd_sc_mcu9t5v0__filltie
X_14404_ wire199/Z _14404_/A2 _14405_/C VSS _14404_/VNW VSS VSS gf180mcu_fd_sc_mcu9t5v0__nand2_1
XTAP_TAPCELL_ROW_309_7580 VSS VSS gf180mcu_fd_sc_mcu9t5v0__filltie
X_17123_ _17260_/S _18523_/Q _17125_/A3 VSS VSS VSS VSS gf180mcu_fd_sc_mcu9t5v0__nor2_1
X_11547_ _18567_/Q _11547_/A2 _11547_/B _12181_/A2 VSS _15979_/VNW VSS VSS gf180mcu_fd_sc_mcu9t5v0__aoi21_4
XTAP_TAPCELL_ROW_111_4022 VSS VSS gf180mcu_fd_sc_mcu9t5v0__filltie
X_14335_ _14365_/I0 _19407_/Q _14337_/S _19407_/D VSS VSS VSS VSS gf180mcu_fd_sc_mcu9t5v0__mux2_1
XTAP_TAPCELL_ROW_305_7455 VSS VSS gf180mcu_fd_sc_mcu9t5v0__filltie
X_17054_ _17053_/Z _18518_/Q _17054_/S _18518_/D VSS VSS VSS VSS gf180mcu_fd_sc_mcu9t5v0__mux2_4
Xmax_cap217 _11706_/B _11988_/B VSS _09391_/VNW VSS VSS gf180mcu_fd_sc_mcu9t5v0__buf_4
XTAP_TAPCELL_ROW_111_4044 VSS VSS gf180mcu_fd_sc_mcu9t5v0__filltie
XTAP_TAPCELL_ROW_111_4033 VSS VSS gf180mcu_fd_sc_mcu9t5v0__filltie
XTAP_TAPCELL_ROW_305_7466 VSS VSS gf180mcu_fd_sc_mcu9t5v0__filltie
X_16005_ _16005_/A1 _16005_/A2 _16005_/B _18153_/D VSS VSS VSS VSS gf180mcu_fd_sc_mcu9t5v0__oai21_1
X_11478_ _18886_/Q _11878_/A1 _11490_/A2 VSS VSS VSS VSS gf180mcu_fd_sc_mcu9t5v0__nor2_1
X_14266_ _14322_/I0 _19341_/Q _14266_/S _19341_/D VSS VSS VSS VSS gf180mcu_fd_sc_mcu9t5v0__mux2_1
X_10429_ _17378_/A1 _18256_/Q _10432_/A2 VSS _12196_/VNW VSS VSS gf180mcu_fd_sc_mcu9t5v0__nor2_1
XTAP_TAPCELL_ROW_297_7245 VSS VSS gf180mcu_fd_sc_mcu9t5v0__filltie
XTAP_TAPCELL_ROW_297_7234 VSS VSS gf180mcu_fd_sc_mcu9t5v0__filltie
XPHY_EDGE_ROW_249_Right_176 VSS VSS gf180mcu_fd_sc_mcu9t5v0__endcap
X_13217_ _16436_/A1 _13497_/B _13217_/B1 _13217_/B2 _19242_/D VSS _13227_/VNW VSS
+ VSS gf180mcu_fd_sc_mcu9t5v0__aoi22_1
X_14197_ _14198_/A1 _14198_/A2 _14221_/B VSS _14197_/VNW VSS VSS gf180mcu_fd_sc_mcu9t5v0__nor2_1
X_13148_ _13184_/A1 _13148_/A2 _13419_/B _13149_/B2 VSS _13149_/VNW VSS VSS gf180mcu_fd_sc_mcu9t5v0__aoi21_1
XTAP_TAPCELL_ROW_318_7827 VSS VSS gf180mcu_fd_sc_mcu9t5v0__filltie
XTAP_TAPCELL_ROW_318_7816 VSS VSS gf180mcu_fd_sc_mcu9t5v0__filltie
XTAP_TAPCELL_ROW_318_7805 VSS VSS gf180mcu_fd_sc_mcu9t5v0__filltie
XTAP_TAPCELL_ROW_124_4405 VSS VSS gf180mcu_fd_sc_mcu9t5v0__filltie
X_13079_ _13104_/A1 _13079_/A2 _13534_/A1 VSS _13538_/VNW VSS VSS gf180mcu_fd_sc_mcu9t5v0__nand2_1
X_17956_ _17889_/I _17956_/A2 _17956_/B _18855_/D VSS VSS VSS VSS gf180mcu_fd_sc_mcu9t5v0__oai21_1
XPHY_EDGE_ROW_295_Right_222 VSS VSS gf180mcu_fd_sc_mcu9t5v0__endcap
X_16907_ _16606_/B _19249_/Q _16925_/S _16907_/Z VSS VSS VSS VSS gf180mcu_fd_sc_mcu9t5v0__mux2_1
X_17887_ _17887_/I _17913_/A1 VSS VSS VSS VSS gf180mcu_fd_sc_mcu9t5v0__clkinv_1
X_16838_ _18411_/Q _16837_/Z _16850_/S _18411_/D VSS VSS VSS VSS gf180mcu_fd_sc_mcu9t5v0__mux2_4
XPHY_EDGE_ROW_162_2_Left_674 VSS VSS gf180mcu_fd_sc_mcu9t5v0__endcap
X_19626_ _19626_/D _20138_/RN clkload9/I _19626_/Q VSS VSS VSS VSS gf180mcu_fd_sc_mcu9t5v0__dffrnq_1
X_16769_ _16622_/B _19283_/Q _16783_/S _16769_/Z VSS VSS VSS VSS gf180mcu_fd_sc_mcu9t5v0__mux2_1
X_19557_ _19557_/D _20069_/RN clkload16/I _19557_/Q VSS VSS VSS VSS gf180mcu_fd_sc_mcu9t5v0__dffrnq_1
X_18508_ _18508_/D _20129_/CLK _18508_/Q VSS VSS VSS VSS gf180mcu_fd_sc_mcu9t5v0__dffq_1
X_09310_ _19993_/Q _15829_/B2 VSS VSS VSS VSS gf180mcu_fd_sc_mcu9t5v0__clkinv_1
X_19488_ _19488_/D _20064_/RN clkload14/I _19488_/Q VSS VSS VSS VSS gf180mcu_fd_sc_mcu9t5v0__dffrnq_1
X_18439_ _18439_/D clkload79/I _18439_/Q VSS VSS VSS VSS gf180mcu_fd_sc_mcu9t5v0__dffq_1
X_09241_ _18788_/Q _15952_/I1 VSS VSS VSS VSS gf180mcu_fd_sc_mcu9t5v0__clkinv_1
XPHY_EDGE_ROW_155_2_Right_886 VSS VSS gf180mcu_fd_sc_mcu9t5v0__endcap
X_09172_ _19111_/Q _13706_/A2 VSS VSS VSS VSS gf180mcu_fd_sc_mcu9t5v0__clkinv_1
XTAP_TAPCELL_ROW_282_6835 VSS VSS gf180mcu_fd_sc_mcu9t5v0__filltie
XTAP_TAPCELL_ROW_282_6824 VSS VSS gf180mcu_fd_sc_mcu9t5v0__filltie
XTAP_TAPCELL_ROW_282_6813 VSS VSS gf180mcu_fd_sc_mcu9t5v0__filltie
Xoutput18 output18/I dout[7] VSS VSS VSS VSS gf180mcu_fd_sc_mcu9t5v0__dlyd_1
XPHY_EDGE_ROW_216_Right_143 VSS VSS gf180mcu_fd_sc_mcu9t5v0__endcap
XTAP_TAPCELL_ROW_107_3935 VSS VSS gf180mcu_fd_sc_mcu9t5v0__filltie
XTAP_TAPCELL_ROW_107_3924 VSS VSS gf180mcu_fd_sc_mcu9t5v0__filltie
XTAP_TAPCELL_ROW_107_3913 VSS VSS gf180mcu_fd_sc_mcu9t5v0__filltie
XTAP_TAPCELL_ROW_49_2330 VSS VSS gf180mcu_fd_sc_mcu9t5v0__filltie
XTAP_TAPCELL_ROW_49_2341 VSS VSS gf180mcu_fd_sc_mcu9t5v0__filltie
XTAP_TAPCELL_ROW_216_5001 VSS VSS gf180mcu_fd_sc_mcu9t5v0__filltie
XTAP_TAPCELL_ROW_45_2216 VSS VSS gf180mcu_fd_sc_mcu9t5v0__filltie
XTAP_TAPCELL_ROW_216_5023 VSS VSS gf180mcu_fd_sc_mcu9t5v0__filltie
XTAP_TAPCELL_ROW_216_5012 VSS VSS gf180mcu_fd_sc_mcu9t5v0__filltie
XTAP_TAPCELL_ROW_45_2227 VSS VSS gf180mcu_fd_sc_mcu9t5v0__filltie
X_09508_ _19123_/Q _14730_/S _09511_/B _12010_/A1 VSS _12012_/VNW VSS VSS gf180mcu_fd_sc_mcu9t5v0__aoi21_4
X_10780_ _10797_/A1 _10797_/A2 _10785_/A2 VSS VSS VSS VSS gf180mcu_fd_sc_mcu9t5v0__xnor2_1
X_09439_ _19992_/Q _15829_/B2 _10057_/A1 VSS VSS VSS VSS gf180mcu_fd_sc_mcu9t5v0__nand2_1
XTAP_TAPCELL_ROW_252_5993 VSS VSS gf180mcu_fd_sc_mcu9t5v0__filltie
X_12450_ _12616_/B _12450_/A2 _12450_/A3 _12450_/B1 _12450_/B2 wire281/I VSS VSS VSS
+ VSS gf180mcu_fd_sc_mcu9t5v0__oai32_1
X_11401_ _11401_/A1 _11401_/A2 _11521_/B _11401_/C _11402_/B VSS VSS VSS VSS gf180mcu_fd_sc_mcu9t5v0__oai211_1
XPHY_EDGE_ROW_143_3_Right_258 VSS VSS gf180mcu_fd_sc_mcu9t5v0__endcap
X_14120_ _14120_/A1 _19323_/Q _14192_/A2 VSS _14120_/VNW VSS VSS gf180mcu_fd_sc_mcu9t5v0__nand2_1
X_12381_ _19144_/Q _12355_/I _12386_/B VSS _12381_/VNW VSS VSS gf180mcu_fd_sc_mcu9t5v0__nand2_1
X_11332_ _18521_/Q _18505_/Q _18489_/Q _18473_/Q _11334_/A2 wire136/I _11332_/Z VSS
+ VSS VSS VSS gf180mcu_fd_sc_mcu9t5v0__mux4_1
XTAP_TAPCELL_ROW_21_1570 VSS VSS gf180mcu_fd_sc_mcu9t5v0__filltie
X_11263_ _18292_/Q _11509_/A2 _11510_/B _11265_/A2 VSS VSS VSS VSS gf180mcu_fd_sc_mcu9t5v0__oai21_1
X_14051_ _14051_/A1 _14049_/Z _14053_/A2 VSS _14090_/VNW VSS VSS gf180mcu_fd_sc_mcu9t5v0__xnor2_1
XTAP_TAPCELL_ROW_300_7330 VSS VSS gf180mcu_fd_sc_mcu9t5v0__filltie
X_11194_ _18191_/Q _11509_/A2 _11428_/B _11194_/C _11196_/B1 VSS VSS VSS VSS gf180mcu_fd_sc_mcu9t5v0__oai211_1
X_10214_ _15552_/A1 _10724_/C _15544_/S _20052_/D VSS VSS VSS VSS gf180mcu_fd_sc_mcu9t5v0__nor3_1
X_13002_ _12985_/Z _13003_/A2 _13511_/B _13010_/A1 VSS VSS VSS VSS gf180mcu_fd_sc_mcu9t5v0__nor3_1
X_10145_ _19259_/Q wire285/Z _10169_/B1 _19243_/Q _10175_/A2 VSS VSS VSS VSS gf180mcu_fd_sc_mcu9t5v0__aoi22_1
X_17810_ _18788_/Q _18767_/Q _18769_/D _18788_/D VSS _17810_/VNW VSS VSS gf180mcu_fd_sc_mcu9t5v0__mux2_1
XTAP_TAPCELL_ROW_34_1920 VSS VSS gf180mcu_fd_sc_mcu9t5v0__filltie
XTAP_TAPCELL_ROW_34_1931 VSS VSS gf180mcu_fd_sc_mcu9t5v0__filltie
X_18790_ _18790_/D _20070_/RN _20049_/CLK _18790_/Q VSS VSS VSS VSS gf180mcu_fd_sc_mcu9t5v0__dffrnq_1
X_10076_ _19224_/Q _09898_/C wire297/Z _19248_/Q _10078_/A1 VSS VSS VSS VSS gf180mcu_fd_sc_mcu9t5v0__aoi22_1
X_17741_ _17570_/B _17681_/S _17741_/B _18746_/D VSS VSS VSS VSS gf180mcu_fd_sc_mcu9t5v0__oai21_1
XTAP_TAPCELL_ROW_30_1806 VSS VSS gf180mcu_fd_sc_mcu9t5v0__filltie
XTAP_TAPCELL_ROW_30_1817 VSS VSS gf180mcu_fd_sc_mcu9t5v0__filltie
X_14953_ _19425_/Q _19370_/Q _14957_/A2 VSS VSS VSS VSS gf180mcu_fd_sc_mcu9t5v0__nor2_1
X_17672_ _18635_/Q _18711_/Q _17742_/S _18711_/D VSS _17672_/VNW VSS VSS gf180mcu_fd_sc_mcu9t5v0__mux2_1
X_14884_ _15148_/S _14884_/A2 _14884_/B _19593_/D VSS VSS VSS VSS gf180mcu_fd_sc_mcu9t5v0__aoi21_1
X_13904_ _13906_/A1 _13906_/A2 _13904_/Z VSS VSS VSS VSS gf180mcu_fd_sc_mcu9t5v0__xor2_1
XTAP_TAPCELL_ROW_15_1385 VSS VSS gf180mcu_fd_sc_mcu9t5v0__filltie
XTAP_TAPCELL_ROW_15_1396 VSS VSS gf180mcu_fd_sc_mcu9t5v0__filltie
X_16623_ _19251_/Q _16744_/A2 wire71/Z _16624_/A3 VSS VSS VSS VSS gf180mcu_fd_sc_mcu9t5v0__nor3_1
X_19411_ _19411_/D _20051_/RN clkload7/I _19411_/Q VSS VSS VSS VSS gf180mcu_fd_sc_mcu9t5v0__dffrnq_1
X_13835_ _19307_/Q _14359_/I0 _14139_/S _19307_/D VSS VSS VSS VSS gf180mcu_fd_sc_mcu9t5v0__mux2_1
Xmax_cap60 _16741_/A1 _16747_/A3 VSS VSS VSS VSS gf180mcu_fd_sc_mcu9t5v0__clkbuf_8
Xmax_cap93 _16744_/A2 _16751_/A2 VSS VSS VSS VSS gf180mcu_fd_sc_mcu9t5v0__clkbuf_8
X_16554_ _18337_/Q _16058_/B _17069_/S _18337_/D VSS _16554_/VNW VSS VSS gf180mcu_fd_sc_mcu9t5v0__mux2_1
X_10978_ _10977_/Z _19013_/Q _18148_/S _19013_/D VSS _10978_/VNW VSS VSS gf180mcu_fd_sc_mcu9t5v0__mux2_1
X_13766_ _13803_/A1 _13803_/A2 _13782_/A1 VSS VSS VSS VSS gf180mcu_fd_sc_mcu9t5v0__nor2_1
XTAP_TAPCELL_ROW_28_1746 VSS VSS gf180mcu_fd_sc_mcu9t5v0__filltie
X_19342_ _19342_/D _20046_/RN clkload7/I _19342_/Q VSS VSS VSS VSS gf180mcu_fd_sc_mcu9t5v0__dffrnq_1
X_15505_ _15505_/A1 _15512_/A1 _15506_/A3 VSS _15506_/VNW VSS VSS gf180mcu_fd_sc_mcu9t5v0__nand2_1
X_16485_ _19231_/Q _16131_/B _17003_/S _16485_/Z VSS VSS VSS VSS gf180mcu_fd_sc_mcu9t5v0__mux2_1
X_19273_ _19273_/D _20041_/RN clkload42/I _19273_/Q VSS VSS VSS VSS gf180mcu_fd_sc_mcu9t5v0__dffrnq_1
X_13697_ _13697_/A1 _13697_/A2 _13704_/A2 VSS VSS VSS VSS gf180mcu_fd_sc_mcu9t5v0__nand2_1
X_12717_ _12724_/A2 _12716_/Z _12718_/A2 VSS _12717_/VNW VSS VSS gf180mcu_fd_sc_mcu9t5v0__xnor2_1
XTAP_TAPCELL_ROW_28_1757 VSS VSS gf180mcu_fd_sc_mcu9t5v0__filltie
XPHY_EDGE_ROW_318_Right_245 VSS VSS gf180mcu_fd_sc_mcu9t5v0__endcap
X_18224_ _18224_/D clkload73/I _18224_/Q VSS VSS VSS VSS gf180mcu_fd_sc_mcu9t5v0__dffq_1
XTAP_TAPCELL_ROW_307_7506 VSS VSS gf180mcu_fd_sc_mcu9t5v0__filltie
X_15436_ _19819_/Q _19818_/Q _19820_/Q _15436_/Z VSS _15453_/VNW VSS VSS gf180mcu_fd_sc_mcu9t5v0__and3_1
XPHY_EDGE_ROW_154_1_Right_738 VSS VSS gf180mcu_fd_sc_mcu9t5v0__endcap
X_12648_ _11656_/B _11649_/B _12648_/B _12650_/A2 VSS VSS VSS VSS gf180mcu_fd_sc_mcu9t5v0__aoi21_1
XTAP_TAPCELL_ROW_307_7517 VSS VSS gf180mcu_fd_sc_mcu9t5v0__filltie
X_18155_ _18155_/D clkload63/I _18155_/Q VSS VSS VSS VSS gf180mcu_fd_sc_mcu9t5v0__dffq_1
X_17106_ _18474_/Q _17322_/A2 _17255_/B1 _18490_/Q _17275_/C _17107_/B VSS VSS VSS
+ VSS gf180mcu_fd_sc_mcu9t5v0__aoi221_1
X_12579_ _19168_/Q _12620_/A1 _12580_/B VSS _12580_/VNW VSS VSS gf180mcu_fd_sc_mcu9t5v0__nand2_1
X_15367_ _19652_/Q _19752_/Q _15417_/S _19752_/D VSS VSS VSS VSS gf180mcu_fd_sc_mcu9t5v0__mux2_1
Xwire281 wire281/I wire281/Z VSS wire281/VNW VSS VSS gf180mcu_fd_sc_mcu9t5v0__clkbuf_2
XPHY_EDGE_ROW_260_Right_187 VSS VSS gf180mcu_fd_sc_mcu9t5v0__endcap
X_18086_ _18097_/A1 _18086_/A2 _18086_/B _18933_/D VSS VSS VSS VSS gf180mcu_fd_sc_mcu9t5v0__oai21_1
X_15298_ _19637_/Q _19614_/Q _15304_/B VSS _15298_/VNW VSS VSS gf180mcu_fd_sc_mcu9t5v0__nand2_1
X_14318_ _14367_/I0 _19391_/Q _14322_/S _19391_/D VSS VSS VSS VSS gf180mcu_fd_sc_mcu9t5v0__mux2_1
X_17037_ _16606_/B _19249_/Q _17055_/S _17037_/Z VSS VSS VSS VSS gf180mcu_fd_sc_mcu9t5v0__mux2_1
XTAP_TAPCELL_ROW_91_3482 VSS VSS gf180mcu_fd_sc_mcu9t5v0__filltie
X_14249_ _14115_/Z _14249_/A2 _14251_/A2 VSS VSS VSS VSS gf180mcu_fd_sc_mcu9t5v0__xnor2_1
XTAP_TAPCELL_ROW_91_3493 VSS VSS gf180mcu_fd_sc_mcu9t5v0__filltie
X_18988_ _18988_/D _20140_/RN _20099_/CLK _18988_/Q VSS VSS VSS VSS gf180mcu_fd_sc_mcu9t5v0__dffrnq_1
X_09790_ _09784_/Z _09790_/A2 _09793_/B VSS VSS VSS VSS gf180mcu_fd_sc_mcu9t5v0__nand2_1
Xload_slew286 _10216_/ZN _17243_/A1 VSS VSS VSS VSS gf180mcu_fd_sc_mcu9t5v0__clkbuf_4
X_17939_ _17939_/A1 _17938_/Z _18850_/D VSS VSS VSS VSS gf180mcu_fd_sc_mcu9t5v0__nor2_1
XTAP_TAPCELL_ROW_271_6514 VSS VSS gf180mcu_fd_sc_mcu9t5v0__filltie
XTAP_TAPCELL_ROW_137_3_8003 VSS VSS gf180mcu_fd_sc_mcu9t5v0__filltie
XTAP_TAPCELL_ROW_271_6536 VSS VSS gf180mcu_fd_sc_mcu9t5v0__filltie
XTAP_TAPCELL_ROW_271_6525 VSS VSS gf180mcu_fd_sc_mcu9t5v0__filltie
X_19609_ _19609_/D _20057_/RN _19633_/CLK _19609_/Q VSS VSS VSS VSS gf180mcu_fd_sc_mcu9t5v0__dffrnq_1
XPHY_EDGE_ROW_5_Right_5 VSS VSS gf180mcu_fd_sc_mcu9t5v0__endcap
XTAP_TAPCELL_ROW_269_6465 VSS VSS gf180mcu_fd_sc_mcu9t5v0__filltie
Xclkbuf_leaf_84_clk_regs clkbuf_3_0_0_clk_regs/Z clkload19/I VSS VSS VSS VSS gf180mcu_fd_sc_mcu9t5v0__clkbuf_8
X_09224_ _19601_/Q _15263_/A1 VSS VSS VSS VSS gf180mcu_fd_sc_mcu9t5v0__clkinv_1
XTAP_TAPCELL_ROW_98_3669 VSS VSS gf180mcu_fd_sc_mcu9t5v0__filltie
XTAP_TAPCELL_ROW_269_6476 VSS VSS gf180mcu_fd_sc_mcu9t5v0__filltie
Xclkbuf_leaf_13_clk_regs clkload3/I _20049_/CLK VSS VSS VSS VSS gf180mcu_fd_sc_mcu9t5v0__clkbuf_8
XPHY_EDGE_ROW_156_2_Right_887 VSS VSS gf180mcu_fd_sc_mcu9t5v0__endcap
X_09155_ _19807_/Q _13343_/A2 VSS VSS VSS VSS gf180mcu_fd_sc_mcu9t5v0__clkinv_1
X_09086_ _18827_/Q _17861_/B2 VSS VSS VSS VSS gf180mcu_fd_sc_mcu9t5v0__clkinv_1
XTAP_TAPCELL_ROW_38_2020 VSS VSS gf180mcu_fd_sc_mcu9t5v0__filltie
XTAP_TAPCELL_ROW_38_2031 VSS VSS gf180mcu_fd_sc_mcu9t5v0__filltie
X_09988_ _19261_/Q _10165_/A2 _09991_/A1 VSS VSS VSS VSS gf180mcu_fd_sc_mcu9t5v0__nand2_1
XTAP_TAPCELL_ROW_70_2898 VSS VSS gf180mcu_fd_sc_mcu9t5v0__filltie
XTAP_TAPCELL_ROW_241_5694 VSS VSS gf180mcu_fd_sc_mcu9t5v0__filltie
X_11950_ _18166_/Q _12340_/S _11951_/A3 VSS _11950_/VNW VSS VSS gf180mcu_fd_sc_mcu9t5v0__nand2_1
X_10901_ _19247_/Q _19253_/Q _18151_/S _10901_/Z VSS VSS VSS VSS gf180mcu_fd_sc_mcu9t5v0__mux2_1
XTAP_TAPCELL_ROW_10_1260 VSS VSS gf180mcu_fd_sc_mcu9t5v0__filltie
X_11881_ _19117_/Q _11966_/B _11904_/A1 VSS _11881_/VNW VSS VSS gf180mcu_fd_sc_mcu9t5v0__nand2_1
XTAP_TAPCELL_ROW_10_1271 VSS VSS gf180mcu_fd_sc_mcu9t5v0__filltie
X_10832_ _20068_/Q _10834_/A2 _10833_/B1 VSS VSS VSS VSS gf180mcu_fd_sc_mcu9t5v0__xnor2_1
X_13620_ _13620_/A1 _13620_/A2 _13620_/B _13625_/A2 VSS VSS VSS VSS gf180mcu_fd_sc_mcu9t5v0__oai21_1
X_13551_ _13551_/A1 _13551_/A2 _13551_/B _13556_/A1 VSS VSS VSS VSS gf180mcu_fd_sc_mcu9t5v0__aoi21_1
X_10763_ _18852_/Q _10776_/A2 _10763_/B _10803_/C _10767_/A2 VSS VSS VSS VSS gf180mcu_fd_sc_mcu9t5v0__oai211_1
X_16270_ _16162_/B _16809_/S _16426_/B VSS VSS VSS VSS gf180mcu_fd_sc_mcu9t5v0__nand2_4
X_12502_ _12541_/B _12502_/A2 _12502_/A3 _12502_/B _12503_/B2 VSS VSS VSS VSS gf180mcu_fd_sc_mcu9t5v0__oai31_1
XTAP_TAPCELL_ROW_23_1610 VSS VSS gf180mcu_fd_sc_mcu9t5v0__filltie
X_10694_ _19935_/Q _19887_/Q _20043_/Q _10694_/Z VSS VSS VSS VSS gf180mcu_fd_sc_mcu9t5v0__mux2_1
X_13482_ _13482_/A1 _13482_/A2 _13488_/B1 VSS _13482_/VNW VSS VSS gf180mcu_fd_sc_mcu9t5v0__nand2_1
X_15221_ _19594_/Q _19571_/Q _15225_/B _15222_/I0 VSS VSS VSS VSS gf180mcu_fd_sc_mcu9t5v0__xnor3_1
XTAP_TAPCELL_ROW_23_1621 VSS VSS gf180mcu_fd_sc_mcu9t5v0__filltie
X_12433_ _18306_/Q _12608_/A2 _12616_/B _12434_/B2 VSS VSS VSS VSS gf180mcu_fd_sc_mcu9t5v0__oai21_1
XPHY_EDGE_ROW_144_3_Right_259 VSS VSS gf180mcu_fd_sc_mcu9t5v0__endcap
X_12364_ _12628_/A1 _12355_/I _12364_/A3 _12364_/B _19141_/D VSS VSS VSS VSS gf180mcu_fd_sc_mcu9t5v0__oai31_1
X_15152_ _19694_/Q _19534_/Q wire108/Z _19694_/D VSS VSS VSS VSS gf180mcu_fd_sc_mcu9t5v0__mux2_1
X_11315_ _18296_/Q _11509_/A2 _11510_/B _11317_/A2 VSS _11996_/VNW VSS VSS gf180mcu_fd_sc_mcu9t5v0__oai21_1
X_19960_ _19960_/D _19960_/RN clkload46/I _19960_/Q VSS VSS VSS VSS gf180mcu_fd_sc_mcu9t5v0__dffrnq_1
X_14103_ _14103_/A1 _14103_/A2 _14103_/B _14136_/A1 VSS VSS VSS VSS gf180mcu_fd_sc_mcu9t5v0__aoi21_1
X_15083_ _19645_/Q _15083_/I1 _20039_/Q _19645_/D VSS _15083_/VNW VSS VSS gf180mcu_fd_sc_mcu9t5v0__mux2_1
X_12295_ _11988_/B _12295_/A2 _12293_/B _12295_/B _12296_/B1 VSS VSS VSS VSS gf180mcu_fd_sc_mcu9t5v0__oai31_4
XTAP_TAPCELL_ROW_143_3_8024 VSS VSS gf180mcu_fd_sc_mcu9t5v0__filltie
X_14034_ _14036_/A2 _14036_/A3 _14034_/B _14035_/I VSS VSS VSS VSS gf180mcu_fd_sc_mcu9t5v0__oai21_1
X_18911_ _18911_/D _20063_/RN clkload10/I _18911_/Q VSS VSS VSS VSS gf180mcu_fd_sc_mcu9t5v0__dffrnq_1
X_11246_ _18259_/Q _11519_/A2 _11249_/A1 VSS VSS VSS VSS gf180mcu_fd_sc_mcu9t5v0__nor2_1
XPHY_EDGE_ROW_161_3_Left_819 VSS VSS gf180mcu_fd_sc_mcu9t5v0__endcap
X_19891_ _19891_/D _20019_/RN clkload71/I _19891_/Q VSS VSS VSS VSS gf180mcu_fd_sc_mcu9t5v0__dffrnq_1
X_11177_ _11526_/B _11177_/A2 _11177_/A3 _11183_/B1 VSS VSS VSS VSS gf180mcu_fd_sc_mcu9t5v0__nand3_1
XTAP_TAPCELL_ROW_17_1447 VSS VSS gf180mcu_fd_sc_mcu9t5v0__filltie
X_18842_ _18842_/D _20058_/RN clkload33/I _18842_/Q VSS VSS VSS VSS gf180mcu_fd_sc_mcu9t5v0__dffrnq_1
XTAP_TAPCELL_ROW_17_1458 VSS VSS gf180mcu_fd_sc_mcu9t5v0__filltie
X_10128_ _19265_/Q _10165_/A2 _10130_/A2 VSS VSS VSS VSS gf180mcu_fd_sc_mcu9t5v0__nand2_1
X_15985_ _18567_/Q _15967_/C _15985_/B1 _15854_/Z _15985_/C _16107_/A2 VSS VSS VSS
+ VSS gf180mcu_fd_sc_mcu9t5v0__aoi221_4
X_18773_ _18773_/D _20053_/RN _20049_/CLK _18773_/Q VSS VSS VSS VSS gf180mcu_fd_sc_mcu9t5v0__dffrnq_1
X_10059_ _10059_/A1 _10059_/A2 _10059_/A3 _10059_/A4 _10081_/A2 VSS VSS VSS VSS gf180mcu_fd_sc_mcu9t5v0__nand4_1
X_17724_ _18738_/Q _17681_/S _17743_/B _18662_/Q _17725_/I VSS VSS VSS VSS gf180mcu_fd_sc_mcu9t5v0__aoi22_1
X_14936_ _19602_/Q _14936_/I1 _20039_/D _19602_/D VSS _14936_/VNW VSS VSS gf180mcu_fd_sc_mcu9t5v0__mux2_1
XPHY_EDGE_ROW_286_Left_609 VSS VSS gf180mcu_fd_sc_mcu9t5v0__endcap
X_17655_ _20033_/RN _17702_/A3 _17673_/S VSS VSS VSS VSS gf180mcu_fd_sc_mcu9t5v0__nand2_1
X_14867_ _19411_/Q _19352_/Q _14872_/B VSS VSS VSS VSS gf180mcu_fd_sc_mcu9t5v0__nand2_1
X_16606_ _16668_/A1 _16628_/A2 _16606_/B _16608_/A2 VSS VSS VSS VSS gf180mcu_fd_sc_mcu9t5v0__aoi21_1
X_17586_ _17584_/S _17586_/A2 _17589_/A1 VSS VSS VSS VSS gf180mcu_fd_sc_mcu9t5v0__nand2_1
X_13818_ _13818_/A1 _13818_/A2 _13818_/Z VSS _13818_/VNW VSS VSS gf180mcu_fd_sc_mcu9t5v0__xor2_1
X_14798_ _19570_/Q _09462_/I _14799_/B VSS VSS VSS VSS gf180mcu_fd_sc_mcu9t5v0__nand2_1
X_16537_ _16177_/C _19240_/Q _17057_/S _16537_/Z VSS VSS VSS VSS gf180mcu_fd_sc_mcu9t5v0__mux2_1
XTAP_TAPCELL_ROW_80_3194 VSS VSS gf180mcu_fd_sc_mcu9t5v0__filltie
XTAP_TAPCELL_ROW_80_3183 VSS VSS gf180mcu_fd_sc_mcu9t5v0__filltie
X_19325_ _19325_/D _20029_/RN clkload7/I _19325_/Q VSS VSS VSS VSS gf180mcu_fd_sc_mcu9t5v0__dffrnq_1
X_13749_ _19149_/Q _19115_/Q _13749_/Z VSS VSS VSS VSS gf180mcu_fd_sc_mcu9t5v0__xor2_1
XTAP_TAPCELL_ROW_80_3172 VSS VSS gf180mcu_fd_sc_mcu9t5v0__filltie
X_16468_ _18292_/Q _16467_/Z _16990_/S _18292_/D VSS VSS VSS VSS gf180mcu_fd_sc_mcu9t5v0__mux2_4
X_19256_ _19256_/D _19960_/RN _19680_/CLK _19256_/Q VSS VSS VSS VSS gf180mcu_fd_sc_mcu9t5v0__dffrnq_2
XPHY_EDGE_ROW_295_Left_618 VSS VSS gf180mcu_fd_sc_mcu9t5v0__endcap
X_18207_ _18207_/D _20099_/CLK _18207_/Q VSS VSS VSS VSS gf180mcu_fd_sc_mcu9t5v0__dffq_1
X_16399_ _16187_/C _19242_/Q _16927_/S _16399_/Z VSS VSS VSS VSS gf180mcu_fd_sc_mcu9t5v0__mux2_1
XPHY_EDGE_ROW_155_1_Right_739 VSS VSS gf180mcu_fd_sc_mcu9t5v0__endcap
X_19187_ _19187_/D _20019_/RN clkload13/I _19187_/Q VSS VSS VSS VSS gf180mcu_fd_sc_mcu9t5v0__dffrnq_1
XTAP_TAPCELL_ROW_93_3533 VSS VSS gf180mcu_fd_sc_mcu9t5v0__filltie
X_15419_ _19704_/Q _19804_/Q _15420_/S _19804_/D VSS VSS VSS VSS gf180mcu_fd_sc_mcu9t5v0__mux2_1
XTAP_TAPCELL_ROW_264_6340 VSS VSS gf180mcu_fd_sc_mcu9t5v0__filltie
X_18138_ _18137_/Z _18956_/Q _18152_/S _18956_/D VSS VSS VSS VSS gf180mcu_fd_sc_mcu9t5v0__mux2_1
XTAP_TAPCELL_ROW_93_3544 VSS VSS gf180mcu_fd_sc_mcu9t5v0__filltie
Xu_transform_scheduler_core.u_fft_scratch_sram.u_lo.g_pin_drive\[6\].u_addr_driver
+ _10792_/ZN u_transform_scheduler_core.u_fft_scratch_sram.u_lo.u_sram/A[6] VSS VSS
+ VSS VSS gf180mcu_fd_sc_mcu9t5v0__buf_8
XTAP_TAPCELL_ROW_260_6226 VSS VSS gf180mcu_fd_sc_mcu9t5v0__filltie
XTAP_TAPCELL_ROW_260_6215 VSS VSS gf180mcu_fd_sc_mcu9t5v0__filltie
X_18069_ _18928_/Q _18062_/I _18072_/A1 VSS _18069_/VNW VSS VSS gf180mcu_fd_sc_mcu9t5v0__nand2_1
X_20100_ _20100_/D clkload74/I _20100_/Q VSS VSS VSS VSS gf180mcu_fd_sc_mcu9t5v0__dffq_1
X_09911_ _09926_/A1 _10054_/A2 _10136_/B1 VSS VSS VSS VSS gf180mcu_fd_sc_mcu9t5v0__nor2_2
XTAP_TAPCELL_ROW_277_6701 VSS VSS gf180mcu_fd_sc_mcu9t5v0__filltie
X_09842_ _19847_/Q _09849_/B _17412_/B VSS _10664_/VNW VSS VSS gf180mcu_fd_sc_mcu9t5v0__and2_1
X_20031_ _20031_/D _20031_/RN clkload45/I _20031_/Q VSS VSS VSS VSS gf180mcu_fd_sc_mcu9t5v0__dffrnq_1
X_09773_ _17869_/A2 _09835_/C _09773_/B _09829_/A1 VSS _09834_/VNW VSS VSS gf180mcu_fd_sc_mcu9t5v0__aoi21_1
XTAP_TAPCELL_ROW_258_6177 VSS VSS gf180mcu_fd_sc_mcu9t5v0__filltie
XTAP_TAPCELL_ROW_258_6166 VSS VSS gf180mcu_fd_sc_mcu9t5v0__filltie
XTAP_TAPCELL_ROW_258_6155 VSS VSS gf180mcu_fd_sc_mcu9t5v0__filltie
XTAP_TAPCELL_ROW_7_1170 VSS VSS gf180mcu_fd_sc_mcu9t5v0__filltie
XTAP_TAPCELL_ROW_7_1181 VSS VSS gf180mcu_fd_sc_mcu9t5v0__filltie
XTAP_TAPCELL_ROW_3_1056 VSS VSS gf180mcu_fd_sc_mcu9t5v0__filltie
XTAP_TAPCELL_ROW_3_1067 VSS VSS gf180mcu_fd_sc_mcu9t5v0__filltie
XTAP_TAPCELL_ROW_3_1078 VSS VSS gf180mcu_fd_sc_mcu9t5v0__filltie
XTAP_TAPCELL_ROW_230_5395 VSS VSS gf180mcu_fd_sc_mcu9t5v0__filltie
XTAP_TAPCELL_ROW_230_5384 VSS VSS gf180mcu_fd_sc_mcu9t5v0__filltie
XPHY_EDGE_ROW_157_2_Right_888 VSS VSS gf180mcu_fd_sc_mcu9t5v0__endcap
X_09207_ _19585_/Q _15185_/A1 VSS VSS VSS VSS gf180mcu_fd_sc_mcu9t5v0__clkinv_1
X_09138_ _19798_/Q _13204_/A2 VSS _13202_/VNW VSS VSS gf180mcu_fd_sc_mcu9t5v0__clkinv_1
Xrebuffer266 _16545_/ZN rebuffer266/Z VSS VSS VSS VSS gf180mcu_fd_sc_mcu9t5v0__buf_8
X_11100_ _11100_/A1 _11100_/A2 _11100_/B1 _11098_/B _11104_/A2 VSS _16686_/VNW VSS
+ VSS gf180mcu_fd_sc_mcu9t5v0__aoi22_1
XTAP_TAPCELL_ROW_247_5870 VSS VSS gf180mcu_fd_sc_mcu9t5v0__filltie
X_09069_ _20023_/Q _09704_/A1 VSS _17771_/VNW VSS VSS gf180mcu_fd_sc_mcu9t5v0__clkinv_1
XTAP_TAPCELL_ROW_72_2949 VSS VSS gf180mcu_fd_sc_mcu9t5v0__filltie
X_12080_ _18364_/Q _12046_/S _12082_/A2 VSS _12080_/VNW VSS VSS gf180mcu_fd_sc_mcu9t5v0__nor2_1
XTAP_TAPCELL_ROW_243_5756 VSS VSS gf180mcu_fd_sc_mcu9t5v0__filltie
XTAP_TAPCELL_ROW_243_5745 VSS VSS gf180mcu_fd_sc_mcu9t5v0__filltie
X_11031_ _19064_/Q _19032_/Q _11051_/S _19032_/D VSS VSS VSS VSS gf180mcu_fd_sc_mcu9t5v0__mux2_1
XTAP_TAPCELL_ROW_12_1300 VSS VSS gf180mcu_fd_sc_mcu9t5v0__filltie
XTAP_TAPCELL_ROW_12_1311 VSS VSS gf180mcu_fd_sc_mcu9t5v0__filltie
XTAP_TAPCELL_ROW_12_1322 VSS VSS gf180mcu_fd_sc_mcu9t5v0__filltie
X_15770_ input8/Z _19940_/Q _15770_/S _19940_/D VSS VSS VSS VSS gf180mcu_fd_sc_mcu9t5v0__mux2_1
X_12982_ _19752_/Q _19786_/Q _12983_/B VSS VSS VSS VSS gf180mcu_fd_sc_mcu9t5v0__xor2_1
X_11933_ _18229_/Q _12340_/S _12347_/C _11936_/A2 VSS _11936_/VNW VSS VSS gf180mcu_fd_sc_mcu9t5v0__aoi21_1
X_14721_ _14722_/A1 _14722_/A2 _14721_/Z VSS _15418_/VNW VSS VSS gf180mcu_fd_sc_mcu9t5v0__and2_1
X_11864_ _18290_/Q _12315_/S _11866_/A2 VSS _16532_/VNW VSS VSS gf180mcu_fd_sc_mcu9t5v0__nand2_1
X_17440_ _09688_/B _17443_/A2 _17443_/B1 VSS VSS VSS VSS gf180mcu_fd_sc_mcu9t5v0__nand2_1
X_14652_ _13675_/B _14653_/A2 _14657_/A3 VSS VSS VSS VSS gf180mcu_fd_sc_mcu9t5v0__nand2_1
X_10815_ _09721_/B _10816_/B1 _10817_/A2 VSS VSS VSS VSS gf180mcu_fd_sc_mcu9t5v0__nand2_1
X_17371_ _17412_/A1 _17371_/A2 _17412_/B _17372_/A2 VSS VSS VSS VSS gf180mcu_fd_sc_mcu9t5v0__aoi21_1
X_13603_ _19740_/Q _13603_/A2 _13327_/Z _13603_/B _13608_/A2 VSS _17976_/VNW VSS VSS
+ gf180mcu_fd_sc_mcu9t5v0__oai31_1
X_16322_ _18226_/Q _16321_/Z _16854_/S _18226_/D VSS VSS VSS VSS gf180mcu_fd_sc_mcu9t5v0__mux2_4
X_19110_ _19110_/D _20070_/RN clkload12/I _19110_/Q VSS VSS VSS VSS gf180mcu_fd_sc_mcu9t5v0__dffrnq_1
X_11795_ _18897_/Q _11795_/A2 _11796_/A2 VSS VSS VSS VSS gf180mcu_fd_sc_mcu9t5v0__xnor2_1
X_14583_ _14578_/Z _14583_/A2 _14587_/B VSS VSS VSS VSS gf180mcu_fd_sc_mcu9t5v0__nand2_1
X_10746_ _19822_/Q _10389_/C _10745_/Z _17225_/B _17412_/B _10747_/B VSS _15459_/VNW
+ VSS VSS gf180mcu_fd_sc_mcu9t5v0__aoi221_1
X_13534_ _13534_/A1 _13534_/A2 _13534_/B _13536_/A2 VSS VSS VSS VSS gf180mcu_fd_sc_mcu9t5v0__aoi21_1
X_16253_ _19264_/Q _16137_/C _16955_/S _16253_/Z VSS VSS VSS VSS gf180mcu_fd_sc_mcu9t5v0__mux2_1
X_10677_ _19828_/Q _19827_/Q _17322_/A2 _10678_/A2 VSS VSS VSS VSS gf180mcu_fd_sc_mcu9t5v0__nand3_1
X_13465_ _13465_/A1 _13465_/A2 _13634_/B _13465_/B _13471_/B1 VSS VSS VSS VSS gf180mcu_fd_sc_mcu9t5v0__oai31_1
X_19041_ _19041_/D _20065_/RN _19806_/CLK _19041_/Q VSS VSS VSS VSS gf180mcu_fd_sc_mcu9t5v0__dffrnq_1
X_12416_ _18208_/Q _12582_/A2 _12419_/A3 VSS VSS VSS VSS gf180mcu_fd_sc_mcu9t5v0__nor2_1
X_16184_ _16184_/A1 _16184_/A2 _16184_/B _16185_/I1 VSS VSS VSS VSS gf180mcu_fd_sc_mcu9t5v0__oai21_4
X_15204_ _15204_/A1 _19567_/Q _15204_/B1 _15204_/B2 _15204_/C _15209_/A3 VSS VSS VSS
+ VSS gf180mcu_fd_sc_mcu9t5v0__aoi221_1
XTAP_TAPCELL_ROW_131_4592 VSS VSS gf180mcu_fd_sc_mcu9t5v0__filltie
X_15135_ _19677_/Q _19517_/Q wire108/Z _19677_/D VSS VSS VSS VSS gf180mcu_fd_sc_mcu9t5v0__mux2_1
X_13396_ _13416_/B1 _13416_/B2 _13416_/C _13398_/A3 VSS VSS VSS VSS gf180mcu_fd_sc_mcu9t5v0__aoi21_1
XTAP_TAPCELL_ROW_131_4581 VSS VSS gf180mcu_fd_sc_mcu9t5v0__filltie
X_12347_ _12347_/A1 _12347_/A2 _12347_/B _12347_/C _12348_/B VSS _12347_/VNW VSS VSS
+ gf180mcu_fd_sc_mcu9t5v0__oai211_1
XTAP_TAPCELL_ROW_162_3_8090 VSS VSS gf180mcu_fd_sc_mcu9t5v0__filltie
XPHY_EDGE_ROW_171_2_Left_683 VSS VSS gf180mcu_fd_sc_mcu9t5v0__endcap
XTAP_TAPCELL_ROW_19_1509 VSS VSS gf180mcu_fd_sc_mcu9t5v0__filltie
XTAP_TAPCELL_ROW_321_7889 VSS VSS gf180mcu_fd_sc_mcu9t5v0__filltie
X_19943_ _19943_/D _20071_/RN clkload50/I _19943_/Q VSS VSS VSS VSS gf180mcu_fd_sc_mcu9t5v0__dffrnq_1
X_12278_ _12279_/A1 _12279_/A2 _12336_/A3 VSS VSS VSS VSS gf180mcu_fd_sc_mcu9t5v0__nand2_1
X_15066_ _15066_/A1 _15066_/A2 _15066_/Z VSS _15201_/VNW VSS VSS gf180mcu_fd_sc_mcu9t5v0__xor2_1
X_11229_ _18194_/Q _11524_/S _11231_/A2 VSS VSS VSS VSS gf180mcu_fd_sc_mcu9t5v0__nand2_1
X_19874_ _19874_/D _20066_/RN clkload56/I _19874_/Q VSS VSS VSS VSS gf180mcu_fd_sc_mcu9t5v0__dffrnq_1
X_14017_ _14018_/A1 _14016_/Z _14033_/B VSS VSS VSS VSS gf180mcu_fd_sc_mcu9t5v0__nand2_1
X_18825_ _18825_/D _20041_/RN clkload55/I _18825_/Q VSS VSS VSS VSS gf180mcu_fd_sc_mcu9t5v0__dffrnq_1
X_15968_ _15938_/Z _15969_/B2 _16198_/B VSS VSS VSS VSS gf180mcu_fd_sc_mcu9t5v0__and2_4
X_18756_ _18756_/D _20036_/RN _20049_/CLK _18756_/Q VSS VSS VSS VSS gf180mcu_fd_sc_mcu9t5v0__dffrnq_1
XTAP_TAPCELL_ROW_253_6041 VSS VSS gf180mcu_fd_sc_mcu9t5v0__filltie
XTAP_TAPCELL_ROW_253_6030 VSS VSS gf180mcu_fd_sc_mcu9t5v0__filltie
X_15899_ _20108_/Q _19244_/Q _15905_/S _20108_/D VSS VSS VSS VSS gf180mcu_fd_sc_mcu9t5v0__mux2_1
X_17707_ _17709_/A1 _17707_/A2 _18729_/D VSS _17707_/VNW VSS VSS gf180mcu_fd_sc_mcu9t5v0__nand2_1
XTAP_TAPCELL_ROW_82_3245 VSS VSS gf180mcu_fd_sc_mcu9t5v0__filltie
X_18687_ _18687_/D _19963_/RN clkload27/I _18687_/Q VSS VSS VSS VSS gf180mcu_fd_sc_mcu9t5v0__dffrnq_1
X_14919_ _14932_/A1 _14932_/A2 _14923_/A2 VSS _14922_/VNW VSS VSS gf180mcu_fd_sc_mcu9t5v0__nand2_1
XTAP_TAPCELL_ROW_82_3234 VSS VSS gf180mcu_fd_sc_mcu9t5v0__filltie
X_17638_ _18687_/Q _17636_/B _17639_/B VSS VSS VSS VSS gf180mcu_fd_sc_mcu9t5v0__nand2_1
X_17569_ _17779_/A1 _17569_/A2 _17703_/A2 VSS VSS VSS VSS gf180mcu_fd_sc_mcu9t5v0__xnor2_1
XTAP_TAPCELL_ROW_95_3606 VSS VSS gf180mcu_fd_sc_mcu9t5v0__filltie
X_19308_ _19308_/D _20140_/RN clkload8/I _19308_/Q VSS VSS VSS VSS gf180mcu_fd_sc_mcu9t5v0__dffrnq_1
X_19239_ _19239_/D _20071_/RN clkload69/I _19239_/Q VSS VSS VSS VSS gf180mcu_fd_sc_mcu9t5v0__dffrnq_1
Xeco10_buf_09742 _09742_/ZN _15936_/C VSS VSS VSS VSS gf180mcu_fd_sc_mcu9t5v0__clkbuf_16
XTAP_TAPCELL_ROW_110_3997 VSS VSS gf180mcu_fd_sc_mcu9t5v0__filltie
X_20014_ _20014_/D _20142_/RN clkload50/I _20014_/Q VSS VSS VSS VSS gf180mcu_fd_sc_mcu9t5v0__dffrnq_1
X_09825_ _10657_/B _09825_/A2 _09815_/I _10783_/A1 _09826_/B VSS VSS VSS VSS gf180mcu_fd_sc_mcu9t5v0__nor4_1
XTAP_TAPCELL_ROW_9_1221 VSS VSS gf180mcu_fd_sc_mcu9t5v0__filltie
XTAP_TAPCELL_ROW_9_1232 VSS VSS gf180mcu_fd_sc_mcu9t5v0__filltie
XTAP_TAPCELL_ROW_9_1243 VSS VSS gf180mcu_fd_sc_mcu9t5v0__filltie
X_09756_ _09675_/B _15850_/A2 _20013_/Q _09761_/A1 VSS _17618_/VNW VSS VSS gf180mcu_fd_sc_mcu9t5v0__oai21_1
XTAP_TAPCELL_ROW_5_1107 VSS VSS gf180mcu_fd_sc_mcu9t5v0__filltie
XTAP_TAPCELL_ROW_5_1118 VSS VSS gf180mcu_fd_sc_mcu9t5v0__filltie
XTAP_TAPCELL_ROW_5_1129 VSS VSS gf180mcu_fd_sc_mcu9t5v0__filltie
X_09687_ _09687_/A1 _09687_/A2 _09695_/A3 VSS VSS VSS VSS gf180mcu_fd_sc_mcu9t5v0__nand2_1
XTAP_TAPCELL_ROW_236_5571 VSS VSS gf180mcu_fd_sc_mcu9t5v0__filltie
XTAP_TAPCELL_ROW_236_5560 VSS VSS gf180mcu_fd_sc_mcu9t5v0__filltie
XTAP_TAPCELL_ROW_65_2764 VSS VSS gf180mcu_fd_sc_mcu9t5v0__filltie
XTAP_TAPCELL_ROW_65_2775 VSS VSS gf180mcu_fd_sc_mcu9t5v0__filltie
XTAP_TAPCELL_ROW_232_5446 VSS VSS gf180mcu_fd_sc_mcu9t5v0__filltie
XTAP_TAPCELL_ROW_232_5457 VSS VSS gf180mcu_fd_sc_mcu9t5v0__filltie
X_10600_ _18968_/Q wire165/Z _10652_/B1 _18984_/Q _10601_/A3 VSS VSS VSS VSS gf180mcu_fd_sc_mcu9t5v0__aoi22_1
X_11580_ _18845_/Q _17912_/A2 _11589_/B VSS VSS VSS VSS gf180mcu_fd_sc_mcu9t5v0__nand2_1
XTAP_TAPCELL_ROW_249_5921 VSS VSS gf180mcu_fd_sc_mcu9t5v0__filltie
X_10531_ _18998_/Q _10654_/A2 _10531_/B wire160/Z _10552_/A1 VSS _10531_/VNW VSS VSS
+ gf180mcu_fd_sc_mcu9t5v0__oai211_1
XTAP_TAPCELL_ROW_249_5910 VSS VSS gf180mcu_fd_sc_mcu9t5v0__filltie
X_13250_ _13242_/Z _13250_/A2 _13250_/B1 _13250_/B2 _13251_/I0 VSS VSS VSS VSS gf180mcu_fd_sc_mcu9t5v0__oai22_1
X_12201_ _18433_/Q _12203_/A2 _12207_/A2 VSS VSS VSS VSS gf180mcu_fd_sc_mcu9t5v0__nand2_1
XTAP_TAPCELL_ROW_245_5818 VSS VSS gf180mcu_fd_sc_mcu9t5v0__filltie
XTAP_TAPCELL_ROW_245_5807 VSS VSS gf180mcu_fd_sc_mcu9t5v0__filltie
X_10462_ _17404_/S _18209_/Q _10464_/A3 VSS _11223_/VNW VSS VSS gf180mcu_fd_sc_mcu9t5v0__nor2_1
XPHY_EDGE_ROW_158_2_Right_889 VSS VSS gf180mcu_fd_sc_mcu9t5v0__endcap
X_10393_ _18976_/Q _10804_/A2 wire166/Z _18944_/Q _10394_/A3 VSS VSS VSS VSS gf180mcu_fd_sc_mcu9t5v0__aoi22_1
X_13181_ _13183_/A1 _19762_/Q _13195_/A1 VSS VSS VSS VSS gf180mcu_fd_sc_mcu9t5v0__nor2_1
X_12132_ _12159_/B _12130_/Z _12142_/A2 VSS VSS VSS VSS gf180mcu_fd_sc_mcu9t5v0__nand2_1
X_12063_ _18411_/Q _12315_/S _12322_/B _12066_/A2 VSS VSS VSS VSS gf180mcu_fd_sc_mcu9t5v0__aoi21_1
X_16940_ _16939_/Z _18461_/Q _16940_/S _18461_/D VSS VSS VSS VSS gf180mcu_fd_sc_mcu9t5v0__mux2_1
X_11014_ _19018_/Q _11016_/A2 _19019_/Q _11015_/A2 VSS VSS VSS VSS gf180mcu_fd_sc_mcu9t5v0__aoi21_1
X_16871_ _19247_/Q _16592_/B _16871_/S _16871_/Z VSS _17149_/VNW VSS VSS gf180mcu_fd_sc_mcu9t5v0__mux2_1
X_18610_ _18610_/D clkload72/I _18610_/Q VSS VSS VSS VSS gf180mcu_fd_sc_mcu9t5v0__dffq_1
X_15822_ _15822_/A1 _15824_/A3 _15823_/B VSS _15822_/VNW VSS VSS gf180mcu_fd_sc_mcu9t5v0__nor2_1
X_19590_ _19590_/D _20038_/RN clkload7/I _19590_/Q VSS VSS VSS VSS gf180mcu_fd_sc_mcu9t5v0__dffrnq_1
X_18541_ _18541_/D _20041_/RN clkload57/I _18541_/Q VSS VSS VSS VSS gf180mcu_fd_sc_mcu9t5v0__dffrnq_1
X_15753_ _19930_/Q _15753_/A2 _15754_/A2 VSS VSS VSS VSS gf180mcu_fd_sc_mcu9t5v0__xnor2_1
X_12965_ _13500_/A1 _13502_/B _12967_/A2 VSS _13502_/VNW VSS VSS gf180mcu_fd_sc_mcu9t5v0__nor2_1
X_11916_ _18324_/Q _12299_/S _11917_/B VSS VSS VSS VSS gf180mcu_fd_sc_mcu9t5v0__nor2_1
XTAP_TAPCELL_ROW_120_4282 VSS VSS gf180mcu_fd_sc_mcu9t5v0__filltie
XTAP_TAPCELL_ROW_120_4271 VSS VSS gf180mcu_fd_sc_mcu9t5v0__filltie
X_14704_ _19538_/Q _14703_/Z _14704_/S _19538_/D VSS VSS VSS VSS gf180mcu_fd_sc_mcu9t5v0__mux2_1
X_18472_ _18472_/D clkload77/I _18472_/Q VSS VSS VSS VSS gf180mcu_fd_sc_mcu9t5v0__dffq_1
XTAP_TAPCELL_ROW_314_7693 VSS VSS gf180mcu_fd_sc_mcu9t5v0__filltie
X_15684_ _09665_/Z _15686_/B _15685_/I VSS VSS VSS VSS gf180mcu_fd_sc_mcu9t5v0__and2_1
XTAP_TAPCELL_ROW_120_4293 VSS VSS gf180mcu_fd_sc_mcu9t5v0__filltie
X_12896_ _19773_/Q _12895_/Z _12896_/Z VSS VSS VSS VSS gf180mcu_fd_sc_mcu9t5v0__and2_1
X_11847_ _11847_/A1 _12116_/C _11847_/B1 _11847_/B2 _12299_/S _11848_/B VSS VSS VSS
+ VSS gf180mcu_fd_sc_mcu9t5v0__aoi221_1
X_17423_ _17423_/A1 _17422_/S _18562_/D VSS VSS VSS VSS gf180mcu_fd_sc_mcu9t5v0__nand2_1
X_14635_ _19097_/Q _19513_/Q _14730_/S _19513_/D VSS VSS VSS VSS gf180mcu_fd_sc_mcu9t5v0__mux2_1
X_11778_ _18318_/Q _12159_/B _12320_/C _11779_/A2 VSS VSS VSS VSS gf180mcu_fd_sc_mcu9t5v0__oai21_1
X_17354_ _17358_/A1 _18454_/Q _17357_/A2 VSS _17357_/VNW VSS VSS gf180mcu_fd_sc_mcu9t5v0__nor2_1
X_14566_ _19470_/Q _14766_/A2 _14574_/A1 VSS VSS VSS VSS gf180mcu_fd_sc_mcu9t5v0__nand2_1
X_17285_ _20132_/Q _17407_/C _17286_/A3 VSS VSS VSS VSS gf180mcu_fd_sc_mcu9t5v0__nand2_1
XTAP_TAPCELL_ROW_215_4987 VSS VSS gf180mcu_fd_sc_mcu9t5v0__filltie
X_16305_ _19229_/Q _16009_/B _16863_/S _16305_/Z VSS VSS VSS VSS gf180mcu_fd_sc_mcu9t5v0__mux2_1
XTAP_TAPCELL_ROW_215_4976 VSS VSS gf180mcu_fd_sc_mcu9t5v0__filltie
XTAP_TAPCELL_ROW_133_4643 VSS VSS gf180mcu_fd_sc_mcu9t5v0__filltie
XTAP_TAPCELL_ROW_133_4632 VSS VSS gf180mcu_fd_sc_mcu9t5v0__filltie
X_10729_ _18556_/Q _10796_/A2 _17417_/I0 _17075_/A1 _10743_/A2 VSS VSS VSS VSS gf180mcu_fd_sc_mcu9t5v0__aoi22_4
X_13517_ _13516_/B _13517_/A2 _13517_/Z VSS VSS VSS VSS gf180mcu_fd_sc_mcu9t5v0__xor2_1
X_16236_ _16236_/A1 _16545_/A3 _16198_/C _16787_/S _16236_/ZN VSS VSS VSS VSS gf180mcu_fd_sc_mcu9t5v0__oai31_4
X_19024_ _19024_/D _20048_/RN clkload34/I _19024_/Q VSS VSS VSS VSS gf180mcu_fd_sc_mcu9t5v0__dffrnq_1
X_14497_ _19163_/Q _19129_/Q _14728_/A1 VSS VSS VSS VSS gf180mcu_fd_sc_mcu9t5v0__nor2_1
X_13448_ _13448_/A1 _13448_/A2 _13630_/B _13465_/A2 VSS VSS VSS VSS gf180mcu_fd_sc_mcu9t5v0__aoi21_1
Xclkload23 clkload23/I clkload23/ZN VSS VSS VSS VSS gf180mcu_fd_sc_mcu9t5v0__clkinv_1
Xclkload12 clkload12/I clkload12/ZN VSS VSS VSS VSS gf180mcu_fd_sc_mcu9t5v0__inv_2
Xclkload34 clkload34/I clkload34/Z VSS VSS VSS VSS gf180mcu_fd_sc_mcu9t5v0__clkbuf_4
Xclkload78 clkload78/I clkload78/ZN VSS _11499_/VNW VSS VSS gf180mcu_fd_sc_mcu9t5v0__inv_3
X_16167_ _16668_/A1 _16750_/A2 _16167_/B _16169_/A1 VSS VSS VSS VSS gf180mcu_fd_sc_mcu9t5v0__aoi21_1
Xclkload56 clkload56/I clkload56/ZN VSS VSS VSS VSS gf180mcu_fd_sc_mcu9t5v0__inv_3
Xclkload67 clkload67/I clkload67/ZN VSS VSS VSS VSS gf180mcu_fd_sc_mcu9t5v0__clkinv_1
Xclkload45 clkload45/I clkload45/ZN VSS VSS VSS VSS gf180mcu_fd_sc_mcu9t5v0__inv_4
X_13379_ _19742_/Q _19774_/Q _13380_/I VSS _13381_/VNW VSS VSS gf180mcu_fd_sc_mcu9t5v0__xor2_1
X_16098_ _16098_/A1 _16672_/A2 _16098_/B _16099_/B VSS VSS VSS VSS gf180mcu_fd_sc_mcu9t5v0__oai21_4
X_15118_ _19660_/Q _19500_/Q wire108/Z _19660_/D VSS _15118_/VNW VSS VSS gf180mcu_fd_sc_mcu9t5v0__mux2_1
X_19926_ _19926_/D _20054_/RN clkload49/I _19926_/Q VSS VSS VSS VSS gf180mcu_fd_sc_mcu9t5v0__dffrnq_1
X_15049_ _15050_/A1 _15050_/A2 _15052_/B VSS VSS VSS VSS gf180mcu_fd_sc_mcu9t5v0__nor2_1
XTAP_TAPCELL_ROW_88_3410 VSS VSS gf180mcu_fd_sc_mcu9t5v0__filltie
XTAP_TAPCELL_ROW_127_4469 VSS VSS gf180mcu_fd_sc_mcu9t5v0__filltie
X_19857_ _19857_/D _20049_/RN clkload57/I _19857_/Q VSS VSS VSS VSS gf180mcu_fd_sc_mcu9t5v0__dffrnq_1
X_09610_ _09688_/B _17438_/C VSS VSS VSS VSS gf180mcu_fd_sc_mcu9t5v0__clkinv_1
X_19788_ _19788_/D _20044_/RN clkload11/I _19788_/Q VSS VSS VSS VSS gf180mcu_fd_sc_mcu9t5v0__dffrnq_1
X_18808_ _18808_/D _19960_/RN _19806_/CLK _18808_/Q VSS VSS VSS VSS gf180mcu_fd_sc_mcu9t5v0__dffrnq_1
X_18739_ _18739_/D clkload47/I _18739_/Q VSS VSS VSS VSS gf180mcu_fd_sc_mcu9t5v0__dffq_1
X_09541_ _17628_/A1 _09408_/Z _09541_/B _15855_/A2 VSS _15847_/VNW VSS VSS gf180mcu_fd_sc_mcu9t5v0__aoi21_4
X_09472_ _15148_/S _10187_/A2 _09473_/B _09472_/ZN VSS VSS VSS VSS gf180mcu_fd_sc_mcu9t5v0__oai21_4
Xclkload6 clkload6/I clkload6/ZN VSS VSS VSS VSS gf180mcu_fd_sc_mcu9t5v0__clkinv_8
XTAP_TAPCELL_ROW_285_6899 VSS VSS gf180mcu_fd_sc_mcu9t5v0__filltie
XPHY_EDGE_ROW_182_1_Left_505 VSS VSS gf180mcu_fd_sc_mcu9t5v0__endcap
XTAP_TAPCELL_ROW_58_2590 VSS VSS gf180mcu_fd_sc_mcu9t5v0__filltie
XTAP_TAPCELL_ROW_225_5261 VSS VSS gf180mcu_fd_sc_mcu9t5v0__filltie
XTAP_TAPCELL_ROW_225_5250 VSS VSS gf180mcu_fd_sc_mcu9t5v0__filltie
XTAP_TAPCELL_ROW_54_2454 VSS VSS gf180mcu_fd_sc_mcu9t5v0__filltie
XTAP_TAPCELL_ROW_54_2465 VSS VSS gf180mcu_fd_sc_mcu9t5v0__filltie
XTAP_TAPCELL_ROW_54_2476 VSS VSS gf180mcu_fd_sc_mcu9t5v0__filltie
Xfanout243 _17024_/S _17020_/S VSS VSS VSS VSS gf180mcu_fd_sc_mcu9t5v0__clkbuf_16
XTAP_TAPCELL_ROW_221_5158 VSS VSS gf180mcu_fd_sc_mcu9t5v0__filltie
Xfanout254 _16994_/S _16990_/S VSS VSS VSS VSS gf180mcu_fd_sc_mcu9t5v0__clkbuf_16
XTAP_TAPCELL_ROW_221_5147 VSS VSS gf180mcu_fd_sc_mcu9t5v0__filltie
XTAP_TAPCELL_ROW_221_5136 VSS VSS gf180mcu_fd_sc_mcu9t5v0__filltie
X_09808_ _17918_/A1 _17918_/A2 _09812_/B VSS _09808_/VNW VSS VSS gf180mcu_fd_sc_mcu9t5v0__nand2_1
XTAP_TAPCELL_ROW_238_5622 VSS VSS gf180mcu_fd_sc_mcu9t5v0__filltie
X_09739_ _20021_/Q _20052_/Q _09740_/B VSS _17620_/VNW VSS VSS gf180mcu_fd_sc_mcu9t5v0__nand2_1
XTAP_TAPCELL_ROW_238_5611 VSS VSS gf180mcu_fd_sc_mcu9t5v0__filltie
XTAP_TAPCELL_ROW_67_2815 VSS VSS gf180mcu_fd_sc_mcu9t5v0__filltie
XTAP_TAPCELL_ROW_67_2826 VSS VSS gf180mcu_fd_sc_mcu9t5v0__filltie
XTAP_TAPCELL_ROW_67_2837 VSS VSS gf180mcu_fd_sc_mcu9t5v0__filltie
XTAP_TAPCELL_ROW_234_5519 VSS VSS gf180mcu_fd_sc_mcu9t5v0__filltie
XTAP_TAPCELL_ROW_234_5508 VSS VSS gf180mcu_fd_sc_mcu9t5v0__filltie
XTAP_TAPCELL_ROW_219_5087 VSS VSS gf180mcu_fd_sc_mcu9t5v0__filltie
X_12750_ _12753_/A1 _12753_/A2 _12752_/A2 VSS VSS VSS VSS gf180mcu_fd_sc_mcu9t5v0__xnor2_1
XTAP_TAPCELL_ROW_219_5098 VSS VSS gf180mcu_fd_sc_mcu9t5v0__filltie
X_12681_ _12716_/S _12680_/Z _12682_/B VSS VSS VSS VSS gf180mcu_fd_sc_mcu9t5v0__nand2_1
X_11701_ _19108_/Q _11701_/I1 _11985_/B _19108_/D VSS VSS VSS VSS gf180mcu_fd_sc_mcu9t5v0__mux2_1
X_11632_ _12632_/A1 _11663_/A2 _11632_/B _11674_/A1 VSS _12653_/VNW VSS VSS gf180mcu_fd_sc_mcu9t5v0__aoi21_1
X_14420_ _19152_/Q _14422_/A2 _14421_/A2 VSS _14693_/VNW VSS VSS gf180mcu_fd_sc_mcu9t5v0__nand2_1
XPHY_EDGE_ROW_170_3_Left_828 VSS VSS gf180mcu_fd_sc_mcu9t5v0__endcap
X_14351_ _14366_/I0 _19422_/Q _14352_/S _19422_/D VSS VSS VSS VSS gf180mcu_fd_sc_mcu9t5v0__mux2_1
X_11563_ _18185_/Q _12090_/B _12153_/B _11564_/B VSS VSS VSS VSS gf180mcu_fd_sc_mcu9t5v0__aoi21_1
X_13302_ _13303_/A1 _13303_/A2 _13316_/B VSS _13302_/VNW VSS VSS gf180mcu_fd_sc_mcu9t5v0__nand2_1
X_10514_ _17260_/S _18275_/Q _10514_/B _10516_/A2 VSS VSS VSS VSS gf180mcu_fd_sc_mcu9t5v0__oai21_1
X_11494_ _18533_/Q _18517_/Q _18501_/Q _18485_/Q _11524_/S _11485_/C _11494_/Z VSS
+ VSS VSS VSS gf180mcu_fd_sc_mcu9t5v0__mux4_1
X_17070_ _18532_/Q _16647_/B _17073_/S _18532_/D VSS VSS VSS VSS gf180mcu_fd_sc_mcu9t5v0__mux2_4
XTAP_TAPCELL_ROW_210_4851 VSS VSS gf180mcu_fd_sc_mcu9t5v0__filltie
XTAP_TAPCELL_ROW_210_4840 VSS VSS gf180mcu_fd_sc_mcu9t5v0__filltie
X_14282_ _14214_/Z _19356_/Q _14285_/S _19356_/D VSS VSS VSS VSS gf180mcu_fd_sc_mcu9t5v0__mux2_1
X_10445_ _20030_/Q _10445_/A2 _10445_/A3 _10445_/ZN VSS VSS VSS VSS gf180mcu_fd_sc_mcu9t5v0__nor3_4
X_16021_ _19199_/Q _16020_/Z _16598_/S _16131_/B VSS VSS VSS VSS gf180mcu_fd_sc_mcu9t5v0__mux2_4
X_13233_ _12843_/B _13233_/A2 _13577_/A2 _13234_/I0 VSS VSS VSS VSS gf180mcu_fd_sc_mcu9t5v0__xnor3_1
X_13164_ _19729_/Q _13164_/A2 _13182_/B VSS _13164_/VNW VSS VSS gf180mcu_fd_sc_mcu9t5v0__nor2_1
XPHY_EDGE_ROW_276_Right_203 VSS VSS gf180mcu_fd_sc_mcu9t5v0__endcap
X_10376_ _18158_/Q _17322_/A2 _17255_/B1 _18174_/Q _10377_/B VSS VSS VSS VSS gf180mcu_fd_sc_mcu9t5v0__aoi22_1
X_12115_ _12159_/B _12115_/A2 _12115_/A3 _12116_/B VSS VSS VSS VSS gf180mcu_fd_sc_mcu9t5v0__nand3_1
XTAP_TAPCELL_ROW_303_7394 VSS VSS gf180mcu_fd_sc_mcu9t5v0__filltie
X_13095_ _13096_/A1 _13094_/B _13101_/A2 VSS _13096_/VNW VSS VSS gf180mcu_fd_sc_mcu9t5v0__xnor2_1
X_17972_ _18859_/Q _18022_/I0 _17978_/S _18859_/D VSS VSS VSS VSS gf180mcu_fd_sc_mcu9t5v0__mux2_1
XTAP_TAPCELL_ROW_295_7184 VSS VSS gf180mcu_fd_sc_mcu9t5v0__filltie
XTAP_TAPCELL_ROW_295_7173 VSS VSS gf180mcu_fd_sc_mcu9t5v0__filltie
X_12046_ _12500_/A1 _12046_/I1 _12046_/S _12046_/Z VSS VSS VSS VSS gf180mcu_fd_sc_mcu9t5v0__mux2_1
X_16923_ _16660_/B _19257_/Q _16927_/S _16923_/Z VSS VSS VSS VSS gf180mcu_fd_sc_mcu9t5v0__mux2_1
X_19711_ _19711_/D _20031_/RN clkload31/I _19711_/Q VSS VSS VSS VSS gf180mcu_fd_sc_mcu9t5v0__dffrnq_1
XTAP_TAPCELL_ROW_37_1995 VSS VSS gf180mcu_fd_sc_mcu9t5v0__filltie
XTAP_TAPCELL_ROW_295_7195 VSS VSS gf180mcu_fd_sc_mcu9t5v0__filltie
X_16854_ _18419_/Q _16853_/Z _16854_/S _18419_/D VSS VSS VSS VSS gf180mcu_fd_sc_mcu9t5v0__mux2_4
XTAP_TAPCELL_ROW_122_4333 VSS VSS gf180mcu_fd_sc_mcu9t5v0__filltie
X_19642_ _19642_/D _20026_/RN clkload20/I _19642_/Q VSS VSS VSS VSS gf180mcu_fd_sc_mcu9t5v0__dffrnq_1
XTAP_TAPCELL_ROW_316_7766 VSS VSS gf180mcu_fd_sc_mcu9t5v0__filltie
XTAP_TAPCELL_ROW_316_7755 VSS VSS gf180mcu_fd_sc_mcu9t5v0__filltie
X_15805_ wire301/Z _19974_/Q _15811_/S _19974_/D VSS VSS VSS VSS gf180mcu_fd_sc_mcu9t5v0__mux2_1
XTAP_TAPCELL_ROW_122_4344 VSS VSS gf180mcu_fd_sc_mcu9t5v0__filltie
X_16785_ _16750_/B _19291_/Q _16785_/S _16785_/Z VSS wire119/VNW VSS VSS gf180mcu_fd_sc_mcu9t5v0__mux2_1
X_19573_ _19573_/D _20021_/RN clkload18/I _19573_/Q VSS VSS VSS VSS gf180mcu_fd_sc_mcu9t5v0__dffrnq_1
X_13997_ _13997_/A1 _13997_/A2 _14032_/A2 VSS _13999_/VNW VSS VSS gf180mcu_fd_sc_mcu9t5v0__xnor2_1
X_18524_ _18524_/D _20129_/CLK _18524_/Q VSS VSS VSS VSS gf180mcu_fd_sc_mcu9t5v0__dffq_1
X_15736_ _15757_/B _15736_/A2 _15736_/B _19925_/D VSS _15736_/VNW VSS VSS gf180mcu_fd_sc_mcu9t5v0__oai21_1
X_12948_ _19749_/Q _19814_/Q _12948_/S _12948_/Z VSS VSS VSS VSS gf180mcu_fd_sc_mcu9t5v0__mux2_1
X_18455_ _18455_/D clkload79/I _18455_/Q VSS VSS VSS VSS gf180mcu_fd_sc_mcu9t5v0__dffq_1
XTAP_TAPCELL_ROW_135_4705 VSS VSS gf180mcu_fd_sc_mcu9t5v0__filltie
X_15667_ _19908_/Q _15668_/A3 _19909_/Q _15669_/A1 VSS _15667_/VNW VSS VSS gf180mcu_fd_sc_mcu9t5v0__oai21_1
X_12879_ _12879_/A1 _12879_/A2 _12879_/B _12884_/A1 VSS VSS VSS VSS gf180mcu_fd_sc_mcu9t5v0__oai21_1
X_17406_ _18360_/Q _17406_/A2 _17404_/Z _10514_/B _17406_/C _17407_/B2 VSS VSS VSS
+ VSS gf180mcu_fd_sc_mcu9t5v0__aoi221_1
XTAP_TAPCELL_ROW_135_4738 VSS VSS gf180mcu_fd_sc_mcu9t5v0__filltie
XTAP_TAPCELL_ROW_135_4727 VSS VSS gf180mcu_fd_sc_mcu9t5v0__filltie
XTAP_TAPCELL_ROW_135_4716 VSS VSS gf180mcu_fd_sc_mcu9t5v0__filltie
X_14618_ _19079_/Q _19496_/Q _14730_/S _19496_/D VSS VSS VSS VSS gf180mcu_fd_sc_mcu9t5v0__mux2_1
X_18386_ _18386_/D _20132_/CLK _18386_/Q VSS VSS VSS VSS gf180mcu_fd_sc_mcu9t5v0__dffq_1
XTAP_TAPCELL_ROW_150_3_8050 VSS VSS gf180mcu_fd_sc_mcu9t5v0__filltie
XTAP_TAPCELL_ROW_149_3_8044 VSS VSS gf180mcu_fd_sc_mcu9t5v0__filltie
XTAP_TAPCELL_ROW_77_3111 VSS VSS gf180mcu_fd_sc_mcu9t5v0__filltie
X_15598_ _15581_/B _19885_/Q _15598_/S _19885_/D VSS _18101_/VNW VSS VSS gf180mcu_fd_sc_mcu9t5v0__mux2_1
XTAP_TAPCELL_ROW_77_3100 VSS VSS gf180mcu_fd_sc_mcu9t5v0__filltie
XTAP_TAPCELL_ROW_116_4159 VSS VSS gf180mcu_fd_sc_mcu9t5v0__filltie
X_17337_ _17399_/A1 _18389_/Q _17340_/A2 VSS _17340_/VNW VSS VSS gf180mcu_fd_sc_mcu9t5v0__nor2_1
XPHY_EDGE_ROW_201_2_Left_713 VSS VSS gf180mcu_fd_sc_mcu9t5v0__endcap
X_14549_ _19169_/Q _19135_/Q _14752_/A1 VSS _14549_/VNW VSS VSS gf180mcu_fd_sc_mcu9t5v0__nand2_1
X_17268_ _18611_/Q _17159_/B _17269_/A3 VSS VSS VSS VSS gf180mcu_fd_sc_mcu9t5v0__nand2_1
X_16219_ _16218_/Z _18194_/Q _16782_/S _18194_/D VSS _16219_/VNW VSS VSS gf180mcu_fd_sc_mcu9t5v0__mux2_4
X_17199_ _10516_/C _17199_/A2 _17199_/B1 _10353_/C _17199_/C1 _10543_/C _17200_/A2
+ VSS VSS VSS VSS gf180mcu_fd_sc_mcu9t5v0__aoi222_1
XTAP_TAPCELL_ROW_152_1_4746 VSS VSS gf180mcu_fd_sc_mcu9t5v0__filltie
X_19007_ _19007_/D _20031_/RN clkload38/I _19007_/Q VSS VSS VSS VSS gf180mcu_fd_sc_mcu9t5v0__dffrnq_1
XTAP_TAPCELL_ROW_280_6774 VSS VSS gf180mcu_fd_sc_mcu9t5v0__filltie
XTAP_TAPCELL_ROW_280_6763 VSS VSS gf180mcu_fd_sc_mcu9t5v0__filltie
Xclkbuf_leaf_38_clk_regs clkload6/I clkload75/I VSS VSS VSS VSS gf180mcu_fd_sc_mcu9t5v0__clkbuf_8
X_19909_ _19909_/D _20037_/RN clkload41/I _19909_/Q VSS VSS VSS VSS gf180mcu_fd_sc_mcu9t5v0__dffrnq_1
XTAP_TAPCELL_ROW_105_3874 VSS VSS gf180mcu_fd_sc_mcu9t5v0__filltie
XTAP_TAPCELL_ROW_105_3863 VSS VSS gf180mcu_fd_sc_mcu9t5v0__filltie
X_09524_ wire174/I _09525_/A2 _09848_/B VSS VSS VSS VSS gf180mcu_fd_sc_mcu9t5v0__and2_1
XTAP_TAPCELL_ROW_0_955 VSS VSS gf180mcu_fd_sc_mcu9t5v0__filltie
XTAP_TAPCELL_ROW_0_944 VSS VSS gf180mcu_fd_sc_mcu9t5v0__filltie
XTAP_TAPCELL_ROW_62_2701 VSS VSS gf180mcu_fd_sc_mcu9t5v0__filltie
XTAP_TAPCELL_ROW_101_3749 VSS VSS gf180mcu_fd_sc_mcu9t5v0__filltie
X_09455_ _19194_/Q _12731_/A2 _15174_/A2 VSS _09455_/VNW VSS VSS gf180mcu_fd_sc_mcu9t5v0__nand2_1
XTAP_TAPCELL_ROW_0_966 VSS VSS gf180mcu_fd_sc_mcu9t5v0__filltie
XTAP_TAPCELL_ROW_0_977 VSS VSS gf180mcu_fd_sc_mcu9t5v0__filltie
XTAP_TAPCELL_ROW_47_2280 VSS VSS gf180mcu_fd_sc_mcu9t5v0__filltie
XTAP_TAPCELL_ROW_0_988 VSS VSS gf180mcu_fd_sc_mcu9t5v0__filltie
XTAP_TAPCELL_ROW_43_2155 VSS VSS gf180mcu_fd_sc_mcu9t5v0__filltie
XTAP_TAPCELL_ROW_43_2166 VSS VSS gf180mcu_fd_sc_mcu9t5v0__filltie
XTAP_TAPCELL_ROW_43_2177 VSS VSS gf180mcu_fd_sc_mcu9t5v0__filltie
X_09386_ _19071_/Q _09465_/A3 VSS _17965_/VNW VSS VSS gf180mcu_fd_sc_mcu9t5v0__clkinv_1
XTAP_TAPCELL_ROW_227_5312 VSS VSS gf180mcu_fd_sc_mcu9t5v0__filltie
XTAP_TAPCELL_ROW_227_5301 VSS VSS gf180mcu_fd_sc_mcu9t5v0__filltie
XTAP_TAPCELL_ROW_56_2516 VSS VSS gf180mcu_fd_sc_mcu9t5v0__filltie
XTAP_TAPCELL_ROW_56_2527 VSS VSS gf180mcu_fd_sc_mcu9t5v0__filltie
X_10230_ _19825_/Q _18201_/Q _10232_/A3 VSS VSS VSS VSS gf180mcu_fd_sc_mcu9t5v0__nor2_1
XTAP_TAPCELL_ROW_227_5323 VSS VSS gf180mcu_fd_sc_mcu9t5v0__filltie
XTAP_TAPCELL_ROW_223_5209 VSS VSS gf180mcu_fd_sc_mcu9t5v0__filltie
X_10161_ _19252_/Q wire297/Z _09998_/C _19236_/Q _10162_/A2 VSS _10161_/VNW VSS VSS
+ gf180mcu_fd_sc_mcu9t5v0__aoi22_1
X_10092_ _19257_/Q wire285/Z _10168_/B1 _19209_/Q _10094_/A1 VSS VSS VSS VSS gf180mcu_fd_sc_mcu9t5v0__aoi22_1
X_13920_ _13951_/A1 _13951_/A2 _13952_/A1 VSS VSS VSS VSS gf180mcu_fd_sc_mcu9t5v0__xnor2_1
XTAP_TAPCELL_ROW_32_1870 VSS VSS gf180mcu_fd_sc_mcu9t5v0__filltie
XTAP_TAPCELL_ROW_155_3_8065 VSS VSS gf180mcu_fd_sc_mcu9t5v0__filltie
X_13851_ _13851_/A1 _13917_/A1 _13851_/Z VSS VSS VSS VSS gf180mcu_fd_sc_mcu9t5v0__xor2_1
XTAP_TAPCELL_ROW_311_7630 VSS VSS gf180mcu_fd_sc_mcu9t5v0__filltie
X_16570_ _18345_/Q _15976_/Z _16570_/A3 _16571_/B VSS VSS VSS VSS gf180mcu_fd_sc_mcu9t5v0__nor3_1
X_10994_ _18923_/Q _11005_/A2 _18049_/B VSS _10994_/VNW VSS VSS gf180mcu_fd_sc_mcu9t5v0__nor2_1
X_12802_ _19759_/Q _12801_/Z _12810_/A2 VSS VSS VSS VSS gf180mcu_fd_sc_mcu9t5v0__nor2_1
X_13782_ _13782_/A1 _13782_/A2 _13803_/B1 VSS _13782_/VNW VSS VSS gf180mcu_fd_sc_mcu9t5v0__xnor2_1
X_15521_ _19843_/Q _19844_/Q _15515_/Z _15521_/Z VSS VSS VSS VSS gf180mcu_fd_sc_mcu9t5v0__and3_1
XPHY_EDGE_ROW_180_2_Left_692 VSS VSS gf180mcu_fd_sc_mcu9t5v0__endcap
X_12733_ _12843_/A1 _19716_/Q _13244_/B VSS _12735_/VNW VSS VSS gf180mcu_fd_sc_mcu9t5v0__nor2_2
X_18240_ _18240_/D _18320_/CLK _18240_/Q VSS VSS VSS VSS gf180mcu_fd_sc_mcu9t5v0__dffq_4
X_15452_ _19819_/Q _19818_/Q _19820_/Q _15453_/A3 VSS _15453_/VNW VSS VSS gf180mcu_fd_sc_mcu9t5v0__aoi21_1
XPHY_EDGE_ROW_241_Right_168 VSS VSS gf180mcu_fd_sc_mcu9t5v0__endcap
XTAP_TAPCELL_ROW_212_4902 VSS VSS gf180mcu_fd_sc_mcu9t5v0__filltie
X_12664_ _12664_/A1 _11672_/Z _12664_/B _12664_/C _12666_/A1 VSS _12666_/VNW VSS VSS
+ gf180mcu_fd_sc_mcu9t5v0__oai211_1
X_14403_ _14688_/A2 _14403_/A2 _14404_/A2 VSS _14403_/VNW VSS VSS gf180mcu_fd_sc_mcu9t5v0__xnor2_1
X_18171_ _18171_/D clkload62/I _18171_/Q VSS VSS VSS VSS gf180mcu_fd_sc_mcu9t5v0__dffq_4
XTAP_TAPCELL_ROW_212_4913 VSS VSS gf180mcu_fd_sc_mcu9t5v0__filltie
X_12595_ _19170_/Q _12620_/A1 _12596_/B VSS _12595_/VNW VSS VSS gf180mcu_fd_sc_mcu9t5v0__nand2_1
XTAP_TAPCELL_ROW_26_1685 VSS VSS gf180mcu_fd_sc_mcu9t5v0__filltie
X_11615_ _12664_/C _12680_/A2 _12720_/S _11679_/B VSS _11615_/VNW VSS VSS gf180mcu_fd_sc_mcu9t5v0__nand3_1
XTAP_TAPCELL_ROW_26_1696 VSS VSS gf180mcu_fd_sc_mcu9t5v0__filltie
X_15383_ _19668_/Q _19768_/Q _15417_/S _19768_/D VSS VSS VSS VSS gf180mcu_fd_sc_mcu9t5v0__mux2_1
XTAP_TAPCELL_ROW_309_7581 VSS VSS gf180mcu_fd_sc_mcu9t5v0__filltie
XTAP_TAPCELL_ROW_309_7570 VSS VSS gf180mcu_fd_sc_mcu9t5v0__filltie
X_17122_ _17378_/A1 _18507_/Q _17125_/A2 VSS VSS VSS VSS gf180mcu_fd_sc_mcu9t5v0__nor2_1
X_14334_ _14364_/I0 _19406_/Q _14337_/S _19406_/D VSS _14334_/VNW VSS VSS gf180mcu_fd_sc_mcu9t5v0__mux2_1
X_11546_ _11546_/A1 _11966_/B _19106_/D VSS VSS VSS VSS gf180mcu_fd_sc_mcu9t5v0__nand2_1
XTAP_TAPCELL_ROW_305_7445 VSS VSS gf180mcu_fd_sc_mcu9t5v0__filltie
X_17053_ _16660_/B _19257_/Q _17057_/S _17053_/Z VSS VSS VSS VSS gf180mcu_fd_sc_mcu9t5v0__mux2_1
XTAP_TAPCELL_ROW_111_4045 VSS VSS gf180mcu_fd_sc_mcu9t5v0__filltie
XTAP_TAPCELL_ROW_111_4034 VSS VSS gf180mcu_fd_sc_mcu9t5v0__filltie
XTAP_TAPCELL_ROW_111_4023 VSS VSS gf180mcu_fd_sc_mcu9t5v0__filltie
X_14265_ _14265_/A1 _14265_/A2 _14265_/A3 _14322_/I0 VSS _14265_/VNW VSS VSS gf180mcu_fd_sc_mcu9t5v0__nor3_2
XTAP_TAPCELL_ROW_305_7467 VSS VSS gf180mcu_fd_sc_mcu9t5v0__filltie
XTAP_TAPCELL_ROW_305_7456 VSS VSS gf180mcu_fd_sc_mcu9t5v0__filltie
X_16004_ _19260_/Q _15996_/B _16004_/B1 _16117_/C _16004_/C _16005_/A2 VSS VSS VSS
+ VSS gf180mcu_fd_sc_mcu9t5v0__aoi221_1
X_11477_ _11477_/A1 _11477_/A2 _19100_/D VSS VSS VSS VSS gf180mcu_fd_sc_mcu9t5v0__nand2_1
X_13216_ _13497_/A1 _13216_/A2 _13497_/B _13217_/B2 VSS VSS VSS VSS gf180mcu_fd_sc_mcu9t5v0__aoi21_1
X_10428_ _09261_/I _10428_/A2 _10428_/A3 _10428_/B _10437_/A2 VSS VSS VSS VSS gf180mcu_fd_sc_mcu9t5v0__oai31_1
XTAP_TAPCELL_ROW_297_7235 VSS VSS gf180mcu_fd_sc_mcu9t5v0__filltie
X_14196_ _19323_/Q _14196_/A2 _14198_/A2 VSS VSS VSS VSS gf180mcu_fd_sc_mcu9t5v0__nand2_1
XTAP_TAPCELL_ROW_297_7246 VSS VSS gf180mcu_fd_sc_mcu9t5v0__filltie
X_10359_ _18591_/Q _17409_/B _17225_/B _10359_/C _10360_/A3 VSS VSS VSS VSS gf180mcu_fd_sc_mcu9t5v0__oai211_1
X_13147_ _19728_/Q _19760_/Q _13147_/A3 _13148_/A2 VSS VSS VSS VSS gf180mcu_fd_sc_mcu9t5v0__xnor3_1
XTAP_TAPCELL_ROW_318_7817 VSS VSS gf180mcu_fd_sc_mcu9t5v0__filltie
XTAP_TAPCELL_ROW_318_7806 VSS VSS gf180mcu_fd_sc_mcu9t5v0__filltie
XTAP_TAPCELL_ROW_124_4406 VSS VSS gf180mcu_fd_sc_mcu9t5v0__filltie
X_13078_ _13088_/A1 _13075_/Z _13079_/A2 VSS VSS VSS VSS gf180mcu_fd_sc_mcu9t5v0__nand2_1
X_17955_ _18855_/Q _17951_/Z _17956_/A2 VSS _17955_/VNW VSS VSS gf180mcu_fd_sc_mcu9t5v0__xnor2_1
XTAP_TAPCELL_ROW_318_7828 VSS VSS gf180mcu_fd_sc_mcu9t5v0__filltie
X_16906_ _16905_/Z _18445_/Q _16928_/S _18445_/D VSS _16906_/VNW VSS VSS gf180mcu_fd_sc_mcu9t5v0__mux2_1
X_12029_ _18907_/Q _12689_/C _12333_/B _12029_/C _12031_/A1 VSS _12052_/VNW VSS VSS
+ gf180mcu_fd_sc_mcu9t5v0__oai211_1
X_17886_ _18060_/B _17886_/A2 _17887_/I VSS _17909_/VNW VSS VSS gf180mcu_fd_sc_mcu9t5v0__nor2_1
X_16837_ _19246_/Q _16584_/B _16861_/S _16837_/Z VSS VSS VSS VSS gf180mcu_fd_sc_mcu9t5v0__mux2_1
X_19625_ _19625_/D _20073_/RN clkload24/I _19625_/Q VSS VSS VSS VSS gf180mcu_fd_sc_mcu9t5v0__dffrnq_1
X_16768_ _16767_/Z _18383_/Q _16770_/S _18383_/D VSS VSS VSS VSS gf180mcu_fd_sc_mcu9t5v0__mux2_1
X_19556_ _19556_/D _20068_/RN clkload9/I _19556_/Q VSS VSS VSS VSS gf180mcu_fd_sc_mcu9t5v0__dffrnq_1
X_18507_ _18507_/D _18510_/CLK _18507_/Q VSS VSS VSS VSS gf180mcu_fd_sc_mcu9t5v0__dffq_1
X_15719_ _15729_/A1 _15719_/A2 _19921_/D VSS _15719_/VNW VSS VSS gf180mcu_fd_sc_mcu9t5v0__nor2_1
X_16699_ _19281_/Q _16695_/B _16703_/A2 VSS VSS VSS VSS gf180mcu_fd_sc_mcu9t5v0__nor2_1
X_09240_ _20067_/Q _10831_/B2 VSS _09743_/VNW VSS VSS gf180mcu_fd_sc_mcu9t5v0__clkinv_1
X_19487_ _19487_/D _20063_/RN clkload13/I _19487_/Q VSS VSS VSS VSS gf180mcu_fd_sc_mcu9t5v0__dffrnq_1
X_18438_ _18438_/D clkload77/I _18438_/Q VSS VSS VSS VSS gf180mcu_fd_sc_mcu9t5v0__dffq_1
X_18369_ _18369_/D _18369_/CLK _18369_/Q VSS VSS VSS VSS gf180mcu_fd_sc_mcu9t5v0__dffq_4
X_09171_ _19110_/Q _13698_/A2 VSS VSS VSS VSS gf180mcu_fd_sc_mcu9t5v0__clkinv_1
XTAP_TAPCELL_ROW_282_6825 VSS VSS gf180mcu_fd_sc_mcu9t5v0__filltie
XTAP_TAPCELL_ROW_282_6814 VSS VSS gf180mcu_fd_sc_mcu9t5v0__filltie
XTAP_TAPCELL_ROW_282_6836 VSS VSS gf180mcu_fd_sc_mcu9t5v0__filltie
Xoutput19 output19/I dout_valid_o VSS VSS VSS VSS gf180mcu_fd_sc_mcu9t5v0__dlyd_1
XPHY_EDGE_ROW_131_Right_131 VSS VSS gf180mcu_fd_sc_mcu9t5v0__endcap
XTAP_TAPCELL_ROW_161_3_8086 VSS VSS gf180mcu_fd_sc_mcu9t5v0__filltie
XTAP_TAPCELL_ROW_107_3925 VSS VSS gf180mcu_fd_sc_mcu9t5v0__filltie
XTAP_TAPCELL_ROW_107_3914 VSS VSS gf180mcu_fd_sc_mcu9t5v0__filltie
XTAP_TAPCELL_ROW_107_3936 VSS VSS gf180mcu_fd_sc_mcu9t5v0__filltie
XTAP_TAPCELL_ROW_49_2320 VSS VSS gf180mcu_fd_sc_mcu9t5v0__filltie
XTAP_TAPCELL_ROW_49_2331 VSS VSS gf180mcu_fd_sc_mcu9t5v0__filltie
XTAP_TAPCELL_ROW_49_2342 VSS VSS gf180mcu_fd_sc_mcu9t5v0__filltie
XTAP_TAPCELL_ROW_216_5024 VSS VSS gf180mcu_fd_sc_mcu9t5v0__filltie
XTAP_TAPCELL_ROW_216_5013 VSS VSS gf180mcu_fd_sc_mcu9t5v0__filltie
XTAP_TAPCELL_ROW_216_5002 VSS VSS gf180mcu_fd_sc_mcu9t5v0__filltie
XTAP_TAPCELL_ROW_45_2217 VSS VSS gf180mcu_fd_sc_mcu9t5v0__filltie
XTAP_TAPCELL_ROW_45_2228 VSS VSS gf180mcu_fd_sc_mcu9t5v0__filltie
X_09507_ _19123_/Q _14730_/S _17960_/A3 VSS VSS VSS VSS gf180mcu_fd_sc_mcu9t5v0__nand2_1
XTAP_TAPCELL_ROW_252_5994 VSS VSS gf180mcu_fd_sc_mcu9t5v0__filltie
X_09438_ _19993_/Q _19994_/Q _09438_/B _09445_/A3 VSS VSS VSS VSS gf180mcu_fd_sc_mcu9t5v0__oai21_4
X_09369_ _18214_/Q _16288_/A1 VSS _09369_/VNW VSS VSS gf180mcu_fd_sc_mcu9t5v0__clkinv_1
X_11400_ _18526_/Q _18510_/Q _18494_/Q _18478_/Q _11524_/S _11176_/C _11400_/Z VSS
+ VSS VSS VSS gf180mcu_fd_sc_mcu9t5v0__mux4_1
X_12380_ _12628_/A1 _12355_/I _12380_/A3 _12380_/B _19143_/D VSS _12380_/VNW VSS VSS
+ gf180mcu_fd_sc_mcu9t5v0__oai31_1
X_11331_ _11331_/A1 _11331_/A2 _11429_/B _11331_/C _11333_/B VSS _12022_/VNW VSS VSS
+ gf180mcu_fd_sc_mcu9t5v0__oai211_1
XTAP_TAPCELL_ROW_21_1560 VSS VSS gf180mcu_fd_sc_mcu9t5v0__filltie
XTAP_TAPCELL_ROW_21_1571 VSS VSS gf180mcu_fd_sc_mcu9t5v0__filltie
X_11262_ _18308_/Q _11534_/S _11265_/A1 VSS VSS VSS VSS gf180mcu_fd_sc_mcu9t5v0__nor2_1
X_14050_ _19321_/Q _19298_/Q _14049_/Z _14080_/B VSS VSS VSS VSS gf180mcu_fd_sc_mcu9t5v0__nand3_1
XTAP_TAPCELL_ROW_300_7331 VSS VSS gf180mcu_fd_sc_mcu9t5v0__filltie
XTAP_TAPCELL_ROW_300_7320 VSS VSS gf180mcu_fd_sc_mcu9t5v0__filltie
X_11193_ _18207_/Q _11534_/S _11194_/C VSS VSS VSS VSS gf180mcu_fd_sc_mcu9t5v0__or2_1
X_10213_ _10213_/A1 _10211_/Z _15544_/S VSS VSS VSS VSS gf180mcu_fd_sc_mcu9t5v0__nor2_2
X_13001_ _13005_/A1 _13001_/A2 _13511_/B VSS VSS VSS VSS gf180mcu_fd_sc_mcu9t5v0__xnor2_1
X_10144_ _19251_/Q wire297/Z _09998_/C _19235_/Q _10144_/C _10164_/A2 VSS VSS VSS
+ VSS gf180mcu_fd_sc_mcu9t5v0__aoi221_1
XTAP_TAPCELL_ROW_34_1910 VSS VSS gf180mcu_fd_sc_mcu9t5v0__filltie
XTAP_TAPCELL_ROW_34_1921 VSS VSS gf180mcu_fd_sc_mcu9t5v0__filltie
XTAP_TAPCELL_ROW_292_7110 VSS VSS gf180mcu_fd_sc_mcu9t5v0__filltie
X_10075_ _10105_/A1 _10075_/A2 _10079_/B VSS _10478_/VNW VSS VSS gf180mcu_fd_sc_mcu9t5v0__nand2_1
X_17740_ _18746_/Q _17681_/S _17741_/B VSS VSS VSS VSS gf180mcu_fd_sc_mcu9t5v0__nand2_1
XTAP_TAPCELL_ROW_30_1807 VSS VSS gf180mcu_fd_sc_mcu9t5v0__filltie
XTAP_TAPCELL_ROW_30_1818 VSS VSS gf180mcu_fd_sc_mcu9t5v0__filltie
X_14952_ _19425_/Q _19370_/Q _14957_/B VSS VSS VSS VSS gf180mcu_fd_sc_mcu9t5v0__nand2_1
XPHY_EDGE_ROW_310_Right_237 VSS VSS gf180mcu_fd_sc_mcu9t5v0__endcap
X_17671_ _18634_/Q _18710_/Q _17681_/S _18710_/D VSS VSS VSS VSS gf180mcu_fd_sc_mcu9t5v0__mux2_1
X_14883_ _14883_/A1 _14881_/Z _14884_/A2 VSS VSS VSS VSS gf180mcu_fd_sc_mcu9t5v0__xnor2_1
X_13903_ _13903_/A1 _13901_/Z _13906_/A2 VSS VSS VSS VSS gf180mcu_fd_sc_mcu9t5v0__xnor2_1
XTAP_TAPCELL_ROW_15_1386 VSS VSS gf180mcu_fd_sc_mcu9t5v0__filltie
XTAP_TAPCELL_ROW_15_1397 VSS VSS gf180mcu_fd_sc_mcu9t5v0__filltie
X_16622_ _16668_/A1 _16668_/A2 _16622_/B _16624_/A2 VSS VSS VSS VSS gf180mcu_fd_sc_mcu9t5v0__aoi21_1
X_13834_ _13834_/A1 _13836_/A1 _13834_/A3 _14359_/I0 VSS _15216_/VNW VSS VSS gf180mcu_fd_sc_mcu9t5v0__xnor3_1
X_19410_ _19410_/D _20050_/RN clkload7/I _19410_/Q VSS VSS VSS VSS gf180mcu_fd_sc_mcu9t5v0__dffrnq_1
Xmax_cap50 _16971_/S _16991_/S VSS VSS VSS VSS gf180mcu_fd_sc_mcu9t5v0__clkbuf_16
Xmax_cap72 _16668_/A2 _16674_/A2 VSS VSS VSS VSS gf180mcu_fd_sc_mcu9t5v0__clkbuf_8
Xmax_cap61 _17673_/S _17685_/S VSS VSS VSS VSS gf180mcu_fd_sc_mcu9t5v0__clkbuf_8
X_19341_ _19341_/D _20045_/RN clkload17/I _19341_/Q VSS VSS VSS VSS gf180mcu_fd_sc_mcu9t5v0__dffrnq_1
X_16553_ _18336_/Q _16151_/B _17067_/S _18336_/D VSS VSS VSS VSS gf180mcu_fd_sc_mcu9t5v0__mux2_4
X_10977_ _10979_/A1 _10979_/A2 _10977_/Z VSS VSS VSS VSS gf180mcu_fd_sc_mcu9t5v0__xor2_1
XTAP_TAPCELL_ROW_28_1747 VSS VSS gf180mcu_fd_sc_mcu9t5v0__filltie
X_13765_ _19294_/Q _19317_/Q _13803_/A2 VSS VSS VSS VSS gf180mcu_fd_sc_mcu9t5v0__nand2_1
X_16484_ _18299_/Q _16483_/Z _17006_/S _18299_/D VSS _17179_/VNW VSS VSS gf180mcu_fd_sc_mcu9t5v0__mux2_1
X_15504_ _19830_/Q _19839_/Q _15504_/A3 _15507_/A2 VSS _15504_/VNW VSS VSS gf180mcu_fd_sc_mcu9t5v0__nand3_1
XTAP_TAPCELL_ROW_117_4210 VSS VSS gf180mcu_fd_sc_mcu9t5v0__filltie
X_19272_ _19272_/D _20040_/RN clkload42/I _19272_/Q VSS VSS VSS VSS gf180mcu_fd_sc_mcu9t5v0__dffrnq_1
X_13696_ _19444_/Q _14286_/A2 _13745_/B1 _19461_/Q _13656_/Z _19470_/Q _13697_/A2
+ VSS VSS VSS VSS gf180mcu_fd_sc_mcu9t5v0__aoi222_1
X_12716_ _12716_/I0 _12716_/I1 _12716_/S _12716_/Z VSS VSS VSS VSS gf180mcu_fd_sc_mcu9t5v0__mux2_1
XTAP_TAPCELL_ROW_28_1758 VSS VSS gf180mcu_fd_sc_mcu9t5v0__filltie
X_15435_ _10648_/C _15431_/Z _15472_/A2 VSS VSS VSS VSS gf180mcu_fd_sc_mcu9t5v0__nand2_1
X_18223_ _18223_/D clkload72/I _18223_/Q VSS VSS VSS VSS gf180mcu_fd_sc_mcu9t5v0__dffq_4
X_12647_ _12647_/I0 _19177_/Q _12655_/S _19177_/D VSS _12704_/VNW VSS VSS gf180mcu_fd_sc_mcu9t5v0__mux2_1
XTAP_TAPCELL_ROW_307_7518 VSS VSS gf180mcu_fd_sc_mcu9t5v0__filltie
XTAP_TAPCELL_ROW_307_7507 VSS VSS gf180mcu_fd_sc_mcu9t5v0__filltie
X_18154_ _18154_/D clkload53/I _18154_/Q VSS VSS VSS VSS gf180mcu_fd_sc_mcu9t5v0__dffq_1
X_15366_ _19651_/Q _19751_/Q _15417_/S _19751_/D VSS VSS VSS VSS gf180mcu_fd_sc_mcu9t5v0__mux2_1
X_17105_ _19825_/Q _18522_/Q _17107_/A3 VSS VSS VSS VSS gf180mcu_fd_sc_mcu9t5v0__nor2_1
X_12578_ wire175/Z _12578_/A2 _12618_/B _12580_/A3 VSS VSS VSS VSS gf180mcu_fd_sc_mcu9t5v0__aoi21_1
X_11529_ _19104_/Q _11541_/A2 _11530_/A2 VSS _11529_/VNW VSS VSS gf180mcu_fd_sc_mcu9t5v0__nand2_1
X_18085_ _18933_/Q _18932_/Q _18086_/A2 VSS _18090_/VNW VSS VSS gf180mcu_fd_sc_mcu9t5v0__xnor2_1
Xwire282 wire282/I wire282/Z VSS VSS VSS VSS gf180mcu_fd_sc_mcu9t5v0__buf_4
X_15297_ _15296_/Z _19736_/Q _15417_/S _19736_/D VSS _15313_/VNW VSS VSS gf180mcu_fd_sc_mcu9t5v0__mux2_1
X_14317_ _14366_/I0 _19390_/Q _14322_/S _19390_/D VSS VSS VSS VSS gf180mcu_fd_sc_mcu9t5v0__mux2_1
X_17036_ _17035_/Z _18509_/Q _17050_/S _18509_/D VSS VSS VSS VSS gf180mcu_fd_sc_mcu9t5v0__mux2_4
XTAP_TAPCELL_ROW_91_3483 VSS VSS gf180mcu_fd_sc_mcu9t5v0__filltie
X_14248_ _14115_/Z _14249_/A2 _14263_/A2 VSS _14248_/VNW VSS VSS gf180mcu_fd_sc_mcu9t5v0__nor2_1
XTAP_TAPCELL_ROW_91_3472 VSS VSS gf180mcu_fd_sc_mcu9t5v0__filltie
XTAP_TAPCELL_ROW_91_3494 VSS VSS gf180mcu_fd_sc_mcu9t5v0__filltie
X_14179_ _14364_/I0 _19334_/Q _14266_/S _19334_/D VSS VSS VSS VSS gf180mcu_fd_sc_mcu9t5v0__mux2_1
Xload_slew221 _20041_/Q _09916_/B VSS VSS VSS VSS gf180mcu_fd_sc_mcu9t5v0__buf_8
X_18987_ _18987_/D _20139_/RN _20099_/CLK _18987_/Q VSS VSS VSS VSS gf180mcu_fd_sc_mcu9t5v0__dffrnq_1
XTAP_TAPCELL_ROW_275_6640 VSS VSS gf180mcu_fd_sc_mcu9t5v0__filltie
Xload_slew298 _17144_/A2 _10648_/C VSS VSS VSS VSS gf180mcu_fd_sc_mcu9t5v0__clkbuf_8
Xload_slew287 _10216_/ZN _10643_/A1 VSS VSS VSS VSS gf180mcu_fd_sc_mcu9t5v0__buf_2
Xload_slew276 wire277/Z _13043_/I VSS VSS VSS VSS gf180mcu_fd_sc_mcu9t5v0__clkbuf_4
X_17938_ _18850_/Q _17938_/A2 _17938_/Z VSS VSS VSS VSS gf180mcu_fd_sc_mcu9t5v0__xor2_1
XTAP_TAPCELL_ROW_137_3_8004 VSS VSS gf180mcu_fd_sc_mcu9t5v0__filltie
X_17869_ _17869_/A1 _17869_/A2 _17870_/A3 VSS _17870_/VNW VSS VSS gf180mcu_fd_sc_mcu9t5v0__nand2_1
XTAP_TAPCELL_ROW_271_6526 VSS VSS gf180mcu_fd_sc_mcu9t5v0__filltie
XTAP_TAPCELL_ROW_271_6515 VSS VSS gf180mcu_fd_sc_mcu9t5v0__filltie
XTAP_TAPCELL_ROW_102_3800 VSS VSS gf180mcu_fd_sc_mcu9t5v0__filltie
X_19608_ _19608_/D _19992_/RN _19633_/CLK _19608_/Q VSS VSS VSS VSS gf180mcu_fd_sc_mcu9t5v0__dffrnq_1
X_19539_ _19539_/D _20051_/RN _19798_/CLK _19539_/Q VSS VSS VSS VSS gf180mcu_fd_sc_mcu9t5v0__dffrnq_1
XPHY_EDGE_ROW_191_1_Left_514 VSS VSS gf180mcu_fd_sc_mcu9t5v0__endcap
XTAP_TAPCELL_ROW_269_6466 VSS VSS gf180mcu_fd_sc_mcu9t5v0__filltie
XTAP_TAPCELL_ROW_269_6455 VSS VSS gf180mcu_fd_sc_mcu9t5v0__filltie
X_09223_ _19577_/Q _15258_/B2 VSS VSS VSS VSS gf180mcu_fd_sc_mcu9t5v0__clkinv_1
XTAP_TAPCELL_ROW_269_6477 VSS VSS gf180mcu_fd_sc_mcu9t5v0__filltie
X_09154_ _19742_/Q _13373_/A1 VSS _13609_/VNW VSS VSS gf180mcu_fd_sc_mcu9t5v0__clkinv_1
X_09085_ _18828_/Q _17865_/B VSS VSS VSS VSS gf180mcu_fd_sc_mcu9t5v0__clkinv_1
XTAP_TAPCELL_ROW_38_2021 VSS VSS gf180mcu_fd_sc_mcu9t5v0__filltie
Xclkbuf_leaf_53_clk_regs clkload2/I clkload40/I VSS VSS VSS VSS gf180mcu_fd_sc_mcu9t5v0__clkbuf_8
XTAP_TAPCELL_ROW_38_2032 VSS VSS gf180mcu_fd_sc_mcu9t5v0__filltie
X_09987_ _10064_/S _10841_/A2 _09987_/B _09995_/A2 VSS VSS VSS VSS gf180mcu_fd_sc_mcu9t5v0__oai21_1
XTAP_TAPCELL_ROW_241_5695 VSS VSS gf180mcu_fd_sc_mcu9t5v0__filltie
XTAP_TAPCELL_ROW_70_2899 VSS VSS gf180mcu_fd_sc_mcu9t5v0__filltie
X_10900_ _10899_/Z _18989_/Q _18152_/S _18989_/D VSS VSS VSS VSS gf180mcu_fd_sc_mcu9t5v0__mux2_1
XTAP_TAPCELL_ROW_10_1250 VSS VSS gf180mcu_fd_sc_mcu9t5v0__filltie
XTAP_TAPCELL_ROW_10_1261 VSS VSS gf180mcu_fd_sc_mcu9t5v0__filltie
X_11880_ _11966_/B _11880_/A2 _11880_/A3 _11880_/B _19116_/D VSS VSS VSS VSS gf180mcu_fd_sc_mcu9t5v0__oai31_1
X_10831_ _15936_/C _10834_/A2 _10831_/A3 _09749_/B _10831_/B2 _20067_/D VSS VSS VSS
+ VSS gf180mcu_fd_sc_mcu9t5v0__oai32_1
X_13550_ _13551_/A1 _13551_/B _13551_/A2 _13550_/Z VSS _13550_/VNW VSS VSS gf180mcu_fd_sc_mcu9t5v0__and3_1
X_10762_ _18852_/Q _10762_/A2 _10763_/B VSS _10762_/VNW VSS VSS gf180mcu_fd_sc_mcu9t5v0__nand2_1
XPHY_EDGE_ROW_11_Right_11 VSS VSS gf180mcu_fd_sc_mcu9t5v0__endcap
X_12501_ _18442_/Q _12501_/A2 _12541_/B _12501_/C _12502_/B VSS VSS VSS VSS gf180mcu_fd_sc_mcu9t5v0__oai211_1
X_13481_ _13497_/A1 _13493_/A2 _13482_/A2 VSS _13482_/VNW VSS VSS gf180mcu_fd_sc_mcu9t5v0__nor2_1
X_12432_ _18258_/Q _12615_/A2 _12434_/B1 VSS VSS VSS VSS gf180mcu_fd_sc_mcu9t5v0__nor2_1
X_10693_ _10693_/A1 _10693_/A2 _10693_/B _10696_/B1 VSS VSS VSS VSS gf180mcu_fd_sc_mcu9t5v0__oai21_1
X_15220_ _15225_/A1 _19571_/Q _15229_/A1 VSS VSS VSS VSS gf180mcu_fd_sc_mcu9t5v0__nor2_1
XTAP_TAPCELL_ROW_23_1611 VSS VSS gf180mcu_fd_sc_mcu9t5v0__filltie
XTAP_TAPCELL_ROW_23_1622 VSS VSS gf180mcu_fd_sc_mcu9t5v0__filltie
X_12363_ _18731_/Q _12527_/A2 _12543_/B1 _12363_/B2 _12364_/A3 VSS VSS VSS VSS gf180mcu_fd_sc_mcu9t5v0__aoi22_2
X_15151_ _19693_/Q _19533_/Q wire108/Z _19693_/D VSS _15151_/VNW VSS VSS gf180mcu_fd_sc_mcu9t5v0__mux2_1
X_11314_ _18312_/Q _11534_/S _11317_/A1 VSS _11314_/VNW VSS VSS gf180mcu_fd_sc_mcu9t5v0__nor2_1
X_12294_ wire208/Z _12306_/A2 _12295_/B VSS VSS VSS VSS gf180mcu_fd_sc_mcu9t5v0__and2_1
X_14102_ _14102_/A1 _14102_/A2 _14102_/B _14183_/A1 VSS _14102_/VNW VSS VSS gf180mcu_fd_sc_mcu9t5v0__oai21_1
X_15082_ _15082_/A1 _15086_/A2 _15083_/I1 VSS _15082_/VNW VSS VSS gf180mcu_fd_sc_mcu9t5v0__xnor2_1
X_11245_ _18243_/Q _11485_/C _11249_/C VSS VSS VSS VSS gf180mcu_fd_sc_mcu9t5v0__nand2_1
XTAP_TAPCELL_ROW_143_3_8025 VSS VSS gf180mcu_fd_sc_mcu9t5v0__filltie
X_14033_ _14033_/A1 _14033_/A2 _14033_/B _14061_/A2 VSS VSS VSS VSS gf180mcu_fd_sc_mcu9t5v0__oai21_1
X_18910_ _18910_/D _20062_/RN clkload10/I _18910_/Q VSS VSS VSS VSS gf180mcu_fd_sc_mcu9t5v0__dffrnq_1
X_19890_ _19890_/D _20018_/RN clkload71/I _19890_/Q VSS VSS VSS VSS gf180mcu_fd_sc_mcu9t5v0__dffrnq_1
XPHY_EDGE_ROW_20_Right_20 VSS VSS gf180mcu_fd_sc_mcu9t5v0__endcap
X_11176_ _18238_/Q _11483_/B _11176_/B _11176_/C _11177_/A3 VSS VSS VSS VSS gf180mcu_fd_sc_mcu9t5v0__oai211_1
XTAP_TAPCELL_ROW_17_1437 VSS VSS gf180mcu_fd_sc_mcu9t5v0__filltie
X_18841_ _18841_/D _20057_/RN clkload33/I _18841_/Q VSS VSS VSS VSS gf180mcu_fd_sc_mcu9t5v0__dffrnq_1
XTAP_TAPCELL_ROW_17_1448 VSS VSS gf180mcu_fd_sc_mcu9t5v0__filltie
XTAP_TAPCELL_ROW_17_1459 VSS VSS gf180mcu_fd_sc_mcu9t5v0__filltie
X_10127_ _09916_/B _10127_/A2 _10132_/B1 VSS VSS VSS VSS gf180mcu_fd_sc_mcu9t5v0__nand2_1
X_18772_ _18772_/D _20052_/RN clkload51/I _18772_/Q VSS VSS VSS VSS gf180mcu_fd_sc_mcu9t5v0__dffrnq_1
X_15984_ _15953_/B _15989_/A4 _15988_/A2 _15985_/C VSS VSS VSS VSS gf180mcu_fd_sc_mcu9t5v0__nor3_2
X_17723_ _17723_/I _18737_/D VSS _17723_/VNW VSS VSS gf180mcu_fd_sc_mcu9t5v0__clkinv_1
X_10058_ _19199_/Q _10172_/A2 _10074_/A2 _19207_/Q _10169_/B1 _19239_/Q _10059_/A4
+ VSS VSS VSS VSS gf180mcu_fd_sc_mcu9t5v0__aoi222_1
X_14935_ _19359_/Q _14935_/A2 _14937_/S _14936_/I1 VSS _14936_/VNW VSS VSS gf180mcu_fd_sc_mcu9t5v0__xnor3_1
X_17654_ _17654_/A1 _17653_/Z _18694_/D VSS VSS VSS VSS gf180mcu_fd_sc_mcu9t5v0__nand2_1
X_14866_ _19590_/Q _14865_/Z _20039_/D _19590_/D VSS VSS VSS VSS gf180mcu_fd_sc_mcu9t5v0__mux2_1
X_16605_ _19217_/Q _16604_/Z _16612_/S _16606_/B VSS VSS VSS VSS gf180mcu_fd_sc_mcu9t5v0__mux2_1
X_17585_ _18653_/Q _17577_/S _17587_/A1 VSS _17709_/VNW VSS VSS gf180mcu_fd_sc_mcu9t5v0__nand2_1
X_13817_ _19292_/Q _19321_/Q _13818_/A1 _13861_/A1 VSS VSS VSS VSS gf180mcu_fd_sc_mcu9t5v0__nand3_1
X_14797_ _14797_/A1 _14795_/Z _14799_/A2 VSS VSS VSS VSS gf180mcu_fd_sc_mcu9t5v0__xnor2_1
X_16536_ _16535_/Z _18324_/Q _17054_/S _18324_/D VSS VSS VSS VSS gf180mcu_fd_sc_mcu9t5v0__mux2_4
XTAP_TAPCELL_ROW_80_3195 VSS VSS gf180mcu_fd_sc_mcu9t5v0__filltie
XTAP_TAPCELL_ROW_80_3184 VSS VSS gf180mcu_fd_sc_mcu9t5v0__filltie
X_19324_ _19324_/D _20028_/RN clkload7/I _19324_/Q VSS VSS VSS VSS gf180mcu_fd_sc_mcu9t5v0__dffrnq_1
X_13748_ _13748_/A1 _14675_/A1 _13748_/B _13751_/A1 VSS _17825_/VNW VSS VSS gf180mcu_fd_sc_mcu9t5v0__aoi21_1
XTAP_TAPCELL_ROW_80_3173 VSS VSS gf180mcu_fd_sc_mcu9t5v0__filltie
X_19255_ _19255_/D _20023_/RN clkload39/I _19255_/Q VSS VSS VSS VSS gf180mcu_fd_sc_mcu9t5v0__dffrnq_2
X_18206_ _18206_/D clkload72/I _18206_/Q VSS VSS VSS VSS gf180mcu_fd_sc_mcu9t5v0__dffq_4
X_16467_ _19239_/Q _16172_/C _16993_/S _16467_/Z VSS _16467_/VNW VSS VSS gf180mcu_fd_sc_mcu9t5v0__mux2_1
XPHY_EDGE_ROW_143_2_Left_655 VSS VSS gf180mcu_fd_sc_mcu9t5v0__endcap
X_13679_ _19459_/Q _13745_/B1 _13656_/Z _19468_/Q _13681_/A1 VSS VSS VSS VSS gf180mcu_fd_sc_mcu9t5v0__aoi22_1
X_16398_ _16397_/Z _18262_/Q _16924_/S _18262_/D VSS VSS VSS VSS gf180mcu_fd_sc_mcu9t5v0__mux2_1
X_19186_ _19186_/D _20018_/RN clkload12/I _19186_/Q VSS VSS VSS VSS gf180mcu_fd_sc_mcu9t5v0__dffrnq_1
X_15418_ _19703_/Q _19803_/Q _15430_/S _19803_/D VSS _15418_/VNW VSS VSS gf180mcu_fd_sc_mcu9t5v0__mux2_1
XTAP_TAPCELL_ROW_93_3534 VSS VSS gf180mcu_fd_sc_mcu9t5v0__filltie
XTAP_TAPCELL_ROW_264_6341 VSS VSS gf180mcu_fd_sc_mcu9t5v0__filltie
XTAP_TAPCELL_ROW_264_6330 VSS VSS gf180mcu_fd_sc_mcu9t5v0__filltie
X_18137_ _19213_/Q _19219_/Q _18151_/S _18137_/Z VSS _18137_/VNW VSS VSS gf180mcu_fd_sc_mcu9t5v0__mux2_1
XTAP_TAPCELL_ROW_93_3545 VSS VSS gf180mcu_fd_sc_mcu9t5v0__filltie
X_15349_ _15353_/A1 _15349_/A2 _15350_/I1 VSS VSS VSS VSS gf180mcu_fd_sc_mcu9t5v0__xnor2_1
XTAP_TAPCELL_ROW_260_6227 VSS VSS gf180mcu_fd_sc_mcu9t5v0__filltie
XTAP_TAPCELL_ROW_260_6216 VSS VSS gf180mcu_fd_sc_mcu9t5v0__filltie
X_18068_ _18068_/A1 _18100_/A1 _18068_/B _18927_/D VSS _18068_/VNW VSS VSS gf180mcu_fd_sc_mcu9t5v0__oai21_1
X_17019_ _19256_/Q _16654_/B _17023_/S _17019_/Z VSS _17019_/VNW VSS VSS gf180mcu_fd_sc_mcu9t5v0__mux2_1
X_09910_ _15830_/A2 _10054_/A2 _10138_/A2 VSS VSS VSS VSS gf180mcu_fd_sc_mcu9t5v0__nor2_2
X_09841_ _09841_/I _20030_/D VSS _09841_/VNW VSS VSS gf180mcu_fd_sc_mcu9t5v0__clkinv_1
X_20030_ _20030_/D _20030_/RN clkload50/I _20030_/Q VSS VSS VSS VSS gf180mcu_fd_sc_mcu9t5v0__dffrnq_2
X_09772_ _09772_/A1 _09772_/A2 _09773_/B VSS VSS VSS VSS gf180mcu_fd_sc_mcu9t5v0__nand2_1
XTAP_TAPCELL_ROW_258_6178 VSS VSS gf180mcu_fd_sc_mcu9t5v0__filltie
XTAP_TAPCELL_ROW_258_6167 VSS VSS gf180mcu_fd_sc_mcu9t5v0__filltie
XTAP_TAPCELL_ROW_258_6156 VSS VSS gf180mcu_fd_sc_mcu9t5v0__filltie
XTAP_TAPCELL_ROW_156_3_8070 VSS VSS gf180mcu_fd_sc_mcu9t5v0__filltie
XTAP_TAPCELL_ROW_7_1171 VSS VSS gf180mcu_fd_sc_mcu9t5v0__filltie
XTAP_TAPCELL_ROW_7_1182 VSS VSS gf180mcu_fd_sc_mcu9t5v0__filltie
XTAP_TAPCELL_ROW_3_1057 VSS VSS gf180mcu_fd_sc_mcu9t5v0__filltie
XTAP_TAPCELL_ROW_3_1068 VSS VSS gf180mcu_fd_sc_mcu9t5v0__filltie
X_09206_ _19563_/Q _15187_/B1 VSS VSS VSS VSS gf180mcu_fd_sc_mcu9t5v0__clkinv_1
XTAP_TAPCELL_ROW_230_5396 VSS VSS gf180mcu_fd_sc_mcu9t5v0__filltie
XTAP_TAPCELL_ROW_230_5385 VSS VSS gf180mcu_fd_sc_mcu9t5v0__filltie
X_09137_ _19732_/Q _13215_/A1 VSS VSS VSS VSS gf180mcu_fd_sc_mcu9t5v0__clkinv_1
XTAP_TAPCELL_ROW_247_5860 VSS VSS gf180mcu_fd_sc_mcu9t5v0__filltie
Xrebuffer267 _16302_/ZN _16840_/S VSS VSS VSS VSS gf180mcu_fd_sc_mcu9t5v0__buf_8
X_09068_ _20043_/Q _10194_/A1 VSS VSS VSS VSS gf180mcu_fd_sc_mcu9t5v0__clkinv_1
XTAP_TAPCELL_ROW_247_5871 VSS VSS gf180mcu_fd_sc_mcu9t5v0__filltie
XTAP_TAPCELL_ROW_243_5757 VSS VSS gf180mcu_fd_sc_mcu9t5v0__filltie
XTAP_TAPCELL_ROW_243_5746 VSS VSS gf180mcu_fd_sc_mcu9t5v0__filltie
X_11030_ _19063_/Q _19031_/Q _11051_/S _19031_/D VSS _11030_/VNW VSS VSS gf180mcu_fd_sc_mcu9t5v0__mux2_1
XTAP_TAPCELL_ROW_12_1301 VSS VSS gf180mcu_fd_sc_mcu9t5v0__filltie
XTAP_TAPCELL_ROW_12_1312 VSS VSS gf180mcu_fd_sc_mcu9t5v0__filltie
XTAP_TAPCELL_ROW_12_1323 VSS VSS gf180mcu_fd_sc_mcu9t5v0__filltie
X_12981_ _12981_/A1 _19786_/Q _12996_/A1 VSS VSS VSS VSS gf180mcu_fd_sc_mcu9t5v0__nor2_1
X_11932_ _18245_/Q _12345_/A2 _11936_/A1 VSS VSS VSS VSS gf180mcu_fd_sc_mcu9t5v0__nand2_1
X_14720_ _19161_/Q _19127_/Q _14720_/B _14722_/A2 VSS _14720_/VNW VSS VSS gf180mcu_fd_sc_mcu9t5v0__aoi21_1
X_11863_ _18194_/Q _11862_/Z _12299_/S _11863_/Z VSS _16219_/VNW VSS VSS gf180mcu_fd_sc_mcu9t5v0__mux2_1
X_14651_ _13666_/B _14651_/A2 _14651_/B _14653_/A2 VSS _14651_/VNW VSS VSS gf180mcu_fd_sc_mcu9t5v0__oai21_1
X_17370_ _17370_/A1 _17370_/A2 _17370_/B _17411_/C _17371_/A2 VSS VSS VSS VSS gf180mcu_fd_sc_mcu9t5v0__oai211_1
X_10814_ _10818_/A2 _10814_/A2 _10816_/B1 VSS VSS VSS VSS gf180mcu_fd_sc_mcu9t5v0__nand2_1
X_13602_ _19283_/Q _13419_/B _13606_/B VSS _13602_/VNW VSS VSS gf180mcu_fd_sc_mcu9t5v0__nand2_1
X_16321_ _19237_/Q _16162_/B _16833_/S _16321_/Z VSS VSS VSS VSS gf180mcu_fd_sc_mcu9t5v0__mux2_1
X_11794_ _18896_/Q _11814_/A3 _12217_/B _11795_/A2 VSS _18012_/VNW VSS VSS gf180mcu_fd_sc_mcu9t5v0__oai21_1
X_14582_ _14578_/Z _14583_/A2 _14582_/Z VSS VSS VSS VSS gf180mcu_fd_sc_mcu9t5v0__or2_1
X_10745_ _17255_/B1 _10745_/A2 _10745_/Z VSS VSS VSS VSS gf180mcu_fd_sc_mcu9t5v0__or2_1
XTAP_TAPCELL_ROW_182_3_8160 VSS VSS gf180mcu_fd_sc_mcu9t5v0__filltie
X_13533_ _19268_/Q _13419_/B _13538_/B VSS VSS VSS VSS gf180mcu_fd_sc_mcu9t5v0__nand2_1
X_16252_ _18204_/Q _16252_/I1 _16798_/S _18204_/D VSS VSS VSS VSS gf180mcu_fd_sc_mcu9t5v0__mux2_1
X_13464_ _12948_/S _13480_/A2 _13465_/B VSS _13464_/VNW VSS VSS gf180mcu_fd_sc_mcu9t5v0__and2_1
X_10676_ wire282/Z _10675_/Z _10676_/B _10676_/ZN VSS _10676_/VNW VSS VSS gf180mcu_fd_sc_mcu9t5v0__aoi21_4
X_19040_ _19040_/D _20064_/RN clkload34/I _19040_/Q VSS VSS VSS VSS gf180mcu_fd_sc_mcu9t5v0__dffrnq_1
X_12415_ _18160_/Q _12613_/A2 _12419_/A2 VSS VSS VSS VSS gf180mcu_fd_sc_mcu9t5v0__nor2_1
X_16183_ _19241_/Q _16751_/A2 _16751_/A3 _16751_/B _16184_/A2 VSS VSS VSS VSS gf180mcu_fd_sc_mcu9t5v0__oai31_4
X_13395_ _13395_/A1 _13395_/A2 _13614_/B _13395_/B _13400_/B1 VSS _13395_/VNW VSS
+ VSS gf180mcu_fd_sc_mcu9t5v0__oai31_1
X_15203_ _15206_/A1 _19568_/Q _15209_/A2 VSS VSS VSS VSS gf180mcu_fd_sc_mcu9t5v0__nor2_1
X_12346_ _18520_/Q _12320_/C _12347_/B VSS _12347_/VNW VSS VSS gf180mcu_fd_sc_mcu9t5v0__nand2_1
XTAP_TAPCELL_ROW_131_4593 VSS VSS gf180mcu_fd_sc_mcu9t5v0__filltie
XTAP_TAPCELL_ROW_131_4582 VSS VSS gf180mcu_fd_sc_mcu9t5v0__filltie
X_15134_ _19676_/Q _19516_/Q wire108/Z _19676_/D VSS VSS VSS VSS gf180mcu_fd_sc_mcu9t5v0__mux2_1
XTAP_TAPCELL_ROW_162_3_8091 VSS VSS gf180mcu_fd_sc_mcu9t5v0__filltie
X_19942_ _19942_/D _20070_/RN clkload50/I _19942_/Q VSS VSS VSS VSS gf180mcu_fd_sc_mcu9t5v0__dffrnq_1
X_12277_ _18917_/Q _18918_/Q _12257_/B _12336_/B _12279_/A2 VSS _12297_/VNW VSS VSS
+ gf180mcu_fd_sc_mcu9t5v0__oai31_1
X_15065_ _15066_/A1 _15066_/A2 _15068_/B VSS _15201_/VNW VSS VSS gf180mcu_fd_sc_mcu9t5v0__nor2_1
X_19873_ _19873_/D _20065_/RN clkload56/I _19873_/Q VSS VSS VSS VSS gf180mcu_fd_sc_mcu9t5v0__dffrnq_1
X_11228_ _11228_/A1 _11228_/A2 _19081_/D VSS _11228_/VNW VSS VSS gf180mcu_fd_sc_mcu9t5v0__nand2_1
X_14016_ _14006_/Z _14039_/A2 _14016_/Z VSS VSS VSS VSS gf180mcu_fd_sc_mcu9t5v0__xor2_1
X_11159_ _18237_/Q _11483_/B _11159_/B _11176_/C _11160_/A3 VSS _11159_/VNW VSS VSS
+ gf180mcu_fd_sc_mcu9t5v0__oai211_1
X_18824_ _18824_/D _20040_/RN clkload55/I _18824_/Q VSS VSS VSS VSS gf180mcu_fd_sc_mcu9t5v0__dffrnq_1
X_18755_ _18755_/D _20035_/RN clkload49/I _18755_/Q VSS VSS VSS VSS gf180mcu_fd_sc_mcu9t5v0__dffrnq_1
X_15967_ _16234_/A2 _15964_/Z _15967_/B _15967_/C _15969_/B2 VSS VSS VSS VSS gf180mcu_fd_sc_mcu9t5v0__oai211_4
XTAP_TAPCELL_ROW_86_3360 VSS VSS gf180mcu_fd_sc_mcu9t5v0__filltie
X_15898_ _20107_/Q _19242_/Q _15927_/S _20107_/D VSS _15898_/VNW VSS VSS gf180mcu_fd_sc_mcu9t5v0__mux2_1
XTAP_TAPCELL_ROW_253_6031 VSS VSS gf180mcu_fd_sc_mcu9t5v0__filltie
XTAP_TAPCELL_ROW_253_6020 VSS VSS gf180mcu_fd_sc_mcu9t5v0__filltie
X_17706_ _18729_/Q _17742_/S _17743_/B _18653_/Q _17707_/A2 VSS _17707_/VNW VSS VSS
+ gf180mcu_fd_sc_mcu9t5v0__aoi22_1
XTAP_TAPCELL_ROW_82_3246 VSS VSS gf180mcu_fd_sc_mcu9t5v0__filltie
XTAP_TAPCELL_ROW_82_3235 VSS VSS gf180mcu_fd_sc_mcu9t5v0__filltie
X_18686_ _18686_/D _20026_/RN clkload27/I _18686_/Q VSS VSS VSS VSS gf180mcu_fd_sc_mcu9t5v0__dffrnq_1
X_14918_ _14918_/A1 _14918_/A2 _14930_/A1 VSS _14918_/VNW VSS VSS gf180mcu_fd_sc_mcu9t5v0__nor2_1
XTAP_TAPCELL_ROW_82_3224 VSS VSS gf180mcu_fd_sc_mcu9t5v0__filltie
X_17637_ _18687_/Q _17637_/A2 _18687_/D VSS VSS VSS VSS gf180mcu_fd_sc_mcu9t5v0__xor2_1
X_14849_ _14849_/A1 _19408_/Q _14852_/A1 _14850_/I1 VSS VSS VSS VSS gf180mcu_fd_sc_mcu9t5v0__xnor3_1
XTAP_TAPCELL_ROW_99_3710 VSS VSS gf180mcu_fd_sc_mcu9t5v0__filltie
X_17568_ _17570_/B _17568_/A2 _17586_/A2 VSS _17702_/VNW VSS VSS gf180mcu_fd_sc_mcu9t5v0__nand2_1
X_19307_ _19307_/D _20139_/RN clkload21/I _19307_/Q VSS VSS VSS VSS gf180mcu_fd_sc_mcu9t5v0__dffrnq_1
X_17499_ _18604_/Q _19245_/Q _17504_/S _18604_/D VSS VSS VSS VSS gf180mcu_fd_sc_mcu9t5v0__mux2_1
X_16519_ _16131_/B _19231_/Q _17033_/S _16519_/Z VSS _16519_/VNW VSS VSS gf180mcu_fd_sc_mcu9t5v0__mux2_1
XTAP_TAPCELL_ROW_95_3607 VSS VSS gf180mcu_fd_sc_mcu9t5v0__filltie
X_19238_ _19238_/D _20070_/RN clkload68/I _19238_/Q VSS VSS VSS VSS gf180mcu_fd_sc_mcu9t5v0__dffrnq_2
XTAP_TAPCELL_ROW_148_2_8040 VSS VSS gf180mcu_fd_sc_mcu9t5v0__filltie
X_19169_ _19169_/D _20065_/RN clkload31/I _19169_/Q VSS VSS VSS VSS gf180mcu_fd_sc_mcu9t5v0__dffrnq_1
XTAP_TAPCELL_ROW_110_3998 VSS VSS gf180mcu_fd_sc_mcu9t5v0__filltie
X_20013_ _20013_/D _20141_/RN clkload49/I _20013_/Q VSS VSS VSS VSS gf180mcu_fd_sc_mcu9t5v0__dffsnq_1
X_09824_ _11018_/A1 _18060_/B _09835_/B VSS VSS VSS VSS gf180mcu_fd_sc_mcu9t5v0__nor2_1
XTAP_TAPCELL_ROW_9_1222 VSS VSS gf180mcu_fd_sc_mcu9t5v0__filltie
XTAP_TAPCELL_ROW_9_1233 VSS VSS gf180mcu_fd_sc_mcu9t5v0__filltie
X_09755_ _09755_/A1 _20044_/Q _09755_/B _20014_/D VSS VSS VSS VSS gf180mcu_fd_sc_mcu9t5v0__oai21_1
XTAP_TAPCELL_ROW_5_1108 VSS VSS gf180mcu_fd_sc_mcu9t5v0__filltie
XTAP_TAPCELL_ROW_5_1119 VSS VSS gf180mcu_fd_sc_mcu9t5v0__filltie
Xu_transform_scheduler_core.u_fft_scratch_sram.u_lo.u_sram u_transform_scheduler_core.u_fft_scratch_sram.u_lo.u_sram/A[7]
+ u_transform_scheduler_core.u_fft_scratch_sram.u_lo.u_sram/A[6] u_transform_scheduler_core.u_fft_scratch_sram.u_lo.u_sram/A[5]
+ u_transform_scheduler_core.u_fft_scratch_sram.u_lo.u_sram/A[4] u_transform_scheduler_core.u_fft_scratch_sram.u_lo.u_sram/A[3]
+ u_transform_scheduler_core.u_fft_scratch_sram.u_lo.u_sram/A[2] u_transform_scheduler_core.u_fft_scratch_sram.u_lo.u_sram/A[1]
+ u_transform_scheduler_core.u_fft_scratch_sram.u_lo.u_sram/A[0] u_transform_scheduler_core.u_fft_scratch_sram.u_lo.u_sram/CEN
+ clkbuf_1_0__f_clk/Z u_transform_scheduler_core.u_fft_scratch_sram.u_lo.u_sram/D[7]
+ u_transform_scheduler_core.u_fft_scratch_sram.u_lo.u_sram/D[6] u_transform_scheduler_core.u_fft_scratch_sram.u_lo.u_sram/D[5]
+ u_transform_scheduler_core.u_fft_scratch_sram.u_lo.u_sram/D[4] u_transform_scheduler_core.u_fft_scratch_sram.u_lo.u_sram/D[3]
+ u_transform_scheduler_core.u_fft_scratch_sram.u_lo.u_sram/D[2] u_transform_scheduler_core.u_fft_scratch_sram.u_lo.u_sram/D[1]
+ u_transform_scheduler_core.u_fft_scratch_sram.u_lo.u_sram/D[0] u_transform_scheduler_core.u_fft_scratch_sram.u_lo.u_sram/GWEN
+ _18029_/I0 _18028_/I0 _18027_/I0 _18026_/I0 _18025_/I0 _18024_/I0 _18023_/I0 _18022_/I0
+ VSS VSS u_transform_scheduler_core.u_fft_scratch_sram.u_lo.u_sram/GWEN u_transform_scheduler_core.u_fft_scratch_sram.u_lo.u_sram/GWEN
+ u_transform_scheduler_core.u_fft_scratch_sram.u_lo.u_sram/GWEN u_transform_scheduler_core.u_fft_scratch_sram.u_lo.u_sram/GWEN
+ u_transform_scheduler_core.u_fft_scratch_sram.u_lo.u_sram/GWEN u_transform_scheduler_core.u_fft_scratch_sram.u_lo.u_sram/GWEN
+ u_transform_scheduler_core.u_fft_scratch_sram.u_lo.u_sram/GWEN u_transform_scheduler_core.u_fft_scratch_sram.u_lo.u_sram/GWEN
+ gf180mcu_fd_ip_sram__sram256x8m8wm1
X_09686_ _12618_/B _09686_/A2 _09686_/A3 _09686_/A4 _09687_/A2 VSS _09686_/VNW VSS
+ VSS gf180mcu_fd_sc_mcu9t5v0__nor4_1
XTAP_TAPCELL_ROW_69_2890 VSS VSS gf180mcu_fd_sc_mcu9t5v0__filltie
XTAP_TAPCELL_ROW_236_5572 VSS VSS gf180mcu_fd_sc_mcu9t5v0__filltie
XTAP_TAPCELL_ROW_236_5561 VSS VSS gf180mcu_fd_sc_mcu9t5v0__filltie
XTAP_TAPCELL_ROW_236_5550 VSS VSS gf180mcu_fd_sc_mcu9t5v0__filltie
XTAP_TAPCELL_ROW_65_2765 VSS VSS gf180mcu_fd_sc_mcu9t5v0__filltie
XTAP_TAPCELL_ROW_65_2776 VSS VSS gf180mcu_fd_sc_mcu9t5v0__filltie
XTAP_TAPCELL_ROW_232_5447 VSS VSS gf180mcu_fd_sc_mcu9t5v0__filltie
XPHY_EDGE_ROW_59_Left_383 VSS VSS gf180mcu_fd_sc_mcu9t5v0__endcap
XTAP_TAPCELL_ROW_232_5458 VSS VSS gf180mcu_fd_sc_mcu9t5v0__filltie
X_10530_ _10654_/A2 _10530_/A2 _10530_/A3 _10531_/B VSS VSS VSS VSS gf180mcu_fd_sc_mcu9t5v0__nand3_1
XTAP_TAPCELL_ROW_249_5911 VSS VSS gf180mcu_fd_sc_mcu9t5v0__filltie
XTAP_TAPCELL_ROW_249_5922 VSS VSS gf180mcu_fd_sc_mcu9t5v0__filltie
X_10461_ _17358_/A1 _18193_/Q _10464_/A2 VSS VSS VSS VSS gf180mcu_fd_sc_mcu9t5v0__nor2_1
X_12200_ _18465_/Q _18449_/Q _12315_/S _12200_/Z VSS _17259_/VNW VSS VSS gf180mcu_fd_sc_mcu9t5v0__mux2_1
XTAP_TAPCELL_ROW_245_5819 VSS VSS gf180mcu_fd_sc_mcu9t5v0__filltie
XTAP_TAPCELL_ROW_245_5808 VSS VSS gf180mcu_fd_sc_mcu9t5v0__filltie
X_10392_ _18960_/Q wire165/Z _10394_/A2 VSS VSS VSS VSS gf180mcu_fd_sc_mcu9t5v0__nand2_1
X_13180_ _13183_/A1 _19762_/Q _13195_/B VSS _13180_/VNW VSS VSS gf180mcu_fd_sc_mcu9t5v0__nand2_1
X_12131_ _18382_/Q _12322_/B _12153_/B _12142_/A1 VSS VSS VSS VSS gf180mcu_fd_sc_mcu9t5v0__aoi21_1
X_12062_ _18379_/Q _12059_/Z _12159_/B _12062_/Z VSS _17127_/VNW VSS VSS gf180mcu_fd_sc_mcu9t5v0__mux2_1
XPHY_EDGE_ROW_68_Left_392 VSS VSS gf180mcu_fd_sc_mcu9t5v0__endcap
X_11013_ _11013_/A1 _11018_/A1 _11013_/B _18102_/A1 VSS VSS VSS VSS gf180mcu_fd_sc_mcu9t5v0__aoi21_1
X_16870_ _18427_/Q _16869_/Z _16882_/S _18427_/D VSS VSS VSS VSS gf180mcu_fd_sc_mcu9t5v0__mux2_4
X_15821_ _15821_/A1 _15821_/A2 _15824_/A3 VSS _15821_/VNW VSS VSS gf180mcu_fd_sc_mcu9t5v0__nand2_1
X_18540_ _18540_/D _20040_/RN clkload58/I _18540_/Q VSS VSS VSS VSS gf180mcu_fd_sc_mcu9t5v0__dffrnq_1
X_15752_ _15761_/A1 _15752_/A2 _19929_/D VSS _15752_/VNW VSS VSS gf180mcu_fd_sc_mcu9t5v0__nor2_1
X_12964_ _12968_/A1 _12961_/Z _13502_/B VSS _13506_/VNW VSS VSS gf180mcu_fd_sc_mcu9t5v0__xnor2_1
X_18471_ _18471_/D clkload79/I _18471_/Q VSS VSS VSS VSS gf180mcu_fd_sc_mcu9t5v0__dffq_1
X_11915_ _11915_/A1 _12299_/S _12342_/C _11915_/C _11922_/B VSS VSS VSS VSS gf180mcu_fd_sc_mcu9t5v0__oai211_1
XTAP_TAPCELL_ROW_154_2_8061 VSS VSS gf180mcu_fd_sc_mcu9t5v0__filltie
XTAP_TAPCELL_ROW_120_4283 VSS VSS gf180mcu_fd_sc_mcu9t5v0__filltie
XTAP_TAPCELL_ROW_120_4272 VSS VSS gf180mcu_fd_sc_mcu9t5v0__filltie
X_14703_ _14703_/A1 _14706_/B _14703_/Z VSS VSS VSS VSS gf180mcu_fd_sc_mcu9t5v0__xor2_1
XTAP_TAPCELL_ROW_314_7694 VSS VSS gf180mcu_fd_sc_mcu9t5v0__filltie
X_17422_ _09065_/I _18561_/Q _17422_/S _18561_/D VSS VSS VSS VSS gf180mcu_fd_sc_mcu9t5v0__mux2_1
X_15683_ _15683_/I _19913_/D VSS VSS VSS VSS gf180mcu_fd_sc_mcu9t5v0__clkinv_1
XTAP_TAPCELL_ROW_120_4294 VSS VSS gf180mcu_fd_sc_mcu9t5v0__filltie
X_12895_ _19741_/Q _19806_/Q _12948_/S _12895_/Z VSS VSS VSS VSS gf180mcu_fd_sc_mcu9t5v0__mux2_1
X_11846_ _18257_/Q _12340_/S _12116_/C _11847_/B2 VSS VSS VSS VSS gf180mcu_fd_sc_mcu9t5v0__aoi21_1
X_14634_ _19096_/Q _19512_/Q _14730_/S _19512_/D VSS VSS VSS VSS gf180mcu_fd_sc_mcu9t5v0__mux2_1
X_11777_ _18302_/Q _12203_/A2 _12322_/B _11777_/C _11779_/A1 VSS VSS VSS VSS gf180mcu_fd_sc_mcu9t5v0__aoi211_1
X_17353_ _18550_/Q _17394_/A2 _17372_/B VSS VSS VSS VSS gf180mcu_fd_sc_mcu9t5v0__nand2_1
X_14565_ _14565_/A1 _14565_/A2 _19469_/D VSS _14565_/VNW VSS VSS gf180mcu_fd_sc_mcu9t5v0__nand2_1
X_17284_ _17304_/C _17284_/A2 _17284_/A3 _17286_/A2 VSS VSS VSS VSS gf180mcu_fd_sc_mcu9t5v0__nand3_1
XTAP_TAPCELL_ROW_215_4988 VSS VSS gf180mcu_fd_sc_mcu9t5v0__filltie
X_16304_ _18217_/Q _16303_/Z _16840_/S _18217_/D VSS VSS VSS VSS gf180mcu_fd_sc_mcu9t5v0__mux2_1
XTAP_TAPCELL_ROW_215_4977 VSS VSS gf180mcu_fd_sc_mcu9t5v0__filltie
XTAP_TAPCELL_ROW_133_4644 VSS VSS gf180mcu_fd_sc_mcu9t5v0__filltie
X_10728_ _10728_/I _17417_/I0 VSS VSS VSS VSS gf180mcu_fd_sc_mcu9t5v0__clkinv_4
XTAP_TAPCELL_ROW_133_4633 VSS VSS gf180mcu_fd_sc_mcu9t5v0__filltie
X_13516_ _13000_/Z _13516_/A2 _13516_/B _13521_/A3 VSS VSS VSS VSS gf180mcu_fd_sc_mcu9t5v0__oai21_1
X_16235_ _16235_/A1 _16829_/A2 _16832_/A2 VSS VSS VSS VSS gf180mcu_fd_sc_mcu9t5v0__nor2_4
X_14496_ _14507_/B1 _14722_/A1 _14507_/C _14500_/A1 VSS VSS VSS VSS gf180mcu_fd_sc_mcu9t5v0__aoi21_1
X_19023_ _19023_/D _20047_/RN _19806_/CLK _19023_/Q VSS VSS VSS VSS gf180mcu_fd_sc_mcu9t5v0__dffrnq_1
X_10659_ _20043_/Q _19933_/Q _10659_/B _10659_/C _10660_/A2 VSS VSS VSS VSS gf180mcu_fd_sc_mcu9t5v0__oai211_1
X_13447_ _13448_/A1 _13448_/A2 _13630_/B _13450_/A1 VSS _13447_/VNW VSS VSS gf180mcu_fd_sc_mcu9t5v0__nand3_1
XTAP_TAPCELL_ROW_75_3050 VSS VSS gf180mcu_fd_sc_mcu9t5v0__filltie
Xclkload35 clkload35/I clkload35/ZN VSS VSS VSS VSS gf180mcu_fd_sc_mcu9t5v0__clkinv_1
Xclkload13 clkload13/I clkload13/ZN VSS VSS VSS VSS gf180mcu_fd_sc_mcu9t5v0__inv_4
Xclkload24 clkload24/I clkload24/ZN VSS VSS VSS VSS gf180mcu_fd_sc_mcu9t5v0__inv_4
X_16166_ _19270_/Q _16725_/C _16169_/B VSS VSS VSS VSS gf180mcu_fd_sc_mcu9t5v0__nand2_1
Xclkload57 clkload57/I clkload57/ZN VSS VSS VSS VSS gf180mcu_fd_sc_mcu9t5v0__inv_2
Xclkload68 clkload68/I clkload68/ZN VSS VSS VSS VSS gf180mcu_fd_sc_mcu9t5v0__inv_4
Xclkload46 clkload46/I clkload46/ZN VSS VSS VSS VSS gf180mcu_fd_sc_mcu9t5v0__inv_3
X_13378_ _19742_/Q _13378_/A2 _13416_/C VSS VSS VSS VSS gf180mcu_fd_sc_mcu9t5v0__nor2_1
Xclkload79 clkload79/I clkload79/ZN VSS VSS VSS VSS gf180mcu_fd_sc_mcu9t5v0__inv_4
X_16097_ _18167_/Q _16097_/I1 _16643_/S _18167_/D VSS VSS VSS VSS gf180mcu_fd_sc_mcu9t5v0__mux2_4
X_12329_ _11988_/B _12330_/A2 _12329_/B _12339_/A2 VSS VSS VSS VSS gf180mcu_fd_sc_mcu9t5v0__oai21_4
X_15117_ _19659_/Q _19499_/Q wire108/Z _19659_/D VSS VSS VSS VSS gf180mcu_fd_sc_mcu9t5v0__mux2_1
X_19925_ _19925_/D _20053_/RN clkload49/I _19925_/Q VSS VSS VSS VSS gf180mcu_fd_sc_mcu9t5v0__dffrnq_1
XTAP_TAPCELL_ROW_88_3400 VSS VSS gf180mcu_fd_sc_mcu9t5v0__filltie
X_15048_ _19305_/Q _19390_/Q _15050_/A2 VSS _15050_/VNW VSS VSS gf180mcu_fd_sc_mcu9t5v0__xnor2_1
XTAP_TAPCELL_ROW_88_3411 VSS VSS gf180mcu_fd_sc_mcu9t5v0__filltie
X_19856_ _19856_/D _20048_/RN clkload59/I _19856_/Q VSS VSS VSS VSS gf180mcu_fd_sc_mcu9t5v0__dffrnq_1
X_16999_ _19246_/Q _16584_/B _17023_/S _16999_/Z VSS _17132_/VNW VSS VSS gf180mcu_fd_sc_mcu9t5v0__mux2_1
X_19787_ _19787_/D _20043_/RN clkload12/I _19787_/Q VSS VSS VSS VSS gf180mcu_fd_sc_mcu9t5v0__dffrnq_1
X_18807_ _18807_/D _20023_/RN _19806_/CLK _18807_/Q VSS VSS VSS VSS gf180mcu_fd_sc_mcu9t5v0__dffrnq_1
Xclkbuf_3_4_0_clk_regs clkbuf_0_clk_regs/Z clkload3/I VSS _16566_/VNW VSS VSS gf180mcu_fd_sc_mcu9t5v0__clkbuf_8
X_09540_ _09542_/B _09542_/C _09541_/B VSS VSS VSS VSS gf180mcu_fd_sc_mcu9t5v0__nand2_1
X_18738_ _18738_/D clkload65/I _18738_/Q VSS VSS VSS VSS gf180mcu_fd_sc_mcu9t5v0__dffq_1
X_09471_ _14143_/B2 _09471_/A2 _14546_/S VSS VSS VSS VSS gf180mcu_fd_sc_mcu9t5v0__nor2_2
X_18669_ _18669_/D _20073_/RN clkload58/I _18669_/Q VSS VSS VSS VSS gf180mcu_fd_sc_mcu9t5v0__dffrnq_1
XPHY_EDGE_ROW_199_3_Left_857 VSS VSS gf180mcu_fd_sc_mcu9t5v0__endcap
XTAP_TAPCELL_ROW_60_2640 VSS VSS gf180mcu_fd_sc_mcu9t5v0__filltie
Xclkload7 clkload7/I clkload7/ZN VSS VSS VSS VSS gf180mcu_fd_sc_mcu9t5v0__clkinv_1
XTAP_TAPCELL_ROW_58_2580 VSS VSS gf180mcu_fd_sc_mcu9t5v0__filltie
XTAP_TAPCELL_ROW_58_2591 VSS VSS gf180mcu_fd_sc_mcu9t5v0__filltie
XTAP_TAPCELL_ROW_225_5251 VSS VSS gf180mcu_fd_sc_mcu9t5v0__filltie
XTAP_TAPCELL_ROW_54_2455 VSS VSS gf180mcu_fd_sc_mcu9t5v0__filltie
XTAP_TAPCELL_ROW_54_2466 VSS VSS gf180mcu_fd_sc_mcu9t5v0__filltie
XTAP_TAPCELL_ROW_225_5262 VSS VSS gf180mcu_fd_sc_mcu9t5v0__filltie
XTAP_TAPCELL_ROW_160_2_8082 VSS VSS gf180mcu_fd_sc_mcu9t5v0__filltie
XTAP_TAPCELL_ROW_54_2477 VSS VSS gf180mcu_fd_sc_mcu9t5v0__filltie
Xfanout244 _17056_/S _17050_/S VSS VSS VSS VSS gf180mcu_fd_sc_mcu9t5v0__clkbuf_16
XTAP_TAPCELL_ROW_221_5159 VSS VSS gf180mcu_fd_sc_mcu9t5v0__filltie
XTAP_TAPCELL_ROW_221_5148 VSS VSS gf180mcu_fd_sc_mcu9t5v0__filltie
XTAP_TAPCELL_ROW_221_5137 VSS VSS gf180mcu_fd_sc_mcu9t5v0__filltie
X_09807_ _09807_/A1 _17916_/A1 _17918_/A2 VSS _10752_/VNW VSS VSS gf180mcu_fd_sc_mcu9t5v0__nand2_1
XPHY_EDGE_ROW_222_Right_149 VSS VSS gf180mcu_fd_sc_mcu9t5v0__endcap
XTAP_TAPCELL_ROW_238_5623 VSS VSS gf180mcu_fd_sc_mcu9t5v0__filltie
XTAP_TAPCELL_ROW_238_5612 VSS VSS gf180mcu_fd_sc_mcu9t5v0__filltie
X_09738_ _09738_/A1 _09737_/Z _20018_/D VSS _09738_/VNW VSS VSS gf180mcu_fd_sc_mcu9t5v0__nand2_1
XTAP_TAPCELL_ROW_67_2816 VSS VSS gf180mcu_fd_sc_mcu9t5v0__filltie
XTAP_TAPCELL_ROW_67_2827 VSS VSS gf180mcu_fd_sc_mcu9t5v0__filltie
XTAP_TAPCELL_ROW_67_2838 VSS VSS gf180mcu_fd_sc_mcu9t5v0__filltie
Xeco14_skew_10 clkload76/I _18515_/CLK VSS VSS VSS VSS gf180mcu_fd_sc_mcu9t5v0__clkbuf_16
XTAP_TAPCELL_ROW_234_5509 VSS VSS gf180mcu_fd_sc_mcu9t5v0__filltie
X_09669_ _09665_/Z _09669_/A2 _09676_/B VSS _09669_/VNW VSS VSS gf180mcu_fd_sc_mcu9t5v0__and2_1
XTAP_TAPCELL_ROW_219_5099 VSS VSS gf180mcu_fd_sc_mcu9t5v0__filltie
XTAP_TAPCELL_ROW_219_5088 VSS VSS gf180mcu_fd_sc_mcu9t5v0__filltie
X_12680_ _12665_/B _12680_/A2 _12658_/B _12680_/Z VSS VSS VSS VSS gf180mcu_fd_sc_mcu9t5v0__or3_1
X_11700_ _12628_/A1 _11700_/A2 _11700_/B _11701_/I1 VSS _11700_/VNW VSS VSS gf180mcu_fd_sc_mcu9t5v0__oai21_1
X_11631_ _12664_/A1 _11633_/B _12665_/B _11631_/C _11645_/A3 VSS _11659_/VNW VSS VSS
+ gf180mcu_fd_sc_mcu9t5v0__aoi211_1
X_11562_ _18153_/Q _12181_/A2 _11564_/A3 VSS VSS VSS VSS gf180mcu_fd_sc_mcu9t5v0__nor2_1
X_14350_ _14365_/I0 _19421_/Q _14352_/S _19421_/D VSS VSS VSS VSS gf180mcu_fd_sc_mcu9t5v0__mux2_1
X_10513_ _17378_/A1 _18259_/Q _10516_/A1 VSS VSS VSS VSS gf180mcu_fd_sc_mcu9t5v0__nor2_1
Xclkbuf_leaf_8_clk_regs clkload0/I clkload24/I VSS VSS VSS VSS gf180mcu_fd_sc_mcu9t5v0__clkbuf_8
X_13301_ _19738_/Q _19770_/Q _13303_/A2 VSS VSS VSS VSS gf180mcu_fd_sc_mcu9t5v0__xnor2_1
X_11493_ _18469_/Q _11524_/S _11520_/B _11495_/A2 VSS _12284_/VNW VSS VSS gf180mcu_fd_sc_mcu9t5v0__oai21_1
XTAP_TAPCELL_ROW_210_4841 VSS VSS gf180mcu_fd_sc_mcu9t5v0__filltie
X_14281_ _14367_/I0 _19355_/Q _14285_/S _19355_/D VSS VSS VSS VSS gf180mcu_fd_sc_mcu9t5v0__mux2_1
XTAP_TAPCELL_ROW_322_7930 VSS VSS gf180mcu_fd_sc_mcu9t5v0__filltie
X_10444_ _19855_/Q _17161_/C _10445_/A3 VSS VSS VSS VSS gf180mcu_fd_sc_mcu9t5v0__nor2_1
XTAP_TAPCELL_ROW_210_4852 VSS VSS gf180mcu_fd_sc_mcu9t5v0__filltie
X_16020_ _18676_/Q _18773_/Q _16597_/S _16020_/Z VSS _17613_/VNW VSS VSS gf180mcu_fd_sc_mcu9t5v0__mux2_1
X_13232_ _12843_/B _13577_/A2 _13232_/Z VSS VSS VSS VSS gf180mcu_fd_sc_mcu9t5v0__and2_1
X_10375_ _17260_/S _18206_/Q _10377_/A3 VSS VSS VSS VSS gf180mcu_fd_sc_mcu9t5v0__nor2_1
X_13163_ _19729_/Q _13164_/A2 _13182_/A2 VSS _13182_/VNW VSS VSS gf180mcu_fd_sc_mcu9t5v0__nand2_1
XPHY_EDGE_ROW_76_Left_400 VSS VSS gf180mcu_fd_sc_mcu9t5v0__endcap
X_12114_ _18493_/Q _12203_/A2 _12115_/A3 VSS _17174_/VNW VSS VSS gf180mcu_fd_sc_mcu9t5v0__nand2_1
XTAP_TAPCELL_ROW_303_7395 VSS VSS gf180mcu_fd_sc_mcu9t5v0__filltie
X_13094_ _13094_/A1 _13094_/A2 _13094_/B _13132_/A2 VSS _13094_/VNW VSS VSS gf180mcu_fd_sc_mcu9t5v0__aoi21_1
X_17971_ _18854_/Q _18855_/Q _17971_/A3 wire128/I VSS VSS VSS VSS gf180mcu_fd_sc_mcu9t5v0__nor3_1
X_19710_ _19710_/D _20030_/RN clkload37/I _19710_/Q VSS VSS VSS VSS gf180mcu_fd_sc_mcu9t5v0__dffrnq_1
X_16922_ _16921_/Z _18453_/Q _16926_/S _18453_/D VSS VSS VSS VSS gf180mcu_fd_sc_mcu9t5v0__mux2_4
XTAP_TAPCELL_ROW_295_7185 VSS VSS gf180mcu_fd_sc_mcu9t5v0__filltie
X_12045_ _12045_/A1 _12045_/A2 _12045_/B1 _12045_/B2 _12116_/C _12049_/A2 VSS VSS
+ VSS VSS gf180mcu_fd_sc_mcu9t5v0__aoi221_4
XTAP_TAPCELL_ROW_295_7174 VSS VSS gf180mcu_fd_sc_mcu9t5v0__filltie
XTAP_TAPCELL_ROW_37_1996 VSS VSS gf180mcu_fd_sc_mcu9t5v0__filltie
XTAP_TAPCELL_ROW_295_7196 VSS VSS gf180mcu_fd_sc_mcu9t5v0__filltie
X_16853_ _19254_/Q _16641_/B _16863_/S _16853_/Z VSS VSS VSS VSS gf180mcu_fd_sc_mcu9t5v0__mux2_1
XTAP_TAPCELL_ROW_122_4334 VSS VSS gf180mcu_fd_sc_mcu9t5v0__filltie
X_19641_ _19641_/D _20025_/RN clkload21/I _19641_/Q VSS VSS VSS VSS gf180mcu_fd_sc_mcu9t5v0__dffrnq_1
XTAP_TAPCELL_ROW_316_7767 VSS VSS gf180mcu_fd_sc_mcu9t5v0__filltie
XTAP_TAPCELL_ROW_316_7756 VSS VSS gf180mcu_fd_sc_mcu9t5v0__filltie
X_15804_ _09065_/I _19973_/Q _15811_/S _19973_/D VSS _17721_/VNW VSS VSS gf180mcu_fd_sc_mcu9t5v0__mux2_1
XTAP_TAPCELL_ROW_170_3_8120 VSS VSS gf180mcu_fd_sc_mcu9t5v0__filltie
XPHY_EDGE_ROW_152_2_Left_664 VSS VSS gf180mcu_fd_sc_mcu9t5v0__endcap
XTAP_TAPCELL_ROW_122_4345 VSS VSS gf180mcu_fd_sc_mcu9t5v0__filltie
X_19572_ _19572_/D _20020_/RN clkload18/I _19572_/Q VSS VSS VSS VSS gf180mcu_fd_sc_mcu9t5v0__dffrnq_1
X_16784_ _16783_/Z _18391_/Q _16784_/S _18391_/D VSS VSS VSS VSS gf180mcu_fd_sc_mcu9t5v0__mux2_1
X_18523_ _18523_/D clkload61/I _18523_/Q VSS VSS VSS VSS gf180mcu_fd_sc_mcu9t5v0__dffq_1
XTAP_TAPCELL_ROW_169_3_8114 VSS VSS gf180mcu_fd_sc_mcu9t5v0__filltie
X_13996_ _13997_/A1 _13997_/A2 _14032_/B VSS VSS VSS VSS gf180mcu_fd_sc_mcu9t5v0__nand2_1
X_15735_ _19925_/Q _15757_/B _15736_/B VSS VSS VSS VSS gf180mcu_fd_sc_mcu9t5v0__nand2_1
X_12947_ _12942_/Z _12947_/A2 _12947_/B _12949_/A2 VSS _13489_/VNW VSS VSS gf180mcu_fd_sc_mcu9t5v0__aoi21_1
X_18454_ _18454_/D clkload82/I _18454_/Q VSS VSS VSS VSS gf180mcu_fd_sc_mcu9t5v0__dffq_1
XTAP_TAPCELL_ROW_135_4706 VSS VSS gf180mcu_fd_sc_mcu9t5v0__filltie
X_15666_ _19908_/Q _15668_/A3 _15666_/B _19908_/D VSS _15666_/VNW VSS VSS gf180mcu_fd_sc_mcu9t5v0__oai21_1
X_12878_ _13320_/B _12878_/A2 _12878_/B _19216_/D VSS VSS VSS VSS gf180mcu_fd_sc_mcu9t5v0__oai21_1
X_11829_ _12261_/B _11829_/A2 _11829_/A3 _11830_/B VSS _11829_/VNW VSS VSS gf180mcu_fd_sc_mcu9t5v0__nand3_1
X_18385_ _18385_/D clkload73/I _18385_/Q VSS VSS VSS VSS gf180mcu_fd_sc_mcu9t5v0__dffq_1
X_17405_ _18376_/Q _17405_/A2 _17407_/B1 VSS VSS VSS VSS gf180mcu_fd_sc_mcu9t5v0__nand2_1
XTAP_TAPCELL_ROW_135_4728 VSS VSS gf180mcu_fd_sc_mcu9t5v0__filltie
XTAP_TAPCELL_ROW_135_4717 VSS VSS gf180mcu_fd_sc_mcu9t5v0__filltie
X_14617_ _19078_/Q _19495_/Q _14730_/S _19495_/D VSS VSS VSS VSS gf180mcu_fd_sc_mcu9t5v0__mux2_1
X_17336_ _09261_/I _17336_/A2 _17336_/A3 _17336_/B _17345_/A2 VSS _17345_/VNW VSS
+ VSS gf180mcu_fd_sc_mcu9t5v0__oai31_1
XTAP_TAPCELL_ROW_149_3_8045 VSS VSS gf180mcu_fd_sc_mcu9t5v0__filltie
XTAP_TAPCELL_ROW_77_3112 VSS VSS gf180mcu_fd_sc_mcu9t5v0__filltie
X_15597_ _15597_/A1 _20042_/D _15597_/B1 _15597_/B2 _19884_/D VSS _15597_/VNW VSS
+ VSS gf180mcu_fd_sc_mcu9t5v0__oai22_1
XTAP_TAPCELL_ROW_77_3101 VSS VSS gf180mcu_fd_sc_mcu9t5v0__filltie
XPHY_EDGE_ROW_112_Right_112 VSS VSS gf180mcu_fd_sc_mcu9t5v0__endcap
X_14548_ _14540_/Z _14548_/A2 _14548_/A3 _14548_/B _14560_/B VSS VSS VSS VSS gf180mcu_fd_sc_mcu9t5v0__oai31_1
X_17267_ _20116_/Q wire168/Z _17409_/B _17267_/C _17269_/A2 VSS VSS VSS VSS gf180mcu_fd_sc_mcu9t5v0__oai211_1
X_14479_ _19127_/Q _14475_/B _14486_/A2 VSS _14479_/VNW VSS VSS gf180mcu_fd_sc_mcu9t5v0__nor2_1
X_16218_ _16162_/B _19269_/Q _16785_/S _16218_/Z VSS _16218_/VNW VSS VSS gf180mcu_fd_sc_mcu9t5v0__mux2_4
X_17198_ _17198_/A1 _17198_/A2 _17198_/A3 _17198_/B _17199_/B1 VSS _17198_/VNW VSS
+ VSS gf180mcu_fd_sc_mcu9t5v0__oai31_1
X_19006_ _19006_/D _20030_/RN clkload40/I _19006_/Q VSS VSS VSS VSS gf180mcu_fd_sc_mcu9t5v0__dffrnq_1
XTAP_TAPCELL_ROW_280_6775 VSS VSS gf180mcu_fd_sc_mcu9t5v0__filltie
XTAP_TAPCELL_ROW_280_6764 VSS VSS gf180mcu_fd_sc_mcu9t5v0__filltie
X_16149_ _16741_/B2 _16149_/A2 _16149_/B _16149_/C _16150_/I1 VSS VSS VSS VSS gf180mcu_fd_sc_mcu9t5v0__aoi211_1
XPHY_EDGE_ROW_219_Left_542 VSS VSS gf180mcu_fd_sc_mcu9t5v0__endcap
XPHY_EDGE_ROW_49_Right_49 VSS VSS gf180mcu_fd_sc_mcu9t5v0__endcap
X_19908_ _19908_/D _20036_/RN clkload41/I _19908_/Q VSS VSS VSS VSS gf180mcu_fd_sc_mcu9t5v0__dffrnq_1
X_19839_ _19839_/D _20031_/RN clkload56/I _19839_/Q VSS VSS VSS VSS gf180mcu_fd_sc_mcu9t5v0__dffrnq_1
Xu_transform_scheduler_core.u_fft_scratch_sram.u_lo.g_pin_drive\[6\].u_data_driver
+ _10423_/ZN u_transform_scheduler_core.u_fft_scratch_sram.u_lo.u_sram/D[6] VSS VSS
+ VSS VSS gf180mcu_fd_sc_mcu9t5v0__buf_8
Xclkbuf_leaf_78_clk_regs clkbuf_3_0_0_clk_regs/Z clkload13/I VSS VSS VSS VSS gf180mcu_fd_sc_mcu9t5v0__clkbuf_8
XTAP_TAPCELL_ROW_105_3875 VSS VSS gf180mcu_fd_sc_mcu9t5v0__filltie
XPHY_EDGE_ROW_58_Right_58 VSS VSS gf180mcu_fd_sc_mcu9t5v0__endcap
XTAP_TAPCELL_ROW_105_3864 VSS VSS gf180mcu_fd_sc_mcu9t5v0__filltie
XPHY_EDGE_ROW_228_Left_551 VSS VSS gf180mcu_fd_sc_mcu9t5v0__endcap
X_09523_ _20032_/Q _09399_/Z _09525_/A2 VSS VSS VSS VSS gf180mcu_fd_sc_mcu9t5v0__nand2_1
XTAP_TAPCELL_ROW_0_956 VSS VSS gf180mcu_fd_sc_mcu9t5v0__filltie
XTAP_TAPCELL_ROW_0_945 VSS VSS gf180mcu_fd_sc_mcu9t5v0__filltie
X_09454_ _19195_/Q _19194_/Q _10843_/A2 _09454_/A4 _09454_/Z VSS VSS VSS VSS gf180mcu_fd_sc_mcu9t5v0__and4_4
XTAP_TAPCELL_ROW_47_2270 VSS VSS gf180mcu_fd_sc_mcu9t5v0__filltie
XTAP_TAPCELL_ROW_0_967 VSS VSS gf180mcu_fd_sc_mcu9t5v0__filltie
XTAP_TAPCELL_ROW_0_978 VSS VSS gf180mcu_fd_sc_mcu9t5v0__filltie
XTAP_TAPCELL_ROW_47_2281 VSS VSS gf180mcu_fd_sc_mcu9t5v0__filltie
XTAP_TAPCELL_ROW_0_989 VSS VSS gf180mcu_fd_sc_mcu9t5v0__filltie
X_09385_ _18919_/Q _12279_/A1 VSS _12297_/VNW VSS VSS gf180mcu_fd_sc_mcu9t5v0__clkinv_1
XTAP_TAPCELL_ROW_43_2156 VSS VSS gf180mcu_fd_sc_mcu9t5v0__filltie
XTAP_TAPCELL_ROW_43_2167 VSS VSS gf180mcu_fd_sc_mcu9t5v0__filltie
XTAP_TAPCELL_ROW_43_2178 VSS VSS gf180mcu_fd_sc_mcu9t5v0__filltie
XTAP_TAPCELL_ROW_227_5313 VSS VSS gf180mcu_fd_sc_mcu9t5v0__filltie
XPHY_EDGE_ROW_237_Left_560 VSS VSS gf180mcu_fd_sc_mcu9t5v0__endcap
XTAP_TAPCELL_ROW_227_5302 VSS VSS gf180mcu_fd_sc_mcu9t5v0__filltie
XTAP_TAPCELL_ROW_56_2517 VSS VSS gf180mcu_fd_sc_mcu9t5v0__filltie
XPHY_EDGE_ROW_67_Right_67 VSS VSS gf180mcu_fd_sc_mcu9t5v0__endcap
XTAP_TAPCELL_ROW_227_5324 VSS VSS gf180mcu_fd_sc_mcu9t5v0__filltie
XTAP_TAPCELL_ROW_56_2528 VSS VSS gf180mcu_fd_sc_mcu9t5v0__filltie
XTAP_TAPCELL_ROW_175_3_8135 VSS VSS gf180mcu_fd_sc_mcu9t5v0__filltie
X_10160_ _19220_/Q wire172/Z _10172_/A2 _19204_/Q _10162_/A1 VSS _10161_/VNW VSS VSS
+ gf180mcu_fd_sc_mcu9t5v0__aoi22_1
X_10091_ _20072_/Q _10091_/A2 _10091_/A3 _10107_/C VSS _10091_/VNW VSS VSS gf180mcu_fd_sc_mcu9t5v0__nand3_1
XPHY_EDGE_ROW_76_Right_76 VSS VSS gf180mcu_fd_sc_mcu9t5v0__endcap
XTAP_TAPCELL_ROW_32_1860 VSS VSS gf180mcu_fd_sc_mcu9t5v0__filltie
XTAP_TAPCELL_ROW_32_1871 VSS VSS gf180mcu_fd_sc_mcu9t5v0__filltie
XPHY_EDGE_ROW_263_Right_190 VSS VSS gf180mcu_fd_sc_mcu9t5v0__endcap
XTAP_TAPCELL_ROW_155_3_8066 VSS VSS gf180mcu_fd_sc_mcu9t5v0__filltie
X_13850_ _13851_/A1 _13917_/A1 _13850_/Z VSS _13873_/VNW VSS VSS gf180mcu_fd_sc_mcu9t5v0__and2_1
XTAP_TAPCELL_ROW_311_7620 VSS VSS gf180mcu_fd_sc_mcu9t5v0__filltie
X_10993_ _18925_/Q _18924_/Q _11005_/A2 VSS VSS VSS VSS gf180mcu_fd_sc_mcu9t5v0__nand2_1
X_12801_ _19727_/Q _19792_/Q _12948_/S _12801_/Z VSS VSS VSS VSS gf180mcu_fd_sc_mcu9t5v0__mux2_1
X_13781_ _13803_/A2 _13825_/A3 _13781_/B _13782_/A2 VSS _13782_/VNW VSS VSS gf180mcu_fd_sc_mcu9t5v0__aoi21_1
XTAP_TAPCELL_ROW_311_7631 VSS VSS gf180mcu_fd_sc_mcu9t5v0__filltie
X_15520_ _19844_/Q _15518_/Z _15522_/A2 VSS VSS VSS VSS gf180mcu_fd_sc_mcu9t5v0__nor2_1
X_12732_ _19194_/Q _09453_/I _13320_/B VSS _17993_/VNW VSS VSS gf180mcu_fd_sc_mcu9t5v0__nand2_2
X_15451_ _19820_/Q _15445_/B _15453_/B VSS _17208_/VNW VSS VSS gf180mcu_fd_sc_mcu9t5v0__nand2_1
X_12663_ _12663_/A1 _12663_/A2 _12710_/A2 VSS VSS VSS VSS gf180mcu_fd_sc_mcu9t5v0__nand2_1
X_14402_ _19450_/Q _14766_/A2 _14406_/A1 VSS VSS VSS VSS gf180mcu_fd_sc_mcu9t5v0__nand2_1
XTAP_TAPCELL_ROW_212_4914 VSS VSS gf180mcu_fd_sc_mcu9t5v0__filltie
XTAP_TAPCELL_ROW_212_4903 VSS VSS gf180mcu_fd_sc_mcu9t5v0__filltie
X_18170_ _18170_/D _18361_/CLK _18170_/Q VSS VSS VSS VSS gf180mcu_fd_sc_mcu9t5v0__dffq_4
X_12594_ wire175/Z wire120/Z _12618_/B _12596_/A3 VSS _13094_/VNW VSS VSS gf180mcu_fd_sc_mcu9t5v0__aoi21_1
X_15382_ _19667_/Q _19767_/Q _15417_/S _19767_/D VSS VSS VSS VSS gf180mcu_fd_sc_mcu9t5v0__mux2_1
XTAP_TAPCELL_ROW_26_1686 VSS VSS gf180mcu_fd_sc_mcu9t5v0__filltie
X_11614_ _12685_/A1 _12645_/C _11678_/B VSS VSS VSS VSS gf180mcu_fd_sc_mcu9t5v0__nor2_1
XTAP_TAPCELL_ROW_309_7571 VSS VSS gf180mcu_fd_sc_mcu9t5v0__filltie
X_17121_ _18605_/Q _17159_/B _17138_/B VSS VSS VSS VSS gf180mcu_fd_sc_mcu9t5v0__nand2_1
XTAP_TAPCELL_ROW_309_7560 VSS VSS gf180mcu_fd_sc_mcu9t5v0__filltie
XPHY_EDGE_ROW_85_Right_85 VSS VSS gf180mcu_fd_sc_mcu9t5v0__endcap
X_14333_ _13986_/Z _19405_/Q _14337_/S _19405_/D VSS _14334_/VNW VSS VSS gf180mcu_fd_sc_mcu9t5v0__mux2_1
XTAP_TAPCELL_ROW_26_1697 VSS VSS gf180mcu_fd_sc_mcu9t5v0__filltie
X_11545_ _17961_/A2 _11545_/A2 _11966_/B VSS VSS VSS VSS gf180mcu_fd_sc_mcu9t5v0__nand2_2
X_17052_ _17051_/Z _18517_/Q _17056_/S _18517_/D VSS VSS VSS VSS gf180mcu_fd_sc_mcu9t5v0__mux2_1
XTAP_TAPCELL_ROW_305_7446 VSS VSS gf180mcu_fd_sc_mcu9t5v0__filltie
XTAP_TAPCELL_ROW_111_4046 VSS VSS gf180mcu_fd_sc_mcu9t5v0__filltie
X_11476_ _19100_/Q _11541_/A2 _11477_/A2 VSS VSS VSS VSS gf180mcu_fd_sc_mcu9t5v0__nand2_1
XTAP_TAPCELL_ROW_111_4035 VSS VSS gf180mcu_fd_sc_mcu9t5v0__filltie
XTAP_TAPCELL_ROW_111_4024 VSS VSS gf180mcu_fd_sc_mcu9t5v0__filltie
X_14264_ _14264_/A1 _14264_/A2 _14263_/Z _14265_/A3 VSS VSS VSS VSS gf180mcu_fd_sc_mcu9t5v0__xnor3_1
XTAP_TAPCELL_ROW_305_7468 VSS VSS gf180mcu_fd_sc_mcu9t5v0__filltie
X_10427_ _18288_/Q _17322_/A2 _17255_/B1 _18304_/Q _10428_/B VSS _11822_/VNW VSS VSS
+ gf180mcu_fd_sc_mcu9t5v0__aoi22_1
XTAP_TAPCELL_ROW_305_7457 VSS VSS gf180mcu_fd_sc_mcu9t5v0__filltie
X_16003_ _18153_/Q _16003_/A2 _16004_/B1 _16005_/B VSS VSS VSS VSS gf180mcu_fd_sc_mcu9t5v0__nand3_1
X_13215_ _13215_/A1 _19764_/Q _13224_/A2 _13216_/A2 VSS VSS VSS VSS gf180mcu_fd_sc_mcu9t5v0__xnor3_1
XTAP_TAPCELL_ROW_297_7236 VSS VSS gf180mcu_fd_sc_mcu9t5v0__filltie
XTAP_TAPCELL_ROW_297_7225 VSS VSS gf180mcu_fd_sc_mcu9t5v0__filltie
XTAP_TAPCELL_ROW_128_4510 VSS VSS gf180mcu_fd_sc_mcu9t5v0__filltie
X_14195_ _19322_/Q _19300_/Q _14198_/A1 VSS _14199_/VNW VSS VSS gf180mcu_fd_sc_mcu9t5v0__nand2_1
XTAP_TAPCELL_ROW_297_7247 VSS VSS gf180mcu_fd_sc_mcu9t5v0__filltie
X_10358_ _17409_/B _10358_/A2 _10358_/A3 _10359_/C VSS VSS VSS VSS gf180mcu_fd_sc_mcu9t5v0__nand3_1
X_13146_ _13162_/A1 _13162_/A3 _13147_/A3 VSS VSS VSS VSS gf180mcu_fd_sc_mcu9t5v0__nor2_1
XTAP_TAPCELL_ROW_318_7818 VSS VSS gf180mcu_fd_sc_mcu9t5v0__filltie
XTAP_TAPCELL_ROW_318_7807 VSS VSS gf180mcu_fd_sc_mcu9t5v0__filltie
X_10289_ _17260_/S _18203_/Q _10289_/B _10291_/A2 VSS VSS VSS VSS gf180mcu_fd_sc_mcu9t5v0__oai21_1
X_13077_ _19725_/Q _13080_/A2 _13104_/A1 VSS _13077_/VNW VSS VSS gf180mcu_fd_sc_mcu9t5v0__nand2_1
X_17954_ _18855_/Q _11013_/B _17956_/B VSS _17955_/VNW VSS VSS gf180mcu_fd_sc_mcu9t5v0__nand2_1
XTAP_TAPCELL_ROW_318_7829 VSS VSS gf180mcu_fd_sc_mcu9t5v0__filltie
X_16905_ _16599_/B _19248_/Q _16925_/S _16905_/Z VSS VSS VSS VSS gf180mcu_fd_sc_mcu9t5v0__mux2_1
X_12028_ _12028_/A1 _12057_/A1 _12028_/B _12028_/C _12029_/C VSS VSS VSS VSS gf180mcu_fd_sc_mcu9t5v0__oai211_4
XPHY_EDGE_ROW_94_Right_94 VSS VSS gf180mcu_fd_sc_mcu9t5v0__endcap
X_17885_ _18684_/Q _18835_/Q _17885_/S _18835_/D VSS VSS VSS VSS gf180mcu_fd_sc_mcu9t5v0__mux2_1
X_16836_ _18410_/Q _16835_/Z _16840_/S _18410_/D VSS _16868_/VNW VSS VSS gf180mcu_fd_sc_mcu9t5v0__mux2_1
X_19624_ _19624_/D _20072_/RN clkload9/I _19624_/Q VSS VSS VSS VSS gf180mcu_fd_sc_mcu9t5v0__dffrnq_1
X_16767_ _16614_/B _19282_/Q _16783_/S _16767_/Z VSS VSS VSS VSS gf180mcu_fd_sc_mcu9t5v0__mux2_1
X_13979_ _13990_/A1 _13990_/A2 _13979_/Z VSS VSS VSS VSS gf180mcu_fd_sc_mcu9t5v0__xor2_1
X_19555_ _19555_/D _20067_/RN clkload30/I _19555_/Q VSS VSS VSS VSS gf180mcu_fd_sc_mcu9t5v0__dffrnq_1
XTAP_TAPCELL_ROW_273_6590 VSS VSS gf180mcu_fd_sc_mcu9t5v0__filltie
X_18506_ _18506_/D _20129_/CLK _18506_/Q VSS VSS VSS VSS gf180mcu_fd_sc_mcu9t5v0__dffq_1
X_15718_ _19921_/Q _15718_/A2 _15719_/A2 VSS _15719_/VNW VSS VSS gf180mcu_fd_sc_mcu9t5v0__xnor2_1
X_19486_ _19486_/D _20062_/RN clkload13/I _19486_/Q VSS VSS VSS VSS gf180mcu_fd_sc_mcu9t5v0__dffrnq_1
X_18437_ _18437_/D clkload79/I _18437_/Q VSS VSS VSS VSS gf180mcu_fd_sc_mcu9t5v0__dffq_1
X_16698_ _16722_/A1 _16698_/A2 _16698_/A3 _16698_/B _18365_/D VSS VSS VSS VSS gf180mcu_fd_sc_mcu9t5v0__oai31_4
X_15649_ _15649_/A1 _15649_/A2 _19902_/Q _15651_/A1 VSS _15649_/VNW VSS VSS gf180mcu_fd_sc_mcu9t5v0__oai21_1
XTAP_TAPCELL_ROW_286_6940 VSS VSS gf180mcu_fd_sc_mcu9t5v0__filltie
X_18368_ _18368_/D _20099_/CLK _18368_/Q VSS VSS VSS VSS gf180mcu_fd_sc_mcu9t5v0__dffq_4
XTAP_TAPCELL_ROW_181_3_8156 VSS VSS gf180mcu_fd_sc_mcu9t5v0__filltie
X_09170_ _19109_/Q _13683_/A2 VSS VSS VSS VSS gf180mcu_fd_sc_mcu9t5v0__clkinv_1
X_17319_ _09261_/I _17319_/A2 _17319_/A3 _17319_/B _17324_/B1 VSS VSS VSS VSS gf180mcu_fd_sc_mcu9t5v0__oai31_1
XTAP_TAPCELL_ROW_282_6826 VSS VSS gf180mcu_fd_sc_mcu9t5v0__filltie
X_18299_ _18299_/D clkload60/I _18299_/Q VSS VSS VSS VSS gf180mcu_fd_sc_mcu9t5v0__dffq_1
XTAP_TAPCELL_ROW_282_6815 VSS VSS gf180mcu_fd_sc_mcu9t5v0__filltie
XTAP_TAPCELL_ROW_282_6837 VSS VSS gf180mcu_fd_sc_mcu9t5v0__filltie
XTAP_TAPCELL_ROW_161_3_8087 VSS VSS gf180mcu_fd_sc_mcu9t5v0__filltie
XTAP_TAPCELL_ROW_107_3926 VSS VSS gf180mcu_fd_sc_mcu9t5v0__filltie
XTAP_TAPCELL_ROW_107_3915 VSS VSS gf180mcu_fd_sc_mcu9t5v0__filltie
XTAP_TAPCELL_ROW_107_3937 VSS VSS gf180mcu_fd_sc_mcu9t5v0__filltie
XTAP_TAPCELL_ROW_49_2321 VSS VSS gf180mcu_fd_sc_mcu9t5v0__filltie
XTAP_TAPCELL_ROW_49_2332 VSS VSS gf180mcu_fd_sc_mcu9t5v0__filltie
XTAP_TAPCELL_ROW_45_2207 VSS VSS gf180mcu_fd_sc_mcu9t5v0__filltie
XTAP_TAPCELL_ROW_49_2343 VSS VSS gf180mcu_fd_sc_mcu9t5v0__filltie
XTAP_TAPCELL_ROW_216_5014 VSS VSS gf180mcu_fd_sc_mcu9t5v0__filltie
XTAP_TAPCELL_ROW_216_5003 VSS VSS gf180mcu_fd_sc_mcu9t5v0__filltie
XTAP_TAPCELL_ROW_45_2218 VSS VSS gf180mcu_fd_sc_mcu9t5v0__filltie
XTAP_TAPCELL_ROW_45_2229 VSS VSS gf180mcu_fd_sc_mcu9t5v0__filltie
X_09506_ _19089_/Q _14730_/S _09511_/B _11325_/A1 VSS VSS VSS VSS gf180mcu_fd_sc_mcu9t5v0__aoi21_4
X_09437_ _09438_/B _09909_/A2 _09437_/Z VSS VSS VSS VSS gf180mcu_fd_sc_mcu9t5v0__or2_4
XTAP_TAPCELL_ROW_252_5995 VSS VSS gf180mcu_fd_sc_mcu9t5v0__filltie
X_09368_ _18196_/Q _11915_/A1 VSS VSS VSS VSS gf180mcu_fd_sc_mcu9t5v0__clkinv_1
X_09299_ _19255_/Q _16953_/A1 VSS VSS VSS VSS gf180mcu_fd_sc_mcu9t5v0__inv_1
X_11330_ _18457_/Q _11334_/A2 _11428_/B _11331_/A2 VSS _11330_/VNW VSS VSS gf180mcu_fd_sc_mcu9t5v0__oai21_1
Xu_transform_scheduler_core.u_fft_scratch_sram.u_lo.g_pin_drive\[1\].u_addr_driver
+ _10676_/ZN u_transform_scheduler_core.u_fft_scratch_sram.u_lo.u_sram/A[1] VSS VSS
+ VSS VSS gf180mcu_fd_sc_mcu9t5v0__buf_8
XTAP_TAPCELL_ROW_21_1550 VSS VSS gf180mcu_fd_sc_mcu9t5v0__filltie
XTAP_TAPCELL_ROW_21_1561 VSS VSS gf180mcu_fd_sc_mcu9t5v0__filltie
XTAP_TAPCELL_ROW_21_1572 VSS VSS gf180mcu_fd_sc_mcu9t5v0__filltie
X_11261_ _18340_/Q _18324_/Q _18276_/Q _18260_/Q _11534_/S _11469_/B _11261_/Z VSS
+ VSS VSS VSS gf180mcu_fd_sc_mcu9t5v0__mux4_1
XTAP_TAPCELL_ROW_300_7332 VSS VSS gf180mcu_fd_sc_mcu9t5v0__filltie
XTAP_TAPCELL_ROW_300_7321 VSS VSS gf180mcu_fd_sc_mcu9t5v0__filltie
X_11192_ _11469_/B _11190_/Z _11192_/B _11196_/A2 VSS VSS VSS VSS gf180mcu_fd_sc_mcu9t5v0__oai21_1
XTAP_TAPCELL_ROW_300_7310 VSS VSS gf180mcu_fd_sc_mcu9t5v0__filltie
X_10212_ _19830_/Q _15504_/A3 _15512_/A1 VSS VSS VSS VSS gf180mcu_fd_sc_mcu9t5v0__nand2_1
XPHY_EDGE_ROW_151_3_Left_809 VSS VSS gf180mcu_fd_sc_mcu9t5v0__endcap
XPHY_EDGE_ROW_170_2_Right_901 VSS VSS gf180mcu_fd_sc_mcu9t5v0__endcap
X_13000_ _13005_/A1 _13001_/A2 _13000_/Z VSS VSS VSS VSS gf180mcu_fd_sc_mcu9t5v0__and2_1
X_10143_ _10143_/I _10144_/C VSS _10143_/VNW VSS VSS gf180mcu_fd_sc_mcu9t5v0__clkinv_1
XTAP_TAPCELL_ROW_34_1911 VSS VSS gf180mcu_fd_sc_mcu9t5v0__filltie
XTAP_TAPCELL_ROW_34_1922 VSS VSS gf180mcu_fd_sc_mcu9t5v0__filltie
XTAP_TAPCELL_ROW_292_7111 VSS VSS gf180mcu_fd_sc_mcu9t5v0__filltie
XTAP_TAPCELL_ROW_292_7100 VSS VSS gf180mcu_fd_sc_mcu9t5v0__filltie
X_10074_ _19208_/Q _10074_/A2 _10075_/A2 VSS _10105_/VNW VSS VSS gf180mcu_fd_sc_mcu9t5v0__nand2_1
X_14951_ _19613_/Q _14950_/Z _20039_/D _19613_/D VSS _14951_/VNW VSS VSS gf180mcu_fd_sc_mcu9t5v0__mux2_1
XTAP_TAPCELL_ROW_30_1808 VSS VSS gf180mcu_fd_sc_mcu9t5v0__filltie
XTAP_TAPCELL_ROW_30_1819 VSS VSS gf180mcu_fd_sc_mcu9t5v0__filltie
X_17670_ _18633_/Q _18709_/Q _17742_/S _18709_/D VSS VSS VSS VSS gf180mcu_fd_sc_mcu9t5v0__mux2_1
X_13902_ _13903_/A1 _13901_/Z _13906_/B VSS VSS VSS VSS gf180mcu_fd_sc_mcu9t5v0__nand2_1
X_14882_ _14883_/A1 _14881_/Z _14886_/A2 VSS VSS VSS VSS gf180mcu_fd_sc_mcu9t5v0__nand2_1
XTAP_TAPCELL_ROW_15_1387 VSS VSS gf180mcu_fd_sc_mcu9t5v0__filltie
XTAP_TAPCELL_ROW_15_1398 VSS VSS gf180mcu_fd_sc_mcu9t5v0__filltie
X_16621_ _16621_/A1 _16042_/S _16672_/B _16622_/B VSS VSS VSS VSS gf180mcu_fd_sc_mcu9t5v0__oai21_4
X_13833_ _13834_/A1 _13834_/A3 _13833_/Z VSS VSS VSS VSS gf180mcu_fd_sc_mcu9t5v0__and2_1
Xmax_cap40 max_cap40/I _16862_/S VSS VSS VSS VSS gf180mcu_fd_sc_mcu9t5v0__clkbuf_16
X_16552_ _18335_/Q _16147_/C _17069_/S _18335_/D VSS VSS VSS VSS gf180mcu_fd_sc_mcu9t5v0__mux2_1
Xmax_cap51 _16971_/S _16993_/S VSS VSS VSS VSS gf180mcu_fd_sc_mcu9t5v0__clkbuf_8
Xmax_cap73 _16668_/A2 _16628_/A2 VSS VSS VSS VSS gf180mcu_fd_sc_mcu9t5v0__clkbuf_16
X_19340_ _19340_/D _20044_/RN clkload17/I _19340_/Q VSS VSS VSS VSS gf180mcu_fd_sc_mcu9t5v0__dffrnq_1
X_15503_ _17422_/S _15502_/Z _19838_/D VSS VSS VSS VSS gf180mcu_fd_sc_mcu9t5v0__and2_1
Xmax_cap95 _16042_/S _16672_/A2 VSS VSS VSS VSS gf180mcu_fd_sc_mcu9t5v0__clkbuf_16
X_10976_ _10937_/Z _18040_/A2 _10979_/A2 VSS VSS VSS VSS gf180mcu_fd_sc_mcu9t5v0__xnor2_1
X_13764_ _19292_/Q _19318_/Q _13776_/A1 VSS _13771_/VNW VSS VSS gf180mcu_fd_sc_mcu9t5v0__nand2_1
X_16483_ _19230_/Q _16016_/B _17003_/S _16483_/Z VSS VSS VSS VSS gf180mcu_fd_sc_mcu9t5v0__mux2_1
XTAP_TAPCELL_ROW_117_4211 VSS VSS gf180mcu_fd_sc_mcu9t5v0__filltie
XTAP_TAPCELL_ROW_117_4200 VSS VSS gf180mcu_fd_sc_mcu9t5v0__filltie
X_19271_ _19271_/D _20039_/RN clkload43/I _19271_/Q VSS VSS VSS VSS gf180mcu_fd_sc_mcu9t5v0__dffrnq_1
X_13695_ _19453_/Q _13733_/A2 _13697_/A1 VSS VSS VSS VSS gf180mcu_fd_sc_mcu9t5v0__nand2_1
XTAP_TAPCELL_ROW_28_1748 VSS VSS gf180mcu_fd_sc_mcu9t5v0__filltie
X_12715_ _19189_/Q _12724_/C _12718_/B VSS VSS VSS VSS gf180mcu_fd_sc_mcu9t5v0__nand2_1
XTAP_TAPCELL_ROW_28_1759 VSS VSS gf180mcu_fd_sc_mcu9t5v0__filltie
X_18222_ _18222_/D clkload73/I _18222_/Q VSS VSS VSS VSS gf180mcu_fd_sc_mcu9t5v0__dffq_1
X_15434_ _19816_/Q _15434_/A2 _15468_/A3 VSS VSS VSS VSS gf180mcu_fd_sc_mcu9t5v0__nor2_1
X_12646_ _12716_/S _12646_/A2 _12685_/B _12646_/C _12647_/I0 VSS VSS VSS VSS gf180mcu_fd_sc_mcu9t5v0__aoi211_1
XTAP_TAPCELL_ROW_307_7519 VSS VSS gf180mcu_fd_sc_mcu9t5v0__filltie
XTAP_TAPCELL_ROW_307_7508 VSS VSS gf180mcu_fd_sc_mcu9t5v0__filltie
X_18153_ _18153_/D clkload64/I _18153_/Q VSS VSS VSS VSS gf180mcu_fd_sc_mcu9t5v0__dffq_1
X_15365_ _19650_/Q _19750_/Q _15417_/S _19750_/D VSS VSS VSS VSS gf180mcu_fd_sc_mcu9t5v0__mux2_1
X_17104_ _17195_/A1 _18506_/Q _17107_/A2 VSS VSS VSS VSS gf180mcu_fd_sc_mcu9t5v0__nor2_1
X_12577_ _12616_/B _12577_/A2 _12577_/A3 _12577_/B1 _12577_/B2 _12578_/A2 VSS VSS
+ VSS VSS gf180mcu_fd_sc_mcu9t5v0__oai32_4
X_14316_ _14365_/I0 _19389_/Q _14322_/S _19389_/D VSS VSS VSS VSS gf180mcu_fd_sc_mcu9t5v0__mux2_1
Xwire283 wire283/I wire283/Z VSS VSS VSS VSS gf180mcu_fd_sc_mcu9t5v0__buf_4
XPHY_EDGE_ROW_165_3_Right_280 VSS VSS gf180mcu_fd_sc_mcu9t5v0__endcap
X_11528_ _18889_/Q _11878_/A1 _11488_/B _11528_/B2 _11540_/C _11530_/A1 VSS VSS VSS
+ VSS gf180mcu_fd_sc_mcu9t5v0__oai221_1
X_18084_ _18933_/Q _11018_/B _18086_/B VSS VSS VSS VSS gf180mcu_fd_sc_mcu9t5v0__nand2_1
X_15296_ _19636_/Q _19613_/Q _15296_/A3 _15296_/Z VSS VSS VSS VSS gf180mcu_fd_sc_mcu9t5v0__xor3_1
X_17035_ _16599_/B _19248_/Q _17055_/S _17035_/Z VSS VSS VSS VSS gf180mcu_fd_sc_mcu9t5v0__mux2_1
X_11459_ _11459_/A1 _11459_/A2 _11459_/B wire136/Z _11460_/B VSS VSS VSS VSS gf180mcu_fd_sc_mcu9t5v0__oai211_1
X_14247_ _14247_/A1 _14247_/A2 _14249_/A2 VSS VSS VSS VSS gf180mcu_fd_sc_mcu9t5v0__nand2_1
XTAP_TAPCELL_ROW_91_3473 VSS VSS gf180mcu_fd_sc_mcu9t5v0__filltie
XTAP_TAPCELL_ROW_262_6280 VSS VSS gf180mcu_fd_sc_mcu9t5v0__filltie
XTAP_TAPCELL_ROW_91_3495 VSS VSS gf180mcu_fd_sc_mcu9t5v0__filltie
XTAP_TAPCELL_ROW_91_3484 VSS VSS gf180mcu_fd_sc_mcu9t5v0__filltie
X_14178_ _13986_/Z _19333_/Q _14266_/S _19333_/D VSS VSS VSS VSS gf180mcu_fd_sc_mcu9t5v0__mux2_1
Xload_slew222 _19828_/Q _10543_/C VSS VSS VSS VSS gf180mcu_fd_sc_mcu9t5v0__clkbuf_8
X_13129_ _16426_/A1 _13419_/B _13129_/B1 _13129_/B2 _19237_/D VSS VSS VSS VSS gf180mcu_fd_sc_mcu9t5v0__aoi22_2
X_18986_ _18986_/D _20138_/RN clkload67/I _18986_/Q VSS VSS VSS VSS gf180mcu_fd_sc_mcu9t5v0__dffrnq_1
XPHY_EDGE_ROW_13_Left_337 VSS VSS gf180mcu_fd_sc_mcu9t5v0__endcap
XTAP_TAPCELL_ROW_275_6630 VSS VSS gf180mcu_fd_sc_mcu9t5v0__filltie
Xload_slew288 _12164_/B _12237_/B VSS _09928_/VNW VSS VSS gf180mcu_fd_sc_mcu9t5v0__buf_8
X_17937_ _18849_/Q _17968_/A1 _17931_/Z _17938_/A2 VSS _17937_/VNW VSS VSS gf180mcu_fd_sc_mcu9t5v0__nand3_1
XTAP_TAPCELL_ROW_275_6641 VSS VSS gf180mcu_fd_sc_mcu9t5v0__filltie
Xload_slew299 _19816_/Q _17411_/C VSS VSS VSS VSS gf180mcu_fd_sc_mcu9t5v0__clkbuf_8
X_17868_ _18829_/Q _17868_/A2 _17868_/A3 _17868_/B _18829_/D VSS _17868_/VNW VSS VSS
+ gf180mcu_fd_sc_mcu9t5v0__oai31_1
X_16819_ _19288_/Q _16654_/B _16955_/S _16819_/Z VSS VSS VSS VSS gf180mcu_fd_sc_mcu9t5v0__mux2_1
XTAP_TAPCELL_ROW_271_6527 VSS VSS gf180mcu_fd_sc_mcu9t5v0__filltie
XTAP_TAPCELL_ROW_271_6516 VSS VSS gf180mcu_fd_sc_mcu9t5v0__filltie
XTAP_TAPCELL_ROW_102_3801 VSS VSS gf180mcu_fd_sc_mcu9t5v0__filltie
X_19607_ _19607_/D _20055_/RN _19633_/CLK _19607_/Q VSS VSS VSS VSS gf180mcu_fd_sc_mcu9t5v0__dffrnq_1
X_17799_ _18777_/Q _18764_/Q _18769_/D _18777_/D VSS VSS VSS VSS gf180mcu_fd_sc_mcu9t5v0__mux2_1
Xu_transform_scheduler_core.u_fft_scratch_sram.u_hi.g_pin_drive\[3\].u_addr_driver
+ _10719_/ZN u_transform_scheduler_core.u_fft_scratch_sram.u_hi.u_sram/A[3] VSS VSS
+ VSS VSS gf180mcu_fd_sc_mcu9t5v0__buf_8
X_19538_ _19538_/D _20050_/RN _19798_/CLK _19538_/Q VSS VSS VSS VSS gf180mcu_fd_sc_mcu9t5v0__dffrnq_1
XPHY_EDGE_ROW_22_Left_346 VSS VSS gf180mcu_fd_sc_mcu9t5v0__endcap
X_19469_ _19469_/D _20045_/RN clkload31/I _19469_/Q VSS VSS VSS VSS gf180mcu_fd_sc_mcu9t5v0__dffrnq_1
XTAP_TAPCELL_ROW_269_6456 VSS VSS gf180mcu_fd_sc_mcu9t5v0__filltie
X_09222_ _19576_/Q _15258_/A2 VSS VSS VSS VSS gf180mcu_fd_sc_mcu9t5v0__clkinv_1
XTAP_TAPCELL_ROW_269_6478 VSS VSS gf180mcu_fd_sc_mcu9t5v0__filltie
XTAP_TAPCELL_ROW_269_6467 VSS VSS gf180mcu_fd_sc_mcu9t5v0__filltie
XPHY_EDGE_ROW_176_1_Right_760 VSS VSS gf180mcu_fd_sc_mcu9t5v0__endcap
X_09153_ _19741_/Q _13360_/A1 VSS _13377_/VNW VSS VSS gf180mcu_fd_sc_mcu9t5v0__clkinv_1
X_09084_ _18826_/Q _17857_/B2 VSS VSS VSS VSS gf180mcu_fd_sc_mcu9t5v0__clkinv_1
XTAP_TAPCELL_ROW_38_2022 VSS VSS gf180mcu_fd_sc_mcu9t5v0__filltie
XTAP_TAPCELL_ROW_38_2033 VSS VSS gf180mcu_fd_sc_mcu9t5v0__filltie
XTAP_TAPCELL_ROW_182_1_4761 VSS VSS gf180mcu_fd_sc_mcu9t5v0__filltie
XPHY_EDGE_ROW_31_Left_355 VSS VSS gf180mcu_fd_sc_mcu9t5v0__endcap
Xclkbuf_leaf_22_clk_regs clkload4/I clkload60/I VSS VSS VSS VSS gf180mcu_fd_sc_mcu9t5v0__clkbuf_8
X_09986_ _09916_/B _19004_/Q _09987_/B VSS VSS VSS VSS gf180mcu_fd_sc_mcu9t5v0__nand2_1
XTAP_TAPCELL_ROW_241_5696 VSS VSS gf180mcu_fd_sc_mcu9t5v0__filltie
XTAP_TAPCELL_ROW_241_5685 VSS VSS gf180mcu_fd_sc_mcu9t5v0__filltie
XTAP_TAPCELL_ROW_10_1251 VSS VSS gf180mcu_fd_sc_mcu9t5v0__filltie
XTAP_TAPCELL_ROW_10_1262 VSS VSS gf180mcu_fd_sc_mcu9t5v0__filltie
X_10830_ _20066_/Q _20067_/Q _10831_/A3 VSS VSS VSS VSS gf180mcu_fd_sc_mcu9t5v0__nor2_1
XPHY_EDGE_ROW_40_Left_364 VSS VSS gf180mcu_fd_sc_mcu9t5v0__endcap
X_10761_ _10761_/A1 _10759_/I _10762_/A2 VSS VSS VSS VSS gf180mcu_fd_sc_mcu9t5v0__xnor2_1
X_12500_ _12500_/A1 _12501_/A2 _12501_/C VSS VSS VSS VSS gf180mcu_fd_sc_mcu9t5v0__nand2_1
X_10692_ _10692_/A1 _18831_/Q _10715_/C _10692_/C _10693_/A2 VSS VSS VSS VSS gf180mcu_fd_sc_mcu9t5v0__aoi211_1
X_13480_ _13461_/Z _13480_/A2 _13640_/B _13493_/A2 VSS _13480_/VNW VSS VSS gf180mcu_fd_sc_mcu9t5v0__aoi21_1
X_12431_ _18210_/Q wire163/Z _12434_/A3 VSS _12431_/VNW VSS VSS gf180mcu_fd_sc_mcu9t5v0__nor2_1
XTAP_TAPCELL_ROW_23_1612 VSS VSS gf180mcu_fd_sc_mcu9t5v0__filltie
XTAP_TAPCELL_ROW_23_1623 VSS VSS gf180mcu_fd_sc_mcu9t5v0__filltie
X_12362_ _12541_/B _12362_/A2 _12362_/A3 _12362_/B1 _12362_/B2 _12363_/B2 VSS VSS
+ VSS VSS gf180mcu_fd_sc_mcu9t5v0__oai32_1
XPHY_EDGE_ROW_161_2_Left_673 VSS VSS gf180mcu_fd_sc_mcu9t5v0__endcap
X_15150_ _19692_/Q _19532_/Q wire108/Z _19692_/D VSS _15150_/VNW VSS VSS gf180mcu_fd_sc_mcu9t5v0__mux2_1
X_11313_ _18344_/Q _18328_/Q _18280_/Q _18264_/Q _11534_/S _11469_/B _11313_/Z VSS
+ VSS VSS VSS gf180mcu_fd_sc_mcu9t5v0__mux4_1
X_12293_ _11988_/B _12295_/A2 _12293_/B _12306_/A2 VSS _12293_/VNW VSS VSS gf180mcu_fd_sc_mcu9t5v0__oai21_4
X_14101_ _19314_/Q _14366_/I0 _14139_/S _19314_/D VSS VSS VSS VSS gf180mcu_fd_sc_mcu9t5v0__mux2_1
X_15081_ _19395_/Q _19311_/Q _15086_/A2 VSS _15081_/VNW VSS VSS gf180mcu_fd_sc_mcu9t5v0__xnor2_1
X_11244_ _11244_/A1 _11244_/A2 _19082_/D VSS _11244_/VNW VSS VSS gf180mcu_fd_sc_mcu9t5v0__nand2_1
X_14032_ _13954_/Z _14032_/A2 _14032_/B _14068_/A1 VSS _14032_/VNW VSS VSS gf180mcu_fd_sc_mcu9t5v0__oai21_1
XPHY_EDGE_ROW_171_2_Right_902 VSS VSS gf180mcu_fd_sc_mcu9t5v0__endcap
X_11175_ _11483_/B _11175_/A2 _11175_/A3 _11176_/B VSS VSS VSS VSS gf180mcu_fd_sc_mcu9t5v0__nand3_1
XTAP_TAPCELL_ROW_17_1438 VSS VSS gf180mcu_fd_sc_mcu9t5v0__filltie
XTAP_TAPCELL_ROW_17_1449 VSS VSS gf180mcu_fd_sc_mcu9t5v0__filltie
X_18840_ _18840_/D _19992_/RN clkload33/I _18840_/Q VSS VSS VSS VSS gf180mcu_fd_sc_mcu9t5v0__dffrnq_1
X_10126_ _10126_/A1 _10126_/A2 _10126_/A3 _10127_/A2 VSS _10126_/VNW VSS VSS gf180mcu_fd_sc_mcu9t5v0__nand3_1
X_15983_ _18567_/Q _17438_/A1 _18568_/Q _15988_/A2 VSS VSS VSS VSS gf180mcu_fd_sc_mcu9t5v0__aoi21_1
X_18771_ _18771_/D _20051_/RN clkload50/I _18771_/Q VSS VSS VSS VSS gf180mcu_fd_sc_mcu9t5v0__dffrnq_1
X_17722_ _18737_/Q _17681_/S _17743_/B _18661_/Q _17723_/I VSS VSS VSS VSS gf180mcu_fd_sc_mcu9t5v0__aoi22_1
X_10057_ _10057_/A1 _10057_/A2 _10057_/A3 _10074_/A2 VSS wire297/VNW VSS VSS gf180mcu_fd_sc_mcu9t5v0__nor3_1
X_14934_ _19359_/Q _14935_/A2 _14934_/Z VSS VSS VSS VSS gf180mcu_fd_sc_mcu9t5v0__or2_1
X_17653_ _17653_/I0 _17653_/I1 _17653_/S _17653_/Z VSS _17653_/VNW VSS VSS gf180mcu_fd_sc_mcu9t5v0__mux2_1
X_16604_ input6/Z _18783_/Q _16619_/S _16604_/Z VSS VSS VSS VSS gf180mcu_fd_sc_mcu9t5v0__mux2_1
X_14865_ _19410_/Q _19351_/Q _14865_/Z VSS _14865_/VNW VSS VSS gf180mcu_fd_sc_mcu9t5v0__xor2_1
X_17584_ _18652_/Q _17584_/I1 _17584_/S _18652_/D VSS VSS VSS VSS gf180mcu_fd_sc_mcu9t5v0__mux2_1
X_13816_ _19292_/Q _19321_/Q _13818_/A2 VSS _13818_/VNW VSS VSS gf180mcu_fd_sc_mcu9t5v0__nand2_1
X_14796_ _14797_/A1 _14795_/Z _14800_/A2 VSS VSS VSS VSS gf180mcu_fd_sc_mcu9t5v0__nand2_1
X_16535_ _16172_/C _19239_/Q _17057_/S _16535_/Z VSS VSS VSS VSS gf180mcu_fd_sc_mcu9t5v0__mux2_1
XTAP_TAPCELL_ROW_80_3196 VSS VSS gf180mcu_fd_sc_mcu9t5v0__filltie
X_10959_ _19010_/Q _18102_/B _10960_/B VSS _10959_/VNW VSS VSS gf180mcu_fd_sc_mcu9t5v0__nand2_1
XTAP_TAPCELL_ROW_80_3185 VSS VSS gf180mcu_fd_sc_mcu9t5v0__filltie
X_13747_ _14715_/S _13747_/A2 _13754_/B1 VSS VSS VSS VSS gf180mcu_fd_sc_mcu9t5v0__nand2_1
X_19323_ _19323_/D _19963_/RN clkload14/I _19323_/Q VSS VSS VSS VSS gf180mcu_fd_sc_mcu9t5v0__dffrnq_1
XTAP_TAPCELL_ROW_80_3174 VSS VSS gf180mcu_fd_sc_mcu9t5v0__filltie
X_16466_ _18291_/Q _16465_/Z _16986_/S _18291_/D VSS VSS VSS VSS gf180mcu_fd_sc_mcu9t5v0__mux2_4
X_19254_ _19254_/D _20022_/RN clkload39/I _19254_/Q VSS VSS VSS VSS gf180mcu_fd_sc_mcu9t5v0__dffrnq_1
X_18205_ _18205_/D clkload62/I _18205_/Q VSS VSS VSS VSS gf180mcu_fd_sc_mcu9t5v0__dffq_4
XTAP_TAPCELL_ROW_97_3660 VSS VSS gf180mcu_fd_sc_mcu9t5v0__filltie
X_13678_ _14715_/S _13677_/Z _13682_/C VSS VSS VSS VSS gf180mcu_fd_sc_mcu9t5v0__nor2_1
X_15417_ _19702_/Q _19802_/Q _15417_/S _19802_/D VSS VSS VSS VSS gf180mcu_fd_sc_mcu9t5v0__mux2_1
X_16397_ _16182_/B _19241_/Q _16927_/S _16397_/Z VSS _16542_/VNW VSS VSS gf180mcu_fd_sc_mcu9t5v0__mux2_1
X_19185_ _19185_/D _20145_/RN clkload12/I _19185_/Q VSS VSS VSS VSS gf180mcu_fd_sc_mcu9t5v0__dffrnq_1
X_12629_ _12720_/S _12629_/A2 _12630_/C VSS _12629_/VNW VSS VSS gf180mcu_fd_sc_mcu9t5v0__nor2_1
XTAP_TAPCELL_ROW_264_6342 VSS VSS gf180mcu_fd_sc_mcu9t5v0__filltie
XTAP_TAPCELL_ROW_264_6331 VSS VSS gf180mcu_fd_sc_mcu9t5v0__filltie
X_18136_ _18135_/Z _18955_/Q _18152_/S _18955_/D VSS VSS VSS VSS gf180mcu_fd_sc_mcu9t5v0__mux2_1
XTAP_TAPCELL_ROW_264_6320 VSS VSS gf180mcu_fd_sc_mcu9t5v0__filltie
XTAP_TAPCELL_ROW_93_3546 VSS VSS gf180mcu_fd_sc_mcu9t5v0__filltie
XTAP_TAPCELL_ROW_93_3535 VSS VSS gf180mcu_fd_sc_mcu9t5v0__filltie
X_15348_ _15354_/A1 _15347_/Z _15349_/A2 VSS VSS VSS VSS gf180mcu_fd_sc_mcu9t5v0__nand2_1
XTAP_TAPCELL_ROW_260_6217 VSS VSS gf180mcu_fd_sc_mcu9t5v0__filltie
X_18067_ _18045_/Z _18079_/A1 _18079_/A2 _18067_/A4 _18068_/B VSS _18067_/VNW VSS
+ VSS gf180mcu_fd_sc_mcu9t5v0__nand4_1
X_15279_ _15279_/I _15280_/C2 VSS VSS VSS VSS gf180mcu_fd_sc_mcu9t5v0__clkinv_1
X_17018_ _18500_/Q _17017_/Z _17020_/S _18500_/D VSS VSS VSS VSS gf180mcu_fd_sc_mcu9t5v0__mux2_4
XTAP_TAPCELL_ROW_260_6228 VSS VSS gf180mcu_fd_sc_mcu9t5v0__filltie
XTAP_TAPCELL_ROW_176_3_8140 VSS VSS gf180mcu_fd_sc_mcu9t5v0__filltie
XPHY_EDGE_ROW_166_3_Right_281 VSS VSS gf180mcu_fd_sc_mcu9t5v0__endcap
X_09840_ _20030_/Q _09848_/B _17621_/A1 _20027_/Q _09840_/C _09841_/I VSS VSS VSS
+ VSS gf180mcu_fd_sc_mcu9t5v0__aoi221_1
X_18969_ _18969_/D _20057_/RN clkload70/I _18969_/Q VSS VSS VSS VSS gf180mcu_fd_sc_mcu9t5v0__dffrnq_1
X_09771_ _09771_/I _09772_/A2 VSS _09771_/VNW VSS VSS gf180mcu_fd_sc_mcu9t5v0__clkinv_1
XTAP_TAPCELL_ROW_258_6168 VSS VSS gf180mcu_fd_sc_mcu9t5v0__filltie
XTAP_TAPCELL_ROW_258_6157 VSS VSS gf180mcu_fd_sc_mcu9t5v0__filltie
XTAP_TAPCELL_ROW_258_6179 VSS VSS gf180mcu_fd_sc_mcu9t5v0__filltie
XTAP_TAPCELL_ROW_156_3_8071 VSS VSS gf180mcu_fd_sc_mcu9t5v0__filltie
XTAP_TAPCELL_ROW_7_1172 VSS VSS gf180mcu_fd_sc_mcu9t5v0__filltie
XTAP_TAPCELL_ROW_7_1183 VSS VSS gf180mcu_fd_sc_mcu9t5v0__filltie
XTAP_TAPCELL_ROW_3_1058 VSS VSS gf180mcu_fd_sc_mcu9t5v0__filltie
XTAP_TAPCELL_ROW_3_1069 VSS VSS gf180mcu_fd_sc_mcu9t5v0__filltie
X_09205_ _19564_/Q _15187_/A2 VSS VSS VSS VSS gf180mcu_fd_sc_mcu9t5v0__clkinv_1
XTAP_TAPCELL_ROW_230_5386 VSS VSS gf180mcu_fd_sc_mcu9t5v0__filltie
XTAP_TAPCELL_ROW_230_5397 VSS VSS gf180mcu_fd_sc_mcu9t5v0__filltie
Xrebuffer235 _16865_/S _16871_/S VSS VSS VSS VSS gf180mcu_fd_sc_mcu9t5v0__buf_12
XPHY_EDGE_ROW_177_1_Right_761 VSS VSS gf180mcu_fd_sc_mcu9t5v0__endcap
X_09136_ _19763_/Q _13198_/A2 VSS VSS VSS VSS gf180mcu_fd_sc_mcu9t5v0__clkinv_1
Xrebuffer268 _16477_/ZN _17003_/S VSS VSS VSS VSS gf180mcu_fd_sc_mcu9t5v0__buf_8
XTAP_TAPCELL_ROW_247_5850 VSS VSS gf180mcu_fd_sc_mcu9t5v0__filltie
X_09067_ _09916_/B _10659_/C VSS _09067_/VNW VSS VSS gf180mcu_fd_sc_mcu9t5v0__inv_2
XTAP_TAPCELL_ROW_247_5872 VSS VSS gf180mcu_fd_sc_mcu9t5v0__filltie
XTAP_TAPCELL_ROW_247_5861 VSS VSS gf180mcu_fd_sc_mcu9t5v0__filltie
XTAP_TAPCELL_ROW_243_5758 VSS VSS gf180mcu_fd_sc_mcu9t5v0__filltie
XTAP_TAPCELL_ROW_243_5747 VSS VSS gf180mcu_fd_sc_mcu9t5v0__filltie
X_09969_ _18808_/Q _10153_/A2 _10153_/B _09971_/A2 VSS VSS VSS VSS gf180mcu_fd_sc_mcu9t5v0__oai21_1
XTAP_TAPCELL_ROW_12_1302 VSS VSS gf180mcu_fd_sc_mcu9t5v0__filltie
XTAP_TAPCELL_ROW_12_1313 VSS VSS gf180mcu_fd_sc_mcu9t5v0__filltie
X_20089_ _20089_/D clkload78/I _20089_/Q VSS VSS VSS VSS gf180mcu_fd_sc_mcu9t5v0__dffq_1
XTAP_TAPCELL_ROW_12_1324 VSS VSS gf180mcu_fd_sc_mcu9t5v0__filltie
X_12980_ _12983_/A1 _12983_/A2 _12984_/A1 VSS _12980_/VNW VSS VSS gf180mcu_fd_sc_mcu9t5v0__nand2_1
X_11931_ _18197_/Q _11930_/Z _12299_/S _11931_/Z VSS VSS VSS VSS gf180mcu_fd_sc_mcu9t5v0__mux2_1
X_11862_ _18178_/Q _18162_/Q _12315_/S _11862_/Z VSS VSS VSS VSS gf180mcu_fd_sc_mcu9t5v0__mux2_1
X_14650_ _19142_/Q _19108_/Q _14651_/B VSS VSS VSS VSS gf180mcu_fd_sc_mcu9t5v0__nand2_1
X_10813_ _20059_/Q _09721_/B _10813_/B _20059_/D VSS VSS VSS VSS gf180mcu_fd_sc_mcu9t5v0__aoi21_1
X_13601_ _13601_/A1 _13601_/A2 _13601_/B _19282_/D VSS _13601_/VNW VSS VSS gf180mcu_fd_sc_mcu9t5v0__oai21_1
X_14581_ _14581_/A1 _14581_/A2 _14581_/B _14583_/A2 VSS VSS VSS VSS gf180mcu_fd_sc_mcu9t5v0__oai21_1
X_16320_ _18225_/Q _16319_/Z _16854_/S _18225_/D VSS _16320_/VNW VSS VSS gf180mcu_fd_sc_mcu9t5v0__mux2_4
X_13532_ _13043_/I _13530_/Z _13532_/A3 _13532_/B _19267_/D VSS VSS VSS VSS gf180mcu_fd_sc_mcu9t5v0__oai31_1
X_11793_ _11966_/B _11793_/A2 _11793_/B _19112_/D VSS _11793_/VNW VSS VSS gf180mcu_fd_sc_mcu9t5v0__oai21_1
X_10744_ _18827_/Q _20030_/Q _10749_/B VSS VSS VSS VSS gf180mcu_fd_sc_mcu9t5v0__nand2_1
XTAP_TAPCELL_ROW_182_3_8161 VSS VSS gf180mcu_fd_sc_mcu9t5v0__filltie
X_16251_ _16251_/A1 _16414_/A1 _16252_/I1 VSS VSS VSS VSS gf180mcu_fd_sc_mcu9t5v0__nand2_1
XTAP_TAPCELL_ROW_136_1_7997 VSS VSS gf180mcu_fd_sc_mcu9t5v0__filltie
X_10675_ _10675_/A1 _10675_/A2 _10675_/Z VSS VSS VSS VSS gf180mcu_fd_sc_mcu9t5v0__and2_1
X_13463_ _13465_/A1 _13465_/A2 _13634_/B _13480_/A2 VSS VSS VSS VSS gf180mcu_fd_sc_mcu9t5v0__oai21_1
X_16182_ _16750_/A1 _16750_/A2 _16182_/B _16184_/A1 VSS VSS VSS VSS gf180mcu_fd_sc_mcu9t5v0__aoi21_4
X_13394_ _12948_/S _13411_/A2 _13395_/B VSS _13394_/VNW VSS VSS gf180mcu_fd_sc_mcu9t5v0__and2_1
X_12414_ _12548_/A1 _12414_/A2 _12485_/A2 VSS VSS VSS VSS gf180mcu_fd_sc_mcu9t5v0__nand2_1
X_15202_ _15206_/A1 _19568_/Q _15209_/B VSS VSS VSS VSS gf180mcu_fd_sc_mcu9t5v0__nand2_1
X_12345_ _18456_/Q _12345_/A2 _12345_/B _12347_/A2 VSS _12348_/VNW VSS VSS gf180mcu_fd_sc_mcu9t5v0__oai21_1
XTAP_TAPCELL_ROW_131_4594 VSS VSS gf180mcu_fd_sc_mcu9t5v0__filltie
XTAP_TAPCELL_ROW_131_4583 VSS VSS gf180mcu_fd_sc_mcu9t5v0__filltie
X_15133_ _19675_/Q _19515_/Q wire108/Z _19675_/D VSS VSS VSS VSS gf180mcu_fd_sc_mcu9t5v0__mux2_1
XTAP_TAPCELL_ROW_131_4572 VSS VSS gf180mcu_fd_sc_mcu9t5v0__filltie
X_19941_ _19941_/D _20069_/RN clkload50/I _19941_/Q VSS VSS VSS VSS gf180mcu_fd_sc_mcu9t5v0__dffrnq_1
XTAP_TAPCELL_ROW_162_3_8092 VSS VSS gf180mcu_fd_sc_mcu9t5v0__filltie
X_12276_ _19135_/Q _12276_/I1 _12333_/B _19135_/D VSS VSS VSS VSS gf180mcu_fd_sc_mcu9t5v0__mux2_1
X_15064_ _19307_/Q _19392_/Q _15064_/B _15066_/A2 VSS VSS VSS VSS gf180mcu_fd_sc_mcu9t5v0__oai21_1
X_19872_ _19872_/D _20064_/RN clkload56/I _19872_/Q VSS VSS VSS VSS gf180mcu_fd_sc_mcu9t5v0__dffrnq_1
X_11227_ _19081_/Q _11321_/A2 _11228_/A2 VSS _11228_/VNW VSS VSS gf180mcu_fd_sc_mcu9t5v0__nand2_1
X_14015_ _14015_/A1 _14013_/Z _14039_/A2 VSS _14075_/VNW VSS VSS gf180mcu_fd_sc_mcu9t5v0__xnor2_1
X_11158_ _11483_/B _11158_/A2 _11158_/A3 _11159_/B VSS VSS VSS VSS gf180mcu_fd_sc_mcu9t5v0__nand3_1
X_18823_ _18823_/D _20039_/RN clkload55/I _18823_/Q VSS VSS VSS VSS gf180mcu_fd_sc_mcu9t5v0__dffrnq_1
XPHY_EDGE_ROW_172_2_Right_903 VSS VSS gf180mcu_fd_sc_mcu9t5v0__endcap
X_10109_ _18812_/Q _10153_/A2 _10153_/B _10111_/A2 VSS VSS VSS VSS gf180mcu_fd_sc_mcu9t5v0__oai21_1
X_11089_ wire175/I _15959_/A1 _12501_/A2 VSS VSS VSS VSS gf180mcu_fd_sc_mcu9t5v0__nand2_1
X_15966_ _18567_/Q _15989_/A3 _15966_/A3 _15967_/B VSS _16516_/VNW VSS VSS gf180mcu_fd_sc_mcu9t5v0__or3_1
XTAP_TAPCELL_ROW_86_3361 VSS VSS gf180mcu_fd_sc_mcu9t5v0__filltie
XTAP_TAPCELL_ROW_86_3350 VSS VSS gf180mcu_fd_sc_mcu9t5v0__filltie
X_18754_ _18754_/D clkload25/I _18754_/Q VSS VSS VSS VSS gf180mcu_fd_sc_mcu9t5v0__dffq_1
XPHY_EDGE_ROW_282_Right_209 VSS VSS gf180mcu_fd_sc_mcu9t5v0__endcap
X_15897_ _20106_/Q _19241_/Q _15927_/S _20106_/D VSS VSS VSS VSS gf180mcu_fd_sc_mcu9t5v0__mux2_1
XTAP_TAPCELL_ROW_253_6032 VSS VSS gf180mcu_fd_sc_mcu9t5v0__filltie
X_17705_ _17705_/I _18728_/D VSS VSS VSS VSS gf180mcu_fd_sc_mcu9t5v0__clkinv_1
XTAP_TAPCELL_ROW_253_6021 VSS VSS gf180mcu_fd_sc_mcu9t5v0__filltie
X_18685_ _18685_/D _20025_/RN clkload47/I _18685_/Q VSS VSS VSS VSS gf180mcu_fd_sc_mcu9t5v0__dffrnq_1
XTAP_TAPCELL_ROW_82_3247 VSS VSS gf180mcu_fd_sc_mcu9t5v0__filltie
XTAP_TAPCELL_ROW_82_3236 VSS VSS gf180mcu_fd_sc_mcu9t5v0__filltie
X_14917_ _19599_/Q _14917_/I1 _15163_/S _19599_/D VSS VSS VSS VSS gf180mcu_fd_sc_mcu9t5v0__mux2_1
XTAP_TAPCELL_ROW_82_3225 VSS VSS gf180mcu_fd_sc_mcu9t5v0__filltie
XTAP_TAPCELL_ROW_168_2_8110 VSS VSS gf180mcu_fd_sc_mcu9t5v0__filltie
X_17636_ _18686_/Q _17653_/I1 _17636_/B _17637_/A2 VSS VSS VSS VSS gf180mcu_fd_sc_mcu9t5v0__oai21_1
X_14848_ _14849_/A1 _19408_/Q _14851_/A2 VSS VSS VSS VSS gf180mcu_fd_sc_mcu9t5v0__nand2_1
X_17567_ _17567_/I _17568_/A2 VSS _17628_/VNW VSS VSS gf180mcu_fd_sc_mcu9t5v0__clkinv_1
XTAP_TAPCELL_ROW_99_3711 VSS VSS gf180mcu_fd_sc_mcu9t5v0__filltie
XTAP_TAPCELL_ROW_99_3700 VSS VSS gf180mcu_fd_sc_mcu9t5v0__filltie
X_16518_ _16517_/Z _18315_/Q _17050_/S _18315_/D VSS VSS VSS VSS gf180mcu_fd_sc_mcu9t5v0__mux2_4
X_14779_ _19396_/Q _19333_/Q _14786_/A1 VSS _14785_/VNW VSS VSS gf180mcu_fd_sc_mcu9t5v0__nand2_1
X_19306_ _19306_/D _20138_/RN clkload20/I _19306_/Q VSS VSS VSS VSS gf180mcu_fd_sc_mcu9t5v0__dffrnq_1
X_17498_ _18603_/Q _19244_/Q _17504_/S _18603_/D VSS VSS VSS VSS gf180mcu_fd_sc_mcu9t5v0__mux2_1
XTAP_TAPCELL_ROW_95_3608 VSS VSS gf180mcu_fd_sc_mcu9t5v0__filltie
X_16449_ _19230_/Q _16016_/B _16971_/S _16449_/Z VSS VSS VSS VSS gf180mcu_fd_sc_mcu9t5v0__mux2_1
X_19237_ _19237_/D _20069_/RN clkload68/I _19237_/Q VSS VSS VSS VSS gf180mcu_fd_sc_mcu9t5v0__dffrnq_2
X_19168_ _19168_/D _20064_/RN clkload31/I _19168_/Q VSS VSS VSS VSS gf180mcu_fd_sc_mcu9t5v0__dffrnq_1
X_18119_ _19204_/Q _19210_/Q _18151_/S _18119_/Z VSS VSS VSS VSS gf180mcu_fd_sc_mcu9t5v0__mux2_1
X_19099_ _19099_/D _20059_/RN clkload44/I _19099_/Q VSS VSS VSS VSS gf180mcu_fd_sc_mcu9t5v0__dffrnq_1
XPHY_EDGE_ROW_167_3_Right_282 VSS VSS gf180mcu_fd_sc_mcu9t5v0__endcap
XTAP_TAPCELL_ROW_71_2940 VSS VSS gf180mcu_fd_sc_mcu9t5v0__filltie
XTAP_TAPCELL_ROW_110_3999 VSS VSS gf180mcu_fd_sc_mcu9t5v0__filltie
X_20012_ _20012_/D _20140_/RN clkload53/I _20012_/Q VSS VSS VSS VSS gf180mcu_fd_sc_mcu9t5v0__dffrnq_1
X_09823_ _17888_/A2 _09823_/A2 _09823_/B _09826_/C VSS VSS VSS VSS gf180mcu_fd_sc_mcu9t5v0__oai21_1
XTAP_TAPCELL_ROW_223_5190 VSS VSS gf180mcu_fd_sc_mcu9t5v0__filltie
XTAP_TAPCELL_ROW_9_1223 VSS VSS gf180mcu_fd_sc_mcu9t5v0__filltie
XTAP_TAPCELL_ROW_9_1234 VSS VSS gf180mcu_fd_sc_mcu9t5v0__filltie
X_09754_ _20023_/Q _20049_/Q _09755_/B VSS VSS VSS VSS gf180mcu_fd_sc_mcu9t5v0__nand2_1
XTAP_TAPCELL_ROW_5_1109 VSS VSS gf180mcu_fd_sc_mcu9t5v0__filltie
XTAP_TAPCELL_ROW_69_2880 VSS VSS gf180mcu_fd_sc_mcu9t5v0__filltie
X_09685_ _18576_/Q _12622_/A1 _17961_/A2 _18572_/Q _09686_/A4 VSS _09686_/VNW VSS
+ VSS gf180mcu_fd_sc_mcu9t5v0__oai22_1
XPHY_EDGE_ROW_126_Right_126 VSS VSS gf180mcu_fd_sc_mcu9t5v0__endcap
XTAP_TAPCELL_ROW_69_2891 VSS VSS gf180mcu_fd_sc_mcu9t5v0__filltie
XTAP_TAPCELL_ROW_236_5573 VSS VSS gf180mcu_fd_sc_mcu9t5v0__filltie
XTAP_TAPCELL_ROW_236_5562 VSS VSS gf180mcu_fd_sc_mcu9t5v0__filltie
XTAP_TAPCELL_ROW_236_5551 VSS VSS gf180mcu_fd_sc_mcu9t5v0__filltie
XTAP_TAPCELL_ROW_65_2766 VSS VSS gf180mcu_fd_sc_mcu9t5v0__filltie
XTAP_TAPCELL_ROW_65_2777 VSS VSS gf180mcu_fd_sc_mcu9t5v0__filltie
XTAP_TAPCELL_ROW_232_5437 VSS VSS gf180mcu_fd_sc_mcu9t5v0__filltie
XPHY_EDGE_ROW_160_3_Left_818 VSS VSS gf180mcu_fd_sc_mcu9t5v0__endcap
XTAP_TAPCELL_ROW_232_5459 VSS VSS gf180mcu_fd_sc_mcu9t5v0__filltie
XTAP_TAPCELL_ROW_232_5448 VSS VSS gf180mcu_fd_sc_mcu9t5v0__filltie
XTAP_TAPCELL_ROW_249_5923 VSS VSS gf180mcu_fd_sc_mcu9t5v0__filltie
X_10460_ _18289_/Q _17406_/A2 _17405_/A2 _18305_/Q _10460_/C _10466_/A2 VSS VSS VSS
+ VSS gf180mcu_fd_sc_mcu9t5v0__aoi221_1
XTAP_TAPCELL_ROW_249_5912 VSS VSS gf180mcu_fd_sc_mcu9t5v0__filltie
XTAP_TAPCELL_ROW_245_5809 VSS VSS gf180mcu_fd_sc_mcu9t5v0__filltie
XPHY_EDGE_ROW_178_1_Right_762 VSS VSS gf180mcu_fd_sc_mcu9t5v0__endcap
X_09119_ _19722_/Q _13019_/A1 VSS VSS VSS VSS gf180mcu_fd_sc_mcu9t5v0__clkinv_1
X_10391_ _18542_/Q wire80/Z _10390_/Z _10416_/B _10397_/A2 VSS VSS VSS VSS gf180mcu_fd_sc_mcu9t5v0__aoi22_4
X_12130_ _18366_/Q _18350_/Q _12315_/S _12130_/Z VSS VSS VSS VSS gf180mcu_fd_sc_mcu9t5v0__mux2_1
XTAP_TAPCELL_ROW_320_7880 VSS VSS gf180mcu_fd_sc_mcu9t5v0__filltie
X_12061_ _12061_/A1 _12203_/A2 _12067_/C VSS VSS VSS VSS gf180mcu_fd_sc_mcu9t5v0__nor2_1
XTAP_TAPCELL_ROW_174_2_8131 VSS VSS gf180mcu_fd_sc_mcu9t5v0__filltie
X_11012_ _18834_/Q _11012_/A2 _11012_/B _19018_/D VSS VSS VSS VSS gf180mcu_fd_sc_mcu9t5v0__oai21_1
X_15820_ _19996_/Q _15820_/A2 _15820_/B1 _15820_/B2 _15821_/A2 VSS VSS VSS VSS gf180mcu_fd_sc_mcu9t5v0__oai22_1
X_15751_ _19929_/Q _15751_/A2 _15752_/A2 VSS _15751_/VNW VSS VSS gf180mcu_fd_sc_mcu9t5v0__xnor2_1
X_12963_ _19719_/Q _12961_/Z _12989_/A1 VSS _12988_/VNW VSS VSS gf180mcu_fd_sc_mcu9t5v0__nand2_1
X_11914_ _12299_/S _11910_/Z _11915_/C VSS VSS VSS VSS gf180mcu_fd_sc_mcu9t5v0__nand2_1
X_18470_ _18470_/D clkload82/I _18470_/Q VSS VSS VSS VSS gf180mcu_fd_sc_mcu9t5v0__dffq_4
X_15682_ _19913_/Q _15682_/A2 _15761_/A1 _15682_/B2 _15683_/I VSS _15682_/VNW VSS
+ VSS gf180mcu_fd_sc_mcu9t5v0__aoi22_1
XTAP_TAPCELL_ROW_120_4273 VSS VSS gf180mcu_fd_sc_mcu9t5v0__filltie
X_14702_ _14702_/A1 _14702_/A2 _14702_/B _14706_/B VSS _14702_/VNW VSS VSS gf180mcu_fd_sc_mcu9t5v0__aoi21_1
XTAP_TAPCELL_ROW_314_7695 VSS VSS gf180mcu_fd_sc_mcu9t5v0__filltie
XTAP_TAPCELL_ROW_120_4295 VSS VSS gf180mcu_fd_sc_mcu9t5v0__filltie
XTAP_TAPCELL_ROW_120_4284 VSS VSS gf180mcu_fd_sc_mcu9t5v0__filltie
X_12894_ _12898_/A1 _12891_/Z _12899_/A1 VSS _13338_/VNW VSS VSS gf180mcu_fd_sc_mcu9t5v0__nand2_1
X_17421_ _09065_/I _18560_/Q _17421_/S _18560_/D VSS VSS VSS VSS gf180mcu_fd_sc_mcu9t5v0__mux2_1
X_14633_ _19095_/Q _19511_/Q _14730_/S _19511_/D VSS _14633_/VNW VSS VSS gf180mcu_fd_sc_mcu9t5v0__mux2_1
X_11845_ _18273_/Q _12181_/A2 _11847_/B1 VSS VSS VSS VSS gf180mcu_fd_sc_mcu9t5v0__nand2_1
X_11776_ _18286_/Q _12315_/S _11777_/C VSS _11776_/VNW VSS VSS gf180mcu_fd_sc_mcu9t5v0__and2_1
X_17352_ _17250_/Z _17352_/A2 _17352_/B _18549_/D VSS VSS VSS VSS gf180mcu_fd_sc_mcu9t5v0__oai21_4
X_14564_ _19136_/Q wire199/Z _14764_/B _14564_/C _14565_/A2 VSS _14564_/VNW VSS VSS
+ gf180mcu_fd_sc_mcu9t5v0__oai211_1
X_16303_ _19228_/Q _16117_/C _16863_/S _16303_/Z VSS VSS VSS VSS gf180mcu_fd_sc_mcu9t5v0__mux2_1
X_17283_ _10459_/C _17283_/A2 _17283_/A3 _17283_/B _17284_/A3 VSS VSS VSS VSS gf180mcu_fd_sc_mcu9t5v0__oai31_1
X_10727_ _18826_/Q _20030_/Q _10727_/B1 _10727_/B2 _10728_/I VSS VSS VSS VSS gf180mcu_fd_sc_mcu9t5v0__aoi22_4
XTAP_TAPCELL_ROW_215_4978 VSS VSS gf180mcu_fd_sc_mcu9t5v0__filltie
XTAP_TAPCELL_ROW_133_4645 VSS VSS gf180mcu_fd_sc_mcu9t5v0__filltie
XTAP_TAPCELL_ROW_133_4634 VSS VSS gf180mcu_fd_sc_mcu9t5v0__filltie
X_14495_ _19162_/Q _14495_/A2 _14507_/C VSS VSS VSS VSS gf180mcu_fd_sc_mcu9t5v0__nor2_1
X_13515_ _13000_/Z _13516_/A2 _13517_/A2 VSS VSS VSS VSS gf180mcu_fd_sc_mcu9t5v0__nor2_1
XTAP_TAPCELL_ROW_215_4989 VSS VSS gf180mcu_fd_sc_mcu9t5v0__filltie
X_16234_ _16234_/A1 _16234_/A2 _16787_/S VSS VSS VSS VSS gf180mcu_fd_sc_mcu9t5v0__nand2_4
X_13446_ _19746_/Q _13442_/Z _13630_/B VSS _13447_/VNW VSS VSS gf180mcu_fd_sc_mcu9t5v0__xnor2_1
Xeco18_sk_18433 _18513_/CLK _18433_/CLK VSS VSS VSS VSS gf180mcu_fd_sc_mcu9t5v0__clkbuf_16
X_19022_ _19022_/D _20046_/RN clkload34/I _19022_/Q VSS VSS VSS VSS gf180mcu_fd_sc_mcu9t5v0__dffrnq_1
X_10658_ _20043_/Q _15629_/A1 _10659_/B VSS VSS VSS VSS gf180mcu_fd_sc_mcu9t5v0__nand2_1
XTAP_TAPCELL_ROW_75_3051 VSS VSS gf180mcu_fd_sc_mcu9t5v0__filltie
Xclkload25 clkload25/I clkload25/ZN VSS VSS VSS VSS gf180mcu_fd_sc_mcu9t5v0__inv_2
Xclkload14 clkload14/I clkload14/ZN VSS VSS VSS VSS gf180mcu_fd_sc_mcu9t5v0__clkinv_8
XTAP_TAPCELL_ROW_75_3040 VSS VSS gf180mcu_fd_sc_mcu9t5v0__filltie
X_16165_ _18178_/Q _16165_/I1 _16753_/S _18178_/D VSS VSS VSS VSS gf180mcu_fd_sc_mcu9t5v0__mux2_4
Xclkload58 clkload58/I clkload58/ZN VSS VSS VSS VSS gf180mcu_fd_sc_mcu9t5v0__inv_3
X_10589_ _17404_/S _18278_/Q _10591_/A3 VSS VSS VSS VSS gf180mcu_fd_sc_mcu9t5v0__nor2_1
Xclkload69 clkload69/I clkload69/ZN VSS _16400_/VNW VSS VSS gf180mcu_fd_sc_mcu9t5v0__inv_4
Xclkload47 clkload47/I clkload47/ZN VSS VSS VSS VSS gf180mcu_fd_sc_mcu9t5v0__clkinv_4
X_13377_ _13377_/A1 _13377_/A2 _13377_/B _13416_/B1 VSS _13377_/VNW VSS VSS gf180mcu_fd_sc_mcu9t5v0__oai21_1
Xclkload36 clkload36/I clkload36/ZN VSS VSS VSS VSS gf180mcu_fd_sc_mcu9t5v0__inv_2
X_12328_ _12261_/B _12316_/Z _12328_/B _12329_/B VSS _12328_/VNW VSS VSS gf180mcu_fd_sc_mcu9t5v0__oai21_1
X_16096_ _16675_/A1 _16096_/A2 _16096_/A3 _16096_/B _16097_/I1 VSS VSS VSS VSS gf180mcu_fd_sc_mcu9t5v0__oai31_1
X_15116_ _19658_/Q _19498_/Q wire108/Z _19658_/D VSS _15116_/VNW VSS VSS gf180mcu_fd_sc_mcu9t5v0__mux2_1
X_12259_ _18372_/Q _18356_/Q _12315_/S _12259_/Z VSS VSS VSS VSS gf180mcu_fd_sc_mcu9t5v0__mux2_1
X_19924_ _19924_/D _20052_/RN clkload49/I _19924_/Q VSS VSS VSS VSS gf180mcu_fd_sc_mcu9t5v0__dffrnq_1
X_15047_ _15047_/A1 _15043_/Z _15047_/B _15050_/A1 VSS _15047_/VNW VSS VSS gf180mcu_fd_sc_mcu9t5v0__aoi21_1
XTAP_TAPCELL_ROW_88_3412 VSS VSS gf180mcu_fd_sc_mcu9t5v0__filltie
XTAP_TAPCELL_ROW_88_3401 VSS VSS gf180mcu_fd_sc_mcu9t5v0__filltie
X_19855_ _19855_/D _20047_/RN clkload56/I _19855_/Q VSS VSS VSS VSS gf180mcu_fd_sc_mcu9t5v0__dffrnq_1
XPHY_EDGE_ROW_173_2_Right_904 VSS VSS gf180mcu_fd_sc_mcu9t5v0__endcap
X_16998_ _18490_/Q _16997_/Z _17006_/S _18490_/D VSS VSS VSS VSS gf180mcu_fd_sc_mcu9t5v0__mux2_1
X_19786_ _19786_/D _20042_/RN clkload15/I _19786_/Q VSS VSS VSS VSS gf180mcu_fd_sc_mcu9t5v0__dffrnq_1
X_18806_ _18806_/D _20022_/RN clkload35/I _18806_/Q VSS VSS VSS VSS gf180mcu_fd_sc_mcu9t5v0__dffrnq_1
X_18737_ _18737_/D clkload66/I _18737_/Q VSS VSS VSS VSS gf180mcu_fd_sc_mcu9t5v0__dffq_1
X_15949_ _15973_/B _15988_/C _15988_/B _15947_/Z _16443_/A2 VSS VSS VSS VSS gf180mcu_fd_sc_mcu9t5v0__nand4_4
X_09470_ _09473_/B _09471_/A2 VSS VSS VSS VSS gf180mcu_fd_sc_mcu9t5v0__clkinv_1
X_18668_ _18668_/D _20072_/RN clkload58/I _18668_/Q VSS VSS VSS VSS gf180mcu_fd_sc_mcu9t5v0__dffrnq_1
Xrst_tree_leaf_0 rst_tree_mid_0/Z _20019_/RN VSS VSS VSS VSS gf180mcu_fd_sc_mcu9t5v0__clkbuf_16
X_18599_ _18599_/D clkload77/I _18599_/Q VSS VSS VSS VSS gf180mcu_fd_sc_mcu9t5v0__dffq_1
X_17619_ _17767_/A1 _09065_/I _17619_/A3 _17619_/B _18681_/D VSS VSS VSS VSS gf180mcu_fd_sc_mcu9t5v0__oai31_1
XTAP_TAPCELL_ROW_60_2630 VSS VSS gf180mcu_fd_sc_mcu9t5v0__filltie
XTAP_TAPCELL_ROW_60_2641 VSS VSS gf180mcu_fd_sc_mcu9t5v0__filltie
Xclkload8 clkload8/I clkload8/ZN VSS VSS VSS VSS gf180mcu_fd_sc_mcu9t5v0__inv_2
XTAP_TAPCELL_ROW_180_2_8152 VSS VSS gf180mcu_fd_sc_mcu9t5v0__filltie
XTAP_TAPCELL_ROW_58_2570 VSS VSS gf180mcu_fd_sc_mcu9t5v0__filltie
XTAP_TAPCELL_ROW_58_2581 VSS VSS gf180mcu_fd_sc_mcu9t5v0__filltie
XPHY_EDGE_ROW_244_Right_171 VSS VSS gf180mcu_fd_sc_mcu9t5v0__endcap
XTAP_TAPCELL_ROW_225_5252 VSS VSS gf180mcu_fd_sc_mcu9t5v0__filltie
XPHY_EDGE_ROW_5_Left_329 VSS VSS gf180mcu_fd_sc_mcu9t5v0__endcap
XTAP_TAPCELL_ROW_54_2456 VSS VSS gf180mcu_fd_sc_mcu9t5v0__filltie
XTAP_TAPCELL_ROW_54_2467 VSS VSS gf180mcu_fd_sc_mcu9t5v0__filltie
XTAP_TAPCELL_ROW_225_5263 VSS VSS gf180mcu_fd_sc_mcu9t5v0__filltie
XPHY_EDGE_ROW_168_3_Right_283 VSS VSS gf180mcu_fd_sc_mcu9t5v0__endcap
XTAP_TAPCELL_ROW_54_2478 VSS VSS gf180mcu_fd_sc_mcu9t5v0__filltie
Xfanout245 _17058_/S _17054_/S VSS VSS VSS VSS gf180mcu_fd_sc_mcu9t5v0__clkbuf_16
XTAP_TAPCELL_ROW_221_5149 VSS VSS gf180mcu_fd_sc_mcu9t5v0__filltie
Xfanout256 _17074_/S max_cap20/I VSS VSS VSS VSS gf180mcu_fd_sc_mcu9t5v0__clkbuf_16
XTAP_TAPCELL_ROW_221_5138 VSS VSS gf180mcu_fd_sc_mcu9t5v0__filltie
X_09806_ _09798_/Z _17915_/A2 _17916_/A1 VSS _17906_/VNW VSS VSS gf180mcu_fd_sc_mcu9t5v0__nand2_1
XTAP_TAPCELL_ROW_238_5624 VSS VSS gf180mcu_fd_sc_mcu9t5v0__filltie
XTAP_TAPCELL_ROW_238_5613 VSS VSS gf180mcu_fd_sc_mcu9t5v0__filltie
XTAP_TAPCELL_ROW_238_5602 VSS VSS gf180mcu_fd_sc_mcu9t5v0__filltie
X_09737_ _17601_/A2 _15701_/A2 _09737_/Z VSS _09737_/VNW VSS VSS gf180mcu_fd_sc_mcu9t5v0__or2_1
XTAP_TAPCELL_ROW_67_2817 VSS VSS gf180mcu_fd_sc_mcu9t5v0__filltie
XTAP_TAPCELL_ROW_67_2828 VSS VSS gf180mcu_fd_sc_mcu9t5v0__filltie
Xeco14_skew_11 clkload60/I _18315_/CLK VSS VSS VSS VSS gf180mcu_fd_sc_mcu9t5v0__clkbuf_16
X_09668_ _19927_/Q _19930_/Q _19931_/Q _09668_/A4 _09669_/A2 VSS _15743_/VNW VSS VSS
+ gf180mcu_fd_sc_mcu9t5v0__nor4_1
XPHY_EDGE_ROW_170_2_Left_682 VSS VSS gf180mcu_fd_sc_mcu9t5v0__endcap
X_09599_ _20040_/Q _18834_/Q _09852_/A2 VSS _15964_/VNW VSS VSS gf180mcu_fd_sc_mcu9t5v0__nand2_1
XTAP_TAPCELL_ROW_219_5089 VSS VSS gf180mcu_fd_sc_mcu9t5v0__filltie
X_11630_ _12632_/C _11659_/A1 _11633_/B VSS VSS VSS VSS gf180mcu_fd_sc_mcu9t5v0__nand2_1
X_11561_ _18169_/Q _12046_/S _11564_/A2 VSS VSS VSS VSS gf180mcu_fd_sc_mcu9t5v0__nor2_1
X_10512_ _09261_/I _10512_/A2 _10512_/A3 _10512_/B _10521_/A2 VSS VSS VSS VSS gf180mcu_fd_sc_mcu9t5v0__oai31_1
X_13300_ _13300_/A1 _13282_/Z _13300_/B _13303_/A1 VSS _13300_/VNW VSS VSS gf180mcu_fd_sc_mcu9t5v0__oai21_1
X_11492_ _18453_/Q _11519_/A2 _11495_/A1 VSS VSS VSS VSS gf180mcu_fd_sc_mcu9t5v0__nor2_1
XTAP_TAPCELL_ROW_210_4842 VSS VSS gf180mcu_fd_sc_mcu9t5v0__filltie
X_14280_ _14366_/I0 _19354_/Q _14285_/S _19354_/D VSS VSS VSS VSS gf180mcu_fd_sc_mcu9t5v0__mux2_1
XTAP_TAPCELL_ROW_322_7931 VSS VSS gf180mcu_fd_sc_mcu9t5v0__filltie
X_10443_ _10389_/C _10649_/A2 _10443_/A3 _17161_/C _10446_/B1 VSS _10443_/VNW VSS
+ VSS gf180mcu_fd_sc_mcu9t5v0__oai31_1
XTAP_TAPCELL_ROW_322_7920 VSS VSS gf180mcu_fd_sc_mcu9t5v0__filltie
XTAP_TAPCELL_ROW_210_4853 VSS VSS gf180mcu_fd_sc_mcu9t5v0__filltie
X_13231_ _12843_/B _13577_/A2 _13574_/A2 VSS VSS VSS VSS gf180mcu_fd_sc_mcu9t5v0__nor2_1
X_10374_ _17195_/A1 _18190_/Q _10377_/A2 VSS _11773_/VNW VSS VSS gf180mcu_fd_sc_mcu9t5v0__nor2_1
XPHY_EDGE_ROW_179_1_Right_763 VSS VSS gf180mcu_fd_sc_mcu9t5v0__endcap
X_13162_ _13162_/A1 _13162_/A2 _13162_/A3 _13162_/B _13182_/A1 VSS _13162_/VNW VSS
+ VSS gf180mcu_fd_sc_mcu9t5v0__oai31_1
X_12113_ _18477_/Q _12315_/S _12115_/A2 VSS _17174_/VNW VSS VSS gf180mcu_fd_sc_mcu9t5v0__nand2_1
XTAP_TAPCELL_ROW_303_7396 VSS VSS gf180mcu_fd_sc_mcu9t5v0__filltie
X_13093_ _19758_/Q _19792_/Q _13094_/B VSS VSS VSS VSS gf180mcu_fd_sc_mcu9t5v0__xor2_1
X_17970_ _18854_/Q _17971_/A3 _18005_/A2 VSS VSS VSS VSS gf180mcu_fd_sc_mcu9t5v0__nor2_1
X_16921_ _16654_/B _19256_/Q _16925_/S _16921_/Z VSS _16921_/VNW VSS VSS gf180mcu_fd_sc_mcu9t5v0__mux2_1
XPHY_EDGE_ROW_305_Left_628 VSS VSS gf180mcu_fd_sc_mcu9t5v0__endcap
XTAP_TAPCELL_ROW_295_7175 VSS VSS gf180mcu_fd_sc_mcu9t5v0__filltie
X_12044_ _18458_/Q _12203_/A2 _12092_/B _12045_/B2 VSS VSS VSS VSS gf180mcu_fd_sc_mcu9t5v0__aoi21_1
XTAP_TAPCELL_ROW_126_4460 VSS VSS gf180mcu_fd_sc_mcu9t5v0__filltie
XTAP_TAPCELL_ROW_37_1997 VSS VSS gf180mcu_fd_sc_mcu9t5v0__filltie
XTAP_TAPCELL_ROW_295_7186 VSS VSS gf180mcu_fd_sc_mcu9t5v0__filltie
X_16852_ _18418_/Q _16851_/Z _16854_/S _18418_/D VSS VSS VSS VSS gf180mcu_fd_sc_mcu9t5v0__mux2_4
Xclkbuf_regs_0_core_clk clk clkbuf_0_clk_regs/I VSS VSS VSS VSS gf180mcu_fd_sc_mcu9t5v0__clkbuf_16
XTAP_TAPCELL_ROW_122_4324 VSS VSS gf180mcu_fd_sc_mcu9t5v0__filltie
X_19640_ _19640_/D _19960_/RN clkload20/I _19640_/Q VSS VSS VSS VSS gf180mcu_fd_sc_mcu9t5v0__dffrnq_1
X_16783_ _16668_/B _19290_/Q _16783_/S _16783_/Z VSS VSS VSS VSS gf180mcu_fd_sc_mcu9t5v0__mux2_1
XTAP_TAPCELL_ROW_316_7757 VSS VSS gf180mcu_fd_sc_mcu9t5v0__filltie
X_15803_ _20145_/Q input9/Z _15811_/S VSS VSS VSS VSS gf180mcu_fd_sc_mcu9t5v0__nand2_1
XTAP_TAPCELL_ROW_122_4346 VSS VSS gf180mcu_fd_sc_mcu9t5v0__filltie
XTAP_TAPCELL_ROW_122_4335 VSS VSS gf180mcu_fd_sc_mcu9t5v0__filltie
X_19571_ _19571_/D _20019_/RN clkload18/I _19571_/Q VSS VSS VSS VSS gf180mcu_fd_sc_mcu9t5v0__dffrnq_1
XTAP_TAPCELL_ROW_316_7768 VSS VSS gf180mcu_fd_sc_mcu9t5v0__filltie
X_18522_ _18522_/D _20129_/CLK _18522_/Q VSS VSS VSS VSS gf180mcu_fd_sc_mcu9t5v0__dffq_1
X_15734_ _09065_/I _15757_/C _15734_/B1 _19999_/Q _15736_/A2 VSS VSS VSS VSS gf180mcu_fd_sc_mcu9t5v0__aoi22_1
XTAP_TAPCELL_ROW_169_3_8115 VSS VSS gf180mcu_fd_sc_mcu9t5v0__filltie
X_13995_ _13995_/A1 _14003_/A1 _13995_/B _13997_/A2 VSS _13995_/VNW VSS VSS gf180mcu_fd_sc_mcu9t5v0__oai21_1
X_12946_ _12945_/Z _19226_/Q _13419_/B _19226_/D VSS VSS VSS VSS gf180mcu_fd_sc_mcu9t5v0__mux2_1
X_18453_ _18453_/D _18453_/CLK _18453_/Q VSS VSS VSS VSS gf180mcu_fd_sc_mcu9t5v0__dffq_1
X_15665_ _19908_/Q _15677_/B _15668_/A3 _15666_/B VSS VSS VSS VSS gf180mcu_fd_sc_mcu9t5v0__nand3_1
X_12877_ _19216_/Q _13320_/B _12878_/B VSS VSS VSS VSS gf180mcu_fd_sc_mcu9t5v0__nand2_1
X_11828_ _12208_/C _11828_/A2 _11829_/A3 VSS _11828_/VNW VSS VSS gf180mcu_fd_sc_mcu9t5v0__nand2_1
X_17404_ _18408_/Q _18392_/Q _17404_/S _17404_/Z VSS VSS VSS VSS gf180mcu_fd_sc_mcu9t5v0__mux2_1
X_18384_ _18384_/D _20099_/CLK _18384_/Q VSS VSS VSS VSS gf180mcu_fd_sc_mcu9t5v0__dffq_1
XTAP_TAPCELL_ROW_135_4729 VSS VSS gf180mcu_fd_sc_mcu9t5v0__filltie
XTAP_TAPCELL_ROW_135_4718 VSS VSS gf180mcu_fd_sc_mcu9t5v0__filltie
XTAP_TAPCELL_ROW_135_4707 VSS VSS gf180mcu_fd_sc_mcu9t5v0__filltie
X_15596_ _18028_/I0 _15596_/A2 _15597_/B2 VSS _15597_/VNW VSS VSS gf180mcu_fd_sc_mcu9t5v0__nor2_1
X_14616_ _19077_/Q _19494_/Q _14730_/S _19494_/D VSS VSS VSS VSS gf180mcu_fd_sc_mcu9t5v0__mux2_1
X_17335_ _18421_/Q _17380_/A2 _17380_/B1 _18437_/Q _17336_/B VSS VSS VSS VSS gf180mcu_fd_sc_mcu9t5v0__aoi22_1
XPHY_EDGE_ROW_314_Left_637 VSS VSS gf180mcu_fd_sc_mcu9t5v0__endcap
XTAP_TAPCELL_ROW_149_3_8046 VSS VSS gf180mcu_fd_sc_mcu9t5v0__filltie
XTAP_TAPCELL_ROW_77_3113 VSS VSS gf180mcu_fd_sc_mcu9t5v0__filltie
XTAP_TAPCELL_ROW_77_3102 VSS VSS gf180mcu_fd_sc_mcu9t5v0__filltie
X_14547_ _19468_/Q _14766_/A2 _14555_/A1 VSS VSS VSS VSS gf180mcu_fd_sc_mcu9t5v0__nand2_1
X_11759_ _18317_/Q _12159_/B _11759_/B _12320_/C _11760_/A2 VSS VSS VSS VSS gf180mcu_fd_sc_mcu9t5v0__oai211_1
X_17266_ wire168/Z _17266_/A2 _17266_/A3 _17267_/C VSS VSS VSS VSS gf180mcu_fd_sc_mcu9t5v0__nand3_1
X_14478_ _14478_/A1 _14478_/A2 _19459_/D VSS _14478_/VNW VSS VSS gf180mcu_fd_sc_mcu9t5v0__nand2_1
XTAP_TAPCELL_ROW_284_6890 VSS VSS gf180mcu_fd_sc_mcu9t5v0__filltie
X_17197_ _18478_/Q _17322_/A2 _17255_/B1 _18494_/Q _17198_/B VSS _17198_/VNW VSS VSS
+ gf180mcu_fd_sc_mcu9t5v0__aoi22_1
X_16217_ _16216_/Z _18193_/Q _16782_/S _18193_/D VSS _16217_/VNW VSS VSS gf180mcu_fd_sc_mcu9t5v0__mux2_1
X_19005_ _19005_/D _20029_/RN clkload38/I _19005_/Q VSS VSS VSS VSS gf180mcu_fd_sc_mcu9t5v0__dffrnq_1
X_13429_ _13429_/I _13625_/B VSS _13429_/VNW VSS VSS gf180mcu_fd_sc_mcu9t5v0__clkinv_1
XTAP_TAPCELL_ROW_280_6765 VSS VSS gf180mcu_fd_sc_mcu9t5v0__filltie
X_16148_ _19266_/Q _16751_/B _16149_/C VSS VSS VSS VSS gf180mcu_fd_sc_mcu9t5v0__nor2_1
XTAP_TAPCELL_ROW_280_6776 VSS VSS gf180mcu_fd_sc_mcu9t5v0__filltie
X_16079_ _18164_/Q _16079_/I1 _16643_/S _18164_/D VSS VSS VSS VSS gf180mcu_fd_sc_mcu9t5v0__mux2_4
XPHY_EDGE_ROW_323_Left_646 VSS VSS gf180mcu_fd_sc_mcu9t5v0__endcap
X_19907_ _19907_/D _20035_/RN clkload41/I _19907_/Q VSS VSS VSS VSS gf180mcu_fd_sc_mcu9t5v0__dffrnq_1
X_19838_ _19838_/D _20030_/RN clkload56/I _19838_/Q VSS VSS VSS VSS gf180mcu_fd_sc_mcu9t5v0__dffrnq_1
Xinput1 din[0] input1/Z VSS VSS VSS VSS gf180mcu_fd_sc_mcu9t5v0__buf_3
XPHY_EDGE_ROW_174_2_Right_905 VSS VSS gf180mcu_fd_sc_mcu9t5v0__endcap
XTAP_TAPCELL_ROW_109_3990 VSS VSS gf180mcu_fd_sc_mcu9t5v0__filltie
X_09522_ wire174/I _20053_/D VSS _13357_/VNW VSS VSS gf180mcu_fd_sc_mcu9t5v0__clkinv_1
X_19769_ _19769_/D _20025_/RN clkload24/I _19769_/Q VSS VSS VSS VSS gf180mcu_fd_sc_mcu9t5v0__dffrnq_1
XTAP_TAPCELL_ROW_105_3865 VSS VSS gf180mcu_fd_sc_mcu9t5v0__filltie
XTAP_TAPCELL_ROW_105_3876 VSS VSS gf180mcu_fd_sc_mcu9t5v0__filltie
XTAP_TAPCELL_ROW_0_946 VSS VSS gf180mcu_fd_sc_mcu9t5v0__filltie
X_09453_ _09453_/I _12731_/A2 VSS VSS VSS VSS gf180mcu_fd_sc_mcu9t5v0__clkinv_1
XTAP_TAPCELL_ROW_0_957 VSS VSS gf180mcu_fd_sc_mcu9t5v0__filltie
XTAP_TAPCELL_ROW_47_2271 VSS VSS gf180mcu_fd_sc_mcu9t5v0__filltie
XTAP_TAPCELL_ROW_0_968 VSS VSS gf180mcu_fd_sc_mcu9t5v0__filltie
XTAP_TAPCELL_ROW_0_979 VSS VSS gf180mcu_fd_sc_mcu9t5v0__filltie
Xclkbuf_leaf_47_clk_regs clkload5/I clkload69/I VSS VSS VSS VSS gf180mcu_fd_sc_mcu9t5v0__clkbuf_8
XTAP_TAPCELL_ROW_47_2282 VSS VSS gf180mcu_fd_sc_mcu9t5v0__filltie
X_09384_ _18916_/Q _12235_/A1 VSS VSS VSS VSS gf180mcu_fd_sc_mcu9t5v0__clkinv_1
XTAP_TAPCELL_ROW_43_2157 VSS VSS gf180mcu_fd_sc_mcu9t5v0__filltie
XTAP_TAPCELL_ROW_43_2168 VSS VSS gf180mcu_fd_sc_mcu9t5v0__filltie
XPHY_EDGE_ROW_313_Right_240 VSS VSS gf180mcu_fd_sc_mcu9t5v0__endcap
XTAP_TAPCELL_ROW_195_3_8205 VSS VSS gf180mcu_fd_sc_mcu9t5v0__filltie
XTAP_TAPCELL_ROW_227_5303 VSS VSS gf180mcu_fd_sc_mcu9t5v0__filltie
XTAP_TAPCELL_ROW_56_2518 VSS VSS gf180mcu_fd_sc_mcu9t5v0__filltie
XTAP_TAPCELL_ROW_227_5325 VSS VSS gf180mcu_fd_sc_mcu9t5v0__filltie
XTAP_TAPCELL_ROW_227_5314 VSS VSS gf180mcu_fd_sc_mcu9t5v0__filltie
XTAP_TAPCELL_ROW_56_2529 VSS VSS gf180mcu_fd_sc_mcu9t5v0__filltie
XTAP_TAPCELL_ROW_200_3_8223 VSS VSS gf180mcu_fd_sc_mcu9t5v0__filltie
XTAP_TAPCELL_ROW_175_3_8136 VSS VSS gf180mcu_fd_sc_mcu9t5v0__filltie
X_10090_ _19280_/Q _10165_/B1 _10166_/B1 _19288_/Q _19272_/Q _10166_/A2 _10091_/A3
+ VSS _12163_/VNW VSS VSS gf180mcu_fd_sc_mcu9t5v0__aoi222_1
XPHY_EDGE_ROW_169_3_Right_284 VSS VSS gf180mcu_fd_sc_mcu9t5v0__endcap
XTAP_TAPCELL_ROW_32_1850 VSS VSS gf180mcu_fd_sc_mcu9t5v0__filltie
XTAP_TAPCELL_ROW_32_1861 VSS VSS gf180mcu_fd_sc_mcu9t5v0__filltie
XTAP_TAPCELL_ROW_290_7050 VSS VSS gf180mcu_fd_sc_mcu9t5v0__filltie
XTAP_TAPCELL_ROW_155_3_8067 VSS VSS gf180mcu_fd_sc_mcu9t5v0__filltie
X_12800_ _12793_/Z _12796_/Z _12800_/B _12810_/A1 VSS _12800_/VNW VSS VSS gf180mcu_fd_sc_mcu9t5v0__aoi21_1
XTAP_TAPCELL_ROW_32_1872 VSS VSS gf180mcu_fd_sc_mcu9t5v0__filltie
XTAP_TAPCELL_ROW_311_7621 VSS VSS gf180mcu_fd_sc_mcu9t5v0__filltie
XTAP_TAPCELL_ROW_311_7610 VSS VSS gf180mcu_fd_sc_mcu9t5v0__filltie
X_10992_ _10992_/A1 _10992_/A2 _10992_/B _10995_/A2 VSS VSS VSS VSS gf180mcu_fd_sc_mcu9t5v0__oai21_1
X_13780_ _19316_/Q _19295_/Q _13825_/A3 VSS _13825_/VNW VSS VSS gf180mcu_fd_sc_mcu9t5v0__nand2_1
XTAP_TAPCELL_ROW_311_7632 VSS VSS gf180mcu_fd_sc_mcu9t5v0__filltie
X_12731_ _19194_/Q _12731_/A2 _19195_/D VSS _12731_/VNW VSS VSS gf180mcu_fd_sc_mcu9t5v0__or2_1
X_15450_ _19819_/Q _15450_/A2 _15459_/A2 _15450_/B _19819_/D VSS VSS VSS VSS gf180mcu_fd_sc_mcu9t5v0__oai31_1
X_12662_ _12665_/B _12662_/A2 _12664_/B _12663_/A2 VSS _12662_/VNW VSS VSS gf180mcu_fd_sc_mcu9t5v0__nand3_1
X_11613_ _12716_/S _12720_/S VSS VSS VSS VSS gf180mcu_fd_sc_mcu9t5v0__clkinv_1
X_14401_ _14408_/A2 _14408_/A3 _14403_/A2 VSS _14403_/VNW VSS VSS gf180mcu_fd_sc_mcu9t5v0__nor2_1
X_12593_ wire146/Z _12593_/A2 _12593_/A3 _12593_/B1 _12593_/B2 wire120/I VSS _12593_/VNW
+ VSS VSS gf180mcu_fd_sc_mcu9t5v0__oai32_1
X_17120_ _20030_/Q _17394_/A2 _17120_/A3 _17120_/B _18538_/D VSS VSS VSS VSS gf180mcu_fd_sc_mcu9t5v0__oai31_1
XTAP_TAPCELL_ROW_212_4904 VSS VSS gf180mcu_fd_sc_mcu9t5v0__filltie
X_15381_ _19666_/Q _19766_/Q _15417_/S _19766_/D VSS VSS VSS VSS gf180mcu_fd_sc_mcu9t5v0__mux2_1
XTAP_TAPCELL_ROW_26_1687 VSS VSS gf180mcu_fd_sc_mcu9t5v0__filltie
XTAP_TAPCELL_ROW_309_7572 VSS VSS gf180mcu_fd_sc_mcu9t5v0__filltie
XTAP_TAPCELL_ROW_309_7561 VSS VSS gf180mcu_fd_sc_mcu9t5v0__filltie
XTAP_TAPCELL_ROW_115_4150 VSS VSS gf180mcu_fd_sc_mcu9t5v0__filltie
X_14332_ _13948_/Z _19404_/Q _14337_/S _19404_/D VSS VSS VSS VSS gf180mcu_fd_sc_mcu9t5v0__mux2_1
XTAP_TAPCELL_ROW_26_1698 VSS VSS gf180mcu_fd_sc_mcu9t5v0__filltie
X_11544_ _17961_/A2 _11545_/A2 _11985_/B VSS VSS VSS VSS gf180mcu_fd_sc_mcu9t5v0__and2_2
X_17051_ _16654_/B _19256_/Q _17055_/S _17051_/Z VSS VSS VSS VSS gf180mcu_fd_sc_mcu9t5v0__mux2_1
XTAP_TAPCELL_ROW_111_4047 VSS VSS gf180mcu_fd_sc_mcu9t5v0__filltie
X_11475_ _18885_/Q _11878_/A1 _11488_/B _11475_/B2 _11540_/C _11477_/A1 VSS VSS VSS
+ VSS gf180mcu_fd_sc_mcu9t5v0__oai221_1
XTAP_TAPCELL_ROW_111_4036 VSS VSS gf180mcu_fd_sc_mcu9t5v0__filltie
XTAP_TAPCELL_ROW_111_4025 VSS VSS gf180mcu_fd_sc_mcu9t5v0__filltie
X_14263_ _14263_/A1 _14263_/A2 _14263_/Z VSS _14263_/VNW VSS VSS gf180mcu_fd_sc_mcu9t5v0__xor2_1
XTAP_TAPCELL_ROW_305_7469 VSS VSS gf180mcu_fd_sc_mcu9t5v0__filltie
XTAP_TAPCELL_ROW_305_7458 VSS VSS gf180mcu_fd_sc_mcu9t5v0__filltie
X_10426_ _17260_/S _18336_/Q _10428_/A3 VSS _11819_/VNW VSS VSS gf180mcu_fd_sc_mcu9t5v0__nor2_1
XTAP_TAPCELL_ROW_305_7447 VSS VSS gf180mcu_fd_sc_mcu9t5v0__filltie
X_16002_ _19196_/Q _16001_/Z _16598_/S _16117_/C VSS VSS VSS VSS gf180mcu_fd_sc_mcu9t5v0__mux2_4
X_13214_ _13214_/A1 _13214_/A2 _13214_/B _13224_/A2 VSS _13214_/VNW VSS VSS gf180mcu_fd_sc_mcu9t5v0__aoi21_1
XTAP_TAPCELL_ROW_297_7226 VSS VSS gf180mcu_fd_sc_mcu9t5v0__filltie
XTAP_TAPCELL_ROW_128_4511 VSS VSS gf180mcu_fd_sc_mcu9t5v0__filltie
XTAP_TAPCELL_ROW_128_4500 VSS VSS gf180mcu_fd_sc_mcu9t5v0__filltie
X_14194_ _14245_/B _14226_/A1 VSS VSS VSS VSS gf180mcu_fd_sc_mcu9t5v0__clkinv_1
XTAP_TAPCELL_ROW_297_7248 VSS VSS gf180mcu_fd_sc_mcu9t5v0__filltie
XTAP_TAPCELL_ROW_297_7237 VSS VSS gf180mcu_fd_sc_mcu9t5v0__filltie
X_10357_ _20082_/Q _17408_/B _10358_/A3 VSS VSS VSS VSS gf180mcu_fd_sc_mcu9t5v0__nand2_1
X_13145_ _13145_/A1 _19759_/Q _13145_/B1 _13145_/B2 _13145_/C _13162_/A3 VSS VSS VSS
+ VSS gf180mcu_fd_sc_mcu9t5v0__aoi221_1
XTAP_TAPCELL_ROW_318_7808 VSS VSS gf180mcu_fd_sc_mcu9t5v0__filltie
X_10288_ _17260_/S _11131_/A1 _10289_/B VSS VSS VSS VSS gf180mcu_fd_sc_mcu9t5v0__nand2_1
X_13076_ _19725_/Q _13075_/Z _13534_/B VSS _13077_/VNW VSS VSS gf180mcu_fd_sc_mcu9t5v0__nor2_1
X_17953_ _17889_/I _17951_/Z _17953_/A3 _17953_/B _18854_/D VSS VSS VSS VSS gf180mcu_fd_sc_mcu9t5v0__oai31_1
XTAP_TAPCELL_ROW_318_7819 VSS VSS gf180mcu_fd_sc_mcu9t5v0__filltie
X_16904_ _16903_/Z _18444_/Q _16928_/S _18444_/D VSS VSS VSS VSS gf180mcu_fd_sc_mcu9t5v0__mux2_1
X_12027_ _18721_/Q _12527_/A2 _12028_/B VSS _17587_/VNW VSS VSS gf180mcu_fd_sc_mcu9t5v0__nand2_1
X_17884_ _17884_/A1 _17884_/A2 _18834_/D VSS VSS VSS VSS gf180mcu_fd_sc_mcu9t5v0__nand2_1
X_19623_ _19623_/D _20071_/RN clkload9/I _19623_/Q VSS VSS VSS VSS gf180mcu_fd_sc_mcu9t5v0__dffrnq_1
X_16835_ _19245_/Q _16576_/B _16863_/S _16835_/Z VSS VSS VSS VSS gf180mcu_fd_sc_mcu9t5v0__mux2_1
XTAP_TAPCELL_ROW_188_3_8181 VSS VSS gf180mcu_fd_sc_mcu9t5v0__filltie
XTAP_TAPCELL_ROW_273_6580 VSS VSS gf180mcu_fd_sc_mcu9t5v0__filltie
X_16766_ _16765_/Z _18382_/Q _16784_/S _18382_/D VSS VSS VSS VSS gf180mcu_fd_sc_mcu9t5v0__mux2_1
X_13978_ _13978_/A1 _13978_/A2 _13990_/A2 VSS VSS VSS VSS gf180mcu_fd_sc_mcu9t5v0__xnor2_1
X_19554_ _19554_/D _20066_/RN clkload30/I _19554_/Q VSS VSS VSS VSS gf180mcu_fd_sc_mcu9t5v0__dffrnq_1
XTAP_TAPCELL_ROW_273_6591 VSS VSS gf180mcu_fd_sc_mcu9t5v0__filltie
X_16697_ _19280_/Q _16695_/B _16698_/A3 VSS _16697_/VNW VSS VSS gf180mcu_fd_sc_mcu9t5v0__nor2_1
X_18505_ _18505_/D clkload52/I _18505_/Q VSS VSS VSS VSS gf180mcu_fd_sc_mcu9t5v0__dffq_1
X_15717_ _15729_/A1 _15717_/A2 _19920_/D VSS VSS VSS VSS gf180mcu_fd_sc_mcu9t5v0__nor2_1
XPHY_EDGE_ROW_181_1_Left_504 VSS VSS gf180mcu_fd_sc_mcu9t5v0__endcap
X_12929_ _19778_/Q _12928_/Z _12932_/B VSS _12932_/VNW VSS VSS gf180mcu_fd_sc_mcu9t5v0__xor2_1
X_19485_ _19485_/D _20061_/RN clkload13/I _19485_/Q VSS VSS VSS VSS gf180mcu_fd_sc_mcu9t5v0__dffrnq_1
X_18436_ _18436_/D clkload75/I _18436_/Q VSS VSS VSS VSS gf180mcu_fd_sc_mcu9t5v0__dffq_1
XTAP_TAPCELL_ROW_100_3740 VSS VSS gf180mcu_fd_sc_mcu9t5v0__filltie
X_15648_ _15649_/A1 _10201_/B _15648_/B1 _15648_/B2 _19901_/D VSS VSS VSS VSS gf180mcu_fd_sc_mcu9t5v0__oai22_1
XTAP_TAPCELL_ROW_286_6941 VSS VSS gf180mcu_fd_sc_mcu9t5v0__filltie
XTAP_TAPCELL_ROW_286_6930 VSS VSS gf180mcu_fd_sc_mcu9t5v0__filltie
X_18367_ _18367_/D _20099_/CLK _18367_/Q VSS VSS VSS VSS gf180mcu_fd_sc_mcu9t5v0__dffq_4
XTAP_TAPCELL_ROW_181_3_8157 VSS VSS gf180mcu_fd_sc_mcu9t5v0__filltie
X_15579_ _18033_/I0 _18030_/I0 _18031_/I0 _18029_/I0 _15581_/A1 VSS VSS VSS VSS gf180mcu_fd_sc_mcu9t5v0__nand4_1
X_17318_ _18420_/Q _17380_/A2 _17380_/B1 _18436_/Q _17319_/B VSS VSS VSS VSS gf180mcu_fd_sc_mcu9t5v0__aoi22_1
XTAP_TAPCELL_ROW_282_6816 VSS VSS gf180mcu_fd_sc_mcu9t5v0__filltie
X_18298_ _18298_/D clkload52/I _18298_/Q VSS VSS VSS VSS gf180mcu_fd_sc_mcu9t5v0__dffq_1
XTAP_TAPCELL_ROW_282_6838 VSS VSS gf180mcu_fd_sc_mcu9t5v0__filltie
XTAP_TAPCELL_ROW_282_6827 VSS VSS gf180mcu_fd_sc_mcu9t5v0__filltie
X_17249_ _19863_/Q _17161_/C _17250_/A3 VSS VSS VSS VSS gf180mcu_fd_sc_mcu9t5v0__nor2_1
XTAP_TAPCELL_ROW_161_3_8088 VSS VSS gf180mcu_fd_sc_mcu9t5v0__filltie
Xrst_tree_leaf_60 rst_tree_mid_7/Z _20023_/RN VSS VSS VSS VSS gf180mcu_fd_sc_mcu9t5v0__clkbuf_16
XPHY_EDGE_ROW_176_1_Left_499 VSS VSS gf180mcu_fd_sc_mcu9t5v0__endcap
XPHY_EDGE_ROW_95_Left_419 VSS VSS gf180mcu_fd_sc_mcu9t5v0__endcap
XTAP_TAPCELL_ROW_107_3916 VSS VSS gf180mcu_fd_sc_mcu9t5v0__filltie
XTAP_TAPCELL_ROW_107_3938 VSS VSS gf180mcu_fd_sc_mcu9t5v0__filltie
XTAP_TAPCELL_ROW_107_3927 VSS VSS gf180mcu_fd_sc_mcu9t5v0__filltie
XPHY_EDGE_ROW_175_2_Right_906 VSS VSS gf180mcu_fd_sc_mcu9t5v0__endcap
XTAP_TAPCELL_ROW_49_2322 VSS VSS gf180mcu_fd_sc_mcu9t5v0__filltie
XTAP_TAPCELL_ROW_49_2333 VSS VSS gf180mcu_fd_sc_mcu9t5v0__filltie
XTAP_TAPCELL_ROW_216_5015 VSS VSS gf180mcu_fd_sc_mcu9t5v0__filltie
XTAP_TAPCELL_ROW_216_5004 VSS VSS gf180mcu_fd_sc_mcu9t5v0__filltie
XTAP_TAPCELL_ROW_45_2208 VSS VSS gf180mcu_fd_sc_mcu9t5v0__filltie
XTAP_TAPCELL_ROW_45_2219 VSS VSS gf180mcu_fd_sc_mcu9t5v0__filltie
X_09505_ _19089_/Q _14730_/S _17961_/A3 VSS VSS VSS VSS gf180mcu_fd_sc_mcu9t5v0__nand2_1
X_09436_ _15829_/B2 _15832_/A1 _09909_/A2 VSS VSS VSS VSS gf180mcu_fd_sc_mcu9t5v0__nor2_1
X_09367_ _20088_/Q _10523_/A1 VSS _10522_/VNW VSS VSS gf180mcu_fd_sc_mcu9t5v0__clkinv_1
XTAP_TAPCELL_ROW_252_5996 VSS VSS gf180mcu_fd_sc_mcu9t5v0__filltie
X_09298_ _19223_/Q _16645_/A1 VSS _10916_/VNW VSS VSS gf180mcu_fd_sc_mcu9t5v0__clkinv_1
XTAP_TAPCELL_ROW_21_1551 VSS VSS gf180mcu_fd_sc_mcu9t5v0__filltie
XTAP_TAPCELL_ROW_21_1562 VSS VSS gf180mcu_fd_sc_mcu9t5v0__filltie
XTAP_TAPCELL_ROW_21_1573 VSS VSS gf180mcu_fd_sc_mcu9t5v0__filltie
X_11260_ _18180_/Q _11537_/S _11538_/B _11260_/C _11267_/A1 VSS _11267_/VNW VSS VSS
+ gf180mcu_fd_sc_mcu9t5v0__oai211_1
XTAP_TAPCELL_ROW_300_7333 VSS VSS gf180mcu_fd_sc_mcu9t5v0__filltie
XTAP_TAPCELL_ROW_300_7322 VSS VSS gf180mcu_fd_sc_mcu9t5v0__filltie
XTAP_TAPCELL_ROW_300_7311 VSS VSS gf180mcu_fd_sc_mcu9t5v0__filltie
X_11191_ _11191_/A1 _11191_/A2 _11469_/B _11191_/C _11192_/B VSS VSS VSS VSS gf180mcu_fd_sc_mcu9t5v0__oai211_1
X_10211_ _09542_/B _17763_/A3 _10211_/Z VSS _15552_/VNW VSS VSS gf180mcu_fd_sc_mcu9t5v0__or2_1
X_10142_ _19219_/Q wire172/Z _10172_/A2 _19203_/Q _10143_/I VSS _10143_/VNW VSS VSS
+ gf180mcu_fd_sc_mcu9t5v0__aoi22_1
XTAP_TAPCELL_ROW_34_1912 VSS VSS gf180mcu_fd_sc_mcu9t5v0__filltie
XTAP_TAPCELL_ROW_292_7112 VSS VSS gf180mcu_fd_sc_mcu9t5v0__filltie
XTAP_TAPCELL_ROW_292_7101 VSS VSS gf180mcu_fd_sc_mcu9t5v0__filltie
X_10073_ _19200_/Q _10133_/A2 _10136_/B1 _19240_/Q _10105_/A1 VSS _10073_/VNW VSS
+ VSS gf180mcu_fd_sc_mcu9t5v0__aoi22_1
XTAP_TAPCELL_ROW_34_1923 VSS VSS gf180mcu_fd_sc_mcu9t5v0__filltie
X_14950_ _19424_/Q _19369_/Q _14950_/Z VSS _14950_/VNW VSS VSS gf180mcu_fd_sc_mcu9t5v0__xor2_1
XPHY_EDGE_ROW_200_2_Left_712 VSS VSS gf180mcu_fd_sc_mcu9t5v0__endcap
XTAP_TAPCELL_ROW_30_1809 VSS VSS gf180mcu_fd_sc_mcu9t5v0__filltie
X_14881_ _19413_/Q _19354_/Q _14881_/Z VSS VSS VSS VSS gf180mcu_fd_sc_mcu9t5v0__xor2_1
X_13901_ _13907_/A1 _13901_/A2 _13898_/Z _13901_/Z VSS VSS VSS VSS gf180mcu_fd_sc_mcu9t5v0__xor3_1
XTAP_TAPCELL_ROW_15_1388 VSS VSS gf180mcu_fd_sc_mcu9t5v0__filltie
XTAP_TAPCELL_ROW_15_1399 VSS VSS gf180mcu_fd_sc_mcu9t5v0__filltie
Xmax_cap30 wire28/I _16972_/S VSS _16024_/VNW VSS VSS gf180mcu_fd_sc_mcu9t5v0__buf_4
X_16620_ _15973_/B _15988_/C _15988_/B _16619_/Z _16672_/B VSS VSS VSS VSS gf180mcu_fd_sc_mcu9t5v0__nand4_4
X_13832_ _13834_/A1 _13834_/A3 _13836_/B VSS VSS VSS VSS gf180mcu_fd_sc_mcu9t5v0__or2_1
X_16551_ _18334_/Q _16142_/C _17067_/S _18334_/D VSS VSS VSS VSS gf180mcu_fd_sc_mcu9t5v0__mux2_4
X_13763_ _14355_/I0 _19303_/Q _13763_/S _19303_/D VSS _14300_/VNW VSS VSS gf180mcu_fd_sc_mcu9t5v0__mux2_1
X_15502_ _19838_/Q input8/Z _15502_/S _15502_/Z VSS VSS VSS VSS gf180mcu_fd_sc_mcu9t5v0__mux2_1
Xmax_cap74 _16750_/A1 _16668_/A1 VSS VSS VSS VSS gf180mcu_fd_sc_mcu9t5v0__clkbuf_16
Xmax_cap85 _16815_/A2 _16829_/A2 VSS VSS VSS VSS gf180mcu_fd_sc_mcu9t5v0__buf_4
Xmax_cap96 _16612_/S _16042_/S VSS VSS VSS VSS gf180mcu_fd_sc_mcu9t5v0__clkbuf_16
X_10975_ _10937_/Z _18040_/A2 _10979_/B VSS VSS VSS VSS gf180mcu_fd_sc_mcu9t5v0__nand2_1
X_12714_ _12714_/A1 _12724_/C _12714_/B1 _12714_/B2 _19188_/D VSS _12714_/VNW VSS
+ VSS gf180mcu_fd_sc_mcu9t5v0__aoi22_1
X_16482_ _18298_/Q _16481_/Z _16996_/S _18298_/D VSS VSS VSS VSS gf180mcu_fd_sc_mcu9t5v0__mux2_1
XTAP_TAPCELL_ROW_117_4212 VSS VSS gf180mcu_fd_sc_mcu9t5v0__filltie
XTAP_TAPCELL_ROW_117_4201 VSS VSS gf180mcu_fd_sc_mcu9t5v0__filltie
X_19270_ _19270_/D _20038_/RN clkload43/I _19270_/Q VSS VSS VSS VSS gf180mcu_fd_sc_mcu9t5v0__dffrnq_1
XTAP_TAPCELL_ROW_28_1749 VSS VSS gf180mcu_fd_sc_mcu9t5v0__filltie
X_13694_ _14378_/A1 _13694_/A2 _19295_/D VSS _13694_/VNW VSS VSS gf180mcu_fd_sc_mcu9t5v0__nand2_1
X_18221_ _18221_/D clkload62/I _18221_/Q VSS VSS VSS VSS gf180mcu_fd_sc_mcu9t5v0__dffq_1
X_15433_ _10648_/C _15434_/A2 _20050_/D _19816_/D VSS VSS VSS VSS gf180mcu_fd_sc_mcu9t5v0__aoi21_1
X_12645_ _12664_/C _12645_/A2 _12645_/B1 _12645_/B2 _12645_/C _12646_/C VSS VSS VSS
+ VSS gf180mcu_fd_sc_mcu9t5v0__aoi221_1
XTAP_TAPCELL_ROW_307_7509 VSS VSS gf180mcu_fd_sc_mcu9t5v0__filltie
X_12576_ _18499_/Q _12616_/A2 _12616_/B _12577_/B2 VSS VSS VSS VSS gf180mcu_fd_sc_mcu9t5v0__oai21_1
X_18152_ _18151_/Z _18963_/Q _18152_/S _18963_/D VSS VSS VSS VSS gf180mcu_fd_sc_mcu9t5v0__mux2_1
X_15364_ _19749_/Q _15363_/Z _15364_/S _19749_/D VSS VSS VSS VSS gf180mcu_fd_sc_mcu9t5v0__mux2_1
X_11527_ _11526_/B _11527_/A2 _11527_/B1 _11527_/B2 _11788_/B _11528_/B2 VSS VSS VSS
+ VSS gf180mcu_fd_sc_mcu9t5v0__aoi221_4
X_17103_ _17198_/A1 _17103_/A2 _17103_/A3 _17103_/B _17112_/A1 VSS _17103_/VNW VSS
+ VSS gf180mcu_fd_sc_mcu9t5v0__oai31_1
X_18083_ _18060_/B _18082_/Z _18932_/D VSS VSS VSS VSS gf180mcu_fd_sc_mcu9t5v0__nor2_1
X_14315_ _14364_/I0 _19388_/Q _14322_/S _19388_/D VSS _14948_/VNW VSS VSS gf180mcu_fd_sc_mcu9t5v0__mux2_1
X_17034_ _17033_/Z _18508_/Q _17034_/S _18508_/D VSS _17034_/VNW VSS VSS gf180mcu_fd_sc_mcu9t5v0__mux2_1
X_15295_ _19636_/Q _19613_/Q _15300_/A3 VSS _15295_/VNW VSS VSS gf180mcu_fd_sc_mcu9t5v0__nand2_1
X_11458_ _18434_/Q _11469_/B _11459_/B VSS VSS VSS VSS gf180mcu_fd_sc_mcu9t5v0__nand2_1
X_14246_ _14245_/C _14246_/A2 _14246_/B _14246_/C _14247_/A2 VSS VSS VSS VSS gf180mcu_fd_sc_mcu9t5v0__oai211_1
XTAP_TAPCELL_ROW_91_3474 VSS VSS gf180mcu_fd_sc_mcu9t5v0__filltie
X_11389_ _11521_/B _11387_/Z _11389_/B _11392_/A2 VSS VSS VSS VSS gf180mcu_fd_sc_mcu9t5v0__oai21_1
XTAP_TAPCELL_ROW_262_6281 VSS VSS gf180mcu_fd_sc_mcu9t5v0__filltie
X_10409_ _17243_/A1 _10409_/A2 _10409_/B1 _10643_/B2 _10410_/B VSS VSS VSS VSS gf180mcu_fd_sc_mcu9t5v0__aoi22_1
XTAP_TAPCELL_ROW_262_6270 VSS VSS gf180mcu_fd_sc_mcu9t5v0__filltie
XTAP_TAPCELL_ROW_91_3496 VSS VSS gf180mcu_fd_sc_mcu9t5v0__filltie
XTAP_TAPCELL_ROW_91_3485 VSS VSS gf180mcu_fd_sc_mcu9t5v0__filltie
X_14177_ _13948_/Z _19332_/Q _14266_/S _19332_/D VSS VSS VSS VSS gf180mcu_fd_sc_mcu9t5v0__mux2_1
X_13128_ _13184_/A1 _13128_/A2 _13419_/B _13129_/B2 VSS VSS VSS VSS gf180mcu_fd_sc_mcu9t5v0__aoi21_1
Xload_slew223 _17198_/A1 _09261_/I VSS VSS VSS VSS gf180mcu_fd_sc_mcu9t5v0__buf_8
X_18985_ _18985_/D _20073_/RN clkload70/I _18985_/Q VSS VSS VSS VSS gf180mcu_fd_sc_mcu9t5v0__dffrnq_1
XPHY_EDGE_ROW_256_Left_579 VSS VSS gf180mcu_fd_sc_mcu9t5v0__endcap
XTAP_TAPCELL_ROW_275_6631 VSS VSS gf180mcu_fd_sc_mcu9t5v0__filltie
XTAP_TAPCELL_ROW_275_6620 VSS VSS gf180mcu_fd_sc_mcu9t5v0__filltie
Xload_slew289 _15865_/ZN _15928_/S VSS VSS VSS VSS gf180mcu_fd_sc_mcu9t5v0__clkbuf_4
X_13059_ _19724_/Q _13059_/A2 _13525_/B VSS _13529_/VNW VSS VSS gf180mcu_fd_sc_mcu9t5v0__xnor2_1
X_17936_ _17923_/I _17936_/A2 _17936_/B _18849_/D VSS VSS VSS VSS gf180mcu_fd_sc_mcu9t5v0__oai21_1
XTAP_TAPCELL_ROW_275_6642 VSS VSS gf180mcu_fd_sc_mcu9t5v0__filltie
X_17867_ _18829_/Q _17867_/A2 _17868_/B VSS _17867_/VNW VSS VSS gf180mcu_fd_sc_mcu9t5v0__nand2_1
X_16818_ _18404_/Q _16818_/I1 _16818_/S _18404_/D VSS VSS VSS VSS gf180mcu_fd_sc_mcu9t5v0__mux2_4
XTAP_TAPCELL_ROW_271_6528 VSS VSS gf180mcu_fd_sc_mcu9t5v0__filltie
XTAP_TAPCELL_ROW_271_6517 VSS VSS gf180mcu_fd_sc_mcu9t5v0__filltie
X_19606_ _19606_/D _20054_/RN _19633_/CLK _19606_/Q VSS VSS VSS VSS gf180mcu_fd_sc_mcu9t5v0__dffrnq_1
X_17798_ _18776_/Q _18763_/Q _18769_/D _18776_/D VSS _17798_/VNW VSS VSS gf180mcu_fd_sc_mcu9t5v0__mux2_1
X_19537_ _19537_/D _20049_/RN _19798_/CLK _19537_/Q VSS VSS VSS VSS gf180mcu_fd_sc_mcu9t5v0__dffrnq_1
X_16749_ _19291_/Q _16725_/C _16752_/B VSS VSS VSS VSS gf180mcu_fd_sc_mcu9t5v0__nand2_1
XPHY_EDGE_ROW_265_Left_588 VSS VSS gf180mcu_fd_sc_mcu9t5v0__endcap
X_19468_ _19468_/D _20044_/RN clkload13/I _19468_/Q VSS VSS VSS VSS gf180mcu_fd_sc_mcu9t5v0__dffrnq_1
X_18419_ _18419_/D _20132_/CLK _18419_/Q VSS VSS VSS VSS gf180mcu_fd_sc_mcu9t5v0__dffq_4
XTAP_TAPCELL_ROW_269_6457 VSS VSS gf180mcu_fd_sc_mcu9t5v0__filltie
X_19399_ _19399_/D _20039_/RN clkload18/I _19399_/Q VSS VSS VSS VSS gf180mcu_fd_sc_mcu9t5v0__dffrnq_1
X_09221_ _19575_/Q _15247_/A2 VSS _15247_/VNW VSS VSS gf180mcu_fd_sc_mcu9t5v0__clkinv_1
XTAP_TAPCELL_ROW_269_6479 VSS VSS gf180mcu_fd_sc_mcu9t5v0__filltie
XTAP_TAPCELL_ROW_269_6468 VSS VSS gf180mcu_fd_sc_mcu9t5v0__filltie
X_09152_ _19772_/Q _13335_/A2 VSS _13357_/VNW VSS VSS gf180mcu_fd_sc_mcu9t5v0__clkinv_1
X_09083_ _18825_/Q _17854_/B2 VSS _17856_/VNW VSS VSS gf180mcu_fd_sc_mcu9t5v0__clkinv_1
XTAP_TAPCELL_ROW_38_2023 VSS VSS gf180mcu_fd_sc_mcu9t5v0__filltie
XTAP_TAPCELL_ROW_38_2034 VSS VSS gf180mcu_fd_sc_mcu9t5v0__filltie
XPHY_EDGE_ROW_274_Left_597 VSS VSS gf180mcu_fd_sc_mcu9t5v0__endcap
X_09985_ _19222_/Q _09898_/C wire285/Z _19254_/Q _09985_/C _10030_/A1 VSS VSS VSS
+ VSS gf180mcu_fd_sc_mcu9t5v0__aoi221_1
XTAP_TAPCELL_ROW_241_5697 VSS VSS gf180mcu_fd_sc_mcu9t5v0__filltie
XTAP_TAPCELL_ROW_241_5686 VSS VSS gf180mcu_fd_sc_mcu9t5v0__filltie
Xclkbuf_leaf_62_clk_regs clkload1/I clkload33/I VSS _17903_/VNW VSS VSS gf180mcu_fd_sc_mcu9t5v0__clkbuf_8
XPHY_EDGE_ROW_176_2_Right_907 VSS VSS gf180mcu_fd_sc_mcu9t5v0__endcap
XTAP_TAPCELL_ROW_10_1252 VSS VSS gf180mcu_fd_sc_mcu9t5v0__filltie
XTAP_TAPCELL_ROW_10_1263 VSS VSS gf180mcu_fd_sc_mcu9t5v0__filltie
X_10760_ _10761_/A1 _10760_/A2 _10776_/B VSS VSS VSS VSS gf180mcu_fd_sc_mcu9t5v0__nand2_1
X_09419_ _18566_/Q _11988_/B _09605_/A3 VSS VSS VSS VSS gf180mcu_fd_sc_mcu9t5v0__nand2_4
X_10691_ _19004_/Q _10804_/A2 _10692_/C VSS _10691_/VNW VSS VSS gf180mcu_fd_sc_mcu9t5v0__nor2_1
X_12430_ _18162_/Q _12613_/A2 _12434_/A2 VSS VSS VSS VSS gf180mcu_fd_sc_mcu9t5v0__nor2_1
XTAP_TAPCELL_ROW_23_1602 VSS VSS gf180mcu_fd_sc_mcu9t5v0__filltie
XTAP_TAPCELL_ROW_23_1613 VSS VSS gf180mcu_fd_sc_mcu9t5v0__filltie
XTAP_TAPCELL_ROW_23_1624 VSS VSS gf180mcu_fd_sc_mcu9t5v0__filltie
X_12361_ _18297_/Q _12383_/S _12541_/B _12362_/B2 VSS VSS VSS VSS gf180mcu_fd_sc_mcu9t5v0__oai21_1
X_14100_ _14099_/C _14100_/A2 _14366_/I0 VSS VSS VSS VSS gf180mcu_fd_sc_mcu9t5v0__xnor2_2
X_12292_ _12261_/B _12281_/Z _12292_/B1 _12292_/B2 _12293_/B VSS _16921_/VNW VSS VSS
+ gf180mcu_fd_sc_mcu9t5v0__oai22_2
X_11312_ _18184_/Q _11537_/S _11538_/B _11312_/C _11319_/A1 VSS _11312_/VNW VSS VSS
+ gf180mcu_fd_sc_mcu9t5v0__oai211_1
X_15080_ _19395_/Q _19311_/Q _15099_/A2 VSS VSS VSS VSS gf180mcu_fd_sc_mcu9t5v0__nand2_1
XPHY_EDGE_ROW_205_3_Right_320 VSS VSS gf180mcu_fd_sc_mcu9t5v0__endcap
X_11243_ _19082_/Q _11321_/A2 _11244_/A2 VSS VSS VSS VSS gf180mcu_fd_sc_mcu9t5v0__nand2_1
X_14031_ _13984_/Z _14031_/A2 _14031_/A3 _14031_/B1 _14025_/Z _14099_/A1 VSS VSS VSS
+ VSS gf180mcu_fd_sc_mcu9t5v0__oai32_1
X_11174_ _18302_/Q _11519_/A2 _11175_/A3 VSS _12390_/VNW VSS VSS gf180mcu_fd_sc_mcu9t5v0__nand2_1
XTAP_TAPCELL_ROW_17_1439 VSS VSS gf180mcu_fd_sc_mcu9t5v0__filltie
X_15982_ _18568_/Q _10064_/S _16198_/A2 _16106_/A1 VSS VSS VSS VSS gf180mcu_fd_sc_mcu9t5v0__nand3_4
X_10125_ _18968_/Q _09898_/C _10168_/B1 _18952_/Q _10125_/C _10126_/A3 VSS _10602_/VNW
+ VSS VSS gf180mcu_fd_sc_mcu9t5v0__aoi221_1
X_18770_ _18770_/D _20050_/RN _20049_/CLK _18770_/Q VSS VSS VSS VSS gf180mcu_fd_sc_mcu9t5v0__dffrnq_1
X_17721_ _17721_/I _18736_/D VSS _17721_/VNW VSS VSS gf180mcu_fd_sc_mcu9t5v0__clkinv_1
X_10056_ _10659_/C _18950_/Q _10057_/A3 VSS VSS VSS VSS gf180mcu_fd_sc_mcu9t5v0__nor2_1
X_14933_ _19359_/Q _14935_/A2 _14937_/I0 VSS _14936_/VNW VSS VSS gf180mcu_fd_sc_mcu9t5v0__nand2_1
X_17652_ _18694_/Q _18693_/Q _17653_/S VSS _17652_/VNW VSS VSS gf180mcu_fd_sc_mcu9t5v0__xnor2_1
X_16603_ _19281_/Q _15996_/B _16608_/B VSS VSS VSS VSS gf180mcu_fd_sc_mcu9t5v0__nand2_1
X_14864_ _19410_/Q _19351_/Q _14872_/A1 VSS VSS VSS VSS gf180mcu_fd_sc_mcu9t5v0__nand2_1
X_17583_ _18651_/Q _17583_/I1 _17584_/S _18651_/D VSS VSS VSS VSS gf180mcu_fd_sc_mcu9t5v0__mux2_1
X_13815_ _13823_/A2 _13843_/B2 _13873_/A1 _13818_/A1 VSS VSS VSS VSS gf180mcu_fd_sc_mcu9t5v0__xnor3_1
X_14795_ _19399_/Q _19336_/Q _14795_/Z VSS VSS VSS VSS gf180mcu_fd_sc_mcu9t5v0__xor2_1
X_16534_ _16533_/Z _18323_/Q _17050_/S _18323_/D VSS VSS VSS VSS gf180mcu_fd_sc_mcu9t5v0__mux2_4
X_10958_ _18932_/Q _18063_/A1 _11005_/C VSS VSS VSS VSS gf180mcu_fd_sc_mcu9t5v0__xnor2_1
XTAP_TAPCELL_ROW_80_3186 VSS VSS gf180mcu_fd_sc_mcu9t5v0__filltie
X_13746_ _14143_/B2 _13746_/A2 _13747_/A2 VSS VSS VSS VSS gf180mcu_fd_sc_mcu9t5v0__nand2_1
X_19322_ _19322_/D _20026_/RN clkload14/I _19322_/Q VSS VSS VSS VSS gf180mcu_fd_sc_mcu9t5v0__dffrnq_1
XTAP_TAPCELL_ROW_80_3175 VSS VSS gf180mcu_fd_sc_mcu9t5v0__filltie
X_16465_ _19238_/Q _16167_/B _16991_/S _16465_/Z VSS VSS VSS VSS gf180mcu_fd_sc_mcu9t5v0__mux2_1
X_19253_ _19253_/D _20021_/RN clkload37/I _19253_/Q VSS VSS VSS VSS gf180mcu_fd_sc_mcu9t5v0__dffrnq_2
X_13677_ _19109_/Q _13677_/I1 _14501_/S _13677_/Z VSS _13677_/VNW VSS VSS gf180mcu_fd_sc_mcu9t5v0__mux2_1
X_18204_ _18204_/D clkload64/I _18204_/Q VSS VSS VSS VSS gf180mcu_fd_sc_mcu9t5v0__dffq_1
X_10889_ _10889_/I0 _18983_/Q _18148_/S _18983_/D VSS VSS VSS VSS gf180mcu_fd_sc_mcu9t5v0__mux2_1
XTAP_TAPCELL_ROW_196_3_8210 VSS VSS gf180mcu_fd_sc_mcu9t5v0__filltie
XTAP_TAPCELL_ROW_97_3650 VSS VSS gf180mcu_fd_sc_mcu9t5v0__filltie
X_12628_ _12628_/A1 _11679_/B _12685_/B VSS VSS VSS VSS gf180mcu_fd_sc_mcu9t5v0__nand2_1
X_15416_ _19701_/Q _19801_/Q _15417_/S _19801_/D VSS VSS VSS VSS gf180mcu_fd_sc_mcu9t5v0__mux2_1
X_16396_ _16395_/Z _18261_/Q _16924_/S _18261_/D VSS VSS VSS VSS gf180mcu_fd_sc_mcu9t5v0__mux2_1
XTAP_TAPCELL_ROW_97_3661 VSS VSS gf180mcu_fd_sc_mcu9t5v0__filltie
X_19184_ _19184_/D _20144_/RN clkload12/I _19184_/Q VSS VSS VSS VSS gf180mcu_fd_sc_mcu9t5v0__dffrnq_1
X_12559_ _18449_/Q _12607_/A2 _12561_/B1 VSS VSS VSS VSS gf180mcu_fd_sc_mcu9t5v0__nor2_1
XTAP_TAPCELL_ROW_264_6343 VSS VSS gf180mcu_fd_sc_mcu9t5v0__filltie
XTAP_TAPCELL_ROW_264_6332 VSS VSS gf180mcu_fd_sc_mcu9t5v0__filltie
X_18135_ _19212_/Q _19218_/Q _18151_/S _18135_/Z VSS VSS VSS VSS gf180mcu_fd_sc_mcu9t5v0__mux2_1
XTAP_TAPCELL_ROW_264_6321 VSS VSS gf180mcu_fd_sc_mcu9t5v0__filltie
XTAP_TAPCELL_ROW_93_3547 VSS VSS gf180mcu_fd_sc_mcu9t5v0__filltie
XTAP_TAPCELL_ROW_93_3536 VSS VSS gf180mcu_fd_sc_mcu9t5v0__filltie
X_15347_ _19646_/Q _19623_/Q _15347_/Z VSS VSS VSS VSS gf180mcu_fd_sc_mcu9t5v0__or2_1
XTAP_TAPCELL_ROW_260_6218 VSS VSS gf180mcu_fd_sc_mcu9t5v0__filltie
XTAP_TAPCELL_ROW_260_6207 VSS VSS gf180mcu_fd_sc_mcu9t5v0__filltie
X_18066_ _18068_/A1 _18066_/A2 _18067_/A4 VSS VSS VSS VSS gf180mcu_fd_sc_mcu9t5v0__nand2_1
X_15278_ _19631_/Q _19608_/Q _19630_/Q _19607_/Q _15279_/I VSS VSS VSS VSS gf180mcu_fd_sc_mcu9t5v0__aoi22_1
X_17017_ _19255_/Q _16647_/B _17023_/S _17017_/Z VSS VSS VSS VSS gf180mcu_fd_sc_mcu9t5v0__mux2_1
XTAP_TAPCELL_ROW_260_6229 VSS VSS gf180mcu_fd_sc_mcu9t5v0__filltie
XTAP_TAPCELL_ROW_176_3_8141 VSS VSS gf180mcu_fd_sc_mcu9t5v0__filltie
X_14229_ _14115_/Z _14229_/A2 _14229_/A3 _14229_/Z VSS VSS VSS VSS gf180mcu_fd_sc_mcu9t5v0__xor3_1
XPHY_EDGE_ROW_9_Right_9 VSS VSS gf180mcu_fd_sc_mcu9t5v0__endcap
X_18968_ _18968_/D _19992_/RN clkload70/I _18968_/Q VSS VSS VSS VSS gf180mcu_fd_sc_mcu9t5v0__dffrnq_1
XPHY_EDGE_ROW_107_Right_107 VSS VSS gf180mcu_fd_sc_mcu9t5v0__endcap
X_09770_ _09820_/A1 _09416_/C _18060_/B _09770_/B1 _17869_/A1 _11016_/A2 _09771_/I
+ VSS _09770_/VNW VSS VSS gf180mcu_fd_sc_mcu9t5v0__oai33_1
XTAP_TAPCELL_ROW_258_6169 VSS VSS gf180mcu_fd_sc_mcu9t5v0__filltie
XTAP_TAPCELL_ROW_258_6158 VSS VSS gf180mcu_fd_sc_mcu9t5v0__filltie
X_17919_ _17919_/A1 _17926_/A1 _17919_/B1 _17919_/B2 _18843_/D VSS VSS VSS VSS gf180mcu_fd_sc_mcu9t5v0__oai22_1
XTAP_TAPCELL_ROW_7_1162 VSS VSS gf180mcu_fd_sc_mcu9t5v0__filltie
X_18899_ _18899_/D _20051_/RN clkload30/I _18899_/Q VSS VSS VSS VSS gf180mcu_fd_sc_mcu9t5v0__dffrnq_1
Xu_transform_scheduler_core.u_fft_scratch_sram.u_hi.u_gwen_driver _09886_/A1 u_transform_scheduler_core.u_fft_scratch_sram.u_hi.u_gwen_driver/ZN
+ VSS VSS VSS VSS gf180mcu_fd_sc_mcu9t5v0__clkinv_8
XTAP_TAPCELL_ROW_7_1173 VSS VSS gf180mcu_fd_sc_mcu9t5v0__filltie
XTAP_TAPCELL_ROW_7_1184 VSS VSS gf180mcu_fd_sc_mcu9t5v0__filltie
XTAP_TAPCELL_ROW_3_1059 VSS VSS gf180mcu_fd_sc_mcu9t5v0__filltie
X_09204_ _19587_/Q _15188_/A1 VSS VSS VSS VSS gf180mcu_fd_sc_mcu9t5v0__clkinv_1
XTAP_TAPCELL_ROW_230_5387 VSS VSS gf180mcu_fd_sc_mcu9t5v0__filltie
XTAP_TAPCELL_ROW_230_5398 VSS VSS gf180mcu_fd_sc_mcu9t5v0__filltie
Xrebuffer236 _16047_/S _16676_/S VSS VSS VSS VSS gf180mcu_fd_sc_mcu9t5v0__buf_12
X_09135_ _19796_/Q _13168_/A2 VSS VSS VSS VSS gf180mcu_fd_sc_mcu9t5v0__clkinv_1
XPHY_EDGE_ROW_282_Left_605 VSS VSS gf180mcu_fd_sc_mcu9t5v0__endcap
XTAP_TAPCELL_ROW_247_5851 VSS VSS gf180mcu_fd_sc_mcu9t5v0__filltie
Xrebuffer269 _09833_/B2 _17888_/B VSS VSS VSS VSS gf180mcu_fd_sc_mcu9t5v0__buf_8
X_09066_ _18748_/Q _12686_/A1 VSS _09066_/VNW VSS VSS gf180mcu_fd_sc_mcu9t5v0__clkinv_1
XTAP_TAPCELL_ROW_247_5873 VSS VSS gf180mcu_fd_sc_mcu9t5v0__filltie
XTAP_TAPCELL_ROW_247_5862 VSS VSS gf180mcu_fd_sc_mcu9t5v0__filltie
XTAP_TAPCELL_ROW_243_5759 VSS VSS gf180mcu_fd_sc_mcu9t5v0__filltie
XTAP_TAPCELL_ROW_243_5748 VSS VSS gf180mcu_fd_sc_mcu9t5v0__filltie
XPHY_EDGE_ROW_206_1_Left_529 VSS VSS gf180mcu_fd_sc_mcu9t5v0__endcap
X_09968_ _09968_/I output11/I VSS VSS VSS VSS gf180mcu_fd_sc_mcu9t5v0__clkinv_1
XTAP_TAPCELL_ROW_12_1303 VSS VSS gf180mcu_fd_sc_mcu9t5v0__filltie
XTAP_TAPCELL_ROW_12_1314 VSS VSS gf180mcu_fd_sc_mcu9t5v0__filltie
X_20088_ _20088_/D clkload78/I _20088_/Q VSS VSS VSS VSS gf180mcu_fd_sc_mcu9t5v0__dffq_1
X_09899_ _19245_/Q _10028_/B _09939_/B1 VSS VSS VSS VSS gf180mcu_fd_sc_mcu9t5v0__nor2_1
X_11930_ _18181_/Q _18165_/Q _12340_/S _11930_/Z VSS VSS VSS VSS gf180mcu_fd_sc_mcu9t5v0__mux2_1
XTAP_TAPCELL_ROW_12_1325 VSS VSS gf180mcu_fd_sc_mcu9t5v0__filltie
XPHY_EDGE_ROW_291_Left_614 VSS VSS gf180mcu_fd_sc_mcu9t5v0__endcap
X_11861_ _11988_/B _11884_/A1 _11876_/A1 VSS VSS VSS VSS gf180mcu_fd_sc_mcu9t5v0__nor2_1
XPHY_EDGE_ROW_177_2_Right_908 VSS VSS gf180mcu_fd_sc_mcu9t5v0__endcap
X_10812_ _20059_/Q _10814_/A2 _10813_/B VSS VSS VSS VSS gf180mcu_fd_sc_mcu9t5v0__nor2_1
X_11792_ _19112_/Q _11966_/B _11793_/B VSS VSS VSS VSS gf180mcu_fd_sc_mcu9t5v0__nand2_1
X_14580_ _14580_/A1 _19137_/Q _14581_/B VSS _14580_/VNW VSS VSS gf180mcu_fd_sc_mcu9t5v0__nand2_1
X_13600_ _13615_/B _13603_/B _13601_/A2 VSS _13600_/VNW VSS VSS gf180mcu_fd_sc_mcu9t5v0__nand2_1
X_10743_ _10718_/C _10743_/A2 _10743_/B1 _10743_/B2 _10743_/ZN VSS VSS VSS VSS gf180mcu_fd_sc_mcu9t5v0__aoi22_4
X_13531_ _13534_/A1 _13534_/A2 _13532_/A3 VSS VSS VSS VSS gf180mcu_fd_sc_mcu9t5v0__nor2_1
X_16250_ _16131_/B _16787_/S _16414_/A1 VSS _16250_/VNW VSS VSS gf180mcu_fd_sc_mcu9t5v0__nand2_1
XTAP_TAPCELL_ROW_182_3_8162 VSS VSS gf180mcu_fd_sc_mcu9t5v0__filltie
XPHY_EDGE_ROW_258_Right_185 VSS VSS gf180mcu_fd_sc_mcu9t5v0__endcap
X_10674_ _10659_/C _10671_/Z _10674_/B1 wire160/I _10675_/A2 VSS _10691_/VNW VSS VSS
+ gf180mcu_fd_sc_mcu9t5v0__aoi22_1
X_13462_ _19747_/Q _13638_/A2 _13634_/B VSS _13480_/VNW VSS VSS gf180mcu_fd_sc_mcu9t5v0__xnor2_1
X_15201_ _15201_/I0 _19720_/Q _15417_/S _19720_/D VSS _15201_/VNW VSS VSS gf180mcu_fd_sc_mcu9t5v0__mux2_1
X_16181_ _19273_/Q _16725_/C _16184_/B VSS VSS VSS VSS gf180mcu_fd_sc_mcu9t5v0__nand2_1
X_13393_ _13395_/A1 _13395_/A2 _13614_/B _13411_/A2 VSS _13395_/VNW VSS VSS gf180mcu_fd_sc_mcu9t5v0__oai21_1
X_12413_ _12618_/B _12413_/A2 _12414_/A2 VSS _12413_/VNW VSS VSS gf180mcu_fd_sc_mcu9t5v0__nand2_1
X_12344_ _18472_/Q _12340_/S _12347_/A1 VSS _12344_/VNW VSS VSS gf180mcu_fd_sc_mcu9t5v0__nor2_1
XTAP_TAPCELL_ROW_131_4584 VSS VSS gf180mcu_fd_sc_mcu9t5v0__filltie
X_15132_ _19674_/Q _19514_/Q wire108/Z _19674_/D VSS VSS VSS VSS gf180mcu_fd_sc_mcu9t5v0__mux2_1
XTAP_TAPCELL_ROW_131_4573 VSS VSS gf180mcu_fd_sc_mcu9t5v0__filltie
X_19940_ _19940_/D _20068_/RN clkload71/I _19940_/Q VSS VSS VSS VSS gf180mcu_fd_sc_mcu9t5v0__dffrnq_1
XTAP_TAPCELL_ROW_131_4595 VSS VSS gf180mcu_fd_sc_mcu9t5v0__filltie
X_15063_ _15063_/A1 _15063_/A2 _15064_/B VSS VSS VSS VSS gf180mcu_fd_sc_mcu9t5v0__nand2_1
X_14014_ _14015_/A1 _14013_/Z _14039_/B VSS _14014_/VNW VSS VSS gf180mcu_fd_sc_mcu9t5v0__nand2_1
X_12275_ wire213/I _12258_/Z _12275_/B1 _12296_/B2 _12276_/I1 VSS VSS VSS VSS gf180mcu_fd_sc_mcu9t5v0__aoi22_1
X_19871_ _19871_/D _20063_/RN clkload56/I _19871_/Q VSS VSS VSS VSS gf180mcu_fd_sc_mcu9t5v0__dffrnq_1
XPHY_EDGE_ROW_206_3_Right_321 VSS VSS gf180mcu_fd_sc_mcu9t5v0__endcap
XPHY_EDGE_ROW_190_1_Left_513 VSS VSS gf180mcu_fd_sc_mcu9t5v0__endcap
X_11226_ _18867_/Q _11878_/A1 _11320_/B1 _11226_/B2 _11320_/C _11228_/A1 VSS VSS VSS
+ VSS gf180mcu_fd_sc_mcu9t5v0__oai221_1
X_11157_ _18301_/Q _11519_/A2 _11158_/A3 VSS VSS VSS VSS gf180mcu_fd_sc_mcu9t5v0__nand2_1
X_18822_ _18822_/D _20038_/RN clkload34/I _18822_/Q VSS VSS VSS VSS gf180mcu_fd_sc_mcu9t5v0__dffrnq_1
X_10108_ _10063_/C _10108_/A2 _10108_/B1 _10108_/B2 output15/I VSS _10108_/VNW VSS
+ VSS gf180mcu_fd_sc_mcu9t5v0__aoi22_2
X_18753_ _18753_/D clkload25/I _18753_/Q VSS VSS VSS VSS gf180mcu_fd_sc_mcu9t5v0__dffq_1
X_11088_ _09395_/I _16196_/A1 _11091_/B VSS VSS VSS VSS gf180mcu_fd_sc_mcu9t5v0__nor2_1
X_17704_ _18728_/Q _17681_/S _17743_/B _18652_/Q _17704_/C _17705_/I VSS VSS VSS VSS
+ gf180mcu_fd_sc_mcu9t5v0__aoi221_1
X_15965_ _18567_/Q _15988_/B _16111_/A2 VSS VSS VSS VSS gf180mcu_fd_sc_mcu9t5v0__nor2_4
XTAP_TAPCELL_ROW_86_3351 VSS VSS gf180mcu_fd_sc_mcu9t5v0__filltie
XTAP_TAPCELL_ROW_86_3340 VSS VSS gf180mcu_fd_sc_mcu9t5v0__filltie
X_15896_ _20105_/Q _19240_/Q _15927_/S _20105_/D VSS VSS VSS VSS gf180mcu_fd_sc_mcu9t5v0__mux2_1
X_10039_ _19262_/Q _10165_/A2 _10165_/B1 _19278_/Q _10041_/A3 VSS VSS VSS VSS gf180mcu_fd_sc_mcu9t5v0__aoi22_1
XTAP_TAPCELL_ROW_253_6022 VSS VSS gf180mcu_fd_sc_mcu9t5v0__filltie
XTAP_TAPCELL_ROW_82_3237 VSS VSS gf180mcu_fd_sc_mcu9t5v0__filltie
X_18684_ _18684_/D _19960_/RN clkload22/I _18684_/Q VSS VSS VSS VSS gf180mcu_fd_sc_mcu9t5v0__dffrnq_1
X_14916_ _14916_/A1 _14918_/A2 _14917_/I1 VSS _14918_/VNW VSS VSS gf180mcu_fd_sc_mcu9t5v0__xnor2_1
XTAP_TAPCELL_ROW_82_3226 VSS VSS gf180mcu_fd_sc_mcu9t5v0__filltie
XTAP_TAPCELL_ROW_253_6033 VSS VSS gf180mcu_fd_sc_mcu9t5v0__filltie
XPHY_EDGE_ROW_189_3_Left_847 VSS VSS gf180mcu_fd_sc_mcu9t5v0__endcap
XTAP_TAPCELL_ROW_82_3248 VSS VSS gf180mcu_fd_sc_mcu9t5v0__filltie
X_17635_ _18686_/Q _17653_/I1 _17639_/A2 VSS _17653_/VNW VSS VSS gf180mcu_fd_sc_mcu9t5v0__nor2_1
X_14847_ _14849_/A1 _19408_/Q _14852_/A2 VSS VSS VSS VSS gf180mcu_fd_sc_mcu9t5v0__nor2_1
X_17566_ input8/Z _18664_/Q _17569_/A2 _17567_/I VSS VSS VSS VSS gf180mcu_fd_sc_mcu9t5v0__nor3_1
XTAP_TAPCELL_ROW_99_3701 VSS VSS gf180mcu_fd_sc_mcu9t5v0__filltie
X_16517_ _16016_/B _19230_/Q _17055_/S _16517_/Z VSS VSS VSS VSS gf180mcu_fd_sc_mcu9t5v0__mux2_1
XTAP_TAPCELL_ROW_99_3712 VSS VSS gf180mcu_fd_sc_mcu9t5v0__filltie
X_14778_ _19566_/Q _19332_/Q _20039_/D _19566_/D VSS VSS VSS VSS gf180mcu_fd_sc_mcu9t5v0__mux2_1
X_19305_ _19305_/D _20073_/RN clkload20/I _19305_/Q VSS VSS VSS VSS gf180mcu_fd_sc_mcu9t5v0__dffrnq_1
X_17497_ _18602_/Q _19243_/Q _17513_/S _18602_/D VSS VSS VSS VSS gf180mcu_fd_sc_mcu9t5v0__mux2_1
X_13729_ _19463_/Q _13745_/B1 _13656_/Z _19472_/Q _13731_/A1 VSS _13730_/VNW VSS VSS
+ gf180mcu_fd_sc_mcu9t5v0__aoi22_1
X_16448_ _18282_/Q _16447_/Z _16972_/S _18282_/D VSS _16448_/VNW VSS VSS gf180mcu_fd_sc_mcu9t5v0__mux2_1
X_19236_ _19236_/D _20068_/RN _19680_/CLK _19236_/Q VSS VSS VSS VSS gf180mcu_fd_sc_mcu9t5v0__dffrnq_2
X_16379_ _16137_/C _19232_/Q _16925_/S _16379_/Z VSS VSS VSS VSS gf180mcu_fd_sc_mcu9t5v0__mux2_1
XPHY_EDGE_ROW_225_Right_152 VSS VSS gf180mcu_fd_sc_mcu9t5v0__endcap
X_19167_ _19167_/D _20063_/RN clkload36/I _19167_/Q VSS VSS VSS VSS gf180mcu_fd_sc_mcu9t5v0__dffrnq_1
X_18118_ _18117_/Z _18946_/Q _18152_/S _18946_/D VSS _18150_/VNW VSS VSS gf180mcu_fd_sc_mcu9t5v0__mux2_1
X_19098_ _19098_/D _20058_/RN clkload44/I _19098_/Q VSS VSS VSS VSS gf180mcu_fd_sc_mcu9t5v0__dffrnq_1
X_18049_ _18930_/Q _10981_/I _18049_/B _18931_/Q _18050_/B VSS VSS VSS VSS gf180mcu_fd_sc_mcu9t5v0__aoi211_1
XTAP_TAPCELL_ROW_198_1_4769 VSS VSS gf180mcu_fd_sc_mcu9t5v0__filltie
XTAP_TAPCELL_ROW_71_2941 VSS VSS gf180mcu_fd_sc_mcu9t5v0__filltie
XTAP_TAPCELL_ROW_71_2930 VSS VSS gf180mcu_fd_sc_mcu9t5v0__filltie
X_20011_ _20011_/D _20139_/RN clkload54/I _20011_/Q VSS VSS VSS VSS gf180mcu_fd_sc_mcu9t5v0__dffrnq_1
X_09822_ _17869_/A2 _09835_/A1 _09823_/A2 VSS VSS VSS VSS gf180mcu_fd_sc_mcu9t5v0__nand2_1
XTAP_TAPCELL_ROW_223_5191 VSS VSS gf180mcu_fd_sc_mcu9t5v0__filltie
X_09753_ _09753_/A1 _09759_/A2 _09753_/B _20015_/D VSS _15850_/VNW VSS VSS gf180mcu_fd_sc_mcu9t5v0__oai21_1
XTAP_TAPCELL_ROW_9_1224 VSS VSS gf180mcu_fd_sc_mcu9t5v0__filltie
XTAP_TAPCELL_ROW_9_1235 VSS VSS gf180mcu_fd_sc_mcu9t5v0__filltie
XTAP_TAPCELL_ROW_187_3_8177 VSS VSS gf180mcu_fd_sc_mcu9t5v0__filltie
XTAP_TAPCELL_ROW_69_2870 VSS VSS gf180mcu_fd_sc_mcu9t5v0__filltie
X_09684_ _18573_/Q _12010_/A1 _17960_/A4 _18569_/Q _09686_/A3 VSS _12010_/VNW VSS
+ VSS gf180mcu_fd_sc_mcu9t5v0__oai22_1
XTAP_TAPCELL_ROW_69_2892 VSS VSS gf180mcu_fd_sc_mcu9t5v0__filltie
XTAP_TAPCELL_ROW_69_2881 VSS VSS gf180mcu_fd_sc_mcu9t5v0__filltie
XTAP_TAPCELL_ROW_236_5563 VSS VSS gf180mcu_fd_sc_mcu9t5v0__filltie
XTAP_TAPCELL_ROW_236_5552 VSS VSS gf180mcu_fd_sc_mcu9t5v0__filltie
XTAP_TAPCELL_ROW_65_2767 VSS VSS gf180mcu_fd_sc_mcu9t5v0__filltie
XTAP_TAPCELL_ROW_65_2778 VSS VSS gf180mcu_fd_sc_mcu9t5v0__filltie
XTAP_TAPCELL_ROW_236_5574 VSS VSS gf180mcu_fd_sc_mcu9t5v0__filltie
XTAP_TAPCELL_ROW_232_5438 VSS VSS gf180mcu_fd_sc_mcu9t5v0__filltie
XTAP_TAPCELL_ROW_232_5449 VSS VSS gf180mcu_fd_sc_mcu9t5v0__filltie
XTAP_TAPCELL_ROW_249_5924 VSS VSS gf180mcu_fd_sc_mcu9t5v0__filltie
XTAP_TAPCELL_ROW_249_5913 VSS VSS gf180mcu_fd_sc_mcu9t5v0__filltie
XTAP_TAPCELL_ROW_194_2_8201 VSS VSS gf180mcu_fd_sc_mcu9t5v0__filltie
XTAP_TAPCELL_ROW_170_1_4755 VSS VSS gf180mcu_fd_sc_mcu9t5v0__filltie
X_09118_ _19721_/Q _13005_/A1 VSS VSS VSS VSS gf180mcu_fd_sc_mcu9t5v0__clkinv_1
X_10390_ _19853_/Q _10390_/I1 _17161_/C _10390_/Z VSS VSS VSS VSS gf180mcu_fd_sc_mcu9t5v0__mux2_1
XTAP_TAPCELL_ROW_320_7881 VSS VSS gf180mcu_fd_sc_mcu9t5v0__filltie
XTAP_TAPCELL_ROW_320_7870 VSS VSS gf180mcu_fd_sc_mcu9t5v0__filltie
X_12060_ _18427_/Q _12203_/A2 _12066_/A1 VSS _17174_/VNW VSS VSS gf180mcu_fd_sc_mcu9t5v0__nand2_1
X_11011_ _19018_/Q _18102_/B _11012_/B VSS VSS VSS VSS gf180mcu_fd_sc_mcu9t5v0__nand2_1
XPHY_EDGE_ROW_142_2_Left_654 VSS VSS gf180mcu_fd_sc_mcu9t5v0__endcap
Xu_transform_scheduler_core.u_fft_scratch_sram.u_lo.g_pin_drive\[1\].u_data_driver
+ _10286_/ZN u_transform_scheduler_core.u_fft_scratch_sram.u_lo.u_sram/D[1] VSS VSS
+ VSS VSS gf180mcu_fd_sc_mcu9t5v0__buf_8
X_15750_ _19928_/Q _19929_/Q _15757_/B _15740_/Z _15753_/A2 VSS VSS VSS VSS gf180mcu_fd_sc_mcu9t5v0__nor4_1
X_12962_ _12968_/A1 _12961_/Z _12962_/Z VSS _13506_/VNW VSS VSS gf180mcu_fd_sc_mcu9t5v0__and2_1
X_11913_ _18308_/Q _12340_/S _11913_/B _11917_/A2 VSS VSS VSS VSS gf180mcu_fd_sc_mcu9t5v0__oai21_1
X_15681_ _19999_/Q _09675_/B _15820_/B1 _15761_/A1 VSS VSS VSS VSS gf180mcu_fd_sc_mcu9t5v0__nor3_1
X_12893_ _12892_/Z _19218_/Q _13419_/B _19218_/D VSS VSS VSS VSS gf180mcu_fd_sc_mcu9t5v0__mux2_1
X_14701_ _19537_/Q _14701_/I1 _14704_/S _19537_/D VSS _14701_/VNW VSS VSS gf180mcu_fd_sc_mcu9t5v0__mux2_1
XTAP_TAPCELL_ROW_314_7696 VSS VSS gf180mcu_fd_sc_mcu9t5v0__filltie
X_11844_ _18305_/Q _18289_/Q _18241_/Q _18225_/Q _12340_/S _12345_/B _11844_/Z VSS
+ VSS VSS VSS gf180mcu_fd_sc_mcu9t5v0__mux4_1
XTAP_TAPCELL_ROW_120_4296 VSS VSS gf180mcu_fd_sc_mcu9t5v0__filltie
XTAP_TAPCELL_ROW_120_4285 VSS VSS gf180mcu_fd_sc_mcu9t5v0__filltie
X_17420_ _17420_/I0 _18559_/Q _17420_/S _18559_/D VSS _17420_/VNW VSS VSS gf180mcu_fd_sc_mcu9t5v0__mux2_1
XTAP_TAPCELL_ROW_120_4274 VSS VSS gf180mcu_fd_sc_mcu9t5v0__filltie
X_14632_ _19094_/Q _19510_/Q _14730_/S _19510_/D VSS VSS VSS VSS gf180mcu_fd_sc_mcu9t5v0__mux2_1
XPHY_EDGE_ROW_178_2_Right_909 VSS VSS gf180mcu_fd_sc_mcu9t5v0__endcap
X_11775_ _12322_/B _11775_/A2 _11775_/A3 _11775_/B _11785_/B VSS _16487_/VNW VSS VSS
+ gf180mcu_fd_sc_mcu9t5v0__oai31_1
X_17351_ _17412_/A1 _17351_/A2 _17412_/B _17352_/A2 VSS _17351_/VNW VSS VSS gf180mcu_fd_sc_mcu9t5v0__aoi21_1
X_14563_ _14567_/B _14562_/Z wire199/Z _14564_/C VSS VSS VSS VSS gf180mcu_fd_sc_mcu9t5v0__oai21_1
X_10726_ _20030_/Q _10726_/A2 _10727_/B2 VSS VSS VSS VSS gf180mcu_fd_sc_mcu9t5v0__nor2_1
X_17282_ _18354_/Q _17282_/A2 _17282_/B1 _18370_/Q _17406_/C _17283_/B VSS VSS VSS
+ VSS gf180mcu_fd_sc_mcu9t5v0__aoi221_1
X_16302_ _16444_/A1 _16336_/A2 _16863_/S _16302_/ZN VSS VSS VSS VSS gf180mcu_fd_sc_mcu9t5v0__oai21_4
XTAP_TAPCELL_ROW_215_4979 VSS VSS gf180mcu_fd_sc_mcu9t5v0__filltie
XTAP_TAPCELL_ROW_133_4646 VSS VSS gf180mcu_fd_sc_mcu9t5v0__filltie
XTAP_TAPCELL_ROW_133_4635 VSS VSS gf180mcu_fd_sc_mcu9t5v0__filltie
X_14494_ _14494_/A1 _14494_/A2 _19461_/D VSS VSS VSS VSS gf180mcu_fd_sc_mcu9t5v0__nand2_1
X_13514_ _19264_/Q _13320_/B _13518_/B VSS VSS VSS VSS gf180mcu_fd_sc_mcu9t5v0__nand2_1
X_16233_ _17481_/A1 _15988_/B _16815_/A2 VSS VSS VSS VSS gf180mcu_fd_sc_mcu9t5v0__nor2_2
X_10657_ _18851_/Q _10806_/B _10657_/B _10657_/C _10660_/A1 VSS _10740_/VNW VSS VSS
+ gf180mcu_fd_sc_mcu9t5v0__oai211_1
X_13445_ _13454_/A1 _13442_/Z _13635_/A1 VSS _13454_/VNW VSS VSS gf180mcu_fd_sc_mcu9t5v0__nand2_1
X_19021_ _19021_/D _20045_/RN _19806_/CLK _19021_/Q VSS VSS VSS VSS gf180mcu_fd_sc_mcu9t5v0__dffrnq_1
Xclkload26 clkload26/I clkload26/Z VSS VSS VSS VSS gf180mcu_fd_sc_mcu9t5v0__clkbuf_4
XTAP_TAPCELL_ROW_75_3052 VSS VSS gf180mcu_fd_sc_mcu9t5v0__filltie
Xclkload15 clkload15/I clkload15/ZN VSS VSS VSS VSS gf180mcu_fd_sc_mcu9t5v0__inv_4
XTAP_TAPCELL_ROW_75_3041 VSS VSS gf180mcu_fd_sc_mcu9t5v0__filltie
X_16164_ _16164_/A1 _16164_/A2 _16164_/B _16165_/I1 VSS VSS VSS VSS gf180mcu_fd_sc_mcu9t5v0__oai21_4
X_10588_ _17358_/A1 _18262_/Q _10591_/A2 VSS VSS VSS VSS gf180mcu_fd_sc_mcu9t5v0__nor2_1
Xclkload59 clkload59/I clkload59/ZN VSS VSS VSS VSS gf180mcu_fd_sc_mcu9t5v0__clkinv_1
Xclkload48 clkload48/I clkload48/Z VSS VSS VSS VSS gf180mcu_fd_sc_mcu9t5v0__clkbuf_4
X_13376_ _13497_/A1 _13395_/A2 _13375_/Z _13376_/Z VSS VSS VSS VSS gf180mcu_fd_sc_mcu9t5v0__or3_1
Xclkload37 clkload37/I clkload37/ZN VSS VSS VSS VSS gf180mcu_fd_sc_mcu9t5v0__inv_2
X_12327_ _12261_/B _12327_/A2 _12327_/A3 _12328_/B VSS VSS VSS VSS gf180mcu_fd_sc_mcu9t5v0__nand3_1
X_16095_ _19274_/Q _16675_/A1 _16096_/B VSS VSS VSS VSS gf180mcu_fd_sc_mcu9t5v0__nand2_1
X_15115_ _19657_/Q _19497_/Q wire108/Z _19657_/D VSS VSS VSS VSS gf180mcu_fd_sc_mcu9t5v0__mux2_1
X_19923_ _19923_/D _20051_/RN clkload49/I _19923_/Q VSS VSS VSS VSS gf180mcu_fd_sc_mcu9t5v0__dffrnq_1
XTAP_TAPCELL_ROW_193_3_8198 VSS VSS gf180mcu_fd_sc_mcu9t5v0__filltie
X_15046_ _19639_/Q _15090_/A2 _15051_/B VSS _15046_/VNW VSS VSS gf180mcu_fd_sc_mcu9t5v0__nand2_1
X_12258_ _18918_/Q _12258_/A2 _12258_/Z VSS VSS VSS VSS gf180mcu_fd_sc_mcu9t5v0__xor2_1
X_11209_ _18240_/Q _11521_/B _11210_/B VSS VSS VSS VSS gf180mcu_fd_sc_mcu9t5v0__nand2_1
XPHY_EDGE_ROW_207_3_Right_322 VSS VSS gf180mcu_fd_sc_mcu9t5v0__endcap
X_19854_ _19854_/D _20046_/RN clkload55/I _19854_/Q VSS VSS VSS VSS gf180mcu_fd_sc_mcu9t5v0__dffrnq_1
XTAP_TAPCELL_ROW_88_3413 VSS VSS gf180mcu_fd_sc_mcu9t5v0__filltie
XTAP_TAPCELL_ROW_88_3402 VSS VSS gf180mcu_fd_sc_mcu9t5v0__filltie
X_18805_ _18805_/D _20021_/RN clkload32/I _18805_/Q VSS VSS VSS VSS gf180mcu_fd_sc_mcu9t5v0__dffrnq_1
X_12189_ wire213/I _12189_/A2 _12191_/B1 VSS VSS VSS VSS gf180mcu_fd_sc_mcu9t5v0__nor2_1
X_16997_ _19245_/Q _16576_/B _17003_/S _16997_/Z VSS VSS VSS VSS gf180mcu_fd_sc_mcu9t5v0__mux2_1
X_19785_ _19785_/D _20041_/RN clkload16/I _19785_/Q VSS VSS VSS VSS gf180mcu_fd_sc_mcu9t5v0__dffrnq_1
X_15948_ _15973_/B _15988_/C _15988_/B _15947_/Z _15948_/Z VSS VSS VSS VSS gf180mcu_fd_sc_mcu9t5v0__and4_1
X_18736_ _18736_/D clkload66/I _18736_/Q VSS VSS VSS VSS gf180mcu_fd_sc_mcu9t5v0__dffq_1
X_18667_ _18667_/D _20071_/RN clkload58/I _18667_/Q VSS VSS VSS VSS gf180mcu_fd_sc_mcu9t5v0__dffrnq_1
X_15879_ _20088_/Q _19238_/Q wire79/Z _20088_/D VSS _15879_/VNW VSS VSS gf180mcu_fd_sc_mcu9t5v0__mux2_1
X_17618_ _18681_/Q _09709_/Z _17619_/B VSS _17618_/VNW VSS VSS gf180mcu_fd_sc_mcu9t5v0__nand2_1
Xrst_tree_leaf_1 rst_tree_mid_0/Z _20018_/RN VSS VSS VSS VSS gf180mcu_fd_sc_mcu9t5v0__clkbuf_16
X_18598_ _18598_/D clkload75/I _18598_/Q VSS VSS VSS VSS gf180mcu_fd_sc_mcu9t5v0__dffq_1
X_17549_ _18664_/Q input5/Z _17735_/A1 VSS _17693_/VNW VSS VSS gf180mcu_fd_sc_mcu9t5v0__nand2_1
XTAP_TAPCELL_ROW_60_2620 VSS VSS gf180mcu_fd_sc_mcu9t5v0__filltie
XTAP_TAPCELL_ROW_60_2631 VSS VSS gf180mcu_fd_sc_mcu9t5v0__filltie
XTAP_TAPCELL_ROW_60_2642 VSS VSS gf180mcu_fd_sc_mcu9t5v0__filltie
X_19219_ _19219_/D _20051_/RN clkload26/I _19219_/Q VSS VSS VSS VSS gf180mcu_fd_sc_mcu9t5v0__dffrnq_1
Xclkload9 clkload9/I clkload9/ZN VSS _15003_/VNW VSS VSS gf180mcu_fd_sc_mcu9t5v0__inv_2
Xu_transform_scheduler_core.u_fft_scratch_sram.u_hi.g_pin_drive\[3\].u_data_driver
+ _10552_/ZN u_transform_scheduler_core.u_fft_scratch_sram.u_hi.u_sram/D[3] VSS VSS
+ VSS VSS gf180mcu_fd_sc_mcu9t5v0__buf_8
XTAP_TAPCELL_ROW_58_2571 VSS VSS gf180mcu_fd_sc_mcu9t5v0__filltie
XTAP_TAPCELL_ROW_58_2582 VSS VSS gf180mcu_fd_sc_mcu9t5v0__filltie
XTAP_TAPCELL_ROW_54_2457 VSS VSS gf180mcu_fd_sc_mcu9t5v0__filltie
XTAP_TAPCELL_ROW_225_5264 VSS VSS gf180mcu_fd_sc_mcu9t5v0__filltie
XTAP_TAPCELL_ROW_225_5253 VSS VSS gf180mcu_fd_sc_mcu9t5v0__filltie
XTAP_TAPCELL_ROW_54_2468 VSS VSS gf180mcu_fd_sc_mcu9t5v0__filltie
XTAP_TAPCELL_ROW_54_2479 VSS VSS gf180mcu_fd_sc_mcu9t5v0__filltie
Xfanout246 max_cap20/Z _17067_/S VSS VSS VSS VSS gf180mcu_fd_sc_mcu9t5v0__clkbuf_16
XTAP_TAPCELL_ROW_221_5139 VSS VSS gf180mcu_fd_sc_mcu9t5v0__filltie
Xfanout257 _16864_/S max_cap40/I VSS VSS VSS VSS gf180mcu_fd_sc_mcu9t5v0__clkbuf_16
X_09805_ _09805_/A1 _17912_/A3 _09805_/B _17915_/A2 VSS VSS VSS VSS gf180mcu_fd_sc_mcu9t5v0__oai21_1
XTAP_TAPCELL_ROW_238_5614 VSS VSS gf180mcu_fd_sc_mcu9t5v0__filltie
XTAP_TAPCELL_ROW_238_5603 VSS VSS gf180mcu_fd_sc_mcu9t5v0__filltie
X_09736_ _17532_/A2 _15682_/B2 _15701_/A2 VSS _09736_/VNW VSS VSS gf180mcu_fd_sc_mcu9t5v0__nand2_1
XTAP_TAPCELL_ROW_67_2818 VSS VSS gf180mcu_fd_sc_mcu9t5v0__filltie
XTAP_TAPCELL_ROW_67_2829 VSS VSS gf180mcu_fd_sc_mcu9t5v0__filltie
XTAP_TAPCELL_ROW_238_5625 VSS VSS gf180mcu_fd_sc_mcu9t5v0__filltie
X_09667_ _19924_/Q _09667_/A2 _09667_/A3 _09668_/A4 VSS VSS VSS VSS gf180mcu_fd_sc_mcu9t5v0__nand3_1
Xeco14_skew_12 clkload62/I _18431_/CLK VSS VSS VSS VSS gf180mcu_fd_sc_mcu9t5v0__clkbuf_16
X_09598_ _20042_/D _15671_/A2 _15671_/A3 _09598_/A4 _20044_/D VSS VSS VSS VSS gf180mcu_fd_sc_mcu9t5v0__and4_1
X_11560_ _18568_/Q _11094_/B _12153_/B VSS VSS VSS VSS gf180mcu_fd_sc_mcu9t5v0__nand2_2
X_10511_ _18291_/Q _17380_/A2 _17380_/B1 _18307_/Q _17275_/C _10512_/B VSS VSS VSS
+ VSS gf180mcu_fd_sc_mcu9t5v0__aoi221_1
X_11491_ _18437_/Q _11485_/C _11495_/C VSS VSS VSS VSS gf180mcu_fd_sc_mcu9t5v0__nand2_1
XTAP_TAPCELL_ROW_210_4832 VSS VSS gf180mcu_fd_sc_mcu9t5v0__filltie
X_13230_ _19800_/Q _19766_/Q _13577_/A2 VSS _13230_/VNW VSS VSS gf180mcu_fd_sc_mcu9t5v0__xnor2_1
XTAP_TAPCELL_ROW_322_7932 VSS VSS gf180mcu_fd_sc_mcu9t5v0__filltie
X_10442_ _18594_/Q _17306_/C _10442_/B1 _10442_/B2 _10648_/C _10443_/A3 VSS VSS VSS
+ VSS gf180mcu_fd_sc_mcu9t5v0__aoi221_1
XTAP_TAPCELL_ROW_322_7921 VSS VSS gf180mcu_fd_sc_mcu9t5v0__filltie
XTAP_TAPCELL_ROW_210_4854 VSS VSS gf180mcu_fd_sc_mcu9t5v0__filltie
XTAP_TAPCELL_ROW_210_4843 VSS VSS gf180mcu_fd_sc_mcu9t5v0__filltie
X_10373_ _09261_/I _10373_/A2 _10373_/A3 _10373_/B _10382_/A2 VSS VSS VSS VSS gf180mcu_fd_sc_mcu9t5v0__oai31_1
X_13161_ _12948_/S _13177_/A2 _13161_/A3 _13167_/B1 VSS _13161_/VNW VSS VSS gf180mcu_fd_sc_mcu9t5v0__nand3_1
X_12112_ _12112_/A1 _12112_/A2 _12112_/B1 _12112_/B2 _12116_/C _12117_/A2 VSS VSS
+ VSS VSS gf180mcu_fd_sc_mcu9t5v0__aoi221_1
X_13092_ _13107_/A2 _19792_/Q _13132_/A1 VSS _13107_/VNW VSS VSS gf180mcu_fd_sc_mcu9t5v0__nor2_1
XPHY_EDGE_ROW_115_Left_439 VSS VSS gf180mcu_fd_sc_mcu9t5v0__endcap
X_16920_ _16919_/Z _18452_/Q _16926_/S _18452_/D VSS VSS VSS VSS gf180mcu_fd_sc_mcu9t5v0__mux2_4
XTAP_TAPCELL_ROW_299_7290 VSS VSS gf180mcu_fd_sc_mcu9t5v0__filltie
XTAP_TAPCELL_ROW_303_7397 VSS VSS gf180mcu_fd_sc_mcu9t5v0__filltie
X_12043_ _18442_/Q _12046_/S _12045_/B1 VSS VSS VSS VSS gf180mcu_fd_sc_mcu9t5v0__nand2_1
XTAP_TAPCELL_ROW_295_7176 VSS VSS gf180mcu_fd_sc_mcu9t5v0__filltie
XTAP_TAPCELL_ROW_126_4450 VSS VSS gf180mcu_fd_sc_mcu9t5v0__filltie
XTAP_TAPCELL_ROW_37_1987 VSS VSS gf180mcu_fd_sc_mcu9t5v0__filltie
XTAP_TAPCELL_ROW_37_1998 VSS VSS gf180mcu_fd_sc_mcu9t5v0__filltie
XTAP_TAPCELL_ROW_295_7187 VSS VSS gf180mcu_fd_sc_mcu9t5v0__filltie
X_16851_ _19253_/Q _16634_/B _16861_/S _16851_/Z VSS VSS VSS VSS gf180mcu_fd_sc_mcu9t5v0__mux2_1
XTAP_TAPCELL_ROW_126_4461 VSS VSS gf180mcu_fd_sc_mcu9t5v0__filltie
XTAP_TAPCELL_ROW_122_4325 VSS VSS gf180mcu_fd_sc_mcu9t5v0__filltie
XTAP_TAPCELL_ROW_316_7758 VSS VSS gf180mcu_fd_sc_mcu9t5v0__filltie
XTAP_TAPCELL_ROW_316_7747 VSS VSS gf180mcu_fd_sc_mcu9t5v0__filltie
X_16782_ _16781_/Z _18390_/Q _16782_/S _18390_/D VSS VSS VSS VSS gf180mcu_fd_sc_mcu9t5v0__mux2_1
XTAP_TAPCELL_ROW_122_4347 VSS VSS gf180mcu_fd_sc_mcu9t5v0__filltie
XTAP_TAPCELL_ROW_122_4336 VSS VSS gf180mcu_fd_sc_mcu9t5v0__filltie
X_15802_ _15581_/B _19972_/Q _15802_/S _19972_/D VSS VSS VSS VSS gf180mcu_fd_sc_mcu9t5v0__mux2_1
X_19570_ _19570_/D _20018_/RN clkload18/I _19570_/Q VSS VSS VSS VSS gf180mcu_fd_sc_mcu9t5v0__dffrnq_1
XTAP_TAPCELL_ROW_316_7769 VSS VSS gf180mcu_fd_sc_mcu9t5v0__filltie
X_18521_ _18521_/D clkload52/I _18521_/Q VSS VSS VSS VSS gf180mcu_fd_sc_mcu9t5v0__dffq_1
X_15733_ _19924_/Q _19925_/Q _15734_/B1 VSS VSS VSS VSS gf180mcu_fd_sc_mcu9t5v0__xnor2_1
XTAP_TAPCELL_ROW_169_3_8116 VSS VSS gf180mcu_fd_sc_mcu9t5v0__filltie
X_13994_ _19316_/Q _19317_/Q _13994_/B _13997_/A1 VSS VSS VSS VSS gf180mcu_fd_sc_mcu9t5v0__aoi21_1
X_12945_ _19780_/Q _12941_/Z _12947_/A2 _12945_/Z VSS VSS VSS VSS gf180mcu_fd_sc_mcu9t5v0__xor3_1
XPHY_EDGE_ROW_124_Left_448 VSS VSS gf180mcu_fd_sc_mcu9t5v0__endcap
X_18452_ _18452_/D clkload75/I _18452_/Q VSS VSS VSS VSS gf180mcu_fd_sc_mcu9t5v0__dffq_1
X_15664_ _15677_/B _15668_/A3 _15664_/A3 _19907_/D VSS VSS VSS VSS gf180mcu_fd_sc_mcu9t5v0__nand3_1
X_12876_ _12889_/A1 _12889_/A2 _12878_/A2 VSS VSS VSS VSS gf180mcu_fd_sc_mcu9t5v0__xnor2_1
X_11827_ _11827_/A1 _11827_/A2 _11827_/B1 _11827_/B2 _11828_/A2 VSS _11827_/VNW VSS
+ VSS gf180mcu_fd_sc_mcu9t5v0__aoi22_1
X_17403_ _17403_/A1 _17403_/A2 _17407_/A2 VSS _17403_/VNW VSS VSS gf180mcu_fd_sc_mcu9t5v0__nand2_1
X_18383_ _18383_/D clkload63/I _18383_/Q VSS VSS VSS VSS gf180mcu_fd_sc_mcu9t5v0__dffq_1
XTAP_TAPCELL_ROW_135_4719 VSS VSS gf180mcu_fd_sc_mcu9t5v0__filltie
XTAP_TAPCELL_ROW_135_4708 VSS VSS gf180mcu_fd_sc_mcu9t5v0__filltie
X_15595_ _15595_/A1 _20042_/D _15597_/B1 _15595_/B2 _19883_/D VSS VSS VSS VSS gf180mcu_fd_sc_mcu9t5v0__oai22_1
X_14615_ _19076_/Q _19493_/Q _14730_/S _19493_/D VSS VSS VSS VSS gf180mcu_fd_sc_mcu9t5v0__mux2_1
X_17334_ _17260_/S _18469_/Q _17336_/A3 VSS VSS VSS VSS gf180mcu_fd_sc_mcu9t5v0__nor2_1
X_11758_ _12159_/B _11758_/A2 _11758_/A3 _11759_/B VSS VSS VSS VSS gf180mcu_fd_sc_mcu9t5v0__nand3_1
XTAP_TAPCELL_ROW_77_3103 VSS VSS gf180mcu_fd_sc_mcu9t5v0__filltie
X_14546_ _19467_/Q _14545_/Z _14546_/S _19467_/D VSS _14546_/VNW VSS VSS gf180mcu_fd_sc_mcu9t5v0__mux2_1
X_10709_ _17912_/A2 _10713_/I0 _10709_/Z VSS VSS VSS VSS gf180mcu_fd_sc_mcu9t5v0__and2_1
X_17265_ _20131_/Q _17407_/C _17266_/A3 VSS VSS VSS VSS gf180mcu_fd_sc_mcu9t5v0__nand2_1
X_11689_ _18218_/Q _12046_/S _11693_/A1 VSS VSS VSS VSS gf180mcu_fd_sc_mcu9t5v0__nand2_1
X_19004_ _19004_/D _20028_/RN clkload38/I _19004_/Q VSS VSS VSS VSS gf180mcu_fd_sc_mcu9t5v0__dffrnq_1
X_14477_ _19459_/Q _14715_/S _14478_/A2 VSS _14477_/VNW VSS VSS gf180mcu_fd_sc_mcu9t5v0__nand2_1
XTAP_TAPCELL_ROW_284_6891 VSS VSS gf180mcu_fd_sc_mcu9t5v0__filltie
X_17196_ _17260_/S _18526_/Q _17198_/A3 VSS VSS VSS VSS gf180mcu_fd_sc_mcu9t5v0__nor2_1
XTAP_TAPCELL_ROW_284_6880 VSS VSS gf180mcu_fd_sc_mcu9t5v0__filltie
X_16216_ _16058_/B _19268_/Q _16785_/S _16216_/Z VSS VSS VSS VSS gf180mcu_fd_sc_mcu9t5v0__mux2_1
X_13428_ _19745_/Q _13426_/I _13429_/I VSS VSS VSS VSS gf180mcu_fd_sc_mcu9t5v0__xor2_1
XPHY_EDGE_ROW_133_Left_457 VSS VSS gf180mcu_fd_sc_mcu9t5v0__endcap
X_16147_ _16750_/A1 _16477_/A2 _16725_/C _16147_/C _16149_/B VSS VSS VSS VSS gf180mcu_fd_sc_mcu9t5v0__aoi211_1
X_13359_ _13360_/A1 _19773_/Q _13377_/A2 VSS _13359_/VNW VSS VSS gf180mcu_fd_sc_mcu9t5v0__nor2_1
XTAP_TAPCELL_ROW_280_6777 VSS VSS gf180mcu_fd_sc_mcu9t5v0__filltie
XTAP_TAPCELL_ROW_280_6766 VSS VSS gf180mcu_fd_sc_mcu9t5v0__filltie
X_16078_ _16675_/A1 _16078_/A2 _16078_/A3 _16078_/B _16079_/I1 VSS _16078_/VNW VSS
+ VSS gf180mcu_fd_sc_mcu9t5v0__oai31_1
X_19906_ _19906_/D _20034_/RN clkload41/I _19906_/Q VSS VSS VSS VSS gf180mcu_fd_sc_mcu9t5v0__dffrnq_1
X_15029_ _19631_/Q _19382_/Q _20039_/Q _19631_/D VSS VSS VSS VSS gf180mcu_fd_sc_mcu9t5v0__mux2_1
XPHY_EDGE_ROW_208_3_Right_323 VSS VSS gf180mcu_fd_sc_mcu9t5v0__endcap
X_19837_ _19837_/D _20029_/RN clkload55/I _19837_/Q VSS VSS VSS VSS gf180mcu_fd_sc_mcu9t5v0__dffrnq_1
Xinput2 din[1] input2/Z VSS VSS VSS VSS gf180mcu_fd_sc_mcu9t5v0__clkbuf_2
XTAP_TAPCELL_ROW_109_3991 VSS VSS gf180mcu_fd_sc_mcu9t5v0__filltie
XTAP_TAPCELL_ROW_109_3980 VSS VSS gf180mcu_fd_sc_mcu9t5v0__filltie
X_19768_ _19768_/D _19960_/RN clkload23/I _19768_/Q VSS VSS VSS VSS gf180mcu_fd_sc_mcu9t5v0__dffrnq_1
X_18719_ _18719_/D clkload65/I _18719_/Q VSS VSS VSS VSS gf180mcu_fd_sc_mcu9t5v0__dffq_1
X_09521_ _20033_/Q _20054_/Q _09399_/Z wire174/I VSS _10194_/VNW VSS VSS gf180mcu_fd_sc_mcu9t5v0__nand3_1
XTAP_TAPCELL_ROW_105_3866 VSS VSS gf180mcu_fd_sc_mcu9t5v0__filltie
XTAP_TAPCELL_ROW_105_3877 VSS VSS gf180mcu_fd_sc_mcu9t5v0__filltie
X_19699_ _19699_/D _20019_/RN _19798_/CLK _19699_/Q VSS VSS VSS VSS gf180mcu_fd_sc_mcu9t5v0__dffrnq_1
XTAP_TAPCELL_ROW_0_947 VSS VSS gf180mcu_fd_sc_mcu9t5v0__filltie
X_09452_ _19195_/Q _09451_/Z _09453_/I VSS VSS VSS VSS gf180mcu_fd_sc_mcu9t5v0__nand2_1
XTAP_TAPCELL_ROW_0_958 VSS VSS gf180mcu_fd_sc_mcu9t5v0__filltie
XTAP_TAPCELL_ROW_0_969 VSS VSS gf180mcu_fd_sc_mcu9t5v0__filltie
XTAP_TAPCELL_ROW_47_2272 VSS VSS gf180mcu_fd_sc_mcu9t5v0__filltie
X_09383_ _18914_/Q _12192_/A1 VSS VSS VSS VSS gf180mcu_fd_sc_mcu9t5v0__clkinv_1
XTAP_TAPCELL_ROW_47_2283 VSS VSS gf180mcu_fd_sc_mcu9t5v0__filltie
XTAP_TAPCELL_ROW_43_2158 VSS VSS gf180mcu_fd_sc_mcu9t5v0__filltie
XTAP_TAPCELL_ROW_43_2169 VSS VSS gf180mcu_fd_sc_mcu9t5v0__filltie
XTAP_TAPCELL_ROW_195_3_8206 VSS VSS gf180mcu_fd_sc_mcu9t5v0__filltie
Xclkbuf_leaf_16_clk_regs clkload3/I clkload51/I VSS VSS VSS VSS gf180mcu_fd_sc_mcu9t5v0__clkbuf_8
XTAP_TAPCELL_ROW_227_5304 VSS VSS gf180mcu_fd_sc_mcu9t5v0__filltie
XTAP_TAPCELL_ROW_227_5326 VSS VSS gf180mcu_fd_sc_mcu9t5v0__filltie
XTAP_TAPCELL_ROW_227_5315 VSS VSS gf180mcu_fd_sc_mcu9t5v0__filltie
XTAP_TAPCELL_ROW_56_2519 VSS VSS gf180mcu_fd_sc_mcu9t5v0__filltie
XTAP_TAPCELL_ROW_200_3_8224 VSS VSS gf180mcu_fd_sc_mcu9t5v0__filltie
XTAP_TAPCELL_ROW_175_3_8137 VSS VSS gf180mcu_fd_sc_mcu9t5v0__filltie
XTAP_TAPCELL_ROW_32_1851 VSS VSS gf180mcu_fd_sc_mcu9t5v0__filltie
XTAP_TAPCELL_ROW_32_1862 VSS VSS gf180mcu_fd_sc_mcu9t5v0__filltie
XTAP_TAPCELL_ROW_290_7051 VSS VSS gf180mcu_fd_sc_mcu9t5v0__filltie
XTAP_TAPCELL_ROW_290_7040 VSS VSS gf180mcu_fd_sc_mcu9t5v0__filltie
XTAP_TAPCELL_ROW_32_1873 VSS VSS gf180mcu_fd_sc_mcu9t5v0__filltie
XTAP_TAPCELL_ROW_311_7611 VSS VSS gf180mcu_fd_sc_mcu9t5v0__filltie
X_09719_ _17231_/A3 _10836_/B2 _09719_/Z VSS _10702_/VNW VSS VSS gf180mcu_fd_sc_mcu9t5v0__or2_1
X_10991_ _19015_/Q _10990_/Z _10996_/S _19015_/D VSS VSS VSS VSS gf180mcu_fd_sc_mcu9t5v0__mux2_1
XTAP_TAPCELL_ROW_311_7633 VSS VSS gf180mcu_fd_sc_mcu9t5v0__filltie
XTAP_TAPCELL_ROW_311_7622 VSS VSS gf180mcu_fd_sc_mcu9t5v0__filltie
X_12730_ _19193_/Q _09454_/Z _19194_/D VSS _12731_/VNW VSS VSS gf180mcu_fd_sc_mcu9t5v0__or2_1
X_12661_ _12632_/C _12661_/A2 _12661_/A3 _12664_/B VSS _12661_/VNW VSS VSS gf180mcu_fd_sc_mcu9t5v0__nand3_1
X_11612_ _11612_/A1 _11612_/A2 _11612_/A3 _11611_/B _11665_/A2 _12645_/C VSS _11612_/VNW
+ VSS VSS gf180mcu_fd_sc_mcu9t5v0__oai32_1
X_14400_ _14400_/A1 _19115_/Q _14400_/B1 _19116_/Q _14400_/C _14408_/A3 VSS _14400_/VNW
+ VSS VSS gf180mcu_fd_sc_mcu9t5v0__aoi221_1
X_12592_ _18501_/Q _12608_/A2 wire146/Z _12593_/B2 VSS _12593_/VNW VSS VSS gf180mcu_fd_sc_mcu9t5v0__oai21_1
XTAP_TAPCELL_ROW_212_4905 VSS VSS gf180mcu_fd_sc_mcu9t5v0__filltie
X_15380_ _19665_/Q _19765_/Q _15420_/S _19765_/D VSS VSS VSS VSS gf180mcu_fd_sc_mcu9t5v0__mux2_1
XTAP_TAPCELL_ROW_309_7562 VSS VSS gf180mcu_fd_sc_mcu9t5v0__filltie
XTAP_TAPCELL_ROW_115_4151 VSS VSS gf180mcu_fd_sc_mcu9t5v0__filltie
XTAP_TAPCELL_ROW_115_4140 VSS VSS gf180mcu_fd_sc_mcu9t5v0__filltie
XTAP_TAPCELL_ROW_26_1688 VSS VSS gf180mcu_fd_sc_mcu9t5v0__filltie
X_14331_ _13904_/Z _19403_/Q _14337_/S _19403_/D VSS VSS VSS VSS gf180mcu_fd_sc_mcu9t5v0__mux2_1
XTAP_TAPCELL_ROW_26_1699 VSS VSS gf180mcu_fd_sc_mcu9t5v0__filltie
X_11543_ _18581_/Q _12689_/A2 _12618_/B _18572_/Q _12689_/C _11545_/A2 VSS VSS VSS
+ VSS gf180mcu_fd_sc_mcu9t5v0__oai221_1
X_17050_ _17049_/Z _18516_/Q _17050_/S _18516_/D VSS _17050_/VNW VSS VSS gf180mcu_fd_sc_mcu9t5v0__mux2_4
XTAP_TAPCELL_ROW_309_7573 VSS VSS gf180mcu_fd_sc_mcu9t5v0__filltie
X_11474_ wire283/Z _11474_/A2 _11474_/B1 _11474_/B2 _11788_/B _11475_/B2 VSS VSS VSS
+ VSS gf180mcu_fd_sc_mcu9t5v0__aoi221_2
XTAP_TAPCELL_ROW_111_4037 VSS VSS gf180mcu_fd_sc_mcu9t5v0__filltie
XTAP_TAPCELL_ROW_111_4026 VSS VSS gf180mcu_fd_sc_mcu9t5v0__filltie
X_14262_ _14262_/A1 _14262_/A2 _14262_/B _14264_/A2 VSS _14262_/VNW VSS VSS gf180mcu_fd_sc_mcu9t5v0__oai21_1
XTAP_TAPCELL_ROW_305_7459 VSS VSS gf180mcu_fd_sc_mcu9t5v0__filltie
X_10425_ _17378_/A1 _18320_/Q _10428_/A2 VSS VSS VSS VSS gf180mcu_fd_sc_mcu9t5v0__nor2_1
XTAP_TAPCELL_ROW_305_7448 VSS VSS gf180mcu_fd_sc_mcu9t5v0__filltie
X_16001_ _18673_/Q _18770_/Q _16619_/S _16001_/Z VSS VSS VSS VSS gf180mcu_fd_sc_mcu9t5v0__mux2_1
XTAP_TAPCELL_ROW_111_4048 VSS VSS gf180mcu_fd_sc_mcu9t5v0__filltie
X_13213_ _13215_/A1 _19764_/Q _13224_/A1 VSS VSS VSS VSS gf180mcu_fd_sc_mcu9t5v0__nor2_1
X_14193_ _19321_/Q _19301_/Q _14245_/B VSS VSS VSS VSS gf180mcu_fd_sc_mcu9t5v0__nand2_1
XTAP_TAPCELL_ROW_297_7227 VSS VSS gf180mcu_fd_sc_mcu9t5v0__filltie
XPHY_EDGE_ROW_198_3_Left_856 VSS VSS gf180mcu_fd_sc_mcu9t5v0__endcap
XTAP_TAPCELL_ROW_128_4501 VSS VSS gf180mcu_fd_sc_mcu9t5v0__filltie
X_13144_ _13144_/A1 _19760_/Q _13162_/A2 VSS VSS VSS VSS gf180mcu_fd_sc_mcu9t5v0__nor2_1
XTAP_TAPCELL_ROW_297_7249 VSS VSS gf180mcu_fd_sc_mcu9t5v0__filltie
XTAP_TAPCELL_ROW_297_7238 VSS VSS gf180mcu_fd_sc_mcu9t5v0__filltie
X_10356_ _20097_/Q _17326_/A1 wire168/I _10356_/C _10358_/A2 VSS VSS VSS VSS gf180mcu_fd_sc_mcu9t5v0__oai211_1
XTAP_TAPCELL_ROW_128_4512 VSS VSS gf180mcu_fd_sc_mcu9t5v0__filltie
XTAP_TAPCELL_ROW_318_7809 VSS VSS gf180mcu_fd_sc_mcu9t5v0__filltie
X_10287_ _10648_/C _18667_/Q _10821_/B _10306_/A2 VSS VSS VSS VSS gf180mcu_fd_sc_mcu9t5v0__nand3_1
X_17952_ _18854_/Q _17969_/A2 _17953_/A3 VSS _17952_/VNW VSS VSS gf180mcu_fd_sc_mcu9t5v0__nor2_1
X_13075_ _13075_/A1 _13073_/B _13075_/Z VSS _13075_/VNW VSS VSS gf180mcu_fd_sc_mcu9t5v0__xor2_1
X_16903_ _16592_/B _19247_/Q _16925_/S _16903_/Z VSS VSS VSS VSS gf180mcu_fd_sc_mcu9t5v0__mux2_1
X_12026_ _11736_/C _12026_/A2 _12026_/A3 _12026_/B1 _12026_/B2 _12057_/A1 VSS VSS
+ VSS VSS gf180mcu_fd_sc_mcu9t5v0__oai32_1
X_17883_ _18834_/Q _17885_/S _17884_/A2 VSS _17883_/VNW VSS VSS gf180mcu_fd_sc_mcu9t5v0__nand2_1
X_16834_ _18409_/Q _16833_/Z _16840_/S _18409_/D VSS VSS VSS VSS gf180mcu_fd_sc_mcu9t5v0__mux2_1
X_19622_ _19622_/D _20070_/RN clkload9/I _19622_/Q VSS VSS VSS VSS gf180mcu_fd_sc_mcu9t5v0__dffrnq_1
XTAP_TAPCELL_ROW_188_3_8182 VSS VSS gf180mcu_fd_sc_mcu9t5v0__filltie
X_16765_ _16606_/B _19281_/Q _16783_/S _16765_/Z VSS VSS VSS VSS gf180mcu_fd_sc_mcu9t5v0__mux2_1
XTAP_TAPCELL_ROW_273_6570 VSS VSS gf180mcu_fd_sc_mcu9t5v0__filltie
X_13977_ _13978_/A1 _13978_/A2 _13990_/B VSS VSS VSS VSS gf180mcu_fd_sc_mcu9t5v0__nand2_1
X_19553_ _19553_/D _20065_/RN clkload30/I _19553_/Q VSS VSS VSS VSS gf180mcu_fd_sc_mcu9t5v0__dffrnq_1
X_18504_ _18504_/D clkload78/I _18504_/Q VSS VSS VSS VSS gf180mcu_fd_sc_mcu9t5v0__dffq_1
XTAP_TAPCELL_ROW_273_6581 VSS VSS gf180mcu_fd_sc_mcu9t5v0__filltie
X_16696_ _16730_/A1 _16599_/B _16696_/B _16698_/A2 VSS VSS VSS VSS gf180mcu_fd_sc_mcu9t5v0__aoi21_1
X_15716_ _19920_/Q _15716_/A2 _15717_/A2 VSS VSS VSS VSS gf180mcu_fd_sc_mcu9t5v0__xnor2_1
X_12928_ _19746_/Q _19811_/Q _12948_/S _12928_/Z VSS VSS VSS VSS gf180mcu_fd_sc_mcu9t5v0__mux2_1
X_19484_ _19484_/D _20060_/RN clkload12/I _19484_/Q VSS VSS VSS VSS gf180mcu_fd_sc_mcu9t5v0__dffrnq_1
X_18435_ _18435_/D _20132_/CLK _18435_/Q VSS VSS VSS VSS gf180mcu_fd_sc_mcu9t5v0__dffq_1
XTAP_TAPCELL_ROW_100_3741 VSS VSS gf180mcu_fd_sc_mcu9t5v0__filltie
X_15647_ _19901_/Q _15677_/B _15648_/B2 VSS _15647_/VNW VSS VSS gf180mcu_fd_sc_mcu9t5v0__nand2_1
XTAP_TAPCELL_ROW_100_3730 VSS VSS gf180mcu_fd_sc_mcu9t5v0__filltie
X_12859_ _19214_/Q _13304_/B _12860_/B VSS VSS VSS VSS gf180mcu_fd_sc_mcu9t5v0__nand2_1
XTAP_TAPCELL_ROW_286_6942 VSS VSS gf180mcu_fd_sc_mcu9t5v0__filltie
XTAP_TAPCELL_ROW_286_6931 VSS VSS gf180mcu_fd_sc_mcu9t5v0__filltie
X_18366_ _18366_/D _18366_/CLK _18366_/Q VSS VSS VSS VSS gf180mcu_fd_sc_mcu9t5v0__dffq_4
X_15578_ _18022_/I0 _15596_/A2 _15583_/B1 VSS _15578_/VNW VSS VSS gf180mcu_fd_sc_mcu9t5v0__nor2_1
X_17317_ _17260_/S _18468_/Q _17319_/A3 VSS VSS VSS VSS gf180mcu_fd_sc_mcu9t5v0__nor2_1
X_18297_ _18297_/D clkload63/I _18297_/Q VSS VSS VSS VSS gf180mcu_fd_sc_mcu9t5v0__dffq_1
XTAP_TAPCELL_ROW_282_6817 VSS VSS gf180mcu_fd_sc_mcu9t5v0__filltie
XTAP_TAPCELL_ROW_181_3_8158 VSS VSS gf180mcu_fd_sc_mcu9t5v0__filltie
X_14529_ _19466_/Q _14766_/A2 _14538_/A1 VSS _14529_/VNW VSS VSS gf180mcu_fd_sc_mcu9t5v0__nand2_1
XTAP_TAPCELL_ROW_282_6839 VSS VSS gf180mcu_fd_sc_mcu9t5v0__filltie
X_17248_ _17412_/A1 _17248_/A2 _17412_/B _17251_/A1 VSS VSS VSS VSS gf180mcu_fd_sc_mcu9t5v0__aoi21_1
XTAP_TAPCELL_ROW_282_6828 VSS VSS gf180mcu_fd_sc_mcu9t5v0__filltie
X_17179_ _20112_/Q _17408_/B _17180_/B VSS _17179_/VNW VSS VSS gf180mcu_fd_sc_mcu9t5v0__nand2_1
Xrst_tree_leaf_50 rst_tree_mid_6/Z _20033_/RN VSS VSS VSS VSS gf180mcu_fd_sc_mcu9t5v0__clkbuf_16
Xrst_tree_leaf_61 rst_tree_mid_7/Z _20022_/RN VSS VSS VSS VSS gf180mcu_fd_sc_mcu9t5v0__clkbuf_16
XTAP_TAPCELL_ROW_107_3917 VSS VSS gf180mcu_fd_sc_mcu9t5v0__filltie
XTAP_TAPCELL_ROW_107_3928 VSS VSS gf180mcu_fd_sc_mcu9t5v0__filltie
XTAP_TAPCELL_ROW_49_2323 VSS VSS gf180mcu_fd_sc_mcu9t5v0__filltie
XTAP_TAPCELL_ROW_49_2334 VSS VSS gf180mcu_fd_sc_mcu9t5v0__filltie
XTAP_TAPCELL_ROW_216_5016 VSS VSS gf180mcu_fd_sc_mcu9t5v0__filltie
XTAP_TAPCELL_ROW_216_5005 VSS VSS gf180mcu_fd_sc_mcu9t5v0__filltie
XTAP_TAPCELL_ROW_45_2209 VSS VSS gf180mcu_fd_sc_mcu9t5v0__filltie
X_09504_ _18579_/Q _11075_/A1 _17961_/A2 _18581_/Q _18585_/Q _12622_/A1 _09519_/A2
+ VSS VSS VSS VSS gf180mcu_fd_sc_mcu9t5v0__oai222_4
X_09435_ _09428_/Z _09435_/A2 _09430_/Z _09435_/B _09435_/ZN VSS VSS VSS VSS gf180mcu_fd_sc_mcu9t5v0__oai31_4
X_09366_ _18195_/Q _11251_/A1 VSS _11252_/VNW VSS VSS gf180mcu_fd_sc_mcu9t5v0__clkinv_1
XTAP_TAPCELL_ROW_252_5997 VSS VSS gf180mcu_fd_sc_mcu9t5v0__filltie
X_09297_ _19254_/Q _16951_/A1 VSS VSS VSS VSS gf180mcu_fd_sc_mcu9t5v0__clkinv_1
XPHY_EDGE_ROW_151_2_Left_663 VSS VSS gf180mcu_fd_sc_mcu9t5v0__endcap
XTAP_TAPCELL_ROW_21_1552 VSS VSS gf180mcu_fd_sc_mcu9t5v0__filltie
XTAP_TAPCELL_ROW_21_1563 VSS VSS gf180mcu_fd_sc_mcu9t5v0__filltie
X_10210_ _09542_/B _17763_/A3 _15504_/A3 VSS _15485_/VNW VSS VSS gf180mcu_fd_sc_mcu9t5v0__nor2_1
XTAP_TAPCELL_ROW_300_7334 VSS VSS gf180mcu_fd_sc_mcu9t5v0__filltie
XTAP_TAPCELL_ROW_300_7323 VSS VSS gf180mcu_fd_sc_mcu9t5v0__filltie
XTAP_TAPCELL_ROW_300_7312 VSS VSS gf180mcu_fd_sc_mcu9t5v0__filltie
X_11190_ _18335_/Q _18319_/Q _18303_/Q _18287_/Q _11534_/S wire136/I _11190_/Z VSS
+ VSS VSS VSS gf180mcu_fd_sc_mcu9t5v0__mux4_1
X_10141_ _09981_/B _10141_/A2 _10152_/C VSS _10141_/VNW VSS VSS gf180mcu_fd_sc_mcu9t5v0__nor2_1
XTAP_TAPCELL_ROW_34_1913 VSS VSS gf180mcu_fd_sc_mcu9t5v0__filltie
XTAP_TAPCELL_ROW_292_7113 VSS VSS gf180mcu_fd_sc_mcu9t5v0__filltie
XTAP_TAPCELL_ROW_292_7102 VSS VSS gf180mcu_fd_sc_mcu9t5v0__filltie
X_10072_ _18958_/Q wire172/Z wire285/I _18998_/Q _10072_/C _10080_/A2 VSS VSS VSS
+ VSS gf180mcu_fd_sc_mcu9t5v0__aoi221_1
XTAP_TAPCELL_ROW_19_1492 VSS VSS gf180mcu_fd_sc_mcu9t5v0__filltie
XTAP_TAPCELL_ROW_34_1924 VSS VSS gf180mcu_fd_sc_mcu9t5v0__filltie
X_13900_ _13901_/A2 _13898_/Z _13900_/Z VSS VSS VSS VSS gf180mcu_fd_sc_mcu9t5v0__or2_1
X_14880_ _19413_/Q _19354_/Q _14886_/A1 VSS _14886_/VNW VSS VSS gf180mcu_fd_sc_mcu9t5v0__nand2_1
XTAP_TAPCELL_ROW_15_1389 VSS VSS gf180mcu_fd_sc_mcu9t5v0__filltie
Xmax_cap20 max_cap20/I max_cap20/Z VSS VSS VSS VSS gf180mcu_fd_sc_mcu9t5v0__clkbuf_16
X_13831_ _13831_/A1 _13831_/A2 _13828_/Z _13834_/A3 VSS _13831_/VNW VSS VSS gf180mcu_fd_sc_mcu9t5v0__xnor3_1
X_16550_ _18333_/Q _16137_/C _17067_/S _18333_/D VSS _16550_/VNW VSS VSS gf180mcu_fd_sc_mcu9t5v0__mux2_4
Xmax_cap64 _17511_/S _17513_/S VSS VSS VSS VSS gf180mcu_fd_sc_mcu9t5v0__buf_4
Xmax_cap31 _16940_/S _16960_/S VSS _16702_/VNW VSS VSS gf180mcu_fd_sc_mcu9t5v0__clkbuf_8
Xmax_cap42 _16770_/S _16786_/S VSS VSS VSS VSS gf180mcu_fd_sc_mcu9t5v0__buf_4
X_10974_ _18925_/Q _11001_/B1 _18040_/A2 VSS VSS VSS VSS gf180mcu_fd_sc_mcu9t5v0__nor2_1
X_13762_ _13757_/Z _13767_/B _13803_/A1 _13762_/B2 _14355_/I0 VSS VSS VSS VSS gf180mcu_fd_sc_mcu9t5v0__aoi22_1
Xmax_cap75 _15928_/S _15927_/S VSS VSS VSS VSS gf180mcu_fd_sc_mcu9t5v0__buf_4
Xmax_cap86 _16815_/A2 _16932_/A2 VSS VSS VSS VSS gf180mcu_fd_sc_mcu9t5v0__clkbuf_8
X_15501_ _17422_/S _15500_/Z _19837_/D VSS VSS VSS VSS gf180mcu_fd_sc_mcu9t5v0__and2_1
Xmax_cap97 _16612_/S _16598_/S VSS VSS VSS VSS gf180mcu_fd_sc_mcu9t5v0__clkbuf_4
X_12713_ _12682_/C _12713_/A2 _12714_/B2 VSS VSS VSS VSS gf180mcu_fd_sc_mcu9t5v0__nand2_1
X_18220_ _18220_/D _20129_/CLK _18220_/Q VSS VSS VSS VSS gf180mcu_fd_sc_mcu9t5v0__dffq_1
X_16481_ _19229_/Q _16009_/B _17003_/S _16481_/Z VSS VSS VSS VSS gf180mcu_fd_sc_mcu9t5v0__mux2_1
XTAP_TAPCELL_ROW_117_4213 VSS VSS gf180mcu_fd_sc_mcu9t5v0__filltie
XTAP_TAPCELL_ROW_117_4202 VSS VSS gf180mcu_fd_sc_mcu9t5v0__filltie
XTAP_TAPCELL_ROW_28_1739 VSS VSS gf180mcu_fd_sc_mcu9t5v0__filltie
X_13693_ _19295_/Q _14166_/B _13693_/B1 _14143_/B2 _13694_/A2 VSS VSS VSS VSS gf180mcu_fd_sc_mcu9t5v0__aoi22_1
X_15432_ _18563_/Q _10840_/B _15434_/A2 VSS VSS VSS VSS gf180mcu_fd_sc_mcu9t5v0__nand2_1
X_12644_ _12675_/B _12643_/Z _12644_/B _12645_/B1 VSS _12652_/VNW VSS VSS gf180mcu_fd_sc_mcu9t5v0__oai21_1
X_12575_ _18451_/Q _12615_/A2 _12577_/B1 VSS VSS VSS VSS gf180mcu_fd_sc_mcu9t5v0__nor2_1
X_18151_ _19220_/Q _19226_/Q _18151_/S _18151_/Z VSS VSS VSS VSS gf180mcu_fd_sc_mcu9t5v0__mux2_1
X_15363_ _19649_/Q _19626_/Q _15363_/A3 _15363_/Z VSS VSS VSS VSS gf180mcu_fd_sc_mcu9t5v0__xor3_1
X_11526_ _11520_/B _11524_/Z _11526_/B _11527_/B2 VSS VSS VSS VSS gf180mcu_fd_sc_mcu9t5v0__aoi21_1
X_17102_ _18410_/Q _17322_/A2 _17255_/B1 _18426_/Q _17278_/C _17103_/B VSS _17102_/VNW
+ VSS VSS gf180mcu_fd_sc_mcu9t5v0__aoi221_1
X_18082_ _18097_/A1 _10996_/S _18932_/Q _18082_/Z VSS VSS VSS VSS gf180mcu_fd_sc_mcu9t5v0__mux2_1
X_14314_ _13986_/Z _19387_/Q _14322_/S _19387_/D VSS _14950_/VNW VSS VSS gf180mcu_fd_sc_mcu9t5v0__mux2_1
X_17033_ _16592_/B _19247_/Q _17033_/S _17033_/Z VSS VSS VSS VSS gf180mcu_fd_sc_mcu9t5v0__mux2_1
X_15294_ _19636_/Q _19613_/Q _15304_/A1 VSS _15295_/VNW VSS VSS gf180mcu_fd_sc_mcu9t5v0__nor2_1
X_11457_ _18498_/Q _11534_/S _11510_/B _11459_/A2 VSS VSS VSS VSS gf180mcu_fd_sc_mcu9t5v0__oai21_1
Xwire285 wire285/I wire285/Z VSS VSS VSS VSS gf180mcu_fd_sc_mcu9t5v0__clkbuf_3
X_14245_ _14245_/A1 _19301_/Q _14245_/B _14245_/C _14246_/C VSS _14245_/VNW VSS VSS
+ gf180mcu_fd_sc_mcu9t5v0__oai211_1
X_11388_ _11388_/A1 _11388_/A2 _11521_/B _11388_/C _11389_/B VSS VSS VSS VSS gf180mcu_fd_sc_mcu9t5v0__oai211_1
X_10408_ _10459_/C _10408_/A2 _10408_/A3 _10408_/B _10409_/B1 VSS VSS VSS VSS gf180mcu_fd_sc_mcu9t5v0__oai31_1
XTAP_TAPCELL_ROW_262_6282 VSS VSS gf180mcu_fd_sc_mcu9t5v0__filltie
XTAP_TAPCELL_ROW_262_6271 VSS VSS gf180mcu_fd_sc_mcu9t5v0__filltie
XTAP_TAPCELL_ROW_91_3497 VSS VSS gf180mcu_fd_sc_mcu9t5v0__filltie
XTAP_TAPCELL_ROW_91_3486 VSS VSS gf180mcu_fd_sc_mcu9t5v0__filltie
X_14176_ _13904_/Z _19331_/Q _14266_/S _19331_/D VSS VSS VSS VSS gf180mcu_fd_sc_mcu9t5v0__mux2_1
XTAP_TAPCELL_ROW_91_3475 VSS VSS gf180mcu_fd_sc_mcu9t5v0__filltie
X_18984_ _18984_/D _20072_/RN clkload69/I _18984_/Q VSS VSS VSS VSS gf180mcu_fd_sc_mcu9t5v0__dffrnq_1
X_10339_ _19944_/Q wire216/Z _10655_/B _10340_/B2 VSS VSS VSS VSS gf180mcu_fd_sc_mcu9t5v0__aoi21_1
X_13127_ _13145_/A1 _19759_/Q _13127_/A3 _13128_/A2 VSS VSS VSS VSS gf180mcu_fd_sc_mcu9t5v0__xnor3_1
Xload_slew224 _19826_/Q _10459_/C VSS VSS VSS VSS gf180mcu_fd_sc_mcu9t5v0__buf_8
X_13058_ _13058_/I _13082_/A1 VSS _13068_/VNW VSS VSS gf180mcu_fd_sc_mcu9t5v0__clkinv_1
X_17935_ _18849_/Q _17931_/Z _17936_/A2 VSS VSS VSS VSS gf180mcu_fd_sc_mcu9t5v0__xnor2_1
XTAP_TAPCELL_ROW_275_6621 VSS VSS gf180mcu_fd_sc_mcu9t5v0__filltie
X_12009_ _18582_/Q _12689_/A2 _12618_/B _18573_/Q _12689_/C _12010_/A2 VSS _17464_/VNW
+ VSS VSS gf180mcu_fd_sc_mcu9t5v0__oai221_1
XTAP_TAPCELL_ROW_275_6643 VSS VSS gf180mcu_fd_sc_mcu9t5v0__filltie
XTAP_TAPCELL_ROW_275_6632 VSS VSS gf180mcu_fd_sc_mcu9t5v0__filltie
X_17866_ _17867_/A2 _17866_/A2 _18828_/D VSS VSS VSS VSS gf180mcu_fd_sc_mcu9t5v0__and2_1
X_16817_ _16817_/A1 _16953_/B _16818_/I1 VSS _16817_/VNW VSS VSS gf180mcu_fd_sc_mcu9t5v0__nand2_1
XTAP_TAPCELL_ROW_271_6529 VSS VSS gf180mcu_fd_sc_mcu9t5v0__filltie
XTAP_TAPCELL_ROW_271_6518 VSS VSS gf180mcu_fd_sc_mcu9t5v0__filltie
X_17797_ _18775_/Q _18762_/Q _18769_/D _18775_/D VSS VSS VSS VSS gf180mcu_fd_sc_mcu9t5v0__mux2_1
X_19605_ _19605_/D _20053_/RN clkload21/I _19605_/Q VSS VSS VSS VSS gf180mcu_fd_sc_mcu9t5v0__dffrnq_1
X_16748_ _16114_/Z _16748_/A2 _16748_/B _18375_/D VSS VSS VSS VSS gf180mcu_fd_sc_mcu9t5v0__oai21_1
XTAP_TAPCELL_ROW_256_6097 VSS VSS gf180mcu_fd_sc_mcu9t5v0__filltie
X_19536_ _19536_/D _20048_/RN _19798_/CLK _19536_/Q VSS VSS VSS VSS gf180mcu_fd_sc_mcu9t5v0__dffrnq_1
X_16679_ _19244_/Q _16741_/B2 _16679_/B _16679_/C _16681_/A2 VSS VSS VSS VSS gf180mcu_fd_sc_mcu9t5v0__aoi211_1
X_09220_ _19597_/Q _15242_/A1 VSS _09220_/VNW VSS VSS gf180mcu_fd_sc_mcu9t5v0__clkinv_1
X_19467_ _19467_/D _20043_/RN clkload13/I _19467_/Q VSS VSS VSS VSS gf180mcu_fd_sc_mcu9t5v0__dffrnq_1
X_18418_ _18418_/D _20132_/CLK _18418_/Q VSS VSS VSS VSS gf180mcu_fd_sc_mcu9t5v0__dffq_4
X_19398_ _19398_/D _20038_/RN clkload18/I _19398_/Q VSS VSS VSS VSS gf180mcu_fd_sc_mcu9t5v0__dffrnq_1
X_18349_ _18349_/D clkload62/I _18349_/Q VSS VSS VSS VSS gf180mcu_fd_sc_mcu9t5v0__dffq_1
XTAP_TAPCELL_ROW_269_6469 VSS VSS gf180mcu_fd_sc_mcu9t5v0__filltie
XTAP_TAPCELL_ROW_269_6458 VSS VSS gf180mcu_fd_sc_mcu9t5v0__filltie
X_09151_ _19805_/Q _13325_/A2 VSS VSS VSS VSS gf180mcu_fd_sc_mcu9t5v0__clkinv_1
X_09082_ _18824_/Q _17851_/B2 VSS VSS VSS VSS gf180mcu_fd_sc_mcu9t5v0__clkinv_1
XTAP_TAPCELL_ROW_38_2024 VSS VSS gf180mcu_fd_sc_mcu9t5v0__filltie
XTAP_TAPCELL_ROW_38_2035 VSS VSS gf180mcu_fd_sc_mcu9t5v0__filltie
X_09984_ _09984_/A1 _09984_/A2 _09985_/C VSS _09984_/VNW VSS VSS gf180mcu_fd_sc_mcu9t5v0__nand2_1
XTAP_TAPCELL_ROW_241_5698 VSS VSS gf180mcu_fd_sc_mcu9t5v0__filltie
XTAP_TAPCELL_ROW_241_5687 VSS VSS gf180mcu_fd_sc_mcu9t5v0__filltie
XTAP_TAPCELL_ROW_10_1253 VSS VSS gf180mcu_fd_sc_mcu9t5v0__filltie
XPHY_EDGE_ROW_239_Right_166 VSS VSS gf180mcu_fd_sc_mcu9t5v0__endcap
XTAP_TAPCELL_ROW_186_2_8173 VSS VSS gf180mcu_fd_sc_mcu9t5v0__filltie
XTAP_TAPCELL_ROW_10_1264 VSS VSS gf180mcu_fd_sc_mcu9t5v0__filltie
Xclkbuf_leaf_31_clk_regs clkload5/I clkload66/I VSS VSS VSS VSS gf180mcu_fd_sc_mcu9t5v0__clkbuf_8
X_09418_ _20055_/Q _20012_/Q _09448_/B VSS _09418_/VNW VSS VSS gf180mcu_fd_sc_mcu9t5v0__nand2_1
X_10690_ _10686_/I _10690_/A2 _10690_/B1 _18852_/Q _10806_/B _10693_/A1 VSS _10690_/VNW
+ VSS VSS gf180mcu_fd_sc_mcu9t5v0__aoi221_1
X_09349_ _18833_/Q _17881_/A1 VSS _17881_/VNW VSS VSS gf180mcu_fd_sc_mcu9t5v0__clkinv_1
XTAP_TAPCELL_ROW_23_1603 VSS VSS gf180mcu_fd_sc_mcu9t5v0__filltie
XTAP_TAPCELL_ROW_23_1614 VSS VSS gf180mcu_fd_sc_mcu9t5v0__filltie
XTAP_TAPCELL_ROW_23_1625 VSS VSS gf180mcu_fd_sc_mcu9t5v0__filltie
XPHY_EDGE_ROW_285_Right_212 VSS VSS gf180mcu_fd_sc_mcu9t5v0__endcap
X_12360_ _18249_/Q _12607_/A2 _12362_/B1 VSS VSS VSS VSS gf180mcu_fd_sc_mcu9t5v0__nor2_1
X_11311_ _11537_/S _11311_/A2 _11311_/A3 _11312_/C VSS _11312_/VNW VSS VSS gf180mcu_fd_sc_mcu9t5v0__nand3_1
X_12291_ _12261_/B _12291_/A2 _12292_/B2 VSS _12593_/VNW VSS VSS gf180mcu_fd_sc_mcu9t5v0__nand2_1
X_11242_ _18868_/Q _11878_/A1 _11320_/B1 _11242_/B2 _11320_/C _11244_/A1 VSS VSS VSS
+ VSS gf180mcu_fd_sc_mcu9t5v0__oai221_1
X_14030_ _19312_/Q _14364_/I0 _14139_/S _19312_/D VSS VSS VSS VSS gf180mcu_fd_sc_mcu9t5v0__mux2_1
X_11173_ _18286_/Q _11524_/S _11175_/A2 VSS VSS VSS VSS gf180mcu_fd_sc_mcu9t5v0__nand2_1
X_10124_ _10124_/I _10125_/C VSS _10124_/VNW VSS VSS gf180mcu_fd_sc_mcu9t5v0__clkinv_1
Xelec_buf_11319 _11319_/ZN _11320_/B2 VSS VSS VSS VSS gf180mcu_fd_sc_mcu9t5v0__clkbuf_1
X_15981_ _15939_/B _17438_/A1 _15973_/B _15981_/ZN VSS VSS VSS VSS gf180mcu_fd_sc_mcu9t5v0__nor3_4
X_17720_ _18736_/Q _17681_/S _17743_/B _18660_/Q _17721_/I VSS VSS VSS VSS gf180mcu_fd_sc_mcu9t5v0__aoi22_1
X_10055_ _19231_/Q _10069_/C _10059_/A3 VSS VSS VSS VSS gf180mcu_fd_sc_mcu9t5v0__nand2_1
X_14932_ _14932_/A1 _14932_/A2 _14932_/A3 _14932_/A4 _14937_/S VSS VSS VSS VSS gf180mcu_fd_sc_mcu9t5v0__nand4_1
X_17651_ _18694_/Q _17653_/I0 _17653_/I1 _17654_/A1 VSS _17652_/VNW VSS VSS gf180mcu_fd_sc_mcu9t5v0__nand3_1
X_14863_ _19589_/Q _19350_/Q _20039_/D _19589_/D VSS VSS VSS VSS gf180mcu_fd_sc_mcu9t5v0__mux2_1
X_16602_ _18349_/Q _16602_/I1 _16602_/S _18349_/D VSS VSS VSS VSS gf180mcu_fd_sc_mcu9t5v0__mux2_4
X_13814_ _19320_/Q _19293_/Q _19319_/Q _19294_/Q _13843_/B1 VSS _13814_/VNW VSS VSS
+ gf180mcu_fd_sc_mcu9t5v0__aoi22_1
X_17582_ _18650_/Q _17582_/I1 _17584_/S _18650_/D VSS VSS VSS VSS gf180mcu_fd_sc_mcu9t5v0__mux2_1
XTAP_TAPCELL_ROW_84_3290 VSS VSS gf180mcu_fd_sc_mcu9t5v0__filltie
X_14794_ _19399_/Q _19336_/Q _14800_/A1 VSS _15223_/VNW VSS VSS gf180mcu_fd_sc_mcu9t5v0__nand2_1
X_19321_ _19321_/D _20025_/RN clkload14/I _19321_/Q VSS VSS VSS VSS gf180mcu_fd_sc_mcu9t5v0__dffrnq_1
X_16533_ _16167_/B _19238_/Q _17057_/S _16533_/Z VSS VSS VSS VSS gf180mcu_fd_sc_mcu9t5v0__mux2_1
X_10957_ _18925_/Q _18924_/Q _18923_/Q _18063_/A1 VSS _10957_/VNW VSS VSS gf180mcu_fd_sc_mcu9t5v0__nor3_1
XTAP_TAPCELL_ROW_80_3187 VSS VSS gf180mcu_fd_sc_mcu9t5v0__filltie
X_13745_ _19448_/Q _14286_/A2 _13745_/B1 _19465_/Q _13745_/C _13746_/A2 VSS _13745_/VNW
+ VSS VSS gf180mcu_fd_sc_mcu9t5v0__aoi221_1
XTAP_TAPCELL_ROW_80_3176 VSS VSS gf180mcu_fd_sc_mcu9t5v0__filltie
X_16464_ _18290_/Q _16463_/Z _16990_/S _18290_/D VSS VSS VSS VSS gf180mcu_fd_sc_mcu9t5v0__mux2_4
X_19252_ _19252_/D _20020_/RN clkload44/I _19252_/Q VSS VSS VSS VSS gf180mcu_fd_sc_mcu9t5v0__dffrnq_2
X_13676_ _13676_/A1 _13675_/B _13677_/I1 VSS VSS VSS VSS gf180mcu_fd_sc_mcu9t5v0__xnor2_1
X_18203_ _18203_/D clkload61/I _18203_/Q VSS VSS VSS VSS gf180mcu_fd_sc_mcu9t5v0__dffq_1
X_10888_ _16432_/A1 _18147_/S _10892_/B _10889_/I0 VSS VSS VSS VSS gf180mcu_fd_sc_mcu9t5v0__oai21_1
XTAP_TAPCELL_ROW_196_3_8211 VSS VSS gf180mcu_fd_sc_mcu9t5v0__filltie
XTAP_TAPCELL_ROW_97_3651 VSS VSS gf180mcu_fd_sc_mcu9t5v0__filltie
X_12627_ _12147_/S _11678_/B _12682_/C VSS _12693_/VNW VSS VSS gf180mcu_fd_sc_mcu9t5v0__nor2_1
X_15415_ _19700_/Q _19800_/Q _15417_/S _19800_/D VSS _15415_/VNW VSS VSS gf180mcu_fd_sc_mcu9t5v0__mux2_1
X_19183_ _19183_/D _20143_/RN clkload11/I _19183_/Q VSS VSS VSS VSS gf180mcu_fd_sc_mcu9t5v0__dffrnq_1
XTAP_TAPCELL_ROW_97_3640 VSS VSS gf180mcu_fd_sc_mcu9t5v0__filltie
X_18134_ _19211_/Q _18954_/Q _18148_/S _18954_/D VSS VSS VSS VSS gf180mcu_fd_sc_mcu9t5v0__mux2_1
X_16395_ _16177_/C _19240_/Q _16927_/S _16395_/Z VSS VSS VSS VSS gf180mcu_fd_sc_mcu9t5v0__mux2_1
XTAP_TAPCELL_ROW_97_3662 VSS VSS gf180mcu_fd_sc_mcu9t5v0__filltie
X_12558_ _18401_/Q _12582_/A2 _12561_/A3 VSS VSS VSS VSS gf180mcu_fd_sc_mcu9t5v0__nor2_1
XTAP_TAPCELL_ROW_264_6344 VSS VSS gf180mcu_fd_sc_mcu9t5v0__filltie
XTAP_TAPCELL_ROW_264_6333 VSS VSS gf180mcu_fd_sc_mcu9t5v0__filltie
XTAP_TAPCELL_ROW_264_6322 VSS VSS gf180mcu_fd_sc_mcu9t5v0__filltie
XTAP_TAPCELL_ROW_93_3548 VSS VSS gf180mcu_fd_sc_mcu9t5v0__filltie
XTAP_TAPCELL_ROW_93_3537 VSS VSS gf180mcu_fd_sc_mcu9t5v0__filltie
X_15346_ _19646_/Q _19623_/Q _15354_/A1 VSS VSS VSS VSS gf180mcu_fd_sc_mcu9t5v0__nand2_1
X_11509_ _18486_/Q _11509_/A2 _11512_/A1 VSS _11512_/VNW VSS VSS gf180mcu_fd_sc_mcu9t5v0__nor2_1
XTAP_TAPCELL_ROW_260_6208 VSS VSS gf180mcu_fd_sc_mcu9t5v0__filltie
X_18065_ _18100_/A1 _18065_/A2 _18065_/B _18926_/D VSS VSS VSS VSS gf180mcu_fd_sc_mcu9t5v0__aoi21_1
X_12489_ _12489_/A1 _12620_/A1 _19157_/D VSS _18024_/VNW VSS VSS gf180mcu_fd_sc_mcu9t5v0__nand2_1
X_15277_ _15277_/A1 _15277_/A2 _15277_/B _15280_/C1 VSS _15277_/VNW VSS VSS gf180mcu_fd_sc_mcu9t5v0__aoi21_1
X_17016_ _18499_/Q _17015_/Z _17026_/S _18499_/D VSS VSS VSS VSS gf180mcu_fd_sc_mcu9t5v0__mux2_1
XTAP_TAPCELL_ROW_260_6219 VSS VSS gf180mcu_fd_sc_mcu9t5v0__filltie
X_14228_ _14229_/A2 _14229_/A3 _14243_/A2 VSS VSS VSS VSS gf180mcu_fd_sc_mcu9t5v0__nand2_1
X_14159_ _19180_/Q _14158_/Z _14715_/S _14159_/Z VSS VSS VSS VSS gf180mcu_fd_sc_mcu9t5v0__mux2_1
X_18967_ _18967_/D _20055_/RN clkload70/I _18967_/Q VSS VSS VSS VSS gf180mcu_fd_sc_mcu9t5v0__dffrnq_1
XTAP_TAPCELL_ROW_192_2_8194 VSS VSS gf180mcu_fd_sc_mcu9t5v0__filltie
XTAP_TAPCELL_ROW_258_6159 VSS VSS gf180mcu_fd_sc_mcu9t5v0__filltie
X_17918_ _17918_/A1 _17918_/A2 _17919_/B2 VSS _17918_/VNW VSS VSS gf180mcu_fd_sc_mcu9t5v0__nor2_1
X_18898_ _18898_/D _20050_/RN clkload36/I _18898_/Q VSS VSS VSS VSS gf180mcu_fd_sc_mcu9t5v0__dffrnq_1
X_17849_ _17864_/A1 _17868_/A2 _18823_/Q _18823_/D VSS VSS VSS VSS gf180mcu_fd_sc_mcu9t5v0__mux2_1
XTAP_TAPCELL_ROW_7_1163 VSS VSS gf180mcu_fd_sc_mcu9t5v0__filltie
XTAP_TAPCELL_ROW_7_1174 VSS VSS gf180mcu_fd_sc_mcu9t5v0__filltie
XTAP_TAPCELL_ROW_7_1185 VSS VSS gf180mcu_fd_sc_mcu9t5v0__filltie
XPHY_EDGE_ROW_150_3_Left_808 VSS VSS gf180mcu_fd_sc_mcu9t5v0__endcap
X_19519_ _19519_/D _20031_/RN _19680_/CLK _19519_/Q VSS VSS VSS VSS gf180mcu_fd_sc_mcu9t5v0__dffrnq_1
X_09203_ _19588_/Q _15179_/A1 VSS VSS VSS VSS gf180mcu_fd_sc_mcu9t5v0__clkinv_1
X_09134_ _19731_/Q _13198_/A1 VSS VSS VSS VSS gf180mcu_fd_sc_mcu9t5v0__clkinv_1
XTAP_TAPCELL_ROW_230_5399 VSS VSS gf180mcu_fd_sc_mcu9t5v0__filltie
XTAP_TAPCELL_ROW_230_5388 VSS VSS gf180mcu_fd_sc_mcu9t5v0__filltie
X_09065_ _09065_/I _17765_/A1 VSS _09065_/VNW VSS VSS gf180mcu_fd_sc_mcu9t5v0__clkinv_1
XTAP_TAPCELL_ROW_247_5874 VSS VSS gf180mcu_fd_sc_mcu9t5v0__filltie
XTAP_TAPCELL_ROW_247_5863 VSS VSS gf180mcu_fd_sc_mcu9t5v0__filltie
XTAP_TAPCELL_ROW_247_5852 VSS VSS gf180mcu_fd_sc_mcu9t5v0__filltie
XTAP_TAPCELL_ROW_243_5749 VSS VSS gf180mcu_fd_sc_mcu9t5v0__filltie
XPHY_EDGE_ROW_308_Right_235 VSS VSS gf180mcu_fd_sc_mcu9t5v0__endcap
X_09967_ _20072_/Q _09967_/A2 _09967_/B1 _09967_/B2 _09968_/I VSS VSS VSS VSS gf180mcu_fd_sc_mcu9t5v0__aoi22_2
X_20087_ _20087_/D clkload75/I _20087_/Q VSS VSS VSS VSS gf180mcu_fd_sc_mcu9t5v0__dffq_1
XTAP_TAPCELL_ROW_12_1304 VSS VSS gf180mcu_fd_sc_mcu9t5v0__filltie
X_09898_ _10659_/C _18963_/Q _10028_/B _19221_/Q _09898_/C _09939_/A2 VSS _10053_/VNW
+ VSS VSS gf180mcu_fd_sc_mcu9t5v0__oai221_1
XTAP_TAPCELL_ROW_12_1315 VSS VSS gf180mcu_fd_sc_mcu9t5v0__filltie
XTAP_TAPCELL_ROW_12_1326 VSS VSS gf180mcu_fd_sc_mcu9t5v0__filltie
XPHY_EDGE_ROW_250_Right_177 VSS VSS gf180mcu_fd_sc_mcu9t5v0__endcap
X_11860_ _12548_/A1 _11860_/A2 _11880_/A2 VSS _18015_/VNW VSS VSS gf180mcu_fd_sc_mcu9t5v0__nor2_1
X_10811_ _20059_/Q _10814_/A2 _10816_/A2 VSS VSS VSS VSS gf180mcu_fd_sc_mcu9t5v0__nand2_1
Xeco10_buf_15970 _15970_/ZN _16197_/C VSS VSS VSS VSS gf180mcu_fd_sc_mcu9t5v0__clkbuf_16
X_11791_ _12628_/A1 _11791_/A2 _11791_/B _11793_/A2 VSS VSS VSS VSS gf180mcu_fd_sc_mcu9t5v0__aoi21_1
X_10742_ _10659_/C _10741_/Z _10809_/B _10743_/B2 VSS VSS VSS VSS gf180mcu_fd_sc_mcu9t5v0__aoi21_1
X_13530_ _13534_/A1 _13534_/A2 _13530_/Z VSS VSS VSS VSS gf180mcu_fd_sc_mcu9t5v0__and2_1
Xeco7_buf_16299 _16299_/ZN _16833_/S VSS VSS VSS VSS gf180mcu_fd_sc_mcu9t5v0__clkbuf_16
XTAP_TAPCELL_ROW_206_3_8244 VSS VSS gf180mcu_fd_sc_mcu9t5v0__filltie
X_10673_ _10803_/C _10673_/A2 _10674_/B1 VSS VSS VSS VSS gf180mcu_fd_sc_mcu9t5v0__nor2_1
X_13461_ _13469_/A1 _13638_/A2 _13461_/Z VSS VSS VSS VSS gf180mcu_fd_sc_mcu9t5v0__or2_1
X_15200_ _15204_/A1 _19567_/Q _15200_/A3 _15201_/I0 VSS VSS VSS VSS gf180mcu_fd_sc_mcu9t5v0__xnor3_1
X_16180_ _18181_/Q _16180_/I1 _16753_/S _18181_/D VSS VSS VSS VSS gf180mcu_fd_sc_mcu9t5v0__mux2_4
X_13392_ _13389_/Z _13392_/A2 _13615_/A2 VSS VSS VSS VSS gf180mcu_fd_sc_mcu9t5v0__nand2_1
X_12412_ _18738_/Q wire198/I _12413_/A2 VSS _12554_/VNW VSS VSS gf180mcu_fd_sc_mcu9t5v0__nand2_1
X_12343_ _18504_/Q _18488_/Q _18440_/Q _18424_/Q _12340_/S _12345_/B _12343_/Z VSS
+ VSS VSS VSS gf180mcu_fd_sc_mcu9t5v0__mux4_1
XTAP_TAPCELL_ROW_131_4585 VSS VSS gf180mcu_fd_sc_mcu9t5v0__filltie
X_15131_ _19673_/Q _19513_/Q wire108/Z _19673_/D VSS VSS VSS VSS gf180mcu_fd_sc_mcu9t5v0__mux2_1
XTAP_TAPCELL_ROW_131_4574 VSS VSS gf180mcu_fd_sc_mcu9t5v0__filltie
X_12274_ _12274_/A1 _12274_/A2 _12275_/B1 VSS _12274_/VNW VSS VSS gf180mcu_fd_sc_mcu9t5v0__nand2_1
XTAP_TAPCELL_ROW_131_4596 VSS VSS gf180mcu_fd_sc_mcu9t5v0__filltie
X_15062_ _19308_/Q _19393_/Q _15066_/A1 VSS VSS VSS VSS gf180mcu_fd_sc_mcu9t5v0__xnor2_1
X_11225_ wire283/Z _11225_/A2 _11225_/B1 _11225_/B2 _12071_/B _11226_/B2 VSS VSS VSS
+ VSS gf180mcu_fd_sc_mcu9t5v0__aoi221_4
X_14013_ _14045_/A1 _14013_/A2 _14012_/B _14013_/Z VSS _14013_/VNW VSS VSS gf180mcu_fd_sc_mcu9t5v0__xor3_1
X_19870_ _19870_/D _20062_/RN clkload51/I _19870_/Q VSS VSS VSS VSS gf180mcu_fd_sc_mcu9t5v0__dffrnq_1
X_11156_ _18285_/Q _11524_/S _11158_/A2 VSS VSS VSS VSS gf180mcu_fd_sc_mcu9t5v0__nand2_1
X_18821_ _18821_/D _20037_/RN clkload34/I _18821_/Q VSS VSS VSS VSS gf180mcu_fd_sc_mcu9t5v0__dffrnq_1
X_10107_ _09896_/Z _10131_/A2 _10107_/B1 _09916_/B _10107_/C _10108_/B2 VSS _10108_/VNW
+ VSS VSS gf180mcu_fd_sc_mcu9t5v0__aoi221_1
X_11087_ _11087_/A1 _11428_/B _11087_/A3 _11092_/B VSS VSS VSS VSS gf180mcu_fd_sc_mcu9t5v0__nand3_1
X_15964_ _20066_/Q _18786_/Q _16619_/S _15964_/Z VSS _15964_/VNW VSS VSS gf180mcu_fd_sc_mcu9t5v0__mux2_4
X_18752_ _18752_/D clkload25/I _18752_/Q VSS VSS VSS VSS gf180mcu_fd_sc_mcu9t5v0__dffq_1
X_17703_ _18664_/Q _17703_/A2 _17681_/S _17704_/C VSS VSS VSS VSS gf180mcu_fd_sc_mcu9t5v0__nor3_1
X_10038_ _10052_/A1 _19880_/Q _10038_/B _10038_/C _10044_/A2 VSS _10193_/VNW VSS VSS
+ gf180mcu_fd_sc_mcu9t5v0__oai211_1
XTAP_TAPCELL_ROW_86_3352 VSS VSS gf180mcu_fd_sc_mcu9t5v0__filltie
X_14915_ _19359_/Q _19419_/Q _14918_/A2 VSS VSS VSS VSS gf180mcu_fd_sc_mcu9t5v0__xnor2_1
XTAP_TAPCELL_ROW_86_3341 VSS VSS gf180mcu_fd_sc_mcu9t5v0__filltie
X_15895_ _20104_/Q _19239_/Q _15927_/S _20104_/D VSS VSS VSS VSS gf180mcu_fd_sc_mcu9t5v0__mux2_1
XTAP_TAPCELL_ROW_253_6023 VSS VSS gf180mcu_fd_sc_mcu9t5v0__filltie
X_18683_ _18683_/D _20023_/RN clkload50/I _18683_/Q VSS VSS VSS VSS gf180mcu_fd_sc_mcu9t5v0__dffrnq_1
XTAP_TAPCELL_ROW_82_3238 VSS VSS gf180mcu_fd_sc_mcu9t5v0__filltie
XTAP_TAPCELL_ROW_82_3227 VSS VSS gf180mcu_fd_sc_mcu9t5v0__filltie
XTAP_TAPCELL_ROW_253_6034 VSS VSS gf180mcu_fd_sc_mcu9t5v0__filltie
XTAP_TAPCELL_ROW_82_3249 VSS VSS gf180mcu_fd_sc_mcu9t5v0__filltie
X_17634_ _18686_/Q _09517_/I _17649_/S _17636_/B VSS _17653_/VNW VSS VSS gf180mcu_fd_sc_mcu9t5v0__nand3_1
X_14846_ _14833_/I _14846_/A2 _14846_/A3 _14846_/A4 _14852_/A1 VSS VSS VSS VSS gf180mcu_fd_sc_mcu9t5v0__nand4_1
X_17565_ input8/Z _18664_/Q _17570_/B VSS VSS VSS VSS gf180mcu_fd_sc_mcu9t5v0__nand2_1
XTAP_TAPCELL_ROW_99_3702 VSS VSS gf180mcu_fd_sc_mcu9t5v0__filltie
X_14777_ _19565_/Q _19331_/Q _20039_/D _19565_/D VSS VSS VSS VSS gf180mcu_fd_sc_mcu9t5v0__mux2_1
X_11989_ _18184_/Q _18168_/Q _12340_/S _11989_/Z VSS _11989_/VNW VSS VSS gf180mcu_fd_sc_mcu9t5v0__mux2_1
X_16516_ _16515_/Z _18314_/Q _17034_/S _18314_/D VSS _16516_/VNW VSS VSS gf180mcu_fd_sc_mcu9t5v0__mux2_1
XTAP_TAPCELL_ROW_99_3713 VSS VSS gf180mcu_fd_sc_mcu9t5v0__filltie
X_13728_ _13728_/A1 _13728_/A2 _14624_/S _13732_/C VSS _13728_/VNW VSS VSS gf180mcu_fd_sc_mcu9t5v0__aoi21_1
X_19304_ _19304_/D _20072_/RN clkload20/I _19304_/Q VSS VSS VSS VSS gf180mcu_fd_sc_mcu9t5v0__dffrnq_1
X_17496_ _18601_/Q _19242_/Q _17511_/S _18601_/D VSS VSS VSS VSS gf180mcu_fd_sc_mcu9t5v0__mux2_1
X_19235_ _19235_/D _20067_/RN clkload37/I _19235_/Q VSS VSS VSS VSS gf180mcu_fd_sc_mcu9t5v0__dffrnq_2
X_16447_ _19229_/Q _16009_/B _16971_/S _16447_/Z VSS VSS VSS VSS gf180mcu_fd_sc_mcu9t5v0__mux2_1
X_13659_ _19292_/Q _14166_/B _13659_/B1 _14143_/B2 _13660_/A2 VSS VSS VSS VSS gf180mcu_fd_sc_mcu9t5v0__aoi22_1
X_16378_ _16377_/Z _18252_/Q _16910_/S _18252_/D VSS VSS VSS VSS gf180mcu_fd_sc_mcu9t5v0__mux2_1
X_19166_ _19166_/D _20062_/RN clkload35/I _19166_/Q VSS VSS VSS VSS gf180mcu_fd_sc_mcu9t5v0__dffrnq_1
X_18117_ _19209_/Q _19203_/Q _18117_/S _18117_/Z VSS _18117_/VNW VSS VSS gf180mcu_fd_sc_mcu9t5v0__mux2_1
X_19097_ _19097_/D _20057_/RN clkload45/I _19097_/Q VSS VSS VSS VSS gf180mcu_fd_sc_mcu9t5v0__dffrnq_1
X_15329_ _19643_/Q _19620_/Q _15332_/A1 VSS VSS VSS VSS gf180mcu_fd_sc_mcu9t5v0__xnor2_1
X_18048_ _18048_/A1 _18075_/A1 _18048_/Z VSS VSS VSS VSS gf180mcu_fd_sc_mcu9t5v0__and2_1
XTAP_TAPCELL_ROW_71_2942 VSS VSS gf180mcu_fd_sc_mcu9t5v0__filltie
XTAP_TAPCELL_ROW_71_2931 VSS VSS gf180mcu_fd_sc_mcu9t5v0__filltie
X_09821_ _20026_/Q _18858_/Q _09820_/Z _17888_/A2 VSS VSS VSS VSS gf180mcu_fd_sc_mcu9t5v0__nand3_1
X_20010_ _20010_/D _20138_/RN clkload47/I _20010_/Q VSS VSS VSS VSS gf180mcu_fd_sc_mcu9t5v0__dffrnq_4
XTAP_TAPCELL_ROW_223_5192 VSS VSS gf180mcu_fd_sc_mcu9t5v0__filltie
X_09752_ _20055_/Q _20071_/Q _09759_/A2 VSS _09752_/VNW VSS VSS gf180mcu_fd_sc_mcu9t5v0__nor2_1
X_19999_ _19999_/D _20063_/RN clkload49/I _19999_/Q VSS VSS VSS VSS gf180mcu_fd_sc_mcu9t5v0__dffrnq_1
XTAP_TAPCELL_ROW_9_1225 VSS VSS gf180mcu_fd_sc_mcu9t5v0__filltie
XTAP_TAPCELL_ROW_9_1236 VSS VSS gf180mcu_fd_sc_mcu9t5v0__filltie
XPHY_EDGE_ROW_160_2_Left_672 VSS VSS gf180mcu_fd_sc_mcu9t5v0__endcap
XPHY_EDGE_ROW_19_Left_343 VSS VSS gf180mcu_fd_sc_mcu9t5v0__endcap
XTAP_TAPCELL_ROW_69_2871 VSS VSS gf180mcu_fd_sc_mcu9t5v0__filltie
X_09683_ _18570_/Q _11075_/A1 _11325_/A1 _18571_/Q _17961_/A4 _18577_/Q _09686_/A2
+ VSS VSS VSS VSS gf180mcu_fd_sc_mcu9t5v0__oai222_1
XTAP_TAPCELL_ROW_187_3_8178 VSS VSS gf180mcu_fd_sc_mcu9t5v0__filltie
XTAP_TAPCELL_ROW_69_2893 VSS VSS gf180mcu_fd_sc_mcu9t5v0__filltie
XTAP_TAPCELL_ROW_69_2882 VSS VSS gf180mcu_fd_sc_mcu9t5v0__filltie
XTAP_TAPCELL_ROW_236_5564 VSS VSS gf180mcu_fd_sc_mcu9t5v0__filltie
XTAP_TAPCELL_ROW_236_5553 VSS VSS gf180mcu_fd_sc_mcu9t5v0__filltie
XTAP_TAPCELL_ROW_65_2757 VSS VSS gf180mcu_fd_sc_mcu9t5v0__filltie
XTAP_TAPCELL_ROW_65_2768 VSS VSS gf180mcu_fd_sc_mcu9t5v0__filltie
XTAP_TAPCELL_ROW_65_2779 VSS VSS gf180mcu_fd_sc_mcu9t5v0__filltie
XTAP_TAPCELL_ROW_232_5439 VSS VSS gf180mcu_fd_sc_mcu9t5v0__filltie
XTAP_TAPCELL_ROW_249_5925 VSS VSS gf180mcu_fd_sc_mcu9t5v0__filltie
XTAP_TAPCELL_ROW_249_5914 VSS VSS gf180mcu_fd_sc_mcu9t5v0__filltie
XPHY_EDGE_ROW_28_Left_352 VSS VSS gf180mcu_fd_sc_mcu9t5v0__endcap
X_09117_ _19752_/Q _12981_/A1 VSS _12958_/VNW VSS VSS gf180mcu_fd_sc_mcu9t5v0__clkinv_1
XTAP_TAPCELL_ROW_320_7871 VSS VSS gf180mcu_fd_sc_mcu9t5v0__filltie
XTAP_TAPCELL_ROW_320_7860 VSS VSS gf180mcu_fd_sc_mcu9t5v0__filltie
XTAP_TAPCELL_ROW_320_7882 VSS VSS gf180mcu_fd_sc_mcu9t5v0__filltie
Xmax_cap190 _17255_/B1 _17282_/B1 VSS _16808_/VNW VSS VSS gf180mcu_fd_sc_mcu9t5v0__clkbuf_8
X_11010_ _18053_/A2 _11012_/A2 _11010_/B _19017_/D VSS VSS VSS VSS gf180mcu_fd_sc_mcu9t5v0__oai21_1
X_20139_ _20139_/D _20139_/RN clkload48/I _20139_/Q VSS VSS VSS VSS gf180mcu_fd_sc_mcu9t5v0__dffrnq_1
XPHY_EDGE_ROW_37_Left_361 VSS VSS gf180mcu_fd_sc_mcu9t5v0__endcap
X_12961_ _12961_/A1 _12960_/B _12961_/Z VSS _12961_/VNW VSS VSS gf180mcu_fd_sc_mcu9t5v0__xor2_1
X_11912_ _18292_/Q _12345_/A2 _11913_/B VSS VSS VSS VSS gf180mcu_fd_sc_mcu9t5v0__or2_1
X_15680_ _15680_/A1 _15686_/B _15682_/A2 VSS _15680_/VNW VSS VSS gf180mcu_fd_sc_mcu9t5v0__nand2_1
X_12892_ _12892_/A1 _12891_/Z _12892_/Z VSS _12892_/VNW VSS VSS gf180mcu_fd_sc_mcu9t5v0__and2_1
X_14700_ _14439_/Z _14702_/A2 _14701_/I1 VSS _14701_/VNW VSS VSS gf180mcu_fd_sc_mcu9t5v0__xnor2_1
XTAP_TAPCELL_ROW_314_7697 VSS VSS gf180mcu_fd_sc_mcu9t5v0__filltie
X_11843_ _12299_/S _11841_/Z _11843_/B _12348_/C _11849_/A1 VSS _11843_/VNW VSS VSS
+ gf180mcu_fd_sc_mcu9t5v0__aoi211_1
XTAP_TAPCELL_ROW_120_4286 VSS VSS gf180mcu_fd_sc_mcu9t5v0__filltie
X_14631_ _19093_/Q _19509_/Q _14730_/S _19509_/D VSS _14631_/VNW VSS VSS gf180mcu_fd_sc_mcu9t5v0__mux2_1
XTAP_TAPCELL_ROW_120_4275 VSS VSS gf180mcu_fd_sc_mcu9t5v0__filltie
X_17350_ _17350_/A1 _17350_/A2 _17350_/B _17411_/C _17351_/A2 VSS VSS VSS VSS gf180mcu_fd_sc_mcu9t5v0__oai211_1
X_11774_ _18190_/Q _12322_/B _12261_/B _11775_/B VSS VSS VSS VSS gf180mcu_fd_sc_mcu9t5v0__aoi21_1
X_16301_ _16301_/A1 _16443_/A2 _16442_/A2 _16336_/A2 VSS VSS VSS VSS gf180mcu_fd_sc_mcu9t5v0__nand3_1
X_14562_ _14751_/B _14562_/A2 _14562_/A3 _14562_/Z VSS _14564_/VNW VSS VSS gf180mcu_fd_sc_mcu9t5v0__and3_1
X_10725_ _19866_/Q _10724_/C _10726_/A2 VSS VSS VSS VSS gf180mcu_fd_sc_mcu9t5v0__nor2_1
X_17281_ _17404_/S _18402_/Q _17283_/A3 VSS VSS VSS VSS gf180mcu_fd_sc_mcu9t5v0__nor2_1
XTAP_TAPCELL_ROW_133_4636 VSS VSS gf180mcu_fd_sc_mcu9t5v0__filltie
X_14493_ _19461_/Q _14766_/A2 _14494_/A2 VSS VSS VSS VSS gf180mcu_fd_sc_mcu9t5v0__nand2_1
X_13513_ wire277/Z _13516_/A2 _13512_/Z _13513_/B _19263_/D VSS VSS VSS VSS gf180mcu_fd_sc_mcu9t5v0__oai31_1
X_10656_ _10809_/B _10656_/A2 _10656_/B1 _10656_/B2 _10656_/ZN VSS VSS VSS VSS gf180mcu_fd_sc_mcu9t5v0__aoi22_4
X_16232_ _16236_/A1 _16545_/A3 _16198_/C _16235_/A1 VSS VSS VSS VSS gf180mcu_fd_sc_mcu9t5v0__nor3_4
XTAP_TAPCELL_ROW_133_4647 VSS VSS gf180mcu_fd_sc_mcu9t5v0__filltie
X_19020_ _19020_/D _20044_/RN clkload44/I _19020_/Q VSS VSS VSS VSS gf180mcu_fd_sc_mcu9t5v0__dffrnq_1
X_13444_ _13444_/I _13465_/A1 VSS VSS VSS VSS gf180mcu_fd_sc_mcu9t5v0__clkinv_1
XPHY_EDGE_ROW_46_Left_370 VSS VSS gf180mcu_fd_sc_mcu9t5v0__endcap
X_16163_ _19237_/Q _16744_/A2 _16751_/A3 _16695_/B _16164_/A2 VSS VSS VSS VSS gf180mcu_fd_sc_mcu9t5v0__oai31_1
XTAP_TAPCELL_ROW_75_3042 VSS VSS gf180mcu_fd_sc_mcu9t5v0__filltie
Xclkload16 clkload16/I clkload16/ZN VSS VSS VSS VSS gf180mcu_fd_sc_mcu9t5v0__inv_2
X_10587_ _10459_/C _10587_/A2 _10587_/A3 _10587_/B _10592_/B1 VSS _10587_/VNW VSS
+ VSS gf180mcu_fd_sc_mcu9t5v0__oai31_1
Xclkload49 clkload49/I clkload49/ZN VSS _15725_/VNW VSS VSS gf180mcu_fd_sc_mcu9t5v0__inv_3
XTAP_TAPCELL_ROW_75_3053 VSS VSS gf180mcu_fd_sc_mcu9t5v0__filltie
Xclkload38 clkload38/I clkload38/ZN VSS _10805_/VNW VSS VSS gf180mcu_fd_sc_mcu9t5v0__inv_4
X_13375_ _13375_/A1 _13375_/A2 _13374_/B _13375_/Z VSS VSS VSS VSS gf180mcu_fd_sc_mcu9t5v0__and3_1
X_15114_ _19656_/Q _19496_/Q wire108/Z _19656_/D VSS VSS VSS VSS gf180mcu_fd_sc_mcu9t5v0__mux2_1
Xclkload27 clkload27/I clkload27/ZN VSS _13316_/VNW VSS VSS gf180mcu_fd_sc_mcu9t5v0__inv_4
X_12326_ _12345_/B _12326_/A2 _12327_/A3 VSS VSS VSS VSS gf180mcu_fd_sc_mcu9t5v0__nand2_1
X_16094_ _16750_/A1 _16674_/A2 _16187_/C _16096_/A3 VSS VSS VSS VSS gf180mcu_fd_sc_mcu9t5v0__aoi21_1
X_19922_ _19922_/D _20050_/RN clkload49/I _19922_/Q VSS VSS VSS VSS gf180mcu_fd_sc_mcu9t5v0__dffrnq_1
XTAP_TAPCELL_ROW_193_3_8199 VSS VSS gf180mcu_fd_sc_mcu9t5v0__filltie
X_15045_ _19638_/Q _15044_/Z _20039_/Q _19638_/D VSS VSS VSS VSS gf180mcu_fd_sc_mcu9t5v0__mux2_1
X_12257_ _18917_/Q _12336_/B _12257_/B _12258_/A2 VSS VSS VSS VSS gf180mcu_fd_sc_mcu9t5v0__aoi21_1
X_11208_ _18288_/Q _11519_/A2 _11483_/B _11210_/A2 VSS VSS VSS VSS gf180mcu_fd_sc_mcu9t5v0__oai21_1
X_19853_ _19853_/D _20045_/RN clkload57/I _19853_/Q VSS VSS VSS VSS gf180mcu_fd_sc_mcu9t5v0__dffrnq_1
X_12188_ wire208/Z _12187_/Z _12188_/B _12189_/A2 VSS VSS VSS VSS gf180mcu_fd_sc_mcu9t5v0__aoi21_2
XTAP_TAPCELL_ROW_88_3414 VSS VSS gf180mcu_fd_sc_mcu9t5v0__filltie
XTAP_TAPCELL_ROW_88_3403 VSS VSS gf180mcu_fd_sc_mcu9t5v0__filltie
X_18804_ _18804_/D _20020_/RN clkload32/I _18804_/Q VSS VSS VSS VSS gf180mcu_fd_sc_mcu9t5v0__dffrnq_1
X_11139_ _18236_/Q _11098_/B _11142_/C VSS VSS VSS VSS gf180mcu_fd_sc_mcu9t5v0__nand2_1
X_16996_ _18489_/Q _16995_/Z _16996_/S _18489_/D VSS VSS VSS VSS gf180mcu_fd_sc_mcu9t5v0__mux2_1
X_19784_ _19784_/D _20040_/RN clkload16/I _19784_/Q VSS VSS VSS VSS gf180mcu_fd_sc_mcu9t5v0__dffrnq_1
X_18735_ _18735_/D clkload65/I _18735_/Q VSS VSS VSS VSS gf180mcu_fd_sc_mcu9t5v0__dffq_1
X_15947_ _20069_/Q _18789_/Q _16619_/S _15947_/Z VSS VSS VSS VSS gf180mcu_fd_sc_mcu9t5v0__mux2_4
XTAP_TAPCELL_ROW_4_1100 VSS VSS gf180mcu_fd_sc_mcu9t5v0__filltie
X_15878_ _20087_/Q _19237_/Q wire79/Z _20087_/D VSS VSS VSS VSS gf180mcu_fd_sc_mcu9t5v0__mux2_1
X_18666_ _18666_/D _20070_/RN clkload50/I _18666_/Q VSS VSS VSS VSS gf180mcu_fd_sc_mcu9t5v0__dffrnq_1
X_17617_ input8/Z _18680_/Q _17617_/S _18680_/D VSS _17617_/VNW VSS VSS gf180mcu_fd_sc_mcu9t5v0__mux2_1
Xrst_tree_leaf_2 rst_tree_mid_0/Z _20145_/RN VSS VSS VSS VSS gf180mcu_fd_sc_mcu9t5v0__clkbuf_16
X_14829_ _14829_/A1 _14828_/Z _14830_/I1 VSS VSS VSS VSS gf180mcu_fd_sc_mcu9t5v0__xnor2_1
X_18597_ _18597_/D clkload78/I _18597_/Q VSS VSS VSS VSS gf180mcu_fd_sc_mcu9t5v0__dffq_1
X_17548_ _17546_/Z _17548_/A2 _17693_/A1 VSS VSS VSS VSS gf180mcu_fd_sc_mcu9t5v0__nand2_1
XTAP_TAPCELL_ROW_60_2621 VSS VSS gf180mcu_fd_sc_mcu9t5v0__filltie
XTAP_TAPCELL_ROW_60_2632 VSS VSS gf180mcu_fd_sc_mcu9t5v0__filltie
XTAP_TAPCELL_ROW_60_2643 VSS VSS gf180mcu_fd_sc_mcu9t5v0__filltie
X_17479_ wire198/I _17479_/A2 _18586_/Q _17480_/A2 VSS _17479_/VNW VSS VSS gf180mcu_fd_sc_mcu9t5v0__aoi21_1
X_19218_ _19218_/D _20050_/RN clkload26/I _19218_/Q VSS VSS VSS VSS gf180mcu_fd_sc_mcu9t5v0__dffrnq_1
X_19149_ _19149_/D _20045_/RN clkload43/I _19149_/Q VSS VSS VSS VSS gf180mcu_fd_sc_mcu9t5v0__dffrnq_1
XTAP_TAPCELL_ROW_41_2097 VSS VSS gf180mcu_fd_sc_mcu9t5v0__filltie
XTAP_TAPCELL_ROW_58_2572 VSS VSS gf180mcu_fd_sc_mcu9t5v0__filltie
XTAP_TAPCELL_ROW_58_2583 VSS VSS gf180mcu_fd_sc_mcu9t5v0__filltie
XTAP_TAPCELL_ROW_54_2458 VSS VSS gf180mcu_fd_sc_mcu9t5v0__filltie
XTAP_TAPCELL_ROW_225_5265 VSS VSS gf180mcu_fd_sc_mcu9t5v0__filltie
XTAP_TAPCELL_ROW_225_5254 VSS VSS gf180mcu_fd_sc_mcu9t5v0__filltie
XTAP_TAPCELL_ROW_54_2469 VSS VSS gf180mcu_fd_sc_mcu9t5v0__filltie
Xfanout247 max_cap20/Z _17073_/S VSS VSS VSS VSS gf180mcu_fd_sc_mcu9t5v0__clkbuf_16
X_09804_ _18836_/Q _18839_/Q _18840_/Q _10688_/B _17912_/A3 VSS _10705_/VNW VSS VSS
+ gf180mcu_fd_sc_mcu9t5v0__oai211_1
Xfanout258 _16115_/ZN _16707_/S VSS VSS VSS VSS gf180mcu_fd_sc_mcu9t5v0__buf_8
XTAP_TAPCELL_ROW_238_5615 VSS VSS gf180mcu_fd_sc_mcu9t5v0__filltie
XTAP_TAPCELL_ROW_238_5604 VSS VSS gf180mcu_fd_sc_mcu9t5v0__filltie
X_09735_ wire300/Z wire301/Z _09735_/B _15682_/B2 VSS VSS VSS VSS gf180mcu_fd_sc_mcu9t5v0__aoi21_1
XTAP_TAPCELL_ROW_67_2819 VSS VSS gf180mcu_fd_sc_mcu9t5v0__filltie
XTAP_TAPCELL_ROW_238_5626 VSS VSS gf180mcu_fd_sc_mcu9t5v0__filltie
X_09666_ _19932_/Q _19926_/Q _19928_/Q _19929_/Q _09667_/A3 VSS _15760_/VNW VSS VSS
+ gf180mcu_fd_sc_mcu9t5v0__nor4_1
Xeco14_skew_13 clkload79/I _18501_/CLK VSS VSS VSS VSS gf180mcu_fd_sc_mcu9t5v0__clkbuf_16
X_09597_ _19911_/Q _19912_/Q _09597_/A3 _09598_/A4 VSS _15671_/VNW VSS VSS gf180mcu_fd_sc_mcu9t5v0__nor3_1
X_10510_ _17260_/S _18339_/Q _10512_/A3 VSS VSS VSS VSS gf180mcu_fd_sc_mcu9t5v0__nor2_1
X_11490_ _11541_/A2 _11490_/A2 _11490_/A3 _11490_/B _19101_/D VSS VSS VSS VSS gf180mcu_fd_sc_mcu9t5v0__oai31_1
X_10441_ _17306_/C _10441_/A2 _10442_/B2 VSS VSS VSS VSS gf180mcu_fd_sc_mcu9t5v0__nor2_1
XTAP_TAPCELL_ROW_210_4833 VSS VSS gf180mcu_fd_sc_mcu9t5v0__filltie
XTAP_TAPCELL_ROW_322_7922 VSS VSS gf180mcu_fd_sc_mcu9t5v0__filltie
XTAP_TAPCELL_ROW_210_4855 VSS VSS gf180mcu_fd_sc_mcu9t5v0__filltie
XTAP_TAPCELL_ROW_210_4844 VSS VSS gf180mcu_fd_sc_mcu9t5v0__filltie
XTAP_TAPCELL_ROW_322_7933 VSS VSS gf180mcu_fd_sc_mcu9t5v0__filltie
X_10372_ _18222_/Q _17380_/A2 _17380_/B1 _18238_/Q _10373_/B VSS VSS VSS VSS gf180mcu_fd_sc_mcu9t5v0__aoi22_1
XTAP_TAPCELL_ROW_113_4090 VSS VSS gf180mcu_fd_sc_mcu9t5v0__filltie
X_13160_ _13160_/A1 _13158_/I _13161_/A3 VSS _13166_/VNW VSS VSS gf180mcu_fd_sc_mcu9t5v0__nand2_1
X_12111_ _18461_/Q _12203_/A2 _12159_/B _12112_/B2 VSS VSS VSS VSS gf180mcu_fd_sc_mcu9t5v0__aoi21_1
X_13091_ _13094_/A1 _13094_/A2 _13096_/A1 VSS _13091_/VNW VSS VSS gf180mcu_fd_sc_mcu9t5v0__nand2_1
XTAP_TAPCELL_ROW_299_7291 VSS VSS gf180mcu_fd_sc_mcu9t5v0__filltie
XTAP_TAPCELL_ROW_303_7398 VSS VSS gf180mcu_fd_sc_mcu9t5v0__filltie
XTAP_TAPCELL_ROW_299_7280 VSS VSS gf180mcu_fd_sc_mcu9t5v0__filltie
X_12042_ _18410_/Q _12046_/S _12090_/B _12045_/A2 VSS _17034_/VNW VSS VSS gf180mcu_fd_sc_mcu9t5v0__aoi21_1
XTAP_TAPCELL_ROW_126_4451 VSS VSS gf180mcu_fd_sc_mcu9t5v0__filltie
XTAP_TAPCELL_ROW_126_4440 VSS VSS gf180mcu_fd_sc_mcu9t5v0__filltie
XTAP_TAPCELL_ROW_37_1988 VSS VSS gf180mcu_fd_sc_mcu9t5v0__filltie
XTAP_TAPCELL_ROW_37_1999 VSS VSS gf180mcu_fd_sc_mcu9t5v0__filltie
X_16850_ _18417_/Q _16849_/Z _16850_/S _18417_/D VSS VSS VSS VSS gf180mcu_fd_sc_mcu9t5v0__mux2_4
XTAP_TAPCELL_ROW_295_7188 VSS VSS gf180mcu_fd_sc_mcu9t5v0__filltie
XTAP_TAPCELL_ROW_295_7177 VSS VSS gf180mcu_fd_sc_mcu9t5v0__filltie
XTAP_TAPCELL_ROW_316_7748 VSS VSS gf180mcu_fd_sc_mcu9t5v0__filltie
X_16781_ _16660_/B _19289_/Q _16785_/S _16781_/Z VSS _16957_/VNW VSS VSS gf180mcu_fd_sc_mcu9t5v0__mux2_1
XTAP_TAPCELL_ROW_122_4348 VSS VSS gf180mcu_fd_sc_mcu9t5v0__filltie
XTAP_TAPCELL_ROW_122_4337 VSS VSS gf180mcu_fd_sc_mcu9t5v0__filltie
X_15801_ _18036_/I0 _19971_/Q _15802_/S _19971_/D VSS _15801_/VNW VSS VSS gf180mcu_fd_sc_mcu9t5v0__mux2_1
XTAP_TAPCELL_ROW_122_4326 VSS VSS gf180mcu_fd_sc_mcu9t5v0__filltie
X_13993_ _19316_/Q _19317_/Q _19301_/Q _13994_/B VSS _13993_/VNW VSS VSS gf180mcu_fd_sc_mcu9t5v0__oai21_1
XTAP_TAPCELL_ROW_316_7759 VSS VSS gf180mcu_fd_sc_mcu9t5v0__filltie
X_18520_ _18520_/D clkload78/I _18520_/Q VSS VSS VSS VSS gf180mcu_fd_sc_mcu9t5v0__dffq_1
X_15732_ _15761_/A1 _15685_/I _15757_/B VSS VSS VSS VSS gf180mcu_fd_sc_mcu9t5v0__nor2_1
X_12944_ _12944_/A1 _12944_/A2 _12944_/B _12947_/A2 VSS VSS VSS VSS gf180mcu_fd_sc_mcu9t5v0__oai21_1
X_18451_ _18451_/D clkload67/I _18451_/Q VSS VSS VSS VSS gf180mcu_fd_sc_mcu9t5v0__dffq_1
X_17402_ _09261_/I _17402_/A2 _17402_/A3 _17402_/B _17403_/A2 VSS VSS VSS VSS gf180mcu_fd_sc_mcu9t5v0__oai31_1
X_15663_ _19906_/Q _15663_/A2 _19907_/Q _15664_/A3 VSS VSS VSS VSS gf180mcu_fd_sc_mcu9t5v0__oai21_1
X_12875_ _12889_/C _12879_/A2 _12889_/A2 VSS VSS VSS VSS gf180mcu_fd_sc_mcu9t5v0__nor2_1
X_11826_ _18272_/Q _12203_/A2 _12324_/B _11827_/B2 VSS _11827_/VNW VSS VSS gf180mcu_fd_sc_mcu9t5v0__aoi21_1
X_18382_ _18382_/D clkload62/I _18382_/Q VSS VSS VSS VSS gf180mcu_fd_sc_mcu9t5v0__dffq_1
XTAP_TAPCELL_ROW_135_4709 VSS VSS gf180mcu_fd_sc_mcu9t5v0__filltie
X_15594_ _18027_/I0 _15596_/A2 _15595_/B2 VSS VSS VSS VSS gf180mcu_fd_sc_mcu9t5v0__nor2_1
X_14614_ _19075_/Q _19492_/Q _14730_/S _19492_/D VSS _15110_/VNW VSS VSS gf180mcu_fd_sc_mcu9t5v0__mux2_1
X_17333_ _17378_/A1 _18453_/Q _17336_/A2 VSS VSS VSS VSS gf180mcu_fd_sc_mcu9t5v0__nor2_1
X_11757_ _18301_/Q _12203_/A2 _11758_/A3 VSS VSS VSS VSS gf180mcu_fd_sc_mcu9t5v0__nand2_1
X_14545_ _19134_/Q _14545_/I1 wire199/Z _14545_/Z VSS _14545_/VNW VSS VSS gf180mcu_fd_sc_mcu9t5v0__mux2_1
X_17264_ _17326_/A1 _17264_/A2 _17264_/A3 _17266_/A2 VSS VSS VSS VSS gf180mcu_fd_sc_mcu9t5v0__nand3_1
XTAP_TAPCELL_ROW_77_3104 VSS VSS gf180mcu_fd_sc_mcu9t5v0__filltie
X_10708_ _10708_/A1 _10706_/Z _10713_/I0 VSS VSS VSS VSS gf180mcu_fd_sc_mcu9t5v0__xnor2_1
X_16215_ _16214_/Z _18192_/Q _16784_/S _18192_/D VSS VSS VSS VSS gf180mcu_fd_sc_mcu9t5v0__mux2_1
X_11688_ _16409_/A1 _11688_/I1 _12046_/S _11688_/Z VSS _11688_/VNW VSS VSS gf180mcu_fd_sc_mcu9t5v0__mux2_1
X_19003_ _19003_/D _19963_/RN clkload38/I _19003_/Q VSS VSS VSS VSS gf180mcu_fd_sc_mcu9t5v0__dffrnq_1
X_14476_ _19126_/Q _14475_/B _14546_/S _14476_/C _14478_/A1 VSS VSS VSS VSS gf180mcu_fd_sc_mcu9t5v0__oai211_1
XTAP_TAPCELL_ROW_284_6892 VSS VSS gf180mcu_fd_sc_mcu9t5v0__filltie
XTAP_TAPCELL_ROW_284_6881 VSS VSS gf180mcu_fd_sc_mcu9t5v0__filltie
X_17195_ _17195_/A1 _18510_/Q _17198_/A2 VSS VSS VSS VSS gf180mcu_fd_sc_mcu9t5v0__nor2_1
XTAP_TAPCELL_ROW_284_6870 VSS VSS gf180mcu_fd_sc_mcu9t5v0__filltie
X_10639_ _17358_/A1 _18328_/Q _10642_/A2 VSS VSS VSS VSS gf180mcu_fd_sc_mcu9t5v0__nor2_1
X_13427_ _19745_/Q _13427_/A2 _13448_/A1 VSS _13453_/VNW VSS VSS gf180mcu_fd_sc_mcu9t5v0__nand2_1
X_16146_ _19234_/Q _16725_/C _16149_/A2 VSS VSS VSS VSS gf180mcu_fd_sc_mcu9t5v0__nor2_1
X_13358_ _13360_/A1 _19773_/Q _13377_/B VSS _13359_/VNW VSS VSS gf180mcu_fd_sc_mcu9t5v0__nand2_1
XTAP_TAPCELL_ROW_280_6778 VSS VSS gf180mcu_fd_sc_mcu9t5v0__filltie
X_16077_ _19271_/Q _16675_/A1 _16078_/B VSS VSS VSS VSS gf180mcu_fd_sc_mcu9t5v0__nand2_1
XTAP_TAPCELL_ROW_280_6767 VSS VSS gf180mcu_fd_sc_mcu9t5v0__filltie
X_12309_ _12336_/B _12336_/A3 _12310_/A2 VSS VSS VSS VSS gf180mcu_fd_sc_mcu9t5v0__nand2_1
X_19905_ _19905_/D _20033_/RN clkload41/I _19905_/Q VSS VSS VSS VSS gf180mcu_fd_sc_mcu9t5v0__dffrnq_1
X_15028_ _19630_/Q _19381_/Q _20039_/Q _19630_/D VSS VSS VSS VSS gf180mcu_fd_sc_mcu9t5v0__mux2_1
X_13289_ _19770_/Q _19804_/Q _13290_/B VSS VSS VSS VSS gf180mcu_fd_sc_mcu9t5v0__xor2_1
XPHY_EDGE_ROW_166_1_Left_489 VSS VSS gf180mcu_fd_sc_mcu9t5v0__endcap
XPHY_EDGE_ROW_18_Right_18 VSS VSS gf180mcu_fd_sc_mcu9t5v0__endcap
X_19836_ _19836_/D _20028_/RN clkload56/I _19836_/Q VSS VSS VSS VSS gf180mcu_fd_sc_mcu9t5v0__dffrnq_1
XTAP_TAPCELL_ROW_109_3992 VSS VSS gf180mcu_fd_sc_mcu9t5v0__filltie
XTAP_TAPCELL_ROW_109_3981 VSS VSS gf180mcu_fd_sc_mcu9t5v0__filltie
X_19767_ _19767_/D _20023_/RN clkload23/I _19767_/Q VSS VSS VSS VSS gf180mcu_fd_sc_mcu9t5v0__dffrnq_1
XTAP_TAPCELL_ROW_109_3970 VSS VSS gf180mcu_fd_sc_mcu9t5v0__filltie
X_16979_ _19252_/Q _16628_/B _16991_/S _16979_/Z VSS VSS VSS VSS gf180mcu_fd_sc_mcu9t5v0__mux2_1
X_18718_ _18718_/D clkload65/I _18718_/Q VSS VSS VSS VSS gf180mcu_fd_sc_mcu9t5v0__dffq_1
Xinput3 din[2] input3/Z VSS VSS VSS VSS gf180mcu_fd_sc_mcu9t5v0__clkbuf_2
X_09520_ _20054_/Q _09399_/Z _09859_/A2 VSS VSS VSS VSS gf180mcu_fd_sc_mcu9t5v0__nand2_1
XTAP_TAPCELL_ROW_105_3878 VSS VSS gf180mcu_fd_sc_mcu9t5v0__filltie
XTAP_TAPCELL_ROW_105_3867 VSS VSS gf180mcu_fd_sc_mcu9t5v0__filltie
X_19698_ _19698_/D _20018_/RN _19798_/CLK _19698_/Q VSS VSS VSS VSS gf180mcu_fd_sc_mcu9t5v0__dffrnq_1
X_18649_ _18649_/D _20053_/RN clkload53/I _18649_/Q VSS VSS VSS VSS gf180mcu_fd_sc_mcu9t5v0__dffrnq_1
X_09451_ _10843_/A2 _09454_/A4 _09451_/Z VSS _09451_/VNW VSS VSS gf180mcu_fd_sc_mcu9t5v0__and2_1
XTAP_TAPCELL_ROW_0_959 VSS VSS gf180mcu_fd_sc_mcu9t5v0__filltie
XTAP_TAPCELL_ROW_0_948 VSS VSS gf180mcu_fd_sc_mcu9t5v0__filltie
XTAP_TAPCELL_ROW_47_2262 VSS VSS gf180mcu_fd_sc_mcu9t5v0__filltie
X_09382_ _18911_/Q _12126_/A1 VSS _12126_/VNW VSS VSS gf180mcu_fd_sc_mcu9t5v0__clkinv_1
XTAP_TAPCELL_ROW_47_2273 VSS VSS gf180mcu_fd_sc_mcu9t5v0__filltie
XPHY_EDGE_ROW_27_Right_27 VSS VSS gf180mcu_fd_sc_mcu9t5v0__endcap
XTAP_TAPCELL_ROW_47_2284 VSS VSS gf180mcu_fd_sc_mcu9t5v0__filltie
XTAP_TAPCELL_ROW_43_2159 VSS VSS gf180mcu_fd_sc_mcu9t5v0__filltie
XTAP_TAPCELL_ROW_195_3_8207 VSS VSS gf180mcu_fd_sc_mcu9t5v0__filltie
XTAP_TAPCELL_ROW_56_2509 VSS VSS gf180mcu_fd_sc_mcu9t5v0__filltie
XTAP_TAPCELL_ROW_227_5316 VSS VSS gf180mcu_fd_sc_mcu9t5v0__filltie
XTAP_TAPCELL_ROW_227_5305 VSS VSS gf180mcu_fd_sc_mcu9t5v0__filltie
Xclkbuf_leaf_56_clk_regs clkload2/I clkload43/I VSS _13539_/VNW VSS VSS gf180mcu_fd_sc_mcu9t5v0__clkbuf_8
XTAP_TAPCELL_ROW_200_3_8225 VSS VSS gf180mcu_fd_sc_mcu9t5v0__filltie
XPHY_EDGE_ROW_36_Right_36 VSS VSS gf180mcu_fd_sc_mcu9t5v0__endcap
XTAP_TAPCELL_ROW_32_1852 VSS VSS gf180mcu_fd_sc_mcu9t5v0__filltie
XTAP_TAPCELL_ROW_290_7052 VSS VSS gf180mcu_fd_sc_mcu9t5v0__filltie
XTAP_TAPCELL_ROW_290_7041 VSS VSS gf180mcu_fd_sc_mcu9t5v0__filltie
X_09718_ _17231_/A3 _10836_/B2 _10814_/A2 VSS _10702_/VNW VSS VSS gf180mcu_fd_sc_mcu9t5v0__nor2_1
XTAP_TAPCELL_ROW_32_1863 VSS VSS gf180mcu_fd_sc_mcu9t5v0__filltie
XTAP_TAPCELL_ROW_32_1874 VSS VSS gf180mcu_fd_sc_mcu9t5v0__filltie
XTAP_TAPCELL_ROW_311_7612 VSS VSS gf180mcu_fd_sc_mcu9t5v0__filltie
X_10990_ _18053_/A1 _10950_/Z _10987_/I _10990_/Z VSS VSS VSS VSS gf180mcu_fd_sc_mcu9t5v0__xor3_1
XTAP_TAPCELL_ROW_311_7634 VSS VSS gf180mcu_fd_sc_mcu9t5v0__filltie
XTAP_TAPCELL_ROW_311_7623 VSS VSS gf180mcu_fd_sc_mcu9t5v0__filltie
X_09649_ _19921_/Q _19919_/Q _19920_/Q _09650_/I VSS VSS VSS VSS gf180mcu_fd_sc_mcu9t5v0__nor3_1
XPHY_EDGE_ROW_45_Right_45 VSS VSS gf180mcu_fd_sc_mcu9t5v0__endcap
X_12660_ _11656_/B _12675_/B _12660_/B _12662_/A2 VSS VSS VSS VSS gf180mcu_fd_sc_mcu9t5v0__oai21_1
X_11611_ _18849_/Q _17907_/A2 _11611_/B _11612_/A3 VSS VSS VSS VSS gf180mcu_fd_sc_mcu9t5v0__oai21_1
X_12591_ _18453_/Q _12607_/A2 _12593_/B1 VSS VSS VSS VSS gf180mcu_fd_sc_mcu9t5v0__nor2_1
XTAP_TAPCELL_ROW_212_4906 VSS VSS gf180mcu_fd_sc_mcu9t5v0__filltie
X_14330_ _13867_/Z _19402_/Q _14337_/S _19402_/D VSS _15227_/VNW VSS VSS gf180mcu_fd_sc_mcu9t5v0__mux2_1
XTAP_TAPCELL_ROW_309_7563 VSS VSS gf180mcu_fd_sc_mcu9t5v0__filltie
X_11542_ _11542_/A1 _11542_/A2 _19105_/D VSS _11542_/VNW VSS VSS gf180mcu_fd_sc_mcu9t5v0__nand2_1
XTAP_TAPCELL_ROW_115_4152 VSS VSS gf180mcu_fd_sc_mcu9t5v0__filltie
XTAP_TAPCELL_ROW_115_4141 VSS VSS gf180mcu_fd_sc_mcu9t5v0__filltie
XTAP_TAPCELL_ROW_26_1689 VSS VSS gf180mcu_fd_sc_mcu9t5v0__filltie
XTAP_TAPCELL_ROW_309_7574 VSS VSS gf180mcu_fd_sc_mcu9t5v0__filltie
X_11473_ _18371_/Q wire136/Z wire283/Z _11474_/B2 VSS VSS VSS VSS gf180mcu_fd_sc_mcu9t5v0__aoi21_1
XTAP_TAPCELL_ROW_111_4038 VSS VSS gf180mcu_fd_sc_mcu9t5v0__filltie
Xclkbuf_3_3_0_clk_regs clkbuf_0_clk_regs/Z clkload2/I VSS VSS VSS VSS gf180mcu_fd_sc_mcu9t5v0__clkbuf_8
XTAP_TAPCELL_ROW_111_4027 VSS VSS gf180mcu_fd_sc_mcu9t5v0__filltie
X_14261_ _14190_/I _14251_/Z _14261_/B _14264_/A1 VSS _14261_/VNW VSS VSS gf180mcu_fd_sc_mcu9t5v0__aoi21_1
XTAP_TAPCELL_ROW_305_7449 VSS VSS gf180mcu_fd_sc_mcu9t5v0__filltie
X_10424_ _18672_/Q _10821_/B _17411_/C _10649_/A2 VSS VSS VSS VSS gf180mcu_fd_sc_mcu9t5v0__aoi21_2
X_16000_ _19228_/Q _16750_/A1 _16628_/A2 _16004_/C VSS _16203_/VNW VSS VSS gf180mcu_fd_sc_mcu9t5v0__and3_1
X_13212_ _13215_/A1 _19764_/Q _13224_/B VSS VSS VSS VSS gf180mcu_fd_sc_mcu9t5v0__nand2_1
X_14192_ _14192_/A1 _14192_/A2 _14192_/B _14201_/A1 VSS VSS VSS VSS gf180mcu_fd_sc_mcu9t5v0__oai21_1
XTAP_TAPCELL_ROW_128_4502 VSS VSS gf180mcu_fd_sc_mcu9t5v0__filltie
X_13143_ _13144_/A1 _19760_/Q _13162_/B VSS _13162_/VNW VSS VSS gf180mcu_fd_sc_mcu9t5v0__nand2_1
XPHY_EDGE_ROW_54_Right_54 VSS VSS gf180mcu_fd_sc_mcu9t5v0__endcap
XTAP_TAPCELL_ROW_297_7239 VSS VSS gf180mcu_fd_sc_mcu9t5v0__filltie
X_10355_ _17326_/A1 _10355_/A2 _10356_/C VSS VSS VSS VSS gf180mcu_fd_sc_mcu9t5v0__nand2_1
XTAP_TAPCELL_ROW_297_7228 VSS VSS gf180mcu_fd_sc_mcu9t5v0__filltie
XTAP_TAPCELL_ROW_128_4513 VSS VSS gf180mcu_fd_sc_mcu9t5v0__filltie
X_10286_ _10286_/A1 _10286_/A2 _10286_/B1 _10286_/B2 _10286_/ZN VSS VSS VSS VSS gf180mcu_fd_sc_mcu9t5v0__aoi22_4
X_13074_ _13075_/A1 _13073_/B _13080_/A2 VSS _13075_/VNW VSS VSS gf180mcu_fd_sc_mcu9t5v0__xnor2_1
X_17951_ _18854_/Q _17969_/A2 _17951_/Z VSS _17952_/VNW VSS VSS gf180mcu_fd_sc_mcu9t5v0__and2_1
X_16902_ _16901_/Z _18443_/Q _16928_/S _18443_/D VSS VSS VSS VSS gf180mcu_fd_sc_mcu9t5v0__mux2_1
X_12025_ _12025_/A1 _12025_/A2 _12025_/B1 _12025_/B2 _12116_/C _12026_/A3 VSS VSS
+ VSS VSS gf180mcu_fd_sc_mcu9t5v0__aoi221_1
X_17882_ _18682_/Q _18684_/Q _18060_/B _17884_/A1 VSS _17883_/VNW VSS VSS gf180mcu_fd_sc_mcu9t5v0__oai21_1
X_16833_ _19244_/Q _17059_/I1 _16833_/S _16833_/Z VSS VSS VSS VSS gf180mcu_fd_sc_mcu9t5v0__mux2_1
X_19621_ _19621_/D _20069_/RN clkload9/I _19621_/Q VSS VSS VSS VSS gf180mcu_fd_sc_mcu9t5v0__dffrnq_1
XTAP_TAPCELL_ROW_188_3_8183 VSS VSS gf180mcu_fd_sc_mcu9t5v0__filltie
X_16764_ _16763_/Z _18381_/Q _16764_/S _18381_/D VSS VSS VSS VSS gf180mcu_fd_sc_mcu9t5v0__mux2_1
XTAP_TAPCELL_ROW_273_6571 VSS VSS gf180mcu_fd_sc_mcu9t5v0__filltie
X_13976_ _13966_/Z _13976_/A2 _13976_/A3 _13978_/A2 VSS _13999_/VNW VSS VSS gf180mcu_fd_sc_mcu9t5v0__xnor3_1
X_19552_ _19552_/D _20064_/RN clkload31/I _19552_/Q VSS VSS VSS VSS gf180mcu_fd_sc_mcu9t5v0__dffrnq_1
XPHY_EDGE_ROW_63_Right_63 VSS VSS gf180mcu_fd_sc_mcu9t5v0__endcap
XPHY_EDGE_ROW_299_Right_226 VSS VSS gf180mcu_fd_sc_mcu9t5v0__endcap
X_18503_ _18503_/D clkload79/I _18503_/Q VSS VSS VSS VSS gf180mcu_fd_sc_mcu9t5v0__dffq_1
XTAP_TAPCELL_ROW_273_6582 VSS VSS gf180mcu_fd_sc_mcu9t5v0__filltie
X_16695_ _16695_/A1 _16700_/A2 _16714_/A3 _16695_/B _16696_/B VSS VSS VSS VSS gf180mcu_fd_sc_mcu9t5v0__oai31_1
X_15715_ _19920_/Q _15726_/S _15708_/Z _15718_/A2 VSS VSS VSS VSS gf180mcu_fd_sc_mcu9t5v0__nor3_1
X_12927_ _12927_/I0 _19223_/Q _13419_/B _19223_/D VSS _13418_/VNW VSS VSS gf180mcu_fd_sc_mcu9t5v0__mux2_1
X_19483_ _19483_/D _20059_/RN clkload12/I _19483_/Q VSS VSS VSS VSS gf180mcu_fd_sc_mcu9t5v0__dffrnq_1
X_18434_ _18434_/D _20132_/CLK _18434_/Q VSS VSS VSS VSS gf180mcu_fd_sc_mcu9t5v0__dffq_1
XTAP_TAPCELL_ROW_100_3742 VSS VSS gf180mcu_fd_sc_mcu9t5v0__filltie
X_15646_ _15672_/B _15646_/A2 _19900_/D VSS _15646_/VNW VSS VSS gf180mcu_fd_sc_mcu9t5v0__nor2_1
XTAP_TAPCELL_ROW_100_3731 VSS VSS gf180mcu_fd_sc_mcu9t5v0__filltie
X_12858_ _12861_/A1 _12861_/A2 _12860_/A2 VSS _12858_/VNW VSS VSS gf180mcu_fd_sc_mcu9t5v0__xnor2_1
XTAP_TAPCELL_ROW_100_3720 VSS VSS gf180mcu_fd_sc_mcu9t5v0__filltie
X_18365_ _18365_/D _18366_/CLK _18365_/Q VSS VSS VSS VSS gf180mcu_fd_sc_mcu9t5v0__dffq_4
X_11809_ _12164_/B _11808_/B _11809_/A3 _11811_/B1 VSS VSS VSS VSS gf180mcu_fd_sc_mcu9t5v0__nand3_1
X_17316_ _17378_/A1 _18452_/Q _17319_/A2 VSS VSS VSS VSS gf180mcu_fd_sc_mcu9t5v0__nor2_1
XTAP_TAPCELL_ROW_286_6943 VSS VSS gf180mcu_fd_sc_mcu9t5v0__filltie
XTAP_TAPCELL_ROW_286_6932 VSS VSS gf180mcu_fd_sc_mcu9t5v0__filltie
X_15577_ _15581_/B _15576_/Z _15596_/A2 VSS VSS VSS VSS gf180mcu_fd_sc_mcu9t5v0__nor2_1
X_12789_ _19757_/Q _12787_/Z _12790_/B VSS VSS VSS VSS gf180mcu_fd_sc_mcu9t5v0__xnor2_1
X_18296_ _18296_/D clkload81/I _18296_/Q VSS VSS VSS VSS gf180mcu_fd_sc_mcu9t5v0__dffq_1
X_14528_ _19465_/Q _14527_/Z _14704_/S _19465_/D VSS _14546_/VNW VSS VSS gf180mcu_fd_sc_mcu9t5v0__mux2_1
X_17247_ _17247_/A1 _17247_/A2 _17247_/B _17411_/C _17248_/A2 VSS VSS VSS VSS gf180mcu_fd_sc_mcu9t5v0__oai211_1
XTAP_TAPCELL_ROW_282_6829 VSS VSS gf180mcu_fd_sc_mcu9t5v0__filltie
XTAP_TAPCELL_ROW_282_6818 VSS VSS gf180mcu_fd_sc_mcu9t5v0__filltie
X_14459_ _19124_/Q _14458_/Z _14475_/B _14459_/Z VSS VSS VSS VSS gf180mcu_fd_sc_mcu9t5v0__mux2_1
X_17178_ _20127_/Q _17326_/A1 wire168/I _17180_/A2 VSS _17178_/VNW VSS VSS gf180mcu_fd_sc_mcu9t5v0__oai21_1
XPHY_EDGE_ROW_72_Right_72 VSS VSS gf180mcu_fd_sc_mcu9t5v0__endcap
X_16129_ _19262_/Q _16695_/B _16130_/A3 VSS VSS VSS VSS gf180mcu_fd_sc_mcu9t5v0__nor2_1
Xrst_tree_leaf_40 rst_tree_mid_5/Z _20043_/RN VSS VSS VSS VSS gf180mcu_fd_sc_mcu9t5v0__clkbuf_16
Xrst_tree_leaf_62 rst_tree_mid_7/Z _20021_/RN VSS VSS VSS VSS gf180mcu_fd_sc_mcu9t5v0__clkbuf_16
Xrst_tree_leaf_51 rst_tree_mid_6/Z _09246_/I VSS VSS VSS VSS gf180mcu_fd_sc_mcu9t5v0__clkbuf_16
X_19819_ _19819_/D _20139_/RN clkload58/I _19819_/Q VSS VSS VSS VSS gf180mcu_fd_sc_mcu9t5v0__dffrnq_1
XTAP_TAPCELL_ROW_107_3929 VSS VSS gf180mcu_fd_sc_mcu9t5v0__filltie
XTAP_TAPCELL_ROW_107_3918 VSS VSS gf180mcu_fd_sc_mcu9t5v0__filltie
XPHY_EDGE_ROW_81_Right_81 VSS VSS gf180mcu_fd_sc_mcu9t5v0__endcap
XTAP_TAPCELL_ROW_49_2324 VSS VSS gf180mcu_fd_sc_mcu9t5v0__filltie
XTAP_TAPCELL_ROW_49_2335 VSS VSS gf180mcu_fd_sc_mcu9t5v0__filltie
XTAP_TAPCELL_ROW_216_5006 VSS VSS gf180mcu_fd_sc_mcu9t5v0__filltie
X_09503_ _19106_/Q _14730_/S _09511_/B _17961_/A2 VSS _09503_/VNW VSS VSS gf180mcu_fd_sc_mcu9t5v0__aoi21_4
XTAP_TAPCELL_ROW_216_5017 VSS VSS gf180mcu_fd_sc_mcu9t5v0__filltie
XTAP_TAPCELL_ROW_142_1_4741 VSS VSS gf180mcu_fd_sc_mcu9t5v0__filltie
X_09434_ _09889_/A2 _20055_/Q _11013_/A1 _09435_/B VSS _09434_/VNW VSS VSS gf180mcu_fd_sc_mcu9t5v0__nor3_4
XTAP_TAPCELL_ROW_252_5998 VSS VSS gf180mcu_fd_sc_mcu9t5v0__filltie
X_09365_ _18321_/Q _11847_/A1 VSS VSS VSS VSS gf180mcu_fd_sc_mcu9t5v0__clkinv_1
XTAP_TAPCELL_ROW_252_5987 VSS VSS gf180mcu_fd_sc_mcu9t5v0__filltie
X_09296_ _19222_/Q _16639_/A1 VSS _10853_/VNW VSS VSS gf180mcu_fd_sc_mcu9t5v0__clkinv_1
XPHY_EDGE_ROW_90_Right_90 VSS VSS gf180mcu_fd_sc_mcu9t5v0__endcap
XTAP_TAPCELL_ROW_21_1553 VSS VSS gf180mcu_fd_sc_mcu9t5v0__filltie
XTAP_TAPCELL_ROW_21_1564 VSS VSS gf180mcu_fd_sc_mcu9t5v0__filltie
XTAP_TAPCELL_ROW_300_7324 VSS VSS gf180mcu_fd_sc_mcu9t5v0__filltie
XTAP_TAPCELL_ROW_300_7313 VSS VSS gf180mcu_fd_sc_mcu9t5v0__filltie
X_10140_ _09916_/B _10140_/A2 _10159_/A1 VSS _10140_/VNW VSS VSS gf180mcu_fd_sc_mcu9t5v0__nand2_1
XTAP_TAPCELL_ROW_292_7114 VSS VSS gf180mcu_fd_sc_mcu9t5v0__filltie
XTAP_TAPCELL_ROW_292_7103 VSS VSS gf180mcu_fd_sc_mcu9t5v0__filltie
X_10071_ _10071_/A1 _10071_/A2 _10071_/A3 _10072_/C VSS VSS VSS VSS gf180mcu_fd_sc_mcu9t5v0__nand3_1
XTAP_TAPCELL_ROW_34_1914 VSS VSS gf180mcu_fd_sc_mcu9t5v0__filltie
XTAP_TAPCELL_ROW_34_1925 VSS VSS gf180mcu_fd_sc_mcu9t5v0__filltie
XTAP_TAPCELL_ROW_19_1493 VSS VSS gf180mcu_fd_sc_mcu9t5v0__filltie
Xmax_cap21 _16545_/ZN _17074_/S VSS VSS VSS VSS gf180mcu_fd_sc_mcu9t5v0__clkbuf_16
X_13830_ _13831_/A1 _13828_/Z _13837_/A2 VSS _13830_/VNW VSS VSS gf180mcu_fd_sc_mcu9t5v0__xnor2_1
Xmax_cap54 _16895_/S _16893_/S VSS VSS VSS VSS gf180mcu_fd_sc_mcu9t5v0__clkbuf_16
Xmax_cap43 _16764_/S _16784_/S VSS VSS VSS VSS gf180mcu_fd_sc_mcu9t5v0__buf_4
Xmax_cap32 _16940_/S _16962_/S VSS VSS VSS VSS gf180mcu_fd_sc_mcu9t5v0__clkbuf_16
X_10973_ _18924_/Q _18923_/Q _11001_/B1 VSS _11003_/VNW VSS VSS gf180mcu_fd_sc_mcu9t5v0__nand2_1
X_13761_ _19292_/Q _19317_/Q _13762_/B2 VSS VSS VSS VSS gf180mcu_fd_sc_mcu9t5v0__nand2_1
X_16480_ _18297_/Q _16479_/Z _17006_/S _18297_/D VSS VSS VSS VSS gf180mcu_fd_sc_mcu9t5v0__mux2_1
Xmax_cap87 _16763_/S _16785_/S VSS _12404_/VNW VSS VSS gf180mcu_fd_sc_mcu9t5v0__buf_4
Xmax_cap65 _17511_/S _17504_/S VSS VSS VSS VSS gf180mcu_fd_sc_mcu9t5v0__clkbuf_8
Xmax_cap76 _15865_/ZN _15920_/S VSS VSS VSS VSS gf180mcu_fd_sc_mcu9t5v0__clkbuf_8
X_15500_ _19837_/Q input7/Z _15502_/S _15500_/Z VSS VSS VSS VSS gf180mcu_fd_sc_mcu9t5v0__mux2_1
X_12712_ _12724_/A2 _12712_/A2 _12713_/A2 VSS VSS VSS VSS gf180mcu_fd_sc_mcu9t5v0__xnor2_1
X_15431_ _18563_/Q _10840_/B _15431_/Z VSS VSS VSS VSS gf180mcu_fd_sc_mcu9t5v0__and2_1
Xmax_cap98 _16597_/S _16619_/S VSS VSS VSS VSS gf180mcu_fd_sc_mcu9t5v0__clkbuf_16
XTAP_TAPCELL_ROW_117_4203 VSS VSS gf180mcu_fd_sc_mcu9t5v0__filltie
X_13692_ _13692_/A1 _13692_/A2 _13693_/B1 VSS _13692_/VNW VSS VSS gf180mcu_fd_sc_mcu9t5v0__nand2_1
X_12643_ _12643_/A1 _12643_/A2 _12643_/Z VSS VSS VSS VSS gf180mcu_fd_sc_mcu9t5v0__and2_1
X_12574_ _18403_/Q wire163/Z _12577_/A3 VSS VSS VSS VSS gf180mcu_fd_sc_mcu9t5v0__nor2_1
X_18150_ _18149_/Z _18962_/Q _18152_/S _18962_/D VSS _18150_/VNW VSS VSS gf180mcu_fd_sc_mcu9t5v0__mux2_1
X_15362_ _15362_/A1 _15362_/A2 _15362_/B _15363_/A3 VSS _15362_/VNW VSS VSS gf180mcu_fd_sc_mcu9t5v0__oai21_1
X_11525_ _18566_/Q _18375_/Q _11527_/B1 VSS VSS VSS VSS gf180mcu_fd_sc_mcu9t5v0__nand2_1
X_17101_ _17260_/S _18458_/Q _17103_/A3 VSS VSS VSS VSS gf180mcu_fd_sc_mcu9t5v0__nor2_1
X_18081_ _18931_/Q _18062_/I _18931_/D VSS VSS VSS VSS gf180mcu_fd_sc_mcu9t5v0__and2_1
X_15293_ _15300_/A1 _15300_/A2 _15296_/A3 VSS VSS VSS VSS gf180mcu_fd_sc_mcu9t5v0__nand2_1
X_14313_ _13948_/Z _19386_/Q _14322_/S _19386_/D VSS VSS VSS VSS gf180mcu_fd_sc_mcu9t5v0__mux2_1
X_17032_ _17031_/Z _18507_/Q _17050_/S _18507_/D VSS VSS VSS VSS gf180mcu_fd_sc_mcu9t5v0__mux2_4
X_14244_ _19321_/Q _19322_/Q _19301_/Q _14247_/A1 VSS VSS VSS VSS gf180mcu_fd_sc_mcu9t5v0__nand3_1
XTAP_TAPCELL_ROW_95_3590 VSS VSS gf180mcu_fd_sc_mcu9t5v0__filltie
X_11456_ _18482_/Q _11509_/A2 _11459_/A1 VSS VSS VSS VSS gf180mcu_fd_sc_mcu9t5v0__nor2_1
Xwire297 wire297/I wire297/Z VSS wire297/VNW VSS VSS gf180mcu_fd_sc_mcu9t5v0__buf_4
X_10407_ _18287_/Q _17282_/A2 _17282_/B1 _18303_/Q _10408_/B VSS _11805_/VNW VSS VSS
+ gf180mcu_fd_sc_mcu9t5v0__aoi22_1
X_11387_ _18525_/Q _18509_/Q _18493_/Q _18477_/Q _11524_/S _11176_/C _11387_/Z VSS
+ VSS VSS VSS gf180mcu_fd_sc_mcu9t5v0__mux4_1
XTAP_TAPCELL_ROW_262_6283 VSS VSS gf180mcu_fd_sc_mcu9t5v0__filltie
XTAP_TAPCELL_ROW_262_6272 VSS VSS gf180mcu_fd_sc_mcu9t5v0__filltie
XTAP_TAPCELL_ROW_91_3498 VSS VSS gf180mcu_fd_sc_mcu9t5v0__filltie
XTAP_TAPCELL_ROW_91_3487 VSS VSS gf180mcu_fd_sc_mcu9t5v0__filltie
X_14175_ _13867_/Z _19330_/Q _14266_/S _19330_/D VSS VSS VSS VSS gf180mcu_fd_sc_mcu9t5v0__mux2_1
XTAP_TAPCELL_ROW_91_3476 VSS VSS gf180mcu_fd_sc_mcu9t5v0__filltie
X_10338_ _18990_/Q _10654_/A2 _10338_/B wire160/Z _10340_/B1 VSS _10338_/VNW VSS VSS
+ gf180mcu_fd_sc_mcu9t5v0__oai211_1
X_18983_ _18983_/D _20071_/RN clkload69/I _18983_/Q VSS VSS VSS VSS gf180mcu_fd_sc_mcu9t5v0__dffrnq_1
X_13126_ _13145_/A1 _19759_/Q _13162_/A1 VSS VSS VSS VSS gf180mcu_fd_sc_mcu9t5v0__nor2_1
Xload_slew225 _19826_/Q _17198_/A1 VSS VSS VSS VSS gf180mcu_fd_sc_mcu9t5v0__clkbuf_8
X_13057_ _19724_/Q _13059_/A2 _13058_/I VSS VSS VSS VSS gf180mcu_fd_sc_mcu9t5v0__nand2_1
X_17934_ _18849_/Q _17958_/A2 _17936_/B VSS VSS VSS VSS gf180mcu_fd_sc_mcu9t5v0__nand2_1
Xload_slew214 _12686_/C _12628_/A1 VSS max_cap215/VNW VSS VSS gf180mcu_fd_sc_mcu9t5v0__clkbuf_8
XTAP_TAPCELL_ROW_275_6622 VSS VSS gf180mcu_fd_sc_mcu9t5v0__filltie
X_10269_ _19825_/Q _18202_/Q _10271_/A3 VSS VSS VSS VSS gf180mcu_fd_sc_mcu9t5v0__nor2_1
X_12008_ _11966_/B _12008_/A2 _12008_/A3 _12008_/B _19122_/D VSS VSS VSS VSS gf180mcu_fd_sc_mcu9t5v0__oai31_4
Xclkbuf_leaf_1_clk_regs clkbuf_3_0_0_clk_regs/Z _19633_/CLK VSS _14312_/VNW VSS VSS
+ gf180mcu_fd_sc_mcu9t5v0__clkbuf_8
XTAP_TAPCELL_ROW_275_6644 VSS VSS gf180mcu_fd_sc_mcu9t5v0__filltie
XTAP_TAPCELL_ROW_275_6633 VSS VSS gf180mcu_fd_sc_mcu9t5v0__filltie
X_17865_ _17868_/A2 _17865_/A2 _17865_/B _17866_/A2 VSS _17865_/VNW VSS VSS gf180mcu_fd_sc_mcu9t5v0__oai21_1
X_16816_ _16955_/S _16647_/B _16953_/B VSS VSS VSS VSS gf180mcu_fd_sc_mcu9t5v0__nand2_1
XTAP_TAPCELL_ROW_271_6519 VSS VSS gf180mcu_fd_sc_mcu9t5v0__filltie
X_17796_ _18774_/Q _18761_/Q _18769_/D _18774_/D VSS VSS VSS VSS gf180mcu_fd_sc_mcu9t5v0__mux2_1
X_19604_ _19604_/D _20052_/RN clkload21/I _19604_/Q VSS VSS VSS VSS gf180mcu_fd_sc_mcu9t5v0__dffrnq_1
X_16747_ _18375_/Q _16747_/A2 _16747_/A3 _16748_/B VSS VSS VSS VSS gf180mcu_fd_sc_mcu9t5v0__nand3_1
XTAP_TAPCELL_ROW_256_6098 VSS VSS gf180mcu_fd_sc_mcu9t5v0__filltie
X_13959_ _13915_/I _13989_/A2 _13990_/A1 VSS VSS VSS VSS gf180mcu_fd_sc_mcu9t5v0__xnor2_1
X_19535_ _19535_/D _20047_/RN _19798_/CLK _19535_/Q VSS VSS VSS VSS gf180mcu_fd_sc_mcu9t5v0__dffrnq_1
X_16678_ _16750_/A1 _16686_/A3 _16678_/B _16679_/C VSS VSS VSS VSS gf180mcu_fd_sc_mcu9t5v0__aoi21_1
XPHY_EDGE_ROW_185_3_Right_300 VSS VSS gf180mcu_fd_sc_mcu9t5v0__endcap
X_19466_ _19466_/D _20042_/RN clkload32/I _19466_/Q VSS VSS VSS VSS gf180mcu_fd_sc_mcu9t5v0__dffrnq_1
X_18417_ _18417_/D clkload73/I _18417_/Q VSS VSS VSS VSS gf180mcu_fd_sc_mcu9t5v0__dffq_4
X_15629_ _15629_/A1 _10201_/B _15629_/B _19894_/D VSS VSS VSS VSS gf180mcu_fd_sc_mcu9t5v0__aoi21_1
X_19397_ _19397_/D _20037_/RN clkload8/I _19397_/Q VSS VSS VSS VSS gf180mcu_fd_sc_mcu9t5v0__dffrnq_1
X_18348_ _18348_/D clkload61/I _18348_/Q VSS VSS VSS VSS gf180mcu_fd_sc_mcu9t5v0__dffq_1
XTAP_TAPCELL_ROW_269_6459 VSS VSS gf180mcu_fd_sc_mcu9t5v0__filltie
X_09150_ _19771_/Q _13318_/A2 VSS VSS VSS VSS gf180mcu_fd_sc_mcu9t5v0__clkinv_1
X_18279_ _18279_/D _18279_/CLK _18279_/Q VSS VSS VSS VSS gf180mcu_fd_sc_mcu9t5v0__dffq_4
X_09081_ _20029_/Q _09851_/A1 VSS _09081_/VNW VSS VSS gf180mcu_fd_sc_mcu9t5v0__clkinv_1
XTAP_TAPCELL_ROW_38_2014 VSS VSS gf180mcu_fd_sc_mcu9t5v0__filltie
XTAP_TAPCELL_ROW_38_2025 VSS VSS gf180mcu_fd_sc_mcu9t5v0__filltie
XTAP_TAPCELL_ROW_38_2036 VSS VSS gf180mcu_fd_sc_mcu9t5v0__filltie
X_09983_ _19214_/Q wire172/Z _10172_/A2 _19198_/Q _09984_/A2 VSS VSS VSS VSS gf180mcu_fd_sc_mcu9t5v0__aoi22_1
XPHY_EDGE_ROW_231_Right_158 VSS VSS gf180mcu_fd_sc_mcu9t5v0__endcap
XTAP_TAPCELL_ROW_241_5688 VSS VSS gf180mcu_fd_sc_mcu9t5v0__filltie
XTAP_TAPCELL_ROW_241_5699 VSS VSS gf180mcu_fd_sc_mcu9t5v0__filltie
XTAP_TAPCELL_ROW_10_1254 VSS VSS gf180mcu_fd_sc_mcu9t5v0__filltie
XTAP_TAPCELL_ROW_10_1265 VSS VSS gf180mcu_fd_sc_mcu9t5v0__filltie
XPHY_EDGE_ROW_0_Right_0 VSS VSS gf180mcu_fd_sc_mcu9t5v0__endcap
X_09417_ _09417_/I _10843_/A2 VSS _09451_/VNW VSS VSS gf180mcu_fd_sc_mcu9t5v0__clkinv_4
XTAP_TAPCELL_ROW_23_1604 VSS VSS gf180mcu_fd_sc_mcu9t5v0__filltie
XTAP_TAPCELL_ROW_23_1615 VSS VSS gf180mcu_fd_sc_mcu9t5v0__filltie
X_09348_ _19456_/Q _14456_/A1 VSS _14456_/VNW VSS VSS gf180mcu_fd_sc_mcu9t5v0__clkinv_1
XTAP_TAPCELL_ROW_23_1626 VSS VSS gf180mcu_fd_sc_mcu9t5v0__filltie
X_11310_ _18216_/Q _11509_/A2 _11311_/A3 VSS _11310_/VNW VSS VSS gf180mcu_fd_sc_mcu9t5v0__nand2_1
X_09279_ _20019_/Q _09733_/B2 VSS _16563_/VNW VSS VSS gf180mcu_fd_sc_mcu9t5v0__clkinv_1
Xclkbuf_leaf_71_clk_regs clkload0/I _20054_/CLK VSS VSS VSS VSS gf180mcu_fd_sc_mcu9t5v0__clkbuf_8
X_12290_ _18517_/Q _12324_/B _12290_/B _12320_/C _12291_/A2 VSS VSS VSS VSS gf180mcu_fd_sc_mcu9t5v0__oai211_1
X_11241_ _11538_/B _11241_/A2 _11241_/B1 _11241_/B2 _11788_/B _11242_/B2 VSS VSS VSS
+ VSS gf180mcu_fd_sc_mcu9t5v0__aoi221_2
XPHY_EDGE_ROW_180_1_Left_503 VSS VSS gf180mcu_fd_sc_mcu9t5v0__endcap
X_11172_ _11521_/B _11168_/Z _11172_/B _11520_/B _11177_/A2 VSS VSS VSS VSS gf180mcu_fd_sc_mcu9t5v0__oai211_1
X_10123_ _18944_/Q _10133_/A2 _10138_/B1 _19008_/Q _10124_/I VSS VSS VSS VSS gf180mcu_fd_sc_mcu9t5v0__aoi22_1
X_15980_ _18568_/Q _11095_/S _15954_/B _16700_/A2 VSS _15980_/VNW VSS VSS gf180mcu_fd_sc_mcu9t5v0__nand3_4
Xeco6_buf_11548 _11548_/ZN _12046_/S VSS VSS VSS VSS gf180mcu_fd_sc_mcu9t5v0__clkbuf_16
X_10054_ _15830_/A2 _10054_/A2 _10054_/A3 _10069_/C VSS VSS VSS VSS gf180mcu_fd_sc_mcu9t5v0__nor3_1
X_14931_ _19420_/Q _19421_/Q _19359_/Q _14932_/A4 VSS VSS VSS VSS gf180mcu_fd_sc_mcu9t5v0__oai21_1
XPHY_EDGE_ROW_179_3_Left_837 VSS VSS gf180mcu_fd_sc_mcu9t5v0__endcap
X_17650_ _18693_/Q _17650_/A2 _18693_/D VSS VSS VSS VSS gf180mcu_fd_sc_mcu9t5v0__xor2_1
X_14862_ _19588_/Q _19349_/Q _20039_/D _19588_/D VSS VSS VSS VSS gf180mcu_fd_sc_mcu9t5v0__mux2_1
X_16601_ _15996_/B _16601_/A2 _16601_/A3 _16601_/B _16602_/I1 VSS _16689_/VNW VSS
+ VSS gf180mcu_fd_sc_mcu9t5v0__oai31_1
X_17581_ _18649_/Q _17581_/I1 _17584_/S _18649_/D VSS VSS VSS VSS gf180mcu_fd_sc_mcu9t5v0__mux2_1
X_13813_ _19319_/Q _19294_/Q _13873_/A1 VSS _13854_/VNW VSS VSS gf180mcu_fd_sc_mcu9t5v0__nand2_1
X_16532_ _16531_/Z _18322_/Q _17054_/S _18322_/D VSS _16532_/VNW VSS VSS gf180mcu_fd_sc_mcu9t5v0__mux2_4
XPHY_EDGE_ROW_121_Right_121 VSS VSS gf180mcu_fd_sc_mcu9t5v0__endcap
XTAP_TAPCELL_ROW_84_3291 VSS VSS gf180mcu_fd_sc_mcu9t5v0__filltie
X_14793_ _14793_/A1 _14793_/A2 _14797_/A1 VSS VSS VSS VSS gf180mcu_fd_sc_mcu9t5v0__nand2_1
X_19320_ _19320_/D _19960_/RN clkload13/I _19320_/Q VSS VSS VSS VSS gf180mcu_fd_sc_mcu9t5v0__dffrnq_1
XTAP_TAPCELL_ROW_84_3280 VSS VSS gf180mcu_fd_sc_mcu9t5v0__filltie
X_10956_ _18925_/Q _18923_/Q _18042_/A2 VSS _10956_/VNW VSS VSS gf180mcu_fd_sc_mcu9t5v0__nor2_1
X_13744_ _14196_/A2 _14166_/B _13744_/B1 _14143_/B2 _13744_/C _19299_/D VSS VSS VSS
+ VSS gf180mcu_fd_sc_mcu9t5v0__aoi221_1
XTAP_TAPCELL_ROW_80_3177 VSS VSS gf180mcu_fd_sc_mcu9t5v0__filltie
X_16463_ _19237_/Q _16162_/B _16993_/S _16463_/Z VSS _16463_/VNW VSS VSS gf180mcu_fd_sc_mcu9t5v0__mux2_1
X_10887_ _10887_/I0 _18982_/Q _18148_/S _18982_/D VSS VSS VSS VSS gf180mcu_fd_sc_mcu9t5v0__mux2_1
X_19251_ _19251_/D _20019_/RN clkload44/I _19251_/Q VSS VSS VSS VSS gf180mcu_fd_sc_mcu9t5v0__dffrnq_2
XTAP_TAPCELL_ROW_80_3188 VSS VSS gf180mcu_fd_sc_mcu9t5v0__filltie
X_13675_ _13675_/A1 _13675_/A2 _13675_/B _13686_/A1 VSS VSS VSS VSS gf180mcu_fd_sc_mcu9t5v0__aoi21_1
X_16394_ _16393_/Z _18260_/Q _16926_/S _18260_/D VSS VSS VSS VSS gf180mcu_fd_sc_mcu9t5v0__mux2_4
X_18202_ _18202_/D clkload64/I _18202_/Q VSS VSS VSS VSS gf180mcu_fd_sc_mcu9t5v0__dffq_1
XPHY_EDGE_ROW_175_1_Left_498 VSS VSS gf180mcu_fd_sc_mcu9t5v0__endcap
X_15414_ _19699_/Q _19799_/Q _15430_/S _19799_/D VSS VSS VSS VSS gf180mcu_fd_sc_mcu9t5v0__mux2_1
X_19182_ _19182_/D _20142_/RN clkload14/I _19182_/Q VSS VSS VSS VSS gf180mcu_fd_sc_mcu9t5v0__dffrnq_1
X_12626_ _11633_/B _12626_/A2 _12626_/B _12630_/A2 VSS VSS VSS VSS gf180mcu_fd_sc_mcu9t5v0__oai21_1
XTAP_TAPCELL_ROW_97_3641 VSS VSS gf180mcu_fd_sc_mcu9t5v0__filltie
X_18133_ _18133_/I0 _18953_/Q _18148_/S _18953_/D VSS _18133_/VNW VSS VSS gf180mcu_fd_sc_mcu9t5v0__mux2_1
XTAP_TAPCELL_ROW_97_3663 VSS VSS gf180mcu_fd_sc_mcu9t5v0__filltie
XTAP_TAPCELL_ROW_97_3652 VSS VSS gf180mcu_fd_sc_mcu9t5v0__filltie
X_15345_ _15345_/A1 _15345_/A2 _15345_/A3 _15345_/B _15353_/A1 VSS VSS VSS VSS gf180mcu_fd_sc_mcu9t5v0__oai31_1
X_12557_ _18353_/Q _12382_/S _12561_/A2 VSS VSS VSS VSS gf180mcu_fd_sc_mcu9t5v0__nor2_1
XTAP_TAPCELL_ROW_264_6334 VSS VSS gf180mcu_fd_sc_mcu9t5v0__filltie
XTAP_TAPCELL_ROW_264_6323 VSS VSS gf180mcu_fd_sc_mcu9t5v0__filltie
XTAP_TAPCELL_ROW_93_3549 VSS VSS gf180mcu_fd_sc_mcu9t5v0__filltie
XTAP_TAPCELL_ROW_93_3538 VSS VSS gf180mcu_fd_sc_mcu9t5v0__filltie
XTAP_TAPCELL_ROW_93_3527 VSS VSS gf180mcu_fd_sc_mcu9t5v0__filltie
X_11508_ _18534_/Q _18518_/Q _18470_/Q _18454_/Q _11534_/S _11469_/B _11508_/Z VSS
+ VSS VSS VSS gf180mcu_fd_sc_mcu9t5v0__mux4_1
XTAP_TAPCELL_ROW_260_6209 VSS VSS gf180mcu_fd_sc_mcu9t5v0__filltie
X_18064_ _17885_/S _18064_/A2 _18079_/A2 _18065_/A2 VSS VSS VSS VSS gf180mcu_fd_sc_mcu9t5v0__nand3_1
X_15276_ _19630_/Q _19607_/Q _19629_/Q _19606_/Q _15277_/B VSS _15276_/VNW VSS VSS
+ gf180mcu_fd_sc_mcu9t5v0__oai22_1
X_12488_ _12488_/I _17475_/A2 VSS VSS VSS VSS gf180mcu_fd_sc_mcu9t5v0__clkinv_1
X_11439_ _18449_/Q _11519_/A2 _11442_/A1 VSS VSS VSS VSS gf180mcu_fd_sc_mcu9t5v0__nor2_1
X_17015_ _19254_/Q _16641_/B _17025_/S _17015_/Z VSS VSS VSS VSS gf180mcu_fd_sc_mcu9t5v0__mux2_1
X_14227_ _14229_/A2 _14229_/A3 _14243_/B VSS VSS VSS VSS gf180mcu_fd_sc_mcu9t5v0__nor2_1
X_14158_ _19479_/Q _19487_/Q _14165_/S _14158_/Z VSS VSS VSS VSS gf180mcu_fd_sc_mcu9t5v0__mux2_1
X_13109_ _13109_/I _13145_/B2 VSS VSS VSS VSS gf180mcu_fd_sc_mcu9t5v0__clkinv_1
X_18966_ _18966_/D _20054_/RN clkload70/I _18966_/Q VSS VSS VSS VSS gf180mcu_fd_sc_mcu9t5v0__dffrnq_1
X_14089_ _14090_/A1 _14088_/Z _14110_/A2 VSS _14089_/VNW VSS VSS gf180mcu_fd_sc_mcu9t5v0__nand2_1
X_18897_ _18897_/D _20049_/RN clkload11/I _18897_/Q VSS VSS VSS VSS gf180mcu_fd_sc_mcu9t5v0__dffrnq_1
X_17917_ _17917_/A1 _17917_/A2 _18842_/D VSS _17917_/VNW VSS VSS gf180mcu_fd_sc_mcu9t5v0__nand2_1
X_17848_ _20027_/D _17848_/A2 _17864_/A1 VSS VSS VSS VSS gf180mcu_fd_sc_mcu9t5v0__nor2_1
XTAP_TAPCELL_ROW_7_1164 VSS VSS gf180mcu_fd_sc_mcu9t5v0__filltie
XTAP_TAPCELL_ROW_7_1175 VSS VSS gf180mcu_fd_sc_mcu9t5v0__filltie
XTAP_TAPCELL_ROW_7_1186 VSS VSS gf180mcu_fd_sc_mcu9t5v0__filltie
X_17779_ _17779_/A1 _17779_/A2 _17779_/B _17779_/C _18764_/D VSS VSS VSS VSS gf180mcu_fd_sc_mcu9t5v0__aoi211_1
X_19518_ _19518_/D _20030_/RN clkload43/I _19518_/Q VSS VSS VSS VSS gf180mcu_fd_sc_mcu9t5v0__dffrnq_1
X_19449_ _19449_/D _20025_/RN clkload29/I _19449_/Q VSS VSS VSS VSS gf180mcu_fd_sc_mcu9t5v0__dffrnq_1
XTAP_TAPCELL_ROW_234_5492 VSS VSS gf180mcu_fd_sc_mcu9t5v0__filltie
XPHY_EDGE_ROW_186_3_Right_301 VSS VSS gf180mcu_fd_sc_mcu9t5v0__endcap
X_09202_ _19173_/Q _14594_/A1 VSS VSS VSS VSS gf180mcu_fd_sc_mcu9t5v0__clkinv_1
X_09133_ _19730_/Q _13183_/A1 VSS VSS VSS VSS gf180mcu_fd_sc_mcu9t5v0__clkinv_1
XPHY_EDGE_ROW_300_Right_227 VSS VSS gf180mcu_fd_sc_mcu9t5v0__endcap
XTAP_TAPCELL_ROW_230_5389 VSS VSS gf180mcu_fd_sc_mcu9t5v0__filltie
XPHY_EDGE_ROW_160_2_Right_891 VSS VSS gf180mcu_fd_sc_mcu9t5v0__endcap
X_09064_ wire301/Z _17767_/A1 VSS VSS VSS VSS gf180mcu_fd_sc_mcu9t5v0__clkinv_1
XTAP_TAPCELL_ROW_247_5875 VSS VSS gf180mcu_fd_sc_mcu9t5v0__filltie
XTAP_TAPCELL_ROW_247_5864 VSS VSS gf180mcu_fd_sc_mcu9t5v0__filltie
XTAP_TAPCELL_ROW_247_5853 VSS VSS gf180mcu_fd_sc_mcu9t5v0__filltie
X_09966_ _20042_/Q _15583_/A1 _09974_/C _09966_/B2 _20072_/Q _09967_/B2 VSS VSS VSS
+ VSS gf180mcu_fd_sc_mcu9t5v0__aoi221_1
XTAP_TAPCELL_ROW_16_1430 VSS VSS gf180mcu_fd_sc_mcu9t5v0__filltie
X_20086_ _20086_/D clkload76/I _20086_/Q VSS VSS VSS VSS gf180mcu_fd_sc_mcu9t5v0__dffq_1
X_09897_ _10659_/C _10164_/A1 _10028_/B VSS VSS VSS VSS gf180mcu_fd_sc_mcu9t5v0__nand2_1
XTAP_TAPCELL_ROW_12_1305 VSS VSS gf180mcu_fd_sc_mcu9t5v0__filltie
XTAP_TAPCELL_ROW_12_1316 VSS VSS gf180mcu_fd_sc_mcu9t5v0__filltie
X_11790_ _11790_/A1 _11790_/A2 wire213/Z _11791_/B VSS VSS VSS VSS gf180mcu_fd_sc_mcu9t5v0__aoi21_2
X_10810_ _10718_/C _10810_/A2 _10810_/B1 _10810_/B2 _10810_/ZN VSS VSS VSS VSS gf180mcu_fd_sc_mcu9t5v0__aoi22_4
X_10741_ _19937_/Q _19889_/Q _20043_/Q _10741_/Z VSS _15627_/VNW VSS VSS gf180mcu_fd_sc_mcu9t5v0__mux2_1
X_13460_ _13469_/A2 _19813_/Q _13474_/A1 _13638_/A2 VSS VSS VSS VSS gf180mcu_fd_sc_mcu9t5v0__xnor3_1
XTAP_TAPCELL_ROW_206_3_8245 VSS VSS gf180mcu_fd_sc_mcu9t5v0__filltie
X_10672_ _19003_/Q _18831_/Q _10786_/A2 _19010_/Q _10673_/A2 VSS _10672_/VNW VSS VSS
+ gf180mcu_fd_sc_mcu9t5v0__oai22_1
X_12411_ _19148_/Q _12355_/I _12421_/B VSS VSS VSS VSS gf180mcu_fd_sc_mcu9t5v0__nand2_1
X_13391_ _19743_/Q _13618_/A2 _13614_/B VSS _13618_/VNW VSS VSS gf180mcu_fd_sc_mcu9t5v0__xnor2_1
X_12342_ _12347_/C _12340_/Z _12342_/B _12342_/C _12349_/A1 VSS _16832_/VNW VSS VSS
+ gf180mcu_fd_sc_mcu9t5v0__oai211_1
XTAP_TAPCELL_ROW_131_4575 VSS VSS gf180mcu_fd_sc_mcu9t5v0__filltie
X_15130_ _19672_/Q _19512_/Q _15163_/S _19672_/D VSS VSS VSS VSS gf180mcu_fd_sc_mcu9t5v0__mux2_1
X_12273_ _12071_/B _12295_/A2 _12274_/A2 VSS _12273_/VNW VSS VSS gf180mcu_fd_sc_mcu9t5v0__nor2_1
XTAP_TAPCELL_ROW_131_4597 VSS VSS gf180mcu_fd_sc_mcu9t5v0__filltie
XTAP_TAPCELL_ROW_131_4586 VSS VSS gf180mcu_fd_sc_mcu9t5v0__filltie
X_15061_ _19641_/Q _15061_/I1 _20039_/Q _19641_/D VSS VSS VSS VSS gf180mcu_fd_sc_mcu9t5v0__mux2_1
X_11224_ _11537_/S _11222_/Z wire283/Z _11225_/B2 VSS VSS VSS VSS gf180mcu_fd_sc_mcu9t5v0__aoi21_1
X_14012_ _19296_/Q _19322_/Q _14012_/B _14045_/A2 VSS _14013_/VNW VSS VSS gf180mcu_fd_sc_mcu9t5v0__aoi21_1
X_11155_ _11483_/B _11154_/Z _11155_/B _11520_/B _11160_/A2 VSS _11159_/VNW VSS VSS
+ gf180mcu_fd_sc_mcu9t5v0__oai211_1
X_18820_ _18820_/D _20036_/RN clkload36/I _18820_/Q VSS VSS VSS VSS gf180mcu_fd_sc_mcu9t5v0__dffrnq_1
X_10106_ _10079_/C _10106_/A2 _10106_/B _10108_/B1 VSS _10106_/VNW VSS VSS gf180mcu_fd_sc_mcu9t5v0__oai21_1
X_11086_ _18185_/Q _11403_/S _11087_/A3 VSS VSS VSS VSS gf180mcu_fd_sc_mcu9t5v0__nand2_1
X_15963_ _15963_/A1 _15948_/Z _15963_/B1 _15957_/Z _15963_/C _16236_/A1 VSS VSS VSS
+ VSS gf180mcu_fd_sc_mcu9t5v0__oai221_4
X_18751_ _18751_/D clkload25/I _18751_/Q VSS VSS VSS VSS gf180mcu_fd_sc_mcu9t5v0__dffq_1
X_17702_ _20035_/RN _17567_/I _17702_/A3 _17709_/A1 VSS _17702_/VNW VSS VSS gf180mcu_fd_sc_mcu9t5v0__nand3_1
X_10037_ _10178_/A1 _10037_/A2 _10037_/A3 _10038_/C VSS _10037_/VNW VSS VSS gf180mcu_fd_sc_mcu9t5v0__nand3_1
XTAP_TAPCELL_ROW_86_3353 VSS VSS gf180mcu_fd_sc_mcu9t5v0__filltie
X_14914_ _19359_/Q _19419_/Q _14932_/A2 VSS VSS VSS VSS gf180mcu_fd_sc_mcu9t5v0__nand2_1
XTAP_TAPCELL_ROW_86_3342 VSS VSS gf180mcu_fd_sc_mcu9t5v0__filltie
X_15894_ _20103_/Q _19238_/Q _15927_/S _20103_/D VSS VSS VSS VSS gf180mcu_fd_sc_mcu9t5v0__mux2_1
X_18682_ _18682_/D _20022_/RN clkload55/I _18682_/Q VSS VSS VSS VSS gf180mcu_fd_sc_mcu9t5v0__dffrnq_1
XTAP_TAPCELL_ROW_82_3228 VSS VSS gf180mcu_fd_sc_mcu9t5v0__filltie
XTAP_TAPCELL_ROW_253_6035 VSS VSS gf180mcu_fd_sc_mcu9t5v0__filltie
XTAP_TAPCELL_ROW_253_6024 VSS VSS gf180mcu_fd_sc_mcu9t5v0__filltie
XTAP_TAPCELL_ROW_82_3239 VSS VSS gf180mcu_fd_sc_mcu9t5v0__filltie
X_17633_ _18686_/Q _17650_/A2 _18686_/D VSS VSS VSS VSS gf180mcu_fd_sc_mcu9t5v0__xor2_1
X_14845_ _14831_/Z _14837_/B _14846_/A3 _14842_/Z _14846_/A4 VSS _14845_/VNW VSS VSS
+ gf180mcu_fd_sc_mcu9t5v0__nand4_1
X_17564_ _17583_/I1 _18641_/Q _17571_/S _18641_/D VSS VSS VSS VSS gf180mcu_fd_sc_mcu9t5v0__mux2_1
X_11988_ _11988_/A1 _11988_/A2 _11988_/B _12003_/A1 VSS _11988_/VNW VSS VSS gf180mcu_fd_sc_mcu9t5v0__aoi21_4
XPHY_EDGE_ROW_199_2_Right_930 VSS VSS gf180mcu_fd_sc_mcu9t5v0__endcap
X_14776_ _19564_/Q _19330_/Q _14900_/S _19564_/D VSS VSS VSS VSS gf180mcu_fd_sc_mcu9t5v0__mux2_1
X_16515_ _16009_/B _19229_/Q _17033_/S _16515_/Z VSS VSS VSS VSS gf180mcu_fd_sc_mcu9t5v0__mux2_1
XTAP_TAPCELL_ROW_99_3714 VSS VSS gf180mcu_fd_sc_mcu9t5v0__filltie
X_10939_ _18929_/Q _18936_/Q _10944_/A1 VSS _10944_/VNW VSS VSS gf180mcu_fd_sc_mcu9t5v0__xnor2_1
XTAP_TAPCELL_ROW_99_3703 VSS VSS gf180mcu_fd_sc_mcu9t5v0__filltie
X_13727_ _14501_/S _13727_/A2 _13728_/A2 VSS _13728_/VNW VSS VSS gf180mcu_fd_sc_mcu9t5v0__nand2_1
XTAP_TAPCELL_ROW_2_1050 VSS VSS gf180mcu_fd_sc_mcu9t5v0__filltie
X_19303_ _19303_/D _20071_/RN clkload21/I _19303_/Q VSS VSS VSS VSS gf180mcu_fd_sc_mcu9t5v0__dffrnq_1
X_17495_ _18600_/Q _19241_/Q _17511_/S _18600_/D VSS VSS VSS VSS gf180mcu_fd_sc_mcu9t5v0__mux2_1
X_19234_ _19234_/D _20066_/RN clkload45/I _19234_/Q VSS VSS VSS VSS gf180mcu_fd_sc_mcu9t5v0__dffrnq_2
X_16446_ _18281_/Q _16445_/Z wire28/I _18281_/D VSS _17060_/VNW VSS VSS gf180mcu_fd_sc_mcu9t5v0__mux2_4
X_13658_ _13658_/A1 _13658_/A2 _13659_/B1 VSS VSS VSS VSS gf180mcu_fd_sc_mcu9t5v0__nand2_1
X_12609_ wire146/Z _12609_/A2 _12609_/A3 _12609_/B1 _12609_/B2 wire119/I VSS VSS VSS
+ VSS gf180mcu_fd_sc_mcu9t5v0__oai32_1
X_16377_ _16131_/B _19231_/Q _16897_/S _16377_/Z VSS _16377_/VNW VSS VSS gf180mcu_fd_sc_mcu9t5v0__mux2_1
X_19165_ _19165_/D _20061_/RN clkload35/I _19165_/Q VSS VSS VSS VSS gf180mcu_fd_sc_mcu9t5v0__dffrnq_1
X_13589_ _13275_/Z _13590_/A2 _13591_/A2 VSS VSS VSS VSS gf180mcu_fd_sc_mcu9t5v0__nor2_1
X_18116_ _18115_/Z _18945_/Q _18152_/S _18945_/D VSS VSS VSS VSS gf180mcu_fd_sc_mcu9t5v0__mux2_1
X_15328_ _19742_/Q _15327_/Z _15364_/S _19742_/D VSS VSS VSS VSS gf180mcu_fd_sc_mcu9t5v0__mux2_1
X_19096_ _19096_/D _19992_/RN clkload26/I _19096_/Q VSS VSS VSS VSS gf180mcu_fd_sc_mcu9t5v0__dffrnq_1
X_18047_ _18040_/Z _18074_/A2 _18075_/A1 VSS VSS VSS VSS gf180mcu_fd_sc_mcu9t5v0__nand2_1
X_15259_ _15260_/A1 _15260_/A3 _15259_/B _15262_/A2 VSS _15259_/VNW VSS VSS gf180mcu_fd_sc_mcu9t5v0__aoi21_1
XTAP_TAPCELL_ROW_71_2943 VSS VSS gf180mcu_fd_sc_mcu9t5v0__filltie
XTAP_TAPCELL_ROW_71_2932 VSS VSS gf180mcu_fd_sc_mcu9t5v0__filltie
X_19998_ _19998_/D _20062_/RN clkload26/I _19998_/Q VSS VSS VSS VSS gf180mcu_fd_sc_mcu9t5v0__dffrnq_1
X_09820_ _09820_/A1 _17909_/A3 _09820_/Z VSS VSS VSS VSS gf180mcu_fd_sc_mcu9t5v0__and2_1
X_18949_ _18949_/D _20037_/RN clkload70/I _18949_/Q VSS VSS VSS VSS gf180mcu_fd_sc_mcu9t5v0__dffrnq_1
X_09751_ _20138_/Q _09758_/B _09751_/A3 _09753_/B VSS _10833_/VNW VSS VSS gf180mcu_fd_sc_mcu9t5v0__nand3_1
XTAP_TAPCELL_ROW_9_1226 VSS VSS gf180mcu_fd_sc_mcu9t5v0__filltie
XTAP_TAPCELL_ROW_9_1237 VSS VSS gf180mcu_fd_sc_mcu9t5v0__filltie
XTAP_TAPCELL_ROW_223_5193 VSS VSS gf180mcu_fd_sc_mcu9t5v0__filltie
X_09682_ wire175/Z _09682_/A2 _09687_/A1 VSS _17477_/VNW VSS VSS gf180mcu_fd_sc_mcu9t5v0__nand2_1
XTAP_TAPCELL_ROW_187_3_8179 VSS VSS gf180mcu_fd_sc_mcu9t5v0__filltie
XTAP_TAPCELL_ROW_69_2883 VSS VSS gf180mcu_fd_sc_mcu9t5v0__filltie
XTAP_TAPCELL_ROW_69_2872 VSS VSS gf180mcu_fd_sc_mcu9t5v0__filltie
XTAP_TAPCELL_ROW_236_5554 VSS VSS gf180mcu_fd_sc_mcu9t5v0__filltie
XTAP_TAPCELL_ROW_65_2758 VSS VSS gf180mcu_fd_sc_mcu9t5v0__filltie
XTAP_TAPCELL_ROW_65_2769 VSS VSS gf180mcu_fd_sc_mcu9t5v0__filltie
XTAP_TAPCELL_ROW_236_5565 VSS VSS gf180mcu_fd_sc_mcu9t5v0__filltie
XPHY_EDGE_ROW_187_3_Right_302 VSS VSS gf180mcu_fd_sc_mcu9t5v0__endcap
XTAP_TAPCELL_ROW_249_5926 VSS VSS gf180mcu_fd_sc_mcu9t5v0__filltie
XTAP_TAPCELL_ROW_249_5915 VSS VSS gf180mcu_fd_sc_mcu9t5v0__filltie
X_09116_ _19785_/Q _12958_/A2 VSS VSS VSS VSS gf180mcu_fd_sc_mcu9t5v0__clkinv_1
XPHY_EDGE_ROW_161_2_Right_892 VSS VSS gf180mcu_fd_sc_mcu9t5v0__endcap
XTAP_TAPCELL_ROW_320_7872 VSS VSS gf180mcu_fd_sc_mcu9t5v0__filltie
XTAP_TAPCELL_ROW_320_7861 VSS VSS gf180mcu_fd_sc_mcu9t5v0__filltie
Xmax_cap180 _12159_/B _12299_/S VSS VSS VSS VSS gf180mcu_fd_sc_mcu9t5v0__buf_8
XTAP_TAPCELL_ROW_320_7883 VSS VSS gf180mcu_fd_sc_mcu9t5v0__filltie
Xmax_cap191 _17380_/B1 _17255_/B1 VSS VSS VSS VSS gf180mcu_fd_sc_mcu9t5v0__buf_8
X_20138_ _20138_/D _20138_/RN clkload50/I _20138_/Q VSS VSS VSS VSS gf180mcu_fd_sc_mcu9t5v0__dffrnq_1
X_09949_ _18822_/Q _09948_/Z _10153_/A2 VSS _17839_/VNW VSS VSS gf180mcu_fd_sc_mcu9t5v0__nor2_1
X_20069_ _20069_/D _20069_/RN clkload50/I _20069_/Q VSS VSS VSS VSS gf180mcu_fd_sc_mcu9t5v0__dffrnq_1
XTAP_TAPCELL_ROW_124_4390 VSS VSS gf180mcu_fd_sc_mcu9t5v0__filltie
X_12960_ _12960_/A1 _19750_/Q _12960_/B _12983_/A2 VSS VSS VSS VSS gf180mcu_fd_sc_mcu9t5v0__oai21_1
X_11911_ _18244_/Q _12345_/A2 _11921_/A1 VSS _12448_/VNW VSS VSS gf180mcu_fd_sc_mcu9t5v0__nand2_1
X_12891_ _12891_/A1 _12890_/B _12891_/A3 _12891_/Z VSS VSS VSS VSS gf180mcu_fd_sc_mcu9t5v0__or3_1
XTAP_TAPCELL_ROW_314_7698 VSS VSS gf180mcu_fd_sc_mcu9t5v0__filltie
X_11842_ _18193_/Q _12183_/C _11843_/B VSS VSS VSS VSS gf180mcu_fd_sc_mcu9t5v0__and2_1
XTAP_TAPCELL_ROW_120_4287 VSS VSS gf180mcu_fd_sc_mcu9t5v0__filltie
XTAP_TAPCELL_ROW_120_4276 VSS VSS gf180mcu_fd_sc_mcu9t5v0__filltie
X_14630_ _19092_/Q _19508_/Q _14730_/S _19508_/D VSS VSS VSS VSS gf180mcu_fd_sc_mcu9t5v0__mux2_1
X_14561_ _14562_/A2 _14562_/A3 _14751_/B _14567_/B VSS VSS VSS VSS gf180mcu_fd_sc_mcu9t5v0__aoi21_1
X_11773_ _18158_/Q _12203_/A2 _11775_/A3 VSS _11773_/VNW VSS VSS gf180mcu_fd_sc_mcu9t5v0__nor2_1
X_16300_ _16442_/A1 _16443_/A3 _16370_/A1 VSS VSS VSS VSS gf180mcu_fd_sc_mcu9t5v0__nor2_1
X_13512_ _13512_/A1 _13511_/B _13512_/A3 _13512_/Z VSS VSS VSS VSS gf180mcu_fd_sc_mcu9t5v0__and3_1
X_17280_ _17358_/A1 _18386_/Q _17283_/A2 VSS _17280_/VNW VSS VSS gf180mcu_fd_sc_mcu9t5v0__nor2_1
X_10724_ _17231_/A3 _10724_/A2 _10724_/B _10724_/C _10727_/B1 VSS VSS VSS VSS gf180mcu_fd_sc_mcu9t5v0__oai211_4
X_14492_ _19128_/Q _14501_/S _14764_/B _14492_/C _14494_/A1 VSS _14492_/VNW VSS VSS
+ gf180mcu_fd_sc_mcu9t5v0__oai211_1
X_16231_ _16230_/Z _18200_/Q _16782_/S _18200_/D VSS VSS VSS VSS gf180mcu_fd_sc_mcu9t5v0__mux2_1
X_10655_ _19956_/Q wire216/Z _10655_/B _10656_/B2 VSS VSS VSS VSS gf180mcu_fd_sc_mcu9t5v0__aoi21_1
XTAP_TAPCELL_ROW_133_4648 VSS VSS gf180mcu_fd_sc_mcu9t5v0__filltie
XTAP_TAPCELL_ROW_133_4637 VSS VSS gf180mcu_fd_sc_mcu9t5v0__filltie
X_13443_ _19746_/Q _13442_/Z _13444_/I VSS _13454_/VNW VSS VSS gf180mcu_fd_sc_mcu9t5v0__nand2_1
X_16162_ _16668_/A1 _16750_/A2 _16162_/B _16164_/A1 VSS VSS VSS VSS gf180mcu_fd_sc_mcu9t5v0__aoi21_4
X_13374_ _13375_/A1 _13375_/A2 _13374_/B _13395_/A2 VSS VSS VSS VSS gf180mcu_fd_sc_mcu9t5v0__aoi21_1
XTAP_TAPCELL_ROW_75_3043 VSS VSS gf180mcu_fd_sc_mcu9t5v0__filltie
Xclkload17 clkload17/I clkload17/ZN VSS _14817_/VNW VSS VSS gf180mcu_fd_sc_mcu9t5v0__clkinv_8
XTAP_TAPCELL_ROW_75_3032 VSS VSS gf180mcu_fd_sc_mcu9t5v0__filltie
X_12325_ _12325_/A1 _12325_/A2 _12325_/B1 _12325_/B2 _12326_/A2 VSS VSS VSS VSS gf180mcu_fd_sc_mcu9t5v0__aoi22_1
X_10586_ _18294_/Q _17406_/A2 _17405_/A2 _18310_/Q _10587_/B VSS _11290_/VNW VSS VSS
+ gf180mcu_fd_sc_mcu9t5v0__aoi22_1
XTAP_TAPCELL_ROW_75_3054 VSS VSS gf180mcu_fd_sc_mcu9t5v0__filltie
Xclkload39 clkload39/I clkload39/ZN VSS VSS VSS VSS gf180mcu_fd_sc_mcu9t5v0__inv_3
X_15113_ _19655_/Q _19495_/Q wire108/Z _19655_/D VSS VSS VSS VSS gf180mcu_fd_sc_mcu9t5v0__mux2_1
Xclkload28 clkload28/I clkload28/Z VSS VSS VSS VSS gf180mcu_fd_sc_mcu9t5v0__clkbuf_4
X_16093_ _18132_/A1 _16672_/A2 _16098_/B _16187_/C VSS VSS VSS VSS gf180mcu_fd_sc_mcu9t5v0__oai21_4
X_19921_ _19921_/D _20049_/RN clkload49/I _19921_/Q VSS VSS VSS VSS gf180mcu_fd_sc_mcu9t5v0__dffrnq_1
X_15044_ _19304_/Q _19389_/Q _15047_/A1 _15044_/Z VSS VSS VSS VSS gf180mcu_fd_sc_mcu9t5v0__xor3_1
X_12256_ _12256_/I _19134_/D VSS VSS VSS VSS gf180mcu_fd_sc_mcu9t5v0__clkinv_1
X_11207_ _18304_/Q _11524_/S _11210_/A1 VSS _11828_/VNW VSS VSS gf180mcu_fd_sc_mcu9t5v0__nor2_1
X_19852_ _19852_/D _20044_/RN clkload56/I _19852_/Q VSS VSS VSS VSS gf180mcu_fd_sc_mcu9t5v0__dffrnq_1
XTAP_TAPCELL_ROW_259_6200 VSS VSS gf180mcu_fd_sc_mcu9t5v0__filltie
X_12187_ _12187_/A1 _12195_/A2 _12187_/Z VSS VSS VSS VSS gf180mcu_fd_sc_mcu9t5v0__xor2_1
XTAP_TAPCELL_ROW_88_3415 VSS VSS gf180mcu_fd_sc_mcu9t5v0__filltie
XTAP_TAPCELL_ROW_88_3404 VSS VSS gf180mcu_fd_sc_mcu9t5v0__filltie
X_18803_ _18803_/D _20019_/RN clkload32/I _18803_/Q VSS VSS VSS VSS gf180mcu_fd_sc_mcu9t5v0__dffrnq_1
X_11138_ _19076_/Q _11321_/A2 _11151_/B VSS VSS VSS VSS gf180mcu_fd_sc_mcu9t5v0__nand2_1
X_16995_ _19244_/Q _17059_/I1 _17003_/S _16995_/Z VSS _16995_/VNW VSS VSS gf180mcu_fd_sc_mcu9t5v0__mux2_1
X_19783_ _19783_/D _20039_/RN clkload9/I _19783_/Q VSS VSS VSS VSS gf180mcu_fd_sc_mcu9t5v0__dffrnq_1
X_15946_ _20138_/Q _15936_/B _15946_/A3 _15946_/A4 _16597_/S VSS VSS VSS VSS gf180mcu_fd_sc_mcu9t5v0__nand4_4
X_18734_ _18734_/D clkload47/I _18734_/Q VSS VSS VSS VSS gf180mcu_fd_sc_mcu9t5v0__dffq_1
X_11069_ _19069_/Q _14730_/S _11069_/B _11072_/S VSS _12690_/VNW VSS VSS gf180mcu_fd_sc_mcu9t5v0__aoi21_1
X_15877_ _20086_/Q _19236_/Q _15912_/S _20086_/D VSS VSS VSS VSS gf180mcu_fd_sc_mcu9t5v0__mux2_1
X_18665_ _18665_/D _20069_/RN clkload59/I _18665_/Q VSS VSS VSS VSS gf180mcu_fd_sc_mcu9t5v0__dffrnq_1
XTAP_TAPCELL_ROW_4_1101 VSS VSS gf180mcu_fd_sc_mcu9t5v0__filltie
X_17616_ input7/Z _18679_/Q _17617_/S _18679_/D VSS VSS VSS VSS gf180mcu_fd_sc_mcu9t5v0__mux2_1
Xrst_tree_leaf_3 rst_tree_mid_0/Z _20144_/RN VSS VSS VSS VSS gf180mcu_fd_sc_mcu9t5v0__clkbuf_16
X_14828_ _19341_/Q _19405_/Q _14828_/Z VSS VSS VSS VSS gf180mcu_fd_sc_mcu9t5v0__xor2_1
X_18596_ _18596_/D clkload75/I _18596_/Q VSS VSS VSS VSS gf180mcu_fd_sc_mcu9t5v0__dffq_1
XPHY_EDGE_ROW_205_1_Left_528 VSS VSS gf180mcu_fd_sc_mcu9t5v0__endcap
X_17547_ input5/Z _17540_/Z _18664_/Q _17548_/A2 VSS VSS VSS VSS gf180mcu_fd_sc_mcu9t5v0__aoi21_1
XTAP_TAPCELL_ROW_60_2622 VSS VSS gf180mcu_fd_sc_mcu9t5v0__filltie
X_14759_ _14578_/Z _14762_/A2 _14760_/I1 VSS VSS VSS VSS gf180mcu_fd_sc_mcu9t5v0__xnor2_1
XTAP_TAPCELL_ROW_60_2633 VSS VSS gf180mcu_fd_sc_mcu9t5v0__filltie
XTAP_TAPCELL_ROW_60_2644 VSS VSS gf180mcu_fd_sc_mcu9t5v0__filltie
X_17478_ _09517_/I _17478_/A2 _18585_/D VSS _17478_/VNW VSS VSS gf180mcu_fd_sc_mcu9t5v0__nor2_1
X_16429_ _16429_/I0 _18275_/Q _16960_/S _18275_/D VSS VSS VSS VSS gf180mcu_fd_sc_mcu9t5v0__mux2_1
X_19217_ _19217_/D _20049_/RN _20054_/CLK _19217_/Q VSS VSS VSS VSS gf180mcu_fd_sc_mcu9t5v0__dffrnq_1
X_19148_ _19148_/D _20044_/RN clkload37/I _19148_/Q VSS VSS VSS VSS gf180mcu_fd_sc_mcu9t5v0__dffrnq_1
XTAP_TAPCELL_ROW_41_2098 VSS VSS gf180mcu_fd_sc_mcu9t5v0__filltie
XTAP_TAPCELL_ROW_204_2_8236 VSS VSS gf180mcu_fd_sc_mcu9t5v0__filltie
XPHY_EDGE_ROW_160_1_Right_744 VSS VSS gf180mcu_fd_sc_mcu9t5v0__endcap
X_19079_ _19079_/D _20039_/RN clkload45/I _19079_/Q VSS VSS VSS VSS gf180mcu_fd_sc_mcu9t5v0__dffrnq_1
XTAP_TAPCELL_ROW_58_2573 VSS VSS gf180mcu_fd_sc_mcu9t5v0__filltie
XTAP_TAPCELL_ROW_58_2584 VSS VSS gf180mcu_fd_sc_mcu9t5v0__filltie
XTAP_TAPCELL_ROW_229_5380 VSS VSS gf180mcu_fd_sc_mcu9t5v0__filltie
XTAP_TAPCELL_ROW_225_5266 VSS VSS gf180mcu_fd_sc_mcu9t5v0__filltie
XTAP_TAPCELL_ROW_225_5255 VSS VSS gf180mcu_fd_sc_mcu9t5v0__filltie
XTAP_TAPCELL_ROW_54_2459 VSS VSS gf180mcu_fd_sc_mcu9t5v0__filltie
Xfanout237 wire38/Z _16882_/S VSS VSS VSS VSS gf180mcu_fd_sc_mcu9t5v0__clkbuf_16
X_09803_ _18839_/Q _17903_/A1 _17907_/B VSS VSS VSS VSS gf180mcu_fd_sc_mcu9t5v0__nand2_1
Xfanout259 _16115_/ZN _16753_/S VSS VSS VSS VSS gf180mcu_fd_sc_mcu9t5v0__clkbuf_16
Xfanout248 wire37/Z _16892_/S VSS VSS VSS VSS gf180mcu_fd_sc_mcu9t5v0__clkbuf_16
XTAP_TAPCELL_ROW_238_5605 VSS VSS gf180mcu_fd_sc_mcu9t5v0__filltie
X_09734_ _20018_/Q _15850_/A2 _09738_/A1 VSS VSS VSS VSS gf180mcu_fd_sc_mcu9t5v0__nand2_1
XTAP_TAPCELL_ROW_238_5627 VSS VSS gf180mcu_fd_sc_mcu9t5v0__filltie
XTAP_TAPCELL_ROW_238_5616 VSS VSS gf180mcu_fd_sc_mcu9t5v0__filltie
X_09665_ _19914_/Q _10034_/A2 _09665_/Z VSS VSS VSS VSS gf180mcu_fd_sc_mcu9t5v0__and2_1
Xeco14_skew_14 _20099_/CLK _18495_/CLK VSS VSS VSS VSS gf180mcu_fd_sc_mcu9t5v0__clkbuf_16
X_09596_ _19904_/Q _15671_/A1 _09597_/A3 VSS _09596_/VNW VSS VSS gf180mcu_fd_sc_mcu9t5v0__nand2_1
XPHY_EDGE_ROW_279_Left_602 VSS VSS gf180mcu_fd_sc_mcu9t5v0__endcap
XPHY_EDGE_ROW_188_3_Right_303 VSS VSS gf180mcu_fd_sc_mcu9t5v0__endcap
X_10440_ _20085_/Q wire168/Z _10441_/A2 VSS _10443_/VNW VSS VSS gf180mcu_fd_sc_mcu9t5v0__nor2_1
XTAP_TAPCELL_ROW_322_7923 VSS VSS gf180mcu_fd_sc_mcu9t5v0__filltie
XTAP_TAPCELL_ROW_322_7912 VSS VSS gf180mcu_fd_sc_mcu9t5v0__filltie
XTAP_TAPCELL_ROW_210_4856 VSS VSS gf180mcu_fd_sc_mcu9t5v0__filltie
XTAP_TAPCELL_ROW_210_4845 VSS VSS gf180mcu_fd_sc_mcu9t5v0__filltie
XTAP_TAPCELL_ROW_210_4834 VSS VSS gf180mcu_fd_sc_mcu9t5v0__filltie
XTAP_TAPCELL_ROW_322_7934 VSS VSS gf180mcu_fd_sc_mcu9t5v0__filltie
X_10371_ _17260_/S _18270_/Q _10373_/A3 VSS _11169_/VNW VSS VSS gf180mcu_fd_sc_mcu9t5v0__nor2_1
XPHY_EDGE_ROW_188_3_Left_846 VSS VSS gf180mcu_fd_sc_mcu9t5v0__endcap
XPHY_EDGE_ROW_162_2_Right_893 VSS VSS gf180mcu_fd_sc_mcu9t5v0__endcap
XTAP_TAPCELL_ROW_113_4091 VSS VSS gf180mcu_fd_sc_mcu9t5v0__filltie
XTAP_TAPCELL_ROW_113_4080 VSS VSS gf180mcu_fd_sc_mcu9t5v0__filltie
X_12110_ _18445_/Q _12315_/S _12112_/B1 VSS VSS VSS VSS gf180mcu_fd_sc_mcu9t5v0__nand2_1
X_13090_ _16422_/A1 _13320_/B _13090_/B1 _13090_/B2 _19235_/D VSS VSS VSS VSS gf180mcu_fd_sc_mcu9t5v0__aoi22_1
XTAP_TAPCELL_ROW_299_7292 VSS VSS gf180mcu_fd_sc_mcu9t5v0__filltie
XTAP_TAPCELL_ROW_303_7399 VSS VSS gf180mcu_fd_sc_mcu9t5v0__filltie
XTAP_TAPCELL_ROW_299_7281 VSS VSS gf180mcu_fd_sc_mcu9t5v0__filltie
X_12041_ _18426_/Q _12203_/A2 _12045_/A1 VSS VSS VSS VSS gf180mcu_fd_sc_mcu9t5v0__nand2_1
XPHY_EDGE_ROW_288_Left_611 VSS VSS gf180mcu_fd_sc_mcu9t5v0__endcap
XTAP_TAPCELL_ROW_126_4441 VSS VSS gf180mcu_fd_sc_mcu9t5v0__filltie
XTAP_TAPCELL_ROW_37_1989 VSS VSS gf180mcu_fd_sc_mcu9t5v0__filltie
XTAP_TAPCELL_ROW_295_7189 VSS VSS gf180mcu_fd_sc_mcu9t5v0__filltie
XTAP_TAPCELL_ROW_295_7178 VSS VSS gf180mcu_fd_sc_mcu9t5v0__filltie
XTAP_TAPCELL_ROW_126_4452 VSS VSS gf180mcu_fd_sc_mcu9t5v0__filltie
X_16780_ _16779_/Z _18389_/Q _16784_/S _18389_/D VSS _16780_/VNW VSS VSS gf180mcu_fd_sc_mcu9t5v0__mux2_1
XTAP_TAPCELL_ROW_316_7749 VSS VSS gf180mcu_fd_sc_mcu9t5v0__filltie
XTAP_TAPCELL_ROW_122_4349 VSS VSS gf180mcu_fd_sc_mcu9t5v0__filltie
XTAP_TAPCELL_ROW_122_4338 VSS VSS gf180mcu_fd_sc_mcu9t5v0__filltie
X_15800_ _18035_/I0 _19970_/Q _15802_/S _19970_/D VSS VSS VSS VSS gf180mcu_fd_sc_mcu9t5v0__mux2_1
XTAP_TAPCELL_ROW_122_4327 VSS VSS gf180mcu_fd_sc_mcu9t5v0__filltie
X_13992_ _13992_/A1 _13992_/A2 _14034_/B VSS VSS VSS VSS gf180mcu_fd_sc_mcu9t5v0__nand2_1
X_15731_ _15761_/A1 _15731_/A2 _19924_/D VSS VSS VSS VSS gf180mcu_fd_sc_mcu9t5v0__nor2_1
X_12943_ _19780_/Q _12941_/Z _12947_/B VSS _12943_/VNW VSS VSS gf180mcu_fd_sc_mcu9t5v0__and2_1
X_18450_ _18450_/D _20132_/CLK _18450_/Q VSS VSS VSS VSS gf180mcu_fd_sc_mcu9t5v0__dffq_1
X_17401_ _18424_/Q _17406_/A2 _17405_/A2 _18440_/Q _17401_/C _17402_/B VSS _17403_/VNW
+ VSS VSS gf180mcu_fd_sc_mcu9t5v0__aoi221_1
X_15662_ _15671_/A2 _15671_/A4 _15668_/A3 VSS _15662_/VNW VSS VSS gf180mcu_fd_sc_mcu9t5v0__nand2_1
X_12874_ _19770_/Q _12871_/Z _12879_/A2 VSS VSS VSS VSS gf180mcu_fd_sc_mcu9t5v0__nor2_1
X_11825_ _18256_/Q _12315_/S _11827_/B1 VSS VSS VSS VSS gf180mcu_fd_sc_mcu9t5v0__nand2_1
X_18381_ _18381_/D clkload61/I _18381_/Q VSS VSS VSS VSS gf180mcu_fd_sc_mcu9t5v0__dffq_1
XPHY_EDGE_ROW_297_Left_620 VSS VSS gf180mcu_fd_sc_mcu9t5v0__endcap
X_15593_ _15593_/A1 _20042_/D _15597_/B1 _15593_/B2 _19882_/D VSS VSS VSS VSS gf180mcu_fd_sc_mcu9t5v0__oai22_1
XPHY_EDGE_ROW_1_Left_325 VSS VSS gf180mcu_fd_sc_mcu9t5v0__endcap
X_14613_ _19074_/Q _19491_/Q _14730_/S _19491_/D VSS _14613_/VNW VSS VSS gf180mcu_fd_sc_mcu9t5v0__mux2_1
X_11756_ _18285_/Q _12315_/S _11758_/A2 VSS VSS VSS VSS gf180mcu_fd_sc_mcu9t5v0__nand2_1
X_17332_ _18549_/Q _17394_/A2 _17352_/B VSS VSS VSS VSS gf180mcu_fd_sc_mcu9t5v0__nand2_1
X_14544_ _14540_/Z _14544_/A2 _14545_/I1 VSS wire199/VNW VSS VSS gf180mcu_fd_sc_mcu9t5v0__xnor2_1
X_17263_ _17263_/A1 _17263_/A2 _17263_/B1 _17263_/B2 _17264_/A3 VSS VSS VSS VSS gf180mcu_fd_sc_mcu9t5v0__aoi22_1
XTAP_TAPCELL_ROW_77_3105 VSS VSS gf180mcu_fd_sc_mcu9t5v0__filltie
X_10707_ _18839_/Q _18846_/Q _10706_/Z _10730_/A2 VSS _10707_/VNW VSS VSS gf180mcu_fd_sc_mcu9t5v0__nand3_1
X_14475_ _14483_/A1 _14474_/Z _14475_/B _14476_/C VSS _14475_/VNW VSS VSS gf180mcu_fd_sc_mcu9t5v0__oai21_1
X_16214_ _16151_/B _19267_/Q _16783_/S _16214_/Z VSS VSS VSS VSS gf180mcu_fd_sc_mcu9t5v0__mux2_1
X_19002_ _19002_/D _20026_/RN clkload67/I _19002_/Q VSS VSS VSS VSS gf180mcu_fd_sc_mcu9t5v0__dffrnq_1
X_11687_ _18186_/Q _12090_/B _12153_/B _11687_/C _11697_/A1 VSS _12370_/VNW VSS VSS
+ gf180mcu_fd_sc_mcu9t5v0__aoi211_1
X_13426_ _13426_/I _13427_/A2 VSS VSS VSS VSS gf180mcu_fd_sc_mcu9t5v0__clkinv_1
XTAP_TAPCELL_ROW_284_6882 VSS VSS gf180mcu_fd_sc_mcu9t5v0__filltie
X_17194_ _19826_/Q _17194_/A2 _17194_/A3 _17194_/B _17199_/C1 VSS VSS VSS VSS gf180mcu_fd_sc_mcu9t5v0__oai31_1
XTAP_TAPCELL_ROW_284_6871 VSS VSS gf180mcu_fd_sc_mcu9t5v0__filltie
X_10638_ _10459_/C _10638_/A2 _10638_/A3 _10638_/B _10643_/C1 VSS VSS VSS VSS gf180mcu_fd_sc_mcu9t5v0__oai31_1
XTAP_TAPCELL_ROW_284_6893 VSS VSS gf180mcu_fd_sc_mcu9t5v0__filltie
X_16145_ _18174_/Q _16145_/I1 _16707_/S _18174_/D VSS VSS VSS VSS gf180mcu_fd_sc_mcu9t5v0__mux2_4
X_10569_ _17306_/C _10569_/A2 _10570_/B2 VSS VSS VSS VSS gf180mcu_fd_sc_mcu9t5v0__nor2_1
X_13357_ _13357_/A1 _13357_/A2 _13377_/A1 VSS _13357_/VNW VSS VSS gf180mcu_fd_sc_mcu9t5v0__nor2_1
XTAP_TAPCELL_ROW_280_6779 VSS VSS gf180mcu_fd_sc_mcu9t5v0__filltie
X_16076_ _19239_/Q _16744_/A2 wire71/Z _16078_/A3 VSS _16078_/VNW VSS VSS gf180mcu_fd_sc_mcu9t5v0__nor3_1
XTAP_TAPCELL_ROW_280_6768 VSS VSS gf180mcu_fd_sc_mcu9t5v0__filltie
XTAP_TAPCELL_ROW_280_6757 VSS VSS gf180mcu_fd_sc_mcu9t5v0__filltie
X_12308_ _12548_/A1 _12308_/A2 _12312_/B1 VSS _14580_/VNW VSS VSS gf180mcu_fd_sc_mcu9t5v0__nand2_4
X_13288_ _13316_/A2 _19804_/Q _13325_/B1 VSS VSS VSS VSS gf180mcu_fd_sc_mcu9t5v0__nor2_1
X_12239_ _18435_/Q _12345_/A2 _12246_/A1 VSS VSS VSS VSS gf180mcu_fd_sc_mcu9t5v0__nand2_1
X_19904_ _19904_/D _09246_/I clkload41/I _19904_/Q VSS VSS VSS VSS gf180mcu_fd_sc_mcu9t5v0__dffrnq_1
X_15027_ _19629_/Q _19380_/Q _20039_/Q _19629_/D VSS VSS VSS VSS gf180mcu_fd_sc_mcu9t5v0__mux2_1
XPHY_EDGE_ROW_150_3_Right_265 VSS VSS gf180mcu_fd_sc_mcu9t5v0__endcap
X_19835_ _19835_/D _19963_/RN clkload56/I _19835_/Q VSS VSS VSS VSS gf180mcu_fd_sc_mcu9t5v0__dffrnq_1
XTAP_TAPCELL_ROW_220_5130 VSS VSS gf180mcu_fd_sc_mcu9t5v0__filltie
X_16978_ _18480_/Q _16977_/Z _16986_/S _18480_/D VSS VSS VSS VSS gf180mcu_fd_sc_mcu9t5v0__mux2_4
XTAP_TAPCELL_ROW_109_3982 VSS VSS gf180mcu_fd_sc_mcu9t5v0__filltie
X_19766_ _19766_/D _20022_/RN clkload23/I _19766_/Q VSS VSS VSS VSS gf180mcu_fd_sc_mcu9t5v0__dffrnq_1
XTAP_TAPCELL_ROW_109_3971 VSS VSS gf180mcu_fd_sc_mcu9t5v0__filltie
X_18717_ _18717_/D clkload65/I _18717_/Q VSS VSS VSS VSS gf180mcu_fd_sc_mcu9t5v0__dffq_1
X_15929_ _19195_/Q _15929_/A2 _20057_/Q _15941_/A3 _15930_/I VSS VSS VSS VSS gf180mcu_fd_sc_mcu9t5v0__nand4_1
Xinput4 din[3] input4/Z VSS VSS VSS VSS gf180mcu_fd_sc_mcu9t5v0__clkbuf_2
XTAP_TAPCELL_ROW_109_3993 VSS VSS gf180mcu_fd_sc_mcu9t5v0__filltie
XTAP_TAPCELL_ROW_105_3857 VSS VSS gf180mcu_fd_sc_mcu9t5v0__filltie
X_09450_ _09450_/A1 _15941_/A3 _09445_/Z _09450_/B _09450_/ZN VSS VSS VSS VSS gf180mcu_fd_sc_mcu9t5v0__oai31_4
XTAP_TAPCELL_ROW_105_3879 VSS VSS gf180mcu_fd_sc_mcu9t5v0__filltie
XTAP_TAPCELL_ROW_105_3868 VSS VSS gf180mcu_fd_sc_mcu9t5v0__filltie
X_19697_ _19697_/D _20145_/RN _19798_/CLK _19697_/Q VSS VSS VSS VSS gf180mcu_fd_sc_mcu9t5v0__dffrnq_1
X_18648_ _18648_/D _20052_/RN clkload47/I _18648_/Q VSS VSS VSS VSS gf180mcu_fd_sc_mcu9t5v0__dffrnq_1
XTAP_TAPCELL_ROW_0_949 VSS VSS gf180mcu_fd_sc_mcu9t5v0__filltie
XTAP_TAPCELL_ROW_47_2263 VSS VSS gf180mcu_fd_sc_mcu9t5v0__filltie
XTAP_TAPCELL_ROW_218_5070 VSS VSS gf180mcu_fd_sc_mcu9t5v0__filltie
XTAP_TAPCELL_ROW_47_2274 VSS VSS gf180mcu_fd_sc_mcu9t5v0__filltie
X_09381_ _18904_/Q _11964_/A1 VSS _09381_/VNW VSS VSS gf180mcu_fd_sc_mcu9t5v0__clkinv_1
XTAP_TAPCELL_ROW_47_2285 VSS VSS gf180mcu_fd_sc_mcu9t5v0__filltie
X_18579_ _18579_/D _20143_/RN clkload28/I _18579_/Q VSS VSS VSS VSS gf180mcu_fd_sc_mcu9t5v0__dffrnq_1
XPHY_EDGE_ROW_141_2_Left_653 VSS VSS gf180mcu_fd_sc_mcu9t5v0__endcap
XPHY_EDGE_ROW_301_Left_624 VSS VSS gf180mcu_fd_sc_mcu9t5v0__endcap
XTAP_TAPCELL_ROW_227_5317 VSS VSS gf180mcu_fd_sc_mcu9t5v0__filltie
XTAP_TAPCELL_ROW_227_5306 VSS VSS gf180mcu_fd_sc_mcu9t5v0__filltie
XPHY_EDGE_ROW_161_1_Right_745 VSS VSS gf180mcu_fd_sc_mcu9t5v0__endcap
XPHY_EDGE_ROW_65_Left_389 VSS VSS gf180mcu_fd_sc_mcu9t5v0__endcap
XPHY_EDGE_ROW_310_Left_633 VSS VSS gf180mcu_fd_sc_mcu9t5v0__endcap
Xclkbuf_leaf_25_clk_regs clkload4/I clkload63/I VSS VSS VSS VSS gf180mcu_fd_sc_mcu9t5v0__clkbuf_8
XTAP_TAPCELL_ROW_32_1853 VSS VSS gf180mcu_fd_sc_mcu9t5v0__filltie
XTAP_TAPCELL_ROW_290_7053 VSS VSS gf180mcu_fd_sc_mcu9t5v0__filltie
XTAP_TAPCELL_ROW_290_7042 VSS VSS gf180mcu_fd_sc_mcu9t5v0__filltie
X_09717_ _20065_/Q _10824_/A2 _10836_/B2 VSS VSS VSS VSS gf180mcu_fd_sc_mcu9t5v0__nor2_1
XTAP_TAPCELL_ROW_32_1864 VSS VSS gf180mcu_fd_sc_mcu9t5v0__filltie
XTAP_TAPCELL_ROW_32_1875 VSS VSS gf180mcu_fd_sc_mcu9t5v0__filltie
XPHY_EDGE_ROW_74_Left_398 VSS VSS gf180mcu_fd_sc_mcu9t5v0__endcap
XTAP_TAPCELL_ROW_311_7635 VSS VSS gf180mcu_fd_sc_mcu9t5v0__filltie
XTAP_TAPCELL_ROW_311_7624 VSS VSS gf180mcu_fd_sc_mcu9t5v0__filltie
XTAP_TAPCELL_ROW_311_7613 VSS VSS gf180mcu_fd_sc_mcu9t5v0__filltie
X_09648_ _09703_/A3 _09634_/Z _19996_/Q _09698_/A2 VSS _09698_/VNW VSS VSS gf180mcu_fd_sc_mcu9t5v0__oai21_1
X_09579_ _18579_/Q _18580_/Q _18581_/Q _18582_/Q _09582_/A3 VSS VSS VSS VSS gf180mcu_fd_sc_mcu9t5v0__nor4_1
X_12590_ _18405_/Q wire163/Z _12593_/A3 VSS _12593_/VNW VSS VSS gf180mcu_fd_sc_mcu9t5v0__nor2_1
X_11610_ _11610_/A1 _11594_/Z _11610_/B _11612_/A2 VSS VSS VSS VSS gf180mcu_fd_sc_mcu9t5v0__aoi21_1
XTAP_TAPCELL_ROW_212_4907 VSS VSS gf180mcu_fd_sc_mcu9t5v0__filltie
X_11541_ _19105_/Q _11541_/A2 _11542_/A2 VSS VSS VSS VSS gf180mcu_fd_sc_mcu9t5v0__nand2_1
XTAP_TAPCELL_ROW_115_4153 VSS VSS gf180mcu_fd_sc_mcu9t5v0__filltie
XTAP_TAPCELL_ROW_115_4142 VSS VSS gf180mcu_fd_sc_mcu9t5v0__filltie
XTAP_TAPCELL_ROW_309_7575 VSS VSS gf180mcu_fd_sc_mcu9t5v0__filltie
XTAP_TAPCELL_ROW_309_7564 VSS VSS gf180mcu_fd_sc_mcu9t5v0__filltie
X_11472_ _18387_/Q _11509_/A2 _11537_/S _11472_/C _11474_/B1 VSS VSS VSS VSS gf180mcu_fd_sc_mcu9t5v0__oai211_1
XPHY_EDGE_ROW_189_3_Right_304 VSS VSS gf180mcu_fd_sc_mcu9t5v0__endcap
XTAP_TAPCELL_ROW_111_4028 VSS VSS gf180mcu_fd_sc_mcu9t5v0__filltie
X_14260_ _14259_/Z _19340_/Q _14266_/S _19340_/D VSS VSS VSS VSS gf180mcu_fd_sc_mcu9t5v0__mux2_1
X_10423_ _10423_/A1 _10423_/A2 _10423_/B1 _10423_/B2 _10423_/ZN VSS VSS VSS VSS gf180mcu_fd_sc_mcu9t5v0__aoi22_4
X_13211_ _13211_/A1 _13211_/A2 _13217_/B1 VSS VSS VSS VSS gf180mcu_fd_sc_mcu9t5v0__nand2_1
XTAP_TAPCELL_ROW_111_4039 VSS VSS gf180mcu_fd_sc_mcu9t5v0__filltie
X_14191_ _14191_/A1 _14191_/A2 _14205_/A1 VSS _14191_/VNW VSS VSS gf180mcu_fd_sc_mcu9t5v0__nand2_1
X_10354_ _17278_/C _10354_/A2 _10354_/B _10354_/C _10355_/A2 VSS VSS VSS VSS gf180mcu_fd_sc_mcu9t5v0__oai211_1
XPHY_EDGE_ROW_163_2_Right_894 VSS VSS gf180mcu_fd_sc_mcu9t5v0__endcap
X_13142_ _13142_/A1 _13142_/A2 _13149_/B1 VSS _13142_/VNW VSS VSS gf180mcu_fd_sc_mcu9t5v0__nand2_1
XTAP_TAPCELL_ROW_297_7229 VSS VSS gf180mcu_fd_sc_mcu9t5v0__filltie
XTAP_TAPCELL_ROW_128_4514 VSS VSS gf180mcu_fd_sc_mcu9t5v0__filltie
XTAP_TAPCELL_ROW_128_4503 VSS VSS gf180mcu_fd_sc_mcu9t5v0__filltie
XPHY_EDGE_ROW_291_Right_218 VSS VSS gf180mcu_fd_sc_mcu9t5v0__endcap
X_10285_ _19942_/Q wire216/Z _10655_/B _10286_/B2 VSS _10285_/VNW VSS VSS gf180mcu_fd_sc_mcu9t5v0__aoi21_1
X_17950_ _17950_/A1 _18856_/Q _09399_/Z _17969_/A2 VSS _17950_/VNW VSS VSS gf180mcu_fd_sc_mcu9t5v0__nor3_1
X_13073_ _13073_/A1 _13529_/A2 _13073_/B _13094_/A2 VSS VSS VSS VSS gf180mcu_fd_sc_mcu9t5v0__oai21_1
X_16901_ _16584_/B _19246_/Q _16925_/S _16901_/Z VSS VSS VSS VSS gf180mcu_fd_sc_mcu9t5v0__mux2_1
X_12024_ _18457_/Q _12181_/A2 _12092_/B _12025_/B2 VSS VSS VSS VSS gf180mcu_fd_sc_mcu9t5v0__aoi21_1
X_17881_ _17881_/A1 _17885_/S _17881_/B _18833_/D VSS _17881_/VNW VSS VSS gf180mcu_fd_sc_mcu9t5v0__aoi21_1
X_16832_ _16832_/A1 _16832_/A2 _16961_/B _16831_/Z _18408_/D VSS _16832_/VNW VSS VSS
+ gf180mcu_fd_sc_mcu9t5v0__aoi22_1
X_19620_ _19620_/D _20068_/RN clkload9/I _19620_/Q VSS VSS VSS VSS gf180mcu_fd_sc_mcu9t5v0__dffrnq_1
XTAP_TAPCELL_ROW_204_1_4772 VSS VSS gf180mcu_fd_sc_mcu9t5v0__filltie
X_19551_ _19551_/D _20063_/RN clkload31/I _19551_/Q VSS VSS VSS VSS gf180mcu_fd_sc_mcu9t5v0__dffrnq_1
X_16763_ _16599_/B _19280_/Q _16763_/S _16763_/Z VSS VSS VSS VSS gf180mcu_fd_sc_mcu9t5v0__mux2_1
X_18502_ _18502_/D clkload82/I _18502_/Q VSS VSS VSS VSS gf180mcu_fd_sc_mcu9t5v0__dffq_1
X_13975_ _13976_/A2 _13976_/A3 _13999_/A2 VSS _13975_/VNW VSS VSS gf180mcu_fd_sc_mcu9t5v0__nor2_1
XTAP_TAPCELL_ROW_273_6583 VSS VSS gf180mcu_fd_sc_mcu9t5v0__filltie
X_16694_ _18365_/Q _16747_/A2 _16747_/A3 _16698_/B VSS VSS VSS VSS gf180mcu_fd_sc_mcu9t5v0__nand3_1
XTAP_TAPCELL_ROW_273_6572 VSS VSS gf180mcu_fd_sc_mcu9t5v0__filltie
X_15714_ _15726_/S _15708_/Z _15716_/A2 VSS VSS VSS VSS gf180mcu_fd_sc_mcu9t5v0__nor2_1
X_12926_ _13435_/A2 _12926_/A2 _12923_/Z _12927_/I0 VSS VSS VSS VSS gf180mcu_fd_sc_mcu9t5v0__xnor3_1
X_19482_ _19482_/D _20058_/RN clkload12/I _19482_/Q VSS VSS VSS VSS gf180mcu_fd_sc_mcu9t5v0__dffrnq_1
X_18433_ _18433_/D _18433_/CLK _18433_/Q VSS VSS VSS VSS gf180mcu_fd_sc_mcu9t5v0__dffq_4
XTAP_TAPCELL_ROW_100_3743 VSS VSS gf180mcu_fd_sc_mcu9t5v0__filltie
X_15645_ _19900_/Q _15645_/A2 _15646_/A2 VSS VSS VSS VSS gf180mcu_fd_sc_mcu9t5v0__xnor2_1
XTAP_TAPCELL_ROW_100_3732 VSS VSS gf180mcu_fd_sc_mcu9t5v0__filltie
XTAP_TAPCELL_ROW_100_3721 VSS VSS gf180mcu_fd_sc_mcu9t5v0__filltie
X_12857_ _12861_/B _12857_/A2 _12861_/A2 VSS _12861_/VNW VSS VSS gf180mcu_fd_sc_mcu9t5v0__nor2_1
X_18364_ _18364_/D clkload61/I _18364_/Q VSS VSS VSS VSS gf180mcu_fd_sc_mcu9t5v0__dffq_4
X_11808_ _12164_/B _11809_/A3 _11808_/B _11832_/A2 VSS VSS VSS VSS gf180mcu_fd_sc_mcu9t5v0__aoi21_4
X_17315_ _09261_/I _17315_/A2 _17315_/A3 _17315_/B _17324_/A2 VSS _17315_/VNW VSS
+ VSS gf180mcu_fd_sc_mcu9t5v0__oai31_1
XTAP_TAPCELL_ROW_286_6933 VSS VSS gf180mcu_fd_sc_mcu9t5v0__filltie
XTAP_TAPCELL_ROW_286_6922 VSS VSS gf180mcu_fd_sc_mcu9t5v0__filltie
X_15576_ _15576_/A1 _15576_/A2 _15576_/A3 _15576_/Z VSS VSS VSS VSS gf180mcu_fd_sc_mcu9t5v0__and3_1
X_12788_ _19757_/Q _12787_/Z _12788_/Z VSS VSS VSS VSS gf180mcu_fd_sc_mcu9t5v0__and2_1
XTAP_TAPCELL_ROW_286_6944 VSS VSS gf180mcu_fd_sc_mcu9t5v0__filltie
X_18295_ _18295_/D clkload81/I _18295_/Q VSS VSS VSS VSS gf180mcu_fd_sc_mcu9t5v0__dffq_1
X_11739_ _18714_/Q _12527_/A2 wire208/Z _11739_/B2 _11740_/A2 VSS VSS VSS VSS gf180mcu_fd_sc_mcu9t5v0__aoi22_2
X_14527_ _19132_/Q _14526_/Z wire199/I _14527_/Z VSS VSS VSS VSS gf180mcu_fd_sc_mcu9t5v0__mux2_1
X_17246_ _18610_/Q _17306_/C _17247_/B VSS VSS VSS VSS gf180mcu_fd_sc_mcu9t5v0__nand2_1
XTAP_TAPCELL_ROW_282_6819 VSS VSS gf180mcu_fd_sc_mcu9t5v0__filltie
XPHY_EDGE_ROW_212_Right_139 VSS VSS gf180mcu_fd_sc_mcu9t5v0__endcap
X_14458_ _19158_/Q _19124_/Q _14458_/Z VSS VSS VSS VSS gf180mcu_fd_sc_mcu9t5v0__xor2_1
X_17177_ _17177_/A1 _17177_/A2 _17177_/B _17180_/A1 VSS _17177_/VNW VSS VSS gf180mcu_fd_sc_mcu9t5v0__aoi21_1
X_13409_ _19744_/Q _13409_/A2 _13620_/B VSS VSS VSS VSS gf180mcu_fd_sc_mcu9t5v0__xnor2_1
X_14389_ _14400_/A1 _19115_/Q _14400_/C _14392_/A1 VSS VSS VSS VSS gf180mcu_fd_sc_mcu9t5v0__aoi21_1
X_16128_ _16016_/B _16730_/A1 _16730_/C _16128_/C _16130_/A2 VSS VSS VSS VSS gf180mcu_fd_sc_mcu9t5v0__aoi211_1
Xrst_tree_leaf_30 rst_tree_mid_3/Z _20053_/RN VSS VSS VSS VSS gf180mcu_fd_sc_mcu9t5v0__clkbuf_16
Xrst_tree_leaf_41 rst_tree_mid_5/Z _20042_/RN VSS VSS VSS VSS gf180mcu_fd_sc_mcu9t5v0__clkbuf_16
X_16059_ _19236_/Q _16751_/A2 wire71/Z _16060_/A3 VSS _16554_/VNW VSS VSS gf180mcu_fd_sc_mcu9t5v0__nor3_1
Xrst_tree_leaf_52 rst_tree_mid_6/Z _20031_/RN VSS VSS VSS VSS gf180mcu_fd_sc_mcu9t5v0__clkbuf_16
Xrst_tree_leaf_63 rst_tree_mid_7/Z _20020_/RN VSS VSS VSS VSS gf180mcu_fd_sc_mcu9t5v0__clkbuf_16
XPHY_EDGE_ROW_151_3_Right_266 VSS VSS gf180mcu_fd_sc_mcu9t5v0__endcap
XPHY_EDGE_ROW_135_Right_135 VSS VSS gf180mcu_fd_sc_mcu9t5v0__endcap
X_19818_ _19818_/D _20138_/RN clkload58/I _19818_/Q VSS VSS VSS VSS gf180mcu_fd_sc_mcu9t5v0__dffrnq_1
XTAP_TAPCELL_ROW_107_3919 VSS VSS gf180mcu_fd_sc_mcu9t5v0__filltie
X_19749_ _19749_/D _20069_/RN clkload39/I _19749_/Q VSS VSS VSS VSS gf180mcu_fd_sc_mcu9t5v0__dffrnq_1
XTAP_TAPCELL_ROW_49_2325 VSS VSS gf180mcu_fd_sc_mcu9t5v0__filltie
XTAP_TAPCELL_ROW_49_2336 VSS VSS gf180mcu_fd_sc_mcu9t5v0__filltie
X_09502_ _19106_/Q _14730_/S _11546_/A1 VSS _09502_/VNW VSS VSS gf180mcu_fd_sc_mcu9t5v0__nand2_1
XTAP_TAPCELL_ROW_216_5007 VSS VSS gf180mcu_fd_sc_mcu9t5v0__filltie
XTAP_TAPCELL_ROW_216_5018 VSS VSS gf180mcu_fd_sc_mcu9t5v0__filltie
X_09433_ _20055_/Q _09889_/A2 _09615_/A2 VSS _09433_/VNW VSS VSS gf180mcu_fd_sc_mcu9t5v0__nor2_1
X_09364_ _18317_/Q _11153_/A1 VSS VSS VSS VSS gf180mcu_fd_sc_mcu9t5v0__clkinv_1
XTAP_TAPCELL_ROW_252_5999 VSS VSS gf180mcu_fd_sc_mcu9t5v0__filltie
XTAP_TAPCELL_ROW_252_5988 VSS VSS gf180mcu_fd_sc_mcu9t5v0__filltie
XANTENNA_20 output16/I VSS ANTENNA_20/VNW VSS VSS gf180mcu_fd_sc_mcu9t5v0__antenna
X_09295_ _19253_/Q _16719_/A1 VSS VSS VSS VSS gf180mcu_fd_sc_mcu9t5v0__clkinv_1
XPHY_EDGE_ROW_136_1_Left_647 VSS VSS gf180mcu_fd_sc_mcu9t5v0__endcap
XTAP_TAPCELL_ROW_21_1554 VSS VSS gf180mcu_fd_sc_mcu9t5v0__filltie
XTAP_TAPCELL_ROW_21_1565 VSS VSS gf180mcu_fd_sc_mcu9t5v0__filltie
XTAP_TAPCELL_ROW_300_7325 VSS VSS gf180mcu_fd_sc_mcu9t5v0__filltie
XTAP_TAPCELL_ROW_300_7314 VSS VSS gf180mcu_fd_sc_mcu9t5v0__filltie
XPHY_EDGE_ROW_162_1_Right_746 VSS VSS gf180mcu_fd_sc_mcu9t5v0__endcap
XTAP_TAPCELL_ROW_34_1904 VSS VSS gf180mcu_fd_sc_mcu9t5v0__filltie
XTAP_TAPCELL_ROW_292_7104 VSS VSS gf180mcu_fd_sc_mcu9t5v0__filltie
X_10070_ _10659_/C _10074_/A2 _10071_/A3 VSS VSS VSS VSS gf180mcu_fd_sc_mcu9t5v0__nor2_1
XTAP_TAPCELL_ROW_34_1915 VSS VSS gf180mcu_fd_sc_mcu9t5v0__filltie
XTAP_TAPCELL_ROW_34_1926 VSS VSS gf180mcu_fd_sc_mcu9t5v0__filltie
XTAP_TAPCELL_ROW_317_7800 VSS VSS gf180mcu_fd_sc_mcu9t5v0__filltie
XPHY_EDGE_ROW_102_Right_102 VSS VSS gf180mcu_fd_sc_mcu9t5v0__endcap
XTAP_TAPCELL_ROW_19_1494 VSS VSS gf180mcu_fd_sc_mcu9t5v0__filltie
XPHY_EDGE_ROW_82_Left_406 VSS VSS gf180mcu_fd_sc_mcu9t5v0__endcap
Xmax_cap22 _17042_/S _17058_/S VSS VSS VSS VSS gf180mcu_fd_sc_mcu9t5v0__buf_4
Xmax_cap44 _16770_/S _16764_/S VSS VSS VSS VSS gf180mcu_fd_sc_mcu9t5v0__buf_8
X_10972_ _10966_/Z _10972_/A2 _10979_/A1 VSS _10972_/VNW VSS VSS gf180mcu_fd_sc_mcu9t5v0__nor2_1
X_13760_ _19316_/Q _19293_/Q _13803_/A1 VSS VSS VSS VSS gf180mcu_fd_sc_mcu9t5v0__nand2_1
Xmax_cap77 wire79/Z _15912_/S VSS VSS VSS VSS gf180mcu_fd_sc_mcu9t5v0__clkbuf_4
Xmax_cap88 _16763_/S _16783_/S VSS VSS VSS VSS gf180mcu_fd_sc_mcu9t5v0__buf_4
X_12711_ _12716_/S _12711_/A2 _12711_/B _12712_/A2 VSS VSS VSS VSS gf180mcu_fd_sc_mcu9t5v0__oai21_1
X_13691_ _19452_/Q _13733_/A2 _14286_/A2 _19443_/Q _19469_/Q _13656_/Z _13692_/A2
+ VSS VSS VSS VSS gf180mcu_fd_sc_mcu9t5v0__aoi222_1
XTAP_TAPCELL_ROW_117_4204 VSS VSS gf180mcu_fd_sc_mcu9t5v0__filltie
X_15430_ _19715_/Q _19815_/Q _15430_/S _19815_/D VSS VSS VSS VSS gf180mcu_fd_sc_mcu9t5v0__mux2_1
X_12642_ _12665_/B _12675_/B _12644_/B VSS VSS VSS VSS gf180mcu_fd_sc_mcu9t5v0__nand2_1
Xmax_cap99 _12488_/I _12620_/A1 VSS _15418_/VNW VSS VSS gf180mcu_fd_sc_mcu9t5v0__clkbuf_8
X_12573_ _18355_/Q _12613_/A2 _12577_/A2 VSS VSS VSS VSS gf180mcu_fd_sc_mcu9t5v0__nor2_1
X_15361_ _19748_/Q _15361_/I1 _15364_/S _19748_/D VSS _15361_/VNW VSS VSS gf180mcu_fd_sc_mcu9t5v0__mux2_1
X_11524_ _18407_/Q _18391_/Q _11524_/S _11524_/Z VSS VSS VSS VSS gf180mcu_fd_sc_mcu9t5v0__mux2_1
X_17100_ _17195_/A1 _18442_/Q _17103_/A2 VSS _17100_/VNW VSS VSS gf180mcu_fd_sc_mcu9t5v0__nor2_1
X_18080_ _18080_/A1 _18080_/A2 _18930_/D VSS VSS VSS VSS gf180mcu_fd_sc_mcu9t5v0__nand2_1
X_15292_ _15417_/S _15292_/A2 _15292_/B _19735_/D VSS VSS VSS VSS gf180mcu_fd_sc_mcu9t5v0__oai21_1
X_14312_ _13904_/Z _19385_/Q _14322_/S _19385_/D VSS _14312_/VNW VSS VSS gf180mcu_fd_sc_mcu9t5v0__mux2_1
XPHY_EDGE_ROW_91_Left_415 VSS VSS gf180mcu_fd_sc_mcu9t5v0__endcap
X_17031_ _16584_/B _19246_/Q _17055_/S _17031_/Z VSS VSS VSS VSS gf180mcu_fd_sc_mcu9t5v0__mux2_1
X_11455_ _18530_/Q _18514_/Q _18466_/Q _18450_/Q _11534_/S _11469_/B _11455_/Z VSS
+ VSS VSS VSS gf180mcu_fd_sc_mcu9t5v0__mux4_1
XPHY_EDGE_ROW_216_Left_539 VSS VSS gf180mcu_fd_sc_mcu9t5v0__endcap
X_14243_ _14115_/Z _14243_/A2 _14243_/B _14251_/A1 VSS VSS VSS VSS gf180mcu_fd_sc_mcu9t5v0__aoi21_1
XTAP_TAPCELL_ROW_95_3591 VSS VSS gf180mcu_fd_sc_mcu9t5v0__filltie
X_10406_ _17404_/S _18335_/Q _10408_/A3 VSS VSS VSS VSS gf180mcu_fd_sc_mcu9t5v0__nor2_1
X_11386_ _18461_/Q _11524_/S _11520_/B _11388_/A2 VSS _17170_/VNW VSS VSS gf180mcu_fd_sc_mcu9t5v0__oai21_1
XTAP_TAPCELL_ROW_262_6284 VSS VSS gf180mcu_fd_sc_mcu9t5v0__filltie
XTAP_TAPCELL_ROW_262_6273 VSS VSS gf180mcu_fd_sc_mcu9t5v0__filltie
XTAP_TAPCELL_ROW_262_6262 VSS VSS gf180mcu_fd_sc_mcu9t5v0__filltie
XTAP_TAPCELL_ROW_91_3488 VSS VSS gf180mcu_fd_sc_mcu9t5v0__filltie
X_14174_ _14359_/I0 _19329_/Q _14266_/S _19329_/D VSS VSS VSS VSS gf180mcu_fd_sc_mcu9t5v0__mux2_1
XTAP_TAPCELL_ROW_91_3477 VSS VSS gf180mcu_fd_sc_mcu9t5v0__filltie
X_10337_ _10654_/A2 _10337_/A2 _10337_/A3 _10338_/B VSS VSS VSS VSS gf180mcu_fd_sc_mcu9t5v0__nand3_1
X_18982_ _18982_/D _20070_/RN clkload69/I _18982_/Q VSS VSS VSS VSS gf180mcu_fd_sc_mcu9t5v0__dffrnq_1
XPHY_EDGE_ROW_164_2_Right_895 VSS VSS gf180mcu_fd_sc_mcu9t5v0__endcap
Xload_slew204 _09553_/I _17844_/S VSS _15573_/VNW VSS VSS gf180mcu_fd_sc_mcu9t5v0__clkbuf_8
X_13125_ _13145_/B1 _13145_/B2 _13145_/C _13127_/A3 VSS VSS VSS VSS gf180mcu_fd_sc_mcu9t5v0__aoi21_1
Xload_slew226 _19825_/Q _17404_/S VSS VSS VSS VSS gf180mcu_fd_sc_mcu9t5v0__clkbuf_16
X_10268_ _17195_/A1 _18186_/Q _10271_/A2 VSS VSS VSS VSS gf180mcu_fd_sc_mcu9t5v0__nor2_1
X_13056_ _13529_/A2 _13055_/Z _13059_/A2 VSS _13056_/VNW VSS VSS gf180mcu_fd_sc_mcu9t5v0__nor2_1
X_17933_ _17923_/I _17931_/Z _17933_/A3 _17968_/A1 _17933_/B2 _18848_/D VSS VSS VSS
+ VSS gf180mcu_fd_sc_mcu9t5v0__oai32_1
X_12007_ _18906_/Q _12007_/A2 _12007_/B _12008_/A3 VSS VSS VSS VSS gf180mcu_fd_sc_mcu9t5v0__aoi21_1
XTAP_TAPCELL_ROW_275_6645 VSS VSS gf180mcu_fd_sc_mcu9t5v0__filltie
XTAP_TAPCELL_ROW_275_6634 VSS VSS gf180mcu_fd_sc_mcu9t5v0__filltie
XTAP_TAPCELL_ROW_275_6623 VSS VSS gf180mcu_fd_sc_mcu9t5v0__filltie
X_17864_ _17864_/A1 _17864_/A2 _17867_/A2 VSS _17867_/VNW VSS VSS gf180mcu_fd_sc_mcu9t5v0__nand2_1
X_10199_ _20048_/Q _10201_/A2 _10200_/A2 VSS _10201_/VNW VSS VSS gf180mcu_fd_sc_mcu9t5v0__nand2_1
X_19603_ _19603_/D _20051_/RN clkload8/I _19603_/Q VSS VSS VSS VSS gf180mcu_fd_sc_mcu9t5v0__dffrnq_1
X_16815_ _19287_/Q _16815_/A2 _16817_/A1 VSS _16815_/VNW VSS VSS gf180mcu_fd_sc_mcu9t5v0__nand2_1
X_17795_ _18773_/Q _18760_/Q _18769_/D _18773_/D VSS VSS VSS VSS gf180mcu_fd_sc_mcu9t5v0__mux2_1
XPHY_EDGE_ROW_225_Left_548 VSS VSS gf180mcu_fd_sc_mcu9t5v0__endcap
X_16746_ _16725_/C _16746_/A2 _16746_/A3 _16746_/B _16748_/A2 VSS _16927_/VNW VSS
+ VSS gf180mcu_fd_sc_mcu9t5v0__oai31_1
XTAP_TAPCELL_ROW_256_6099 VSS VSS gf180mcu_fd_sc_mcu9t5v0__filltie
X_13958_ _13955_/Z _13958_/A2 _13989_/A2 VSS _14022_/VNW VSS VSS gf180mcu_fd_sc_mcu9t5v0__xnor2_1
X_19534_ _19534_/D _20046_/RN clkload29/I _19534_/Q VSS VSS VSS VSS gf180mcu_fd_sc_mcu9t5v0__dffrnq_1
X_12909_ _19743_/Q _19808_/Q _12948_/S _12909_/Z VSS _12913_/VNW VSS VSS gf180mcu_fd_sc_mcu9t5v0__mux2_1
X_19465_ _19465_/D _20041_/RN clkload34/I _19465_/Q VSS VSS VSS VSS gf180mcu_fd_sc_mcu9t5v0__dffrnq_1
XTAP_TAPCELL_ROW_44_2200 VSS VSS gf180mcu_fd_sc_mcu9t5v0__filltie
X_18416_ _18416_/D clkload72/I _18416_/Q VSS VSS VSS VSS gf180mcu_fd_sc_mcu9t5v0__dffq_1
X_16677_ _18361_/Q _16747_/A2 _16747_/A3 _16681_/B VSS VSS VSS VSS gf180mcu_fd_sc_mcu9t5v0__nand3_1
X_13889_ _13891_/B2 _19323_/Q _13892_/A3 VSS VSS VSS VSS gf180mcu_fd_sc_mcu9t5v0__nand2_1
X_15628_ _19893_/Q _15623_/Z _15628_/B _19893_/D VSS VSS VSS VSS gf180mcu_fd_sc_mcu9t5v0__oai21_1
X_19396_ _19396_/D _20036_/RN clkload8/I _19396_/Q VSS VSS VSS VSS gf180mcu_fd_sc_mcu9t5v0__dffrnq_1
X_18347_ _18347_/D clkload62/I _18347_/Q VSS VSS VSS VSS gf180mcu_fd_sc_mcu9t5v0__dffq_1
X_15559_ _19872_/Q _15553_/Z _19873_/Q _15560_/A3 VSS VSS VSS VSS gf180mcu_fd_sc_mcu9t5v0__aoi21_1
X_18278_ _18278_/D _18328_/CLK _18278_/Q VSS VSS VSS VSS gf180mcu_fd_sc_mcu9t5v0__dffq_4
X_09080_ _20055_/Q _17426_/A1 VSS VSS VSS VSS gf180mcu_fd_sc_mcu9t5v0__clkinv_1
XPHY_EDGE_ROW_234_Left_557 VSS VSS gf180mcu_fd_sc_mcu9t5v0__endcap
XPHY_EDGE_ROW_253_Right_180 VSS VSS gf180mcu_fd_sc_mcu9t5v0__endcap
X_17229_ _20030_/Q _17420_/S _17229_/A3 _17229_/B _18543_/D VSS VSS VSS VSS gf180mcu_fd_sc_mcu9t5v0__oai31_1
XTAP_TAPCELL_ROW_38_2015 VSS VSS gf180mcu_fd_sc_mcu9t5v0__filltie
XTAP_TAPCELL_ROW_38_2026 VSS VSS gf180mcu_fd_sc_mcu9t5v0__filltie
XTAP_TAPCELL_ROW_38_2037 VSS VSS gf180mcu_fd_sc_mcu9t5v0__filltie
X_09982_ _19246_/Q wire297/Z _10168_/B1 _19206_/Q _09984_/A1 VSS VSS VSS VSS gf180mcu_fd_sc_mcu9t5v0__aoi22_1
XTAP_TAPCELL_ROW_241_5689 VSS VSS gf180mcu_fd_sc_mcu9t5v0__filltie
XPHY_EDGE_ROW_243_Left_566 VSS VSS gf180mcu_fd_sc_mcu9t5v0__endcap
XPHY_EDGE_ROW_152_3_Right_267 VSS VSS gf180mcu_fd_sc_mcu9t5v0__endcap
XTAP_TAPCELL_ROW_14_1380 VSS VSS gf180mcu_fd_sc_mcu9t5v0__filltie
XTAP_TAPCELL_ROW_10_1244 VSS VSS gf180mcu_fd_sc_mcu9t5v0__filltie
XPHY_EDGE_ROW_197_3_Left_855 VSS VSS gf180mcu_fd_sc_mcu9t5v0__endcap
XTAP_TAPCELL_ROW_10_1255 VSS VSS gf180mcu_fd_sc_mcu9t5v0__filltie
XTAP_TAPCELL_ROW_10_1266 VSS VSS gf180mcu_fd_sc_mcu9t5v0__filltie
X_09416_ _18938_/Q _09416_/A2 _09416_/B _09416_/C _09417_/I VSS VSS VSS VSS gf180mcu_fd_sc_mcu9t5v0__aoi211_4
XTAP_TAPCELL_ROW_27_1730 VSS VSS gf180mcu_fd_sc_mcu9t5v0__filltie
XPHY_EDGE_ROW_252_Left_575 VSS VSS gf180mcu_fd_sc_mcu9t5v0__endcap
XTAP_TAPCELL_ROW_23_1605 VSS VSS gf180mcu_fd_sc_mcu9t5v0__filltie
XTAP_TAPCELL_ROW_23_1616 VSS VSS gf180mcu_fd_sc_mcu9t5v0__filltie
X_09347_ _19473_/Q _14595_/A1 VSS _09347_/VNW VSS VSS gf180mcu_fd_sc_mcu9t5v0__clkinv_1
X_09278_ _20063_/Q _10822_/A1 VSS _17208_/VNW VSS VSS gf180mcu_fd_sc_mcu9t5v0__clkinv_1
XTAP_TAPCELL_ROW_23_1627 VSS VSS gf180mcu_fd_sc_mcu9t5v0__filltie
X_11240_ _11469_/B _11239_/Z _11538_/B _11241_/B2 VSS _16218_/VNW VSS VSS gf180mcu_fd_sc_mcu9t5v0__aoi21_1
X_11171_ _11521_/B _11171_/A2 _11171_/A3 _11172_/B VSS VSS VSS VSS gf180mcu_fd_sc_mcu9t5v0__nand3_1
Xclkbuf_leaf_40_clk_regs clkload6/I clkload77/I VSS _16752_/VNW VSS VSS gf180mcu_fd_sc_mcu9t5v0__clkbuf_8
X_10122_ _18992_/Q wire297/Z wire285/Z _19000_/Q _10138_/A2 _18976_/Q _10126_/A2 VSS
+ VSS VSS VSS gf180mcu_fd_sc_mcu9t5v0__aoi222_1
XPHY_EDGE_ROW_163_1_Right_747 VSS VSS gf180mcu_fd_sc_mcu9t5v0__endcap
XPHY_EDGE_ROW_261_Left_584 VSS VSS gf180mcu_fd_sc_mcu9t5v0__endcap
X_10053_ _10659_/C _18974_/Q _10054_/A3 VSS _10053_/VNW VSS VSS gf180mcu_fd_sc_mcu9t5v0__nor2_1
X_14930_ _14930_/A1 _14923_/B _14927_/Z _14932_/A3 VSS _14930_/VNW VSS VSS gf180mcu_fd_sc_mcu9t5v0__nand3_1
X_14861_ _19587_/Q _19348_/Q _14900_/S _19587_/D VSS VSS VSS VSS gf180mcu_fd_sc_mcu9t5v0__mux2_1
X_16600_ _19248_/Q _16700_/A2 wire71/I _16601_/A3 VSS VSS VSS VSS gf180mcu_fd_sc_mcu9t5v0__nor3_1
X_17580_ _18648_/Q _17580_/I1 _17584_/S _18648_/D VSS _17692_/VNW VSS VSS gf180mcu_fd_sc_mcu9t5v0__mux2_1
X_13812_ _19320_/Q _19294_/Q _13851_/A1 VSS _13814_/VNW VSS VSS gf180mcu_fd_sc_mcu9t5v0__nand2_1
X_16531_ _16162_/B _19237_/Q _17057_/S _16531_/Z VSS VSS VSS VSS gf180mcu_fd_sc_mcu9t5v0__mux2_4
XTAP_TAPCELL_ROW_84_3292 VSS VSS gf180mcu_fd_sc_mcu9t5v0__filltie
X_14792_ _09462_/I _14792_/A2 _14792_/B _19569_/D VSS VSS VSS VSS gf180mcu_fd_sc_mcu9t5v0__oai21_1
XTAP_TAPCELL_ROW_84_3281 VSS VSS gf180mcu_fd_sc_mcu9t5v0__filltie
X_10955_ _18925_/Q _18924_/Q _18044_/B VSS VSS VSS VSS gf180mcu_fd_sc_mcu9t5v0__nor2_1
X_13743_ _13743_/A1 _13743_/A2 _14624_/S _13744_/C VSS VSS VSS VSS gf180mcu_fd_sc_mcu9t5v0__aoi21_1
XTAP_TAPCELL_ROW_80_3178 VSS VSS gf180mcu_fd_sc_mcu9t5v0__filltie
X_16462_ _18289_/Q _16461_/Z _16990_/S _18289_/D VSS VSS VSS VSS gf180mcu_fd_sc_mcu9t5v0__mux2_4
X_10886_ _16430_/A1 _18147_/S _10892_/B _10887_/I0 VSS _10886_/VNW VSS VSS gf180mcu_fd_sc_mcu9t5v0__oai21_1
XPHY_EDGE_ROW_270_Left_593 VSS VSS gf180mcu_fd_sc_mcu9t5v0__endcap
XTAP_TAPCELL_ROW_80_3189 VSS VSS gf180mcu_fd_sc_mcu9t5v0__filltie
X_19250_ _19250_/D _20018_/RN clkload26/I _19250_/Q VSS VSS VSS VSS gf180mcu_fd_sc_mcu9t5v0__dffrnq_2
X_13674_ _19143_/Q _19109_/Q _13675_/B VSS VSS VSS VSS gf180mcu_fd_sc_mcu9t5v0__xor2_1
X_16393_ _16172_/C _19239_/Q _16927_/S _16393_/Z VSS VSS VSS VSS gf180mcu_fd_sc_mcu9t5v0__mux2_1
X_18201_ _18201_/D clkload64/I _18201_/Q VSS VSS VSS VSS gf180mcu_fd_sc_mcu9t5v0__dffq_1
X_12625_ _12664_/C _12658_/A2 _12626_/A2 VSS VSS VSS VSS gf180mcu_fd_sc_mcu9t5v0__nand2_1
X_19181_ _19181_/D _20141_/RN clkload13/I _19181_/Q VSS VSS VSS VSS gf180mcu_fd_sc_mcu9t5v0__dffrnq_1
X_15413_ _19698_/Q _19798_/Q _15430_/S _19798_/D VSS VSS VSS VSS gf180mcu_fd_sc_mcu9t5v0__mux2_1
XTAP_TAPCELL_ROW_97_3642 VSS VSS gf180mcu_fd_sc_mcu9t5v0__filltie
X_18132_ _18132_/A1 _18147_/S _18132_/B _18133_/I0 VSS VSS VSS VSS gf180mcu_fd_sc_mcu9t5v0__oai21_1
XTAP_TAPCELL_ROW_97_3653 VSS VSS gf180mcu_fd_sc_mcu9t5v0__filltie
X_15344_ _19745_/Q _15344_/I1 _15364_/S _19745_/D VSS VSS VSS VSS gf180mcu_fd_sc_mcu9t5v0__mux2_1
X_12556_ _12620_/A1 _12620_/A2 _12556_/A3 _12556_/B _19165_/D VSS _12556_/VNW VSS
+ VSS gf180mcu_fd_sc_mcu9t5v0__oai31_1
XTAP_TAPCELL_ROW_264_6335 VSS VSS gf180mcu_fd_sc_mcu9t5v0__filltie
X_11507_ _18374_/Q _11537_/S _11538_/B _11507_/C _11514_/A1 VSS VSS VSS VSS gf180mcu_fd_sc_mcu9t5v0__oai211_1
XTAP_TAPCELL_ROW_264_6324 VSS VSS gf180mcu_fd_sc_mcu9t5v0__filltie
XTAP_TAPCELL_ROW_93_3539 VSS VSS gf180mcu_fd_sc_mcu9t5v0__filltie
XTAP_TAPCELL_ROW_93_3528 VSS VSS gf180mcu_fd_sc_mcu9t5v0__filltie
X_18063_ _18063_/A1 _18100_/A1 _18926_/Q _18065_/B VSS VSS VSS VSS gf180mcu_fd_sc_mcu9t5v0__aoi21_1
X_12487_ _12487_/A1 _12487_/A2 _12488_/I VSS VSS VSS VSS gf180mcu_fd_sc_mcu9t5v0__nand2_1
X_15275_ _19629_/Q _19606_/Q _19628_/Q _19605_/Q _15277_/A2 VSS _15277_/VNW VSS VSS
+ gf180mcu_fd_sc_mcu9t5v0__aoi22_1
X_11438_ _18433_/Q _11176_/C _11442_/C VSS VSS VSS VSS gf180mcu_fd_sc_mcu9t5v0__nand2_1
X_17014_ _18498_/Q _17013_/Z _17026_/S _18498_/D VSS VSS VSS VSS gf180mcu_fd_sc_mcu9t5v0__mux2_1
X_14226_ _14226_/A1 _14224_/Z _14229_/A3 VSS VSS VSS VSS gf180mcu_fd_sc_mcu9t5v0__xnor2_1
X_11369_ _19093_/Q _11423_/A1 _11382_/B VSS VSS VSS VSS gf180mcu_fd_sc_mcu9t5v0__nand2_1
X_14157_ _19320_/Q _14156_/Z _19192_/D _19320_/D VSS VSS VSS VSS gf180mcu_fd_sc_mcu9t5v0__mux2_1
XPHY_EDGE_ROW_165_2_Right_896 VSS VSS gf180mcu_fd_sc_mcu9t5v0__endcap
X_13108_ _19726_/Q _19758_/Q _13109_/I VSS VSS VSS VSS gf180mcu_fd_sc_mcu9t5v0__xor2_1
X_18965_ _18965_/D _20053_/RN clkload67/I _18965_/Q VSS VSS VSS VSS gf180mcu_fd_sc_mcu9t5v0__dffrnq_1
X_14088_ _14088_/A1 _14086_/Z _14088_/Z VSS _14088_/VNW VSS VSS gf180mcu_fd_sc_mcu9t5v0__xor2_1
X_13039_ _13039_/A1 _13039_/A2 _13520_/B _13040_/A2 VSS _13525_/VNW VSS VSS gf180mcu_fd_sc_mcu9t5v0__nor3_1
X_18896_ _18896_/D _20048_/RN clkload11/I _18896_/Q VSS VSS VSS VSS gf180mcu_fd_sc_mcu9t5v0__dffrnq_1
X_17916_ _17916_/A1 _17887_/I _17926_/A1 _17915_/Z _17917_/A2 VSS _17916_/VNW VSS
+ VSS gf180mcu_fd_sc_mcu9t5v0__nand4_1
X_17847_ _20028_/Q _20027_/Q _17848_/A2 VSS VSS VSS VSS gf180mcu_fd_sc_mcu9t5v0__nor2_1
XPHY_EDGE_ROW_150_2_Left_662 VSS VSS gf180mcu_fd_sc_mcu9t5v0__endcap
XTAP_TAPCELL_ROW_7_1165 VSS VSS gf180mcu_fd_sc_mcu9t5v0__filltie
XTAP_TAPCELL_ROW_7_1176 VSS VSS gf180mcu_fd_sc_mcu9t5v0__filltie
X_17778_ _18764_/Q _17779_/A2 _17779_/B VSS _17778_/VNW VSS VSS gf180mcu_fd_sc_mcu9t5v0__nor2_1
X_19517_ _19517_/D _20029_/RN _19680_/CLK _19517_/Q VSS VSS VSS VSS gf180mcu_fd_sc_mcu9t5v0__dffrnq_1
XTAP_TAPCELL_ROW_7_1187 VSS VSS gf180mcu_fd_sc_mcu9t5v0__filltie
X_16729_ _16953_/A1 _16744_/A2 _16751_/A3 _16730_/B VSS VSS VSS VSS gf180mcu_fd_sc_mcu9t5v0__nor3_1
XTAP_TAPCELL_ROW_158_1_4749 VSS VSS gf180mcu_fd_sc_mcu9t5v0__filltie
X_19448_ _19448_/D _19960_/RN clkload12/I _19448_/Q VSS VSS VSS VSS gf180mcu_fd_sc_mcu9t5v0__dffrnq_1
XTAP_TAPCELL_ROW_234_5493 VSS VSS gf180mcu_fd_sc_mcu9t5v0__filltie
X_09201_ _19138_/Q _14587_/A2 VSS _14762_/VNW VSS VSS gf180mcu_fd_sc_mcu9t5v0__clkinv_1
X_19379_ _19379_/D _20019_/RN _19633_/CLK _19379_/Q VSS VSS VSS VSS gf180mcu_fd_sc_mcu9t5v0__dffrnq_1
X_09132_ _19761_/Q _13164_/A2 VSS VSS VSS VSS gf180mcu_fd_sc_mcu9t5v0__clkinv_1
X_09063_ wire300/Z _17769_/A1 VSS VSS VSS VSS gf180mcu_fd_sc_mcu9t5v0__clkinv_1
XTAP_TAPCELL_ROW_247_5876 VSS VSS gf180mcu_fd_sc_mcu9t5v0__filltie
XTAP_TAPCELL_ROW_247_5865 VSS VSS gf180mcu_fd_sc_mcu9t5v0__filltie
XTAP_TAPCELL_ROW_247_5854 VSS VSS gf180mcu_fd_sc_mcu9t5v0__filltie
X_09965_ _20000_/Q _19957_/Q _19965_/Q _20004_/Q _19981_/Q _19998_/Q _09966_/B2 VSS
+ VSS VSS VSS gf180mcu_fd_sc_mcu9t5v0__aoi222_1
XTAP_TAPCELL_ROW_16_1420 VSS VSS gf180mcu_fd_sc_mcu9t5v0__filltie
XTAP_TAPCELL_ROW_16_1431 VSS VSS gf180mcu_fd_sc_mcu9t5v0__filltie
X_20085_ _20085_/D clkload74/I _20085_/Q VSS VSS VSS VSS gf180mcu_fd_sc_mcu9t5v0__dffq_1
X_09896_ _10659_/C _10164_/A1 _09896_/Z VSS VSS VSS VSS gf180mcu_fd_sc_mcu9t5v0__and2_1
XPHY_EDGE_ROW_153_3_Right_268 VSS VSS gf180mcu_fd_sc_mcu9t5v0__endcap
XTAP_TAPCELL_ROW_12_1306 VSS VSS gf180mcu_fd_sc_mcu9t5v0__filltie
XTAP_TAPCELL_ROW_12_1317 VSS VSS gf180mcu_fd_sc_mcu9t5v0__filltie
X_10740_ _10693_/B _10740_/A2 _10740_/A3 _10743_/B1 VSS _10740_/VNW VSS VSS gf180mcu_fd_sc_mcu9t5v0__nand3_1
X_10671_ _19934_/Q _19886_/Q _20043_/Q _10671_/Z VSS VSS VSS VSS gf180mcu_fd_sc_mcu9t5v0__mux2_1
XTAP_TAPCELL_ROW_206_3_8246 VSS VSS gf180mcu_fd_sc_mcu9t5v0__filltie
X_12410_ _12628_/A1 _12355_/I _12410_/A3 _12410_/B _19147_/D VSS VSS VSS VSS gf180mcu_fd_sc_mcu9t5v0__oai31_1
X_13390_ _13416_/A1 _13618_/A2 _13392_/A2 VSS VSS VSS VSS gf180mcu_fd_sc_mcu9t5v0__nand2_1
XTAP_TAPCELL_ROW_135_4690 VSS VSS gf180mcu_fd_sc_mcu9t5v0__filltie
X_12341_ _18392_/Q _12299_/S _12342_/B VSS VSS VSS VSS gf180mcu_fd_sc_mcu9t5v0__or2_1
XTAP_TAPCELL_ROW_131_4576 VSS VSS gf180mcu_fd_sc_mcu9t5v0__filltie
X_12272_ _12237_/B _12272_/A2 _12271_/B _12274_/A1 VSS _12274_/VNW VSS VSS gf180mcu_fd_sc_mcu9t5v0__nand3_1
XTAP_TAPCELL_ROW_131_4598 VSS VSS gf180mcu_fd_sc_mcu9t5v0__filltie
XTAP_TAPCELL_ROW_131_4587 VSS VSS gf180mcu_fd_sc_mcu9t5v0__filltie
X_15060_ _19307_/Q _19392_/Q _15063_/A1 _15061_/I1 VSS VSS VSS VSS gf180mcu_fd_sc_mcu9t5v0__xnor3_1
X_11223_ _18566_/Q _18177_/Q _11225_/B1 VSS _11223_/VNW VSS VSS gf180mcu_fd_sc_mcu9t5v0__nand2_1
X_14011_ _19296_/Q _19322_/Q _14012_/B _14045_/B VSS VSS VSS VSS gf180mcu_fd_sc_mcu9t5v0__nand3_1
X_11154_ _18269_/Q _18253_/Q _11524_/S _11154_/Z VSS VSS VSS VSS gf180mcu_fd_sc_mcu9t5v0__mux2_1
XPHY_EDGE_ROW_164_1_Right_748 VSS VSS gf180mcu_fd_sc_mcu9t5v0__endcap
X_11085_ _11558_/C _12382_/S wire136/I VSS VSS VSS VSS gf180mcu_fd_sc_mcu9t5v0__nand2_1
X_10105_ _10105_/A1 _10105_/A2 _10106_/A2 VSS _10105_/VNW VSS VSS gf180mcu_fd_sc_mcu9t5v0__nand2_1
X_15962_ _16301_/A1 _16443_/A2 _15962_/B1 _15962_/B2 _15962_/C _15962_/ZN VSS VSS
+ VSS VSS gf180mcu_fd_sc_mcu9t5v0__aoi221_4
X_18750_ _18750_/D clkload25/I _18750_/Q VSS VSS VSS VSS gf180mcu_fd_sc_mcu9t5v0__dffq_1
X_17701_ _17701_/A1 _17681_/S _17701_/B _17701_/C _18727_/D VSS VSS VSS VSS gf180mcu_fd_sc_mcu9t5v0__oai211_1
X_18681_ _18681_/D _20021_/RN _20049_/CLK _18681_/Q VSS VSS VSS VSS gf180mcu_fd_sc_mcu9t5v0__dffrnq_1
X_10036_ _20000_/Q _19959_/Q _19967_/Q _20004_/Q _19983_/Q _19998_/Q _10037_/A3 VSS
+ VSS VSS VSS gf180mcu_fd_sc_mcu9t5v0__aoi222_1
XTAP_TAPCELL_ROW_86_3354 VSS VSS gf180mcu_fd_sc_mcu9t5v0__filltie
X_14913_ _14932_/A1 _14918_/A1 _14916_/A1 VSS _14913_/VNW VSS VSS gf180mcu_fd_sc_mcu9t5v0__nand2_1
XTAP_TAPCELL_ROW_86_3343 VSS VSS gf180mcu_fd_sc_mcu9t5v0__filltie
X_15893_ _20102_/Q _19237_/Q _15927_/S _20102_/D VSS VSS VSS VSS gf180mcu_fd_sc_mcu9t5v0__mux2_1
XTAP_TAPCELL_ROW_257_6150 VSS VSS gf180mcu_fd_sc_mcu9t5v0__filltie
X_17632_ _17653_/I0 _17653_/I1 _17650_/A2 VSS VSS VSS VSS gf180mcu_fd_sc_mcu9t5v0__nand2_1
XTAP_TAPCELL_ROW_82_3229 VSS VSS gf180mcu_fd_sc_mcu9t5v0__filltie
XTAP_TAPCELL_ROW_253_6036 VSS VSS gf180mcu_fd_sc_mcu9t5v0__filltie
XTAP_TAPCELL_ROW_253_6025 VSS VSS gf180mcu_fd_sc_mcu9t5v0__filltie
X_14844_ _19578_/Q _14844_/I1 _15163_/S _19578_/D VSS VSS VSS VSS gf180mcu_fd_sc_mcu9t5v0__mux2_1
X_17563_ _17701_/A1 _17739_/A1 _17583_/I1 VSS VSS VSS VSS gf180mcu_fd_sc_mcu9t5v0__nand2_1
X_14775_ _19563_/Q _19329_/Q _14900_/S _19563_/D VSS VSS VSS VSS gf180mcu_fd_sc_mcu9t5v0__mux2_1
XTAP_TAPCELL_ROW_2_1040 VSS VSS gf180mcu_fd_sc_mcu9t5v0__filltie
X_11987_ _19122_/Q _11966_/B _12008_/B VSS _11987_/VNW VSS VSS gf180mcu_fd_sc_mcu9t5v0__nand2_1
X_17494_ _18599_/Q _19240_/Q _17513_/S _18599_/D VSS VSS VSS VSS gf180mcu_fd_sc_mcu9t5v0__mux2_1
X_16514_ _16513_/Z _18313_/Q _17042_/S _18313_/D VSS VSS VSS VSS gf180mcu_fd_sc_mcu9t5v0__mux2_1
XTAP_TAPCELL_ROW_99_3715 VSS VSS gf180mcu_fd_sc_mcu9t5v0__filltie
X_10938_ _10937_/Z _19006_/Q _18148_/S _19006_/D VSS VSS VSS VSS gf180mcu_fd_sc_mcu9t5v0__mux2_1
XTAP_TAPCELL_ROW_99_3704 VSS VSS gf180mcu_fd_sc_mcu9t5v0__filltie
X_13726_ _13722_/Z _13726_/A2 _13727_/A2 VSS VSS VSS VSS gf180mcu_fd_sc_mcu9t5v0__xnor2_1
XTAP_TAPCELL_ROW_2_1051 VSS VSS gf180mcu_fd_sc_mcu9t5v0__filltie
X_19302_ _19302_/D _20070_/RN clkload21/I _19302_/Q VSS VSS VSS VSS gf180mcu_fd_sc_mcu9t5v0__dffrnq_1
X_16445_ _19228_/Q _16117_/C _16991_/S _16445_/Z VSS VSS VSS VSS gf180mcu_fd_sc_mcu9t5v0__mux2_4
X_19233_ _19233_/D _20065_/RN clkload45/I _19233_/Q VSS VSS VSS VSS gf180mcu_fd_sc_mcu9t5v0__dffrnq_2
X_10869_ _19237_/Q _19231_/Q _18117_/S _10869_/Z VSS _10869_/VNW VSS VSS gf180mcu_fd_sc_mcu9t5v0__mux2_1
X_13657_ _19449_/Q _13733_/A2 _14286_/A2 _19440_/Q _19466_/Q _13656_/Z _13658_/A2
+ VSS VSS VSS VSS gf180mcu_fd_sc_mcu9t5v0__aoi222_1
X_12608_ _18503_/Q _12608_/A2 wire146/Z _12609_/B2 VSS VSS VSS VSS gf180mcu_fd_sc_mcu9t5v0__oai21_1
X_16376_ _16375_/Z _18251_/Q _16928_/S _18251_/D VSS _16376_/VNW VSS VSS gf180mcu_fd_sc_mcu9t5v0__mux2_1
X_19164_ _19164_/D _20060_/RN clkload35/I _19164_/Q VSS VSS VSS VSS gf180mcu_fd_sc_mcu9t5v0__dffrnq_1
X_13588_ _19280_/Q _13304_/B _13592_/B VSS _13588_/VNW VSS VSS gf180mcu_fd_sc_mcu9t5v0__nand2_1
X_12539_ _18399_/Q _12582_/A2 _12542_/A3 VSS VSS VSS VSS gf180mcu_fd_sc_mcu9t5v0__nor2_1
X_18115_ _19208_/Q _19202_/Q _18117_/S _18115_/Z VSS _18115_/VNW VSS VSS gf180mcu_fd_sc_mcu9t5v0__mux2_1
X_19095_ _19095_/D _20055_/RN clkload26/I _19095_/Q VSS VSS VSS VSS gf180mcu_fd_sc_mcu9t5v0__dffrnq_1
X_15327_ _19642_/Q _19619_/Q _15330_/A1 _15327_/Z VSS VSS VSS VSS gf180mcu_fd_sc_mcu9t5v0__xor3_1
XPHY_EDGE_ROW_200_2_Right_931 VSS VSS gf180mcu_fd_sc_mcu9t5v0__endcap
X_18046_ _18046_/A1 _18045_/Z _18046_/B _18074_/A2 VSS VSS VSS VSS gf180mcu_fd_sc_mcu9t5v0__oai21_1
X_15258_ _19599_/Q _15258_/A2 _19600_/Q _15258_/B2 _15258_/C _15260_/A3 VSS _15259_/VNW
+ VSS VSS gf180mcu_fd_sc_mcu9t5v0__oai221_1
X_14209_ _14034_/B _14209_/A2 _14208_/Z _14217_/A2 VSS _14209_/VNW VSS VSS gf180mcu_fd_sc_mcu9t5v0__nand3_1
XTAP_TAPCELL_ROW_71_2944 VSS VSS gf180mcu_fd_sc_mcu9t5v0__filltie
XTAP_TAPCELL_ROW_71_2933 VSS VSS gf180mcu_fd_sc_mcu9t5v0__filltie
X_15189_ _19588_/Q _19565_/Q _15192_/A2 _15191_/A2 VSS VSS VSS VSS gf180mcu_fd_sc_mcu9t5v0__xnor3_1
XTAP_TAPCELL_ROW_71_2922 VSS VSS gf180mcu_fd_sc_mcu9t5v0__filltie
X_19997_ _19997_/D _20061_/RN _20054_/CLK _19997_/Q VSS VSS VSS VSS gf180mcu_fd_sc_mcu9t5v0__dffrnq_1
X_18948_ _18948_/D _20036_/RN clkload70/I _18948_/Q VSS VSS VSS VSS gf180mcu_fd_sc_mcu9t5v0__dffrnq_1
X_09750_ _09750_/I _20016_/D VSS VSS VSS VSS gf180mcu_fd_sc_mcu9t5v0__clkinv_1
XPHY_EDGE_ROW_166_2_Right_897 VSS VSS gf180mcu_fd_sc_mcu9t5v0__endcap
XTAP_TAPCELL_ROW_9_1227 VSS VSS gf180mcu_fd_sc_mcu9t5v0__filltie
XTAP_TAPCELL_ROW_223_5194 VSS VSS gf180mcu_fd_sc_mcu9t5v0__filltie
XTAP_TAPCELL_ROW_9_1238 VSS VSS gf180mcu_fd_sc_mcu9t5v0__filltie
X_09681_ _18575_/Q _12487_/A1 _12354_/A1 _18574_/Q _09682_/A2 VSS _09681_/VNW VSS
+ VSS gf180mcu_fd_sc_mcu9t5v0__oai22_1
X_18879_ _18879_/D _20031_/RN _20054_/CLK _18879_/Q VSS VSS VSS VSS gf180mcu_fd_sc_mcu9t5v0__dffrnq_1
XTAP_TAPCELL_ROW_69_2884 VSS VSS gf180mcu_fd_sc_mcu9t5v0__filltie
XTAP_TAPCELL_ROW_69_2873 VSS VSS gf180mcu_fd_sc_mcu9t5v0__filltie
XTAP_TAPCELL_ROW_236_5555 VSS VSS gf180mcu_fd_sc_mcu9t5v0__filltie
XTAP_TAPCELL_ROW_65_2759 VSS VSS gf180mcu_fd_sc_mcu9t5v0__filltie
XTAP_TAPCELL_ROW_236_5566 VSS VSS gf180mcu_fd_sc_mcu9t5v0__filltie
XTAP_TAPCELL_ROW_249_5927 VSS VSS gf180mcu_fd_sc_mcu9t5v0__filltie
XTAP_TAPCELL_ROW_249_5916 VSS VSS gf180mcu_fd_sc_mcu9t5v0__filltie
XTAP_TAPCELL_ROW_249_5905 VSS VSS gf180mcu_fd_sc_mcu9t5v0__filltie
X_09115_ _19720_/Q _12986_/A1 VSS _13009_/VNW VSS VSS gf180mcu_fd_sc_mcu9t5v0__clkinv_1
XTAP_TAPCELL_ROW_320_7862 VSS VSS gf180mcu_fd_sc_mcu9t5v0__filltie
Xmax_cap170 _17177_/B _17407_/C VSS VSS VSS VSS gf180mcu_fd_sc_mcu9t5v0__buf_8
XTAP_TAPCELL_ROW_320_7884 VSS VSS gf180mcu_fd_sc_mcu9t5v0__filltie
XTAP_TAPCELL_ROW_320_7873 VSS VSS gf180mcu_fd_sc_mcu9t5v0__filltie
Xmax_cap192 _10216_/ZN _10516_/C VSS VSS VSS VSS gf180mcu_fd_sc_mcu9t5v0__clkbuf_8
Xmax_cap181 _12092_/B _12159_/B VSS VSS VSS VSS gf180mcu_fd_sc_mcu9t5v0__clkbuf_16
X_20137_ _20137_/D clkload74/I _20137_/Q VSS VSS VSS VSS gf180mcu_fd_sc_mcu9t5v0__dffq_1
X_09948_ _09948_/A1 _09948_/A2 _09948_/A3 _09948_/Z VSS VSS VSS VSS gf180mcu_fd_sc_mcu9t5v0__and3_1
X_20068_ _20068_/D _20068_/RN clkload50/I _20068_/Q VSS VSS VSS VSS gf180mcu_fd_sc_mcu9t5v0__dffrnq_1
X_09879_ _20002_/Q wire160/I _10718_/C _09882_/A1 VSS VSS VSS VSS gf180mcu_fd_sc_mcu9t5v0__nor3_1
XTAP_TAPCELL_ROW_124_4391 VSS VSS gf180mcu_fd_sc_mcu9t5v0__filltie
XTAP_TAPCELL_ROW_124_4380 VSS VSS gf180mcu_fd_sc_mcu9t5v0__filltie
X_11910_ _18180_/Q _18164_/Q _12340_/S _11910_/Z VSS VSS VSS VSS gf180mcu_fd_sc_mcu9t5v0__mux2_1
XPHY_EDGE_ROW_154_3_Right_269 VSS VSS gf180mcu_fd_sc_mcu9t5v0__endcap
X_12890_ _12891_/A1 _12891_/A3 _12890_/B _12892_/A1 VSS _12890_/VNW VSS VSS gf180mcu_fd_sc_mcu9t5v0__oai21_1
X_11841_ _18177_/Q _18161_/Q _12340_/S _11841_/Z VSS _11843_/VNW VSS VSS gf180mcu_fd_sc_mcu9t5v0__mux2_1
XTAP_TAPCELL_ROW_120_4288 VSS VSS gf180mcu_fd_sc_mcu9t5v0__filltie
XTAP_TAPCELL_ROW_120_4277 VSS VSS gf180mcu_fd_sc_mcu9t5v0__filltie
X_11772_ _18174_/Q _12315_/S _11775_/A2 VSS _12398_/VNW VSS VSS gf180mcu_fd_sc_mcu9t5v0__nor2_1
XTAP_TAPCELL_ROW_314_7699 VSS VSS gf180mcu_fd_sc_mcu9t5v0__filltie
X_14560_ _14560_/A1 _19135_/Q _14560_/B _14562_/A3 VSS _14560_/VNW VSS VSS gf180mcu_fd_sc_mcu9t5v0__oai21_1
X_10723_ _19821_/Q _10389_/C _15472_/A1 _17411_/C _10724_/B VSS VSS VSS VSS gf180mcu_fd_sc_mcu9t5v0__aoi22_1
X_13511_ _13512_/A1 _13512_/A3 _13511_/B _13516_/A2 VSS VSS VSS VSS gf180mcu_fd_sc_mcu9t5v0__aoi21_1
XPHY_EDGE_ROW_206_1_Right_790 VSS VSS gf180mcu_fd_sc_mcu9t5v0__endcap
XTAP_TAPCELL_ROW_133_4627 VSS VSS gf180mcu_fd_sc_mcu9t5v0__filltie
X_14491_ _14501_/S _14491_/A2 _14492_/C VSS _14492_/VNW VSS VSS gf180mcu_fd_sc_mcu9t5v0__nand2_1
X_16230_ _16099_/B _19275_/Q _16785_/S _16230_/Z VSS VSS VSS VSS gf180mcu_fd_sc_mcu9t5v0__mux2_1
X_10654_ _19002_/Q _10654_/A2 _10654_/B wire160/Z _10656_/B1 VSS VSS VSS VSS gf180mcu_fd_sc_mcu9t5v0__oai211_1
XTAP_TAPCELL_ROW_133_4649 VSS VSS gf180mcu_fd_sc_mcu9t5v0__filltie
XTAP_TAPCELL_ROW_133_4638 VSS VSS gf180mcu_fd_sc_mcu9t5v0__filltie
X_13442_ _13440_/Z _13457_/A2 _13442_/Z VSS VSS VSS VSS gf180mcu_fd_sc_mcu9t5v0__xor2_1
X_16161_ _19269_/Q _16725_/C _16164_/B VSS VSS VSS VSS gf180mcu_fd_sc_mcu9t5v0__nand2_1
X_10585_ _17404_/S _18342_/Q _10587_/A3 VSS _11953_/VNW VSS VSS gf180mcu_fd_sc_mcu9t5v0__nor2_1
X_13373_ _13373_/A1 _13373_/A2 _13610_/A1 VSS VSS VSS VSS gf180mcu_fd_sc_mcu9t5v0__xnor2_1
XTAP_TAPCELL_ROW_75_3033 VSS VSS gf180mcu_fd_sc_mcu9t5v0__filltie
X_12324_ _18471_/Q _12345_/A2 _12324_/B _12325_/B2 VSS VSS VSS VSS gf180mcu_fd_sc_mcu9t5v0__aoi21_1
XTAP_TAPCELL_ROW_75_3055 VSS VSS gf180mcu_fd_sc_mcu9t5v0__filltie
XTAP_TAPCELL_ROW_75_3044 VSS VSS gf180mcu_fd_sc_mcu9t5v0__filltie
Xclkload18 clkload18/I clkload18/ZN VSS _14891_/VNW VSS VSS gf180mcu_fd_sc_mcu9t5v0__inv_2
Xclkload29 clkload29/I clkload29/ZN VSS _14433_/VNW VSS VSS gf180mcu_fd_sc_mcu9t5v0__inv_4
X_15112_ _19654_/Q _19494_/Q _15163_/S _19654_/D VSS VSS VSS VSS gf180mcu_fd_sc_mcu9t5v0__mux2_1
X_16092_ _19242_/Q _16751_/A2 wire71/Z _16096_/A2 VSS _16092_/VNW VSS VSS gf180mcu_fd_sc_mcu9t5v0__nor3_1
X_19920_ _19920_/D _20048_/RN clkload49/I _19920_/Q VSS VSS VSS VSS gf180mcu_fd_sc_mcu9t5v0__dffrnq_1
XPHY_EDGE_ROW_156_1_Left_479 VSS VSS gf180mcu_fd_sc_mcu9t5v0__endcap
X_12255_ _19134_/Q _12311_/B _12255_/B _12256_/I VSS VSS VSS VSS gf180mcu_fd_sc_mcu9t5v0__aoi21_1
X_15043_ _19304_/Q _19389_/Q _15043_/Z VSS VSS VSS VSS gf180mcu_fd_sc_mcu9t5v0__or2_1
X_11206_ _18336_/Q _18320_/Q _18272_/Q _18256_/Q _11524_/S _11521_/B _11206_/Z VSS
+ VSS VSS VSS gf180mcu_fd_sc_mcu9t5v0__mux4_1
X_19851_ _19851_/D _20043_/RN clkload56/I _19851_/Q VSS VSS VSS VSS gf180mcu_fd_sc_mcu9t5v0__dffrnq_1
XTAP_TAPCELL_ROW_259_6201 VSS VSS gf180mcu_fd_sc_mcu9t5v0__filltie
X_12186_ _18728_/Q wire198/Z wire208/Z _12188_/B VSS VSS VSS VSS gf180mcu_fd_sc_mcu9t5v0__aoi21_1
XTAP_TAPCELL_ROW_88_3405 VSS VSS gf180mcu_fd_sc_mcu9t5v0__filltie
XTAP_TAPCELL_ROW_88_3416 VSS VSS gf180mcu_fd_sc_mcu9t5v0__filltie
X_19782_ _19782_/D _20038_/RN clkload16/I _19782_/Q VSS VSS VSS VSS gf180mcu_fd_sc_mcu9t5v0__dffrnq_1
X_18802_ _18802_/D _20018_/RN clkload32/I _18802_/Q VSS VSS VSS VSS gf180mcu_fd_sc_mcu9t5v0__dffrnq_1
X_11137_ _11321_/A2 _11137_/A2 _11137_/A3 _11137_/B _19075_/D VSS _17974_/VNW VSS
+ VSS gf180mcu_fd_sc_mcu9t5v0__oai31_1
X_16994_ _18488_/Q _16993_/Z _16994_/S _18488_/D VSS _17057_/VNW VSS VSS gf180mcu_fd_sc_mcu9t5v0__mux2_1
X_18733_ _18733_/D clkload52/I _18733_/Q VSS VSS VSS VSS gf180mcu_fd_sc_mcu9t5v0__dffq_1
XPHY_EDGE_ROW_165_1_Right_749 VSS VSS gf180mcu_fd_sc_mcu9t5v0__endcap
X_15945_ _15973_/B _15988_/C _15988_/B _16665_/A2 VSS VSS VSS VSS gf180mcu_fd_sc_mcu9t5v0__nand3_1
X_11068_ _11069_/B _17960_/A4 _19069_/D VSS VSS VSS VSS gf180mcu_fd_sc_mcu9t5v0__nand2_1
X_15876_ _20085_/Q _19235_/Q wire79/Z _20085_/D VSS VSS VSS VSS gf180mcu_fd_sc_mcu9t5v0__mux2_1
X_10019_ _15939_/B _18567_/Q _16196_/A1 VSS VSS VSS VSS gf180mcu_fd_sc_mcu9t5v0__nand2_1
X_18664_ _18664_/D _20068_/RN _20049_/CLK _18664_/Q VSS VSS VSS VSS gf180mcu_fd_sc_mcu9t5v0__dffrnq_2
XTAP_TAPCELL_ROW_4_1102 VSS VSS gf180mcu_fd_sc_mcu9t5v0__filltie
X_18595_ _18595_/D clkload76/I _18595_/Q VSS VSS VSS VSS gf180mcu_fd_sc_mcu9t5v0__dffq_1
X_17615_ input6/Z _18678_/Q _17617_/S _18678_/D VSS VSS VSS VSS gf180mcu_fd_sc_mcu9t5v0__mux2_1
Xrst_tree_leaf_4 rst_tree_mid_0/Z _20143_/RN VSS VSS VSS VSS gf180mcu_fd_sc_mcu9t5v0__clkbuf_16
X_14827_ _19404_/Q _19341_/Q _14827_/B _14829_/A1 VSS _14827_/VNW VSS VSS gf180mcu_fd_sc_mcu9t5v0__aoi21_1
X_17546_ input5/Z _17540_/Z _17546_/Z VSS _17546_/VNW VSS VSS gf180mcu_fd_sc_mcu9t5v0__or2_1
XTAP_TAPCELL_ROW_60_2623 VSS VSS gf180mcu_fd_sc_mcu9t5v0__filltie
X_14758_ _14758_/A1 _14758_/A2 _14758_/B _14762_/A2 VSS _14758_/VNW VSS VSS gf180mcu_fd_sc_mcu9t5v0__aoi21_1
XTAP_TAPCELL_ROW_231_5430 VSS VSS gf180mcu_fd_sc_mcu9t5v0__filltie
X_14689_ _14689_/A1 _14691_/A2 _14690_/I1 VSS _14689_/VNW VSS VSS gf180mcu_fd_sc_mcu9t5v0__xnor2_1
X_13709_ _19146_/Q _19112_/Q _14668_/B VSS _13709_/VNW VSS VSS gf180mcu_fd_sc_mcu9t5v0__nand2_1
XTAP_TAPCELL_ROW_60_2634 VSS VSS gf180mcu_fd_sc_mcu9t5v0__filltie
XTAP_TAPCELL_ROW_60_2645 VSS VSS gf180mcu_fd_sc_mcu9t5v0__filltie
X_17477_ wire198/I _17477_/A2 _18585_/Q _17478_/A2 VSS _17477_/VNW VSS VSS gf180mcu_fd_sc_mcu9t5v0__aoi21_1
X_16428_ _16428_/A1 _16955_/S _16428_/B _16429_/I0 VSS VSS VSS VSS gf180mcu_fd_sc_mcu9t5v0__oai21_1
X_19216_ _19216_/D _20048_/RN _20054_/CLK _19216_/Q VSS VSS VSS VSS gf180mcu_fd_sc_mcu9t5v0__dffrnq_1
X_16359_ _19239_/Q _16172_/C _16895_/S _16359_/Z VSS _16359_/VNW VSS VSS gf180mcu_fd_sc_mcu9t5v0__mux2_1
XTAP_TAPCELL_ROW_41_2099 VSS VSS gf180mcu_fd_sc_mcu9t5v0__filltie
X_19147_ _19147_/D _20043_/RN _19806_/CLK _19147_/Q VSS VSS VSS VSS gf180mcu_fd_sc_mcu9t5v0__dffrnq_1
X_19078_ _19078_/D _20038_/RN clkload35/I _19078_/Q VSS VSS VSS VSS gf180mcu_fd_sc_mcu9t5v0__dffrnq_1
XTAP_TAPCELL_ROW_58_2574 VSS VSS gf180mcu_fd_sc_mcu9t5v0__filltie
XTAP_TAPCELL_ROW_229_5381 VSS VSS gf180mcu_fd_sc_mcu9t5v0__filltie
XTAP_TAPCELL_ROW_229_5370 VSS VSS gf180mcu_fd_sc_mcu9t5v0__filltie
XPHY_EDGE_ROW_201_2_Right_932 VSS VSS gf180mcu_fd_sc_mcu9t5v0__endcap
XTAP_TAPCELL_ROW_58_2585 VSS VSS gf180mcu_fd_sc_mcu9t5v0__filltie
X_18029_ _18029_/I0 _18914_/Q _18037_/S _18914_/D VSS VSS VSS VSS gf180mcu_fd_sc_mcu9t5v0__mux2_1
XTAP_TAPCELL_ROW_225_5267 VSS VSS gf180mcu_fd_sc_mcu9t5v0__filltie
XTAP_TAPCELL_ROW_225_5256 VSS VSS gf180mcu_fd_sc_mcu9t5v0__filltie
XTAP_TAPCELL_ROW_225_5245 VSS VSS gf180mcu_fd_sc_mcu9t5v0__filltie
Xfanout238 _16676_/S _16643_/S VSS VSS VSS VSS gf180mcu_fd_sc_mcu9t5v0__clkbuf_16
X_09802_ _17900_/A1 _18836_/Q _17907_/A2 VSS _09802_/VNW VSS VSS gf180mcu_fd_sc_mcu9t5v0__nand2_1
Xfanout249 wire33/Z _16940_/S VSS VSS VSS VSS gf180mcu_fd_sc_mcu9t5v0__clkbuf_16
XPHY_EDGE_ROW_167_2_Right_898 VSS VSS gf180mcu_fd_sc_mcu9t5v0__endcap
X_09733_ _20065_/Q _10826_/B _09760_/C1 _09733_/B2 _20019_/D VSS _10837_/VNW VSS VSS
+ gf180mcu_fd_sc_mcu9t5v0__oai22_1
XTAP_TAPCELL_ROW_238_5606 VSS VSS gf180mcu_fd_sc_mcu9t5v0__filltie
XTAP_TAPCELL_ROW_238_5628 VSS VSS gf180mcu_fd_sc_mcu9t5v0__filltie
XTAP_TAPCELL_ROW_238_5617 VSS VSS gf180mcu_fd_sc_mcu9t5v0__filltie
X_09664_ _19999_/Q _09664_/A2 _15680_/A1 VSS _15682_/VNW VSS VSS gf180mcu_fd_sc_mcu9t5v0__nand2_1
X_09595_ _19908_/Q _19909_/Q _15671_/A3 VSS VSS VSS VSS gf180mcu_fd_sc_mcu9t5v0__nor2_1
XTAP_TAPCELL_ROW_214_4960 VSS VSS gf180mcu_fd_sc_mcu9t5v0__filltie
XTAP_TAPCELL_ROW_322_7913 VSS VSS gf180mcu_fd_sc_mcu9t5v0__filltie
XTAP_TAPCELL_ROW_210_4857 VSS VSS gf180mcu_fd_sc_mcu9t5v0__filltie
XTAP_TAPCELL_ROW_210_4846 VSS VSS gf180mcu_fd_sc_mcu9t5v0__filltie
XTAP_TAPCELL_ROW_210_4835 VSS VSS gf180mcu_fd_sc_mcu9t5v0__filltie
XTAP_TAPCELL_ROW_322_7935 VSS VSS gf180mcu_fd_sc_mcu9t5v0__filltie
XTAP_TAPCELL_ROW_322_7924 VSS VSS gf180mcu_fd_sc_mcu9t5v0__filltie
X_10370_ _17378_/A1 _18254_/Q _10373_/A2 VSS VSS VSS VSS gf180mcu_fd_sc_mcu9t5v0__nor2_1
XTAP_TAPCELL_ROW_113_4092 VSS VSS gf180mcu_fd_sc_mcu9t5v0__filltie
XTAP_TAPCELL_ROW_113_4081 VSS VSS gf180mcu_fd_sc_mcu9t5v0__filltie
XTAP_TAPCELL_ROW_299_7293 VSS VSS gf180mcu_fd_sc_mcu9t5v0__filltie
XTAP_TAPCELL_ROW_299_7282 VSS VSS gf180mcu_fd_sc_mcu9t5v0__filltie
X_12040_ _11736_/C _12040_/A2 _12049_/B2 VSS VSS VSS VSS gf180mcu_fd_sc_mcu9t5v0__nand2_1
XTAP_TAPCELL_ROW_126_4442 VSS VSS gf180mcu_fd_sc_mcu9t5v0__filltie
XTAP_TAPCELL_ROW_295_7179 VSS VSS gf180mcu_fd_sc_mcu9t5v0__filltie
XTAP_TAPCELL_ROW_126_4453 VSS VSS gf180mcu_fd_sc_mcu9t5v0__filltie
XTAP_TAPCELL_ROW_122_4339 VSS VSS gf180mcu_fd_sc_mcu9t5v0__filltie
XTAP_TAPCELL_ROW_122_4328 VSS VSS gf180mcu_fd_sc_mcu9t5v0__filltie
X_13991_ _19317_/Q _19301_/Q _13992_/A2 VSS _14036_/VNW VSS VSS gf180mcu_fd_sc_mcu9t5v0__nand2_1
X_15730_ _19924_/Q _15685_/I _15731_/A2 VSS _15737_/VNW VSS VSS gf180mcu_fd_sc_mcu9t5v0__xnor2_1
X_12942_ _19780_/Q _12941_/Z _12942_/Z VSS _12943_/VNW VSS VSS gf180mcu_fd_sc_mcu9t5v0__or2_1
X_15661_ _15672_/B _15661_/A2 _19906_/D VSS VSS VSS VSS gf180mcu_fd_sc_mcu9t5v0__nor2_1
X_17400_ _17404_/S _18472_/Q _17402_/A3 VSS _17400_/VNW VSS VSS gf180mcu_fd_sc_mcu9t5v0__nor2_1
X_14612_ _19073_/Q _19490_/Q _14730_/S _19490_/D VSS VSS VSS VSS gf180mcu_fd_sc_mcu9t5v0__mux2_1
X_12873_ _19770_/Q _12871_/Z _12879_/B VSS VSS VSS VSS gf180mcu_fd_sc_mcu9t5v0__nand2_1
X_11824_ _18224_/Q _12315_/S _12322_/B _11827_/A2 VSS VSS VSS VSS gf180mcu_fd_sc_mcu9t5v0__aoi21_1
X_18380_ _18380_/D clkload61/I _18380_/Q VSS VSS VSS VSS gf180mcu_fd_sc_mcu9t5v0__dffq_1
X_15592_ _18026_/I0 _15596_/A2 _15593_/B2 VSS VSS VSS VSS gf180mcu_fd_sc_mcu9t5v0__nor2_1
X_11755_ _11755_/A1 _11755_/A2 _11755_/B1 _11755_/B2 _12320_/C _11762_/A1 VSS VSS
+ VSS VSS gf180mcu_fd_sc_mcu9t5v0__aoi221_1
X_17331_ _17250_/Z _17331_/A2 _17331_/B _18548_/D VSS VSS VSS VSS gf180mcu_fd_sc_mcu9t5v0__oai21_4
X_14543_ _14548_/A2 _14548_/A3 _14544_/A2 VSS VSS VSS VSS gf180mcu_fd_sc_mcu9t5v0__nor2_1
X_17262_ _18481_/Q _17380_/A2 _17380_/B1 _18497_/Q _17275_/C _17263_/B2 VSS _17262_/VNW
+ VSS VSS gf180mcu_fd_sc_mcu9t5v0__aoi221_1
XPHY_EDGE_ROW_207_1_Right_791 VSS VSS gf180mcu_fd_sc_mcu9t5v0__endcap
XTAP_TAPCELL_ROW_77_3106 VSS VSS gf180mcu_fd_sc_mcu9t5v0__filltie
X_14474_ _14474_/A1 _14474_/A2 _14473_/B _14474_/Z VSS _14474_/VNW VSS VSS gf180mcu_fd_sc_mcu9t5v0__and3_1
X_10706_ _18840_/Q _18847_/Q _10706_/Z VSS _10707_/VNW VSS VSS gf180mcu_fd_sc_mcu9t5v0__xor2_1
X_16213_ _16212_/Z _18191_/Q _16770_/S _18191_/D VSS VSS VSS VSS gf180mcu_fd_sc_mcu9t5v0__mux2_1
X_19001_ _19001_/D _20025_/RN clkload70/I _19001_/Q VSS VSS VSS VSS gf180mcu_fd_sc_mcu9t5v0__dffrnq_1
X_11686_ _11686_/A1 _11686_/A2 _12090_/B _11687_/C VSS _11686_/VNW VSS VSS gf180mcu_fd_sc_mcu9t5v0__aoi21_1
X_13425_ _13435_/A2 _19811_/Q _13441_/A1 _13426_/I VSS VSS VSS VSS gf180mcu_fd_sc_mcu9t5v0__xnor3_1
XTAP_TAPCELL_ROW_284_6883 VSS VSS gf180mcu_fd_sc_mcu9t5v0__filltie
X_17193_ _18350_/Q _17282_/A2 _17255_/B1 _18366_/Q _17194_/B VSS VSS VSS VSS gf180mcu_fd_sc_mcu9t5v0__aoi22_1
XTAP_TAPCELL_ROW_284_6872 VSS VSS gf180mcu_fd_sc_mcu9t5v0__filltie
X_10637_ _18168_/Q _17406_/A2 _17405_/A2 _18184_/Q _10638_/B VSS VSS VSS VSS gf180mcu_fd_sc_mcu9t5v0__aoi22_1
XTAP_TAPCELL_ROW_284_6894 VSS VSS gf180mcu_fd_sc_mcu9t5v0__filltie
X_16144_ _16741_/B2 _16144_/A2 _16144_/B _16144_/C _16145_/I1 VSS VSS VSS VSS gf180mcu_fd_sc_mcu9t5v0__aoi211_1
X_10568_ _20090_/Q wire168/Z _10569_/A2 VSS VSS VSS VSS gf180mcu_fd_sc_mcu9t5v0__nor2_1
XPHY_EDGE_ROW_116_Right_116 VSS VSS gf180mcu_fd_sc_mcu9t5v0__endcap
X_13356_ _13375_/A2 _13356_/A2 _13362_/B1 VSS VSS VSS VSS gf180mcu_fd_sc_mcu9t5v0__nand2_1
X_10499_ _17306_/C _10499_/A2 _10500_/B2 VSS VSS VSS VSS gf180mcu_fd_sc_mcu9t5v0__nor2_1
XTAP_TAPCELL_ROW_280_6769 VSS VSS gf180mcu_fd_sc_mcu9t5v0__filltie
X_16075_ _16668_/A1 _16674_/A2 _16172_/C _16078_/A2 VSS VSS VSS VSS gf180mcu_fd_sc_mcu9t5v0__aoi21_1
XTAP_TAPCELL_ROW_280_6758 VSS VSS gf180mcu_fd_sc_mcu9t5v0__filltie
X_12307_ _12071_/B _12330_/A2 _12306_/Z _12307_/B _12308_/A2 VSS VSS VSS VSS gf180mcu_fd_sc_mcu9t5v0__oai31_4
X_13287_ _13290_/A1 _13290_/A2 _13291_/A1 VSS _13588_/VNW VSS VSS gf180mcu_fd_sc_mcu9t5v0__nand2_1
X_12238_ _18371_/Q _18355_/Q _12340_/S _12238_/Z VSS VSS VSS VSS gf180mcu_fd_sc_mcu9t5v0__mux2_1
X_19903_ _19903_/D _20031_/RN clkload40/I _19903_/Q VSS VSS VSS VSS gf180mcu_fd_sc_mcu9t5v0__dffrnq_1
X_15026_ _19628_/Q _19379_/Q _20039_/Q _19628_/D VSS VSS VSS VSS gf180mcu_fd_sc_mcu9t5v0__mux2_1
XPHY_EDGE_ROW_102_Left_426 VSS VSS gf180mcu_fd_sc_mcu9t5v0__endcap
X_19834_ _19834_/D _20026_/RN clkload56/I _19834_/Q VSS VSS VSS VSS gf180mcu_fd_sc_mcu9t5v0__dffrnq_1
XTAP_TAPCELL_ROW_220_5131 VSS VSS gf180mcu_fd_sc_mcu9t5v0__filltie
X_12169_ _12169_/A1 _12169_/A2 wire213/Z _12170_/B VSS VSS VSS VSS gf180mcu_fd_sc_mcu9t5v0__aoi21_2
XTAP_TAPCELL_ROW_220_5120 VSS VSS gf180mcu_fd_sc_mcu9t5v0__filltie
X_16977_ _19251_/Q _16622_/B _16991_/S _16977_/Z VSS VSS VSS VSS gf180mcu_fd_sc_mcu9t5v0__mux2_1
XTAP_TAPCELL_ROW_109_3983 VSS VSS gf180mcu_fd_sc_mcu9t5v0__filltie
X_19765_ _19765_/D _20021_/RN clkload41/I _19765_/Q VSS VSS VSS VSS gf180mcu_fd_sc_mcu9t5v0__dffrnq_1
XTAP_TAPCELL_ROW_109_3972 VSS VSS gf180mcu_fd_sc_mcu9t5v0__filltie
X_15928_ _20137_/Q _19258_/Q _15928_/S _20137_/D VSS VSS VSS VSS gf180mcu_fd_sc_mcu9t5v0__mux2_1
X_18716_ _18716_/D clkload54/I _18716_/Q VSS VSS VSS VSS gf180mcu_fd_sc_mcu9t5v0__dffq_1
Xinput5 din[4] input5/Z VSS VSS VSS VSS gf180mcu_fd_sc_mcu9t5v0__clkbuf_2
X_19696_ _19696_/D _20144_/RN _19798_/CLK _19696_/Q VSS VSS VSS VSS gf180mcu_fd_sc_mcu9t5v0__dffrnq_1
XTAP_TAPCELL_ROW_66_2810 VSS VSS gf180mcu_fd_sc_mcu9t5v0__filltie
X_18647_ _18647_/D _20051_/RN clkload47/I _18647_/Q VSS VSS VSS VSS gf180mcu_fd_sc_mcu9t5v0__dffrnq_1
XTAP_TAPCELL_ROW_105_3869 VSS VSS gf180mcu_fd_sc_mcu9t5v0__filltie
XTAP_TAPCELL_ROW_105_3858 VSS VSS gf180mcu_fd_sc_mcu9t5v0__filltie
X_15859_ _15953_/B _15989_/A4 _16198_/A2 VSS VSS VSS VSS gf180mcu_fd_sc_mcu9t5v0__nor2_4
XTAP_TAPCELL_ROW_218_5071 VSS VSS gf180mcu_fd_sc_mcu9t5v0__filltie
XTAP_TAPCELL_ROW_218_5060 VSS VSS gf180mcu_fd_sc_mcu9t5v0__filltie
XPHY_EDGE_ROW_111_Left_435 VSS VSS gf180mcu_fd_sc_mcu9t5v0__endcap
XTAP_TAPCELL_ROW_47_2264 VSS VSS gf180mcu_fd_sc_mcu9t5v0__filltie
XTAP_TAPCELL_ROW_47_2275 VSS VSS gf180mcu_fd_sc_mcu9t5v0__filltie
X_09380_ _18902_/Q _11908_/A1 VSS VSS VSS VSS gf180mcu_fd_sc_mcu9t5v0__clkinv_1
XTAP_TAPCELL_ROW_47_2286 VSS VSS gf180mcu_fd_sc_mcu9t5v0__filltie
X_18578_ _18578_/D _20142_/RN clkload27/I _18578_/Q VSS VSS VSS VSS gf180mcu_fd_sc_mcu9t5v0__dffrnq_1
X_17529_ input8/Z _18634_/Q _17529_/S _18634_/D VSS VSS VSS VSS gf180mcu_fd_sc_mcu9t5v0__mux2_1
XTAP_TAPCELL_ROW_227_5318 VSS VSS gf180mcu_fd_sc_mcu9t5v0__filltie
XTAP_TAPCELL_ROW_227_5307 VSS VSS gf180mcu_fd_sc_mcu9t5v0__filltie
XPHY_EDGE_ROW_202_2_Right_933 VSS VSS gf180mcu_fd_sc_mcu9t5v0__endcap
XPHY_EDGE_ROW_120_Left_444 VSS VSS gf180mcu_fd_sc_mcu9t5v0__endcap
XTAP_TAPCELL_ROW_290_7054 VSS VSS gf180mcu_fd_sc_mcu9t5v0__filltie
XTAP_TAPCELL_ROW_290_7043 VSS VSS gf180mcu_fd_sc_mcu9t5v0__filltie
XTAP_TAPCELL_ROW_290_7032 VSS VSS gf180mcu_fd_sc_mcu9t5v0__filltie
X_09716_ _20064_/Q _10823_/A2 _10824_/A2 VSS _09845_/VNW VSS VSS gf180mcu_fd_sc_mcu9t5v0__nand2_1
XPHY_EDGE_ROW_168_2_Right_899 VSS VSS gf180mcu_fd_sc_mcu9t5v0__endcap
XTAP_TAPCELL_ROW_32_1854 VSS VSS gf180mcu_fd_sc_mcu9t5v0__filltie
XTAP_TAPCELL_ROW_32_1865 VSS VSS gf180mcu_fd_sc_mcu9t5v0__filltie
XTAP_TAPCELL_ROW_32_1876 VSS VSS gf180mcu_fd_sc_mcu9t5v0__filltie
XTAP_TAPCELL_ROW_311_7636 VSS VSS gf180mcu_fd_sc_mcu9t5v0__filltie
XTAP_TAPCELL_ROW_311_7625 VSS VSS gf180mcu_fd_sc_mcu9t5v0__filltie
XTAP_TAPCELL_ROW_311_7614 VSS VSS gf180mcu_fd_sc_mcu9t5v0__filltie
X_09647_ _15820_/B1 _15820_/B2 _09647_/B _20005_/D VSS VSS VSS VSS gf180mcu_fd_sc_mcu9t5v0__oai21_1
Xclkbuf_leaf_65_clk_regs clkload1/I clkload35/I VSS _14514_/VNW VSS VSS gf180mcu_fd_sc_mcu9t5v0__clkbuf_8
XPHY_EDGE_ROW_267_Right_194 VSS VSS gf180mcu_fd_sc_mcu9t5v0__endcap
X_09578_ _19018_/Q _18101_/A2 _09578_/Z VSS _09771_/VNW VSS VSS gf180mcu_fd_sc_mcu9t5v0__or2_1
XTAP_TAPCELL_ROW_212_4908 VSS VSS gf180mcu_fd_sc_mcu9t5v0__filltie
X_11540_ _18890_/Q _11878_/A1 _11488_/B _11540_/B2 _11540_/C _11542_/A1 VSS _18003_/VNW
+ VSS VSS gf180mcu_fd_sc_mcu9t5v0__oai221_1
XTAP_TAPCELL_ROW_115_4154 VSS VSS gf180mcu_fd_sc_mcu9t5v0__filltie
XTAP_TAPCELL_ROW_115_4143 VSS VSS gf180mcu_fd_sc_mcu9t5v0__filltie
XTAP_TAPCELL_ROW_115_4132 VSS VSS gf180mcu_fd_sc_mcu9t5v0__filltie
XTAP_TAPCELL_ROW_309_7576 VSS VSS gf180mcu_fd_sc_mcu9t5v0__filltie
XTAP_TAPCELL_ROW_309_7565 VSS VSS gf180mcu_fd_sc_mcu9t5v0__filltie
X_11471_ _18403_/Q _11534_/S _11472_/C VSS VSS VSS VSS gf180mcu_fd_sc_mcu9t5v0__or2_1
XTAP_TAPCELL_ROW_111_4029 VSS VSS gf180mcu_fd_sc_mcu9t5v0__filltie
X_10422_ _19947_/Q wire216/Z _10655_/B _10423_/B2 VSS VSS VSS VSS gf180mcu_fd_sc_mcu9t5v0__aoi21_1
X_13210_ _13497_/A1 _13222_/A2 _13211_/A2 VSS VSS VSS VSS gf180mcu_fd_sc_mcu9t5v0__nor2_1
X_14190_ _14190_/I _14252_/A1 VSS _14190_/VNW VSS VSS gf180mcu_fd_sc_mcu9t5v0__clkinv_1
X_10353_ _17198_/A1 _10353_/A2 _10353_/B _10353_/C _10354_/C VSS VSS VSS VSS gf180mcu_fd_sc_mcu9t5v0__oai211_1
X_13141_ _13184_/A1 _13159_/A2 _13142_/A2 VSS _13141_/VNW VSS VSS gf180mcu_fd_sc_mcu9t5v0__nor2_1
XTAP_TAPCELL_ROW_128_4515 VSS VSS gf180mcu_fd_sc_mcu9t5v0__filltie
XTAP_TAPCELL_ROW_128_4504 VSS VSS gf180mcu_fd_sc_mcu9t5v0__filltie
X_13072_ _19757_/Q _19791_/Q _13073_/B VSS VSS VSS VSS gf180mcu_fd_sc_mcu9t5v0__xnor2_1
X_16900_ _16899_/Z _18442_/Q _16910_/S _18442_/D VSS VSS VSS VSS gf180mcu_fd_sc_mcu9t5v0__mux2_1
X_10284_ _18988_/Q _10654_/A2 _10284_/B wire160/Z _10286_/B1 VSS VSS VSS VSS gf180mcu_fd_sc_mcu9t5v0__oai211_1
X_12023_ _18441_/Q _12046_/S _12025_/B1 VSS VSS VSS VSS gf180mcu_fd_sc_mcu9t5v0__nand2_1
X_17880_ _17880_/A1 _18681_/Q _17885_/S _18684_/Q _17881_/B VSS VSS VSS VSS gf180mcu_fd_sc_mcu9t5v0__aoi211_2
X_16831_ _16824_/S _16831_/A2 _16831_/Z VSS VSS VSS VSS gf180mcu_fd_sc_mcu9t5v0__and2_1
X_16762_ _16761_/Z _18380_/Q _16764_/S _18380_/D VSS _16906_/VNW VSS VSS gf180mcu_fd_sc_mcu9t5v0__mux2_1
X_19550_ _19550_/D _20062_/RN clkload37/I _19550_/Q VSS VSS VSS VSS gf180mcu_fd_sc_mcu9t5v0__dffrnq_1
X_18501_ _18501_/D _18501_/CLK _18501_/Q VSS VSS VSS VSS gf180mcu_fd_sc_mcu9t5v0__dffq_4
X_15713_ _20003_/Q _09675_/B _15820_/B1 _15729_/A1 VSS VSS VSS VSS gf180mcu_fd_sc_mcu9t5v0__nor3_1
X_13974_ _13976_/A2 _13976_/A3 _13999_/B VSS _13975_/VNW VSS VSS gf180mcu_fd_sc_mcu9t5v0__nand2_1
XTAP_TAPCELL_ROW_273_6584 VSS VSS gf180mcu_fd_sc_mcu9t5v0__filltie
X_16693_ _18364_/Q _16693_/I1 _16707_/S _18364_/D VSS VSS VSS VSS gf180mcu_fd_sc_mcu9t5v0__mux2_4
XTAP_TAPCELL_ROW_273_6573 VSS VSS gf180mcu_fd_sc_mcu9t5v0__filltie
X_12925_ _19777_/Q _12923_/Z _12930_/A3 VSS VSS VSS VSS gf180mcu_fd_sc_mcu9t5v0__nand2_1
X_19481_ _19481_/D _20057_/RN clkload14/I _19481_/Q VSS VSS VSS VSS gf180mcu_fd_sc_mcu9t5v0__dffrnq_1
X_18432_ _18432_/D _18496_/CLK _18432_/Q VSS VSS VSS VSS gf180mcu_fd_sc_mcu9t5v0__dffq_4
XPHY_EDGE_ROW_234_Right_161 VSS VSS gf180mcu_fd_sc_mcu9t5v0__endcap
XTAP_TAPCELL_ROW_100_3744 VSS VSS gf180mcu_fd_sc_mcu9t5v0__filltie
X_15644_ _19899_/Q _19900_/Q _15640_/B _15648_/B1 VSS VSS VSS VSS gf180mcu_fd_sc_mcu9t5v0__nor3_1
XTAP_TAPCELL_ROW_100_3733 VSS VSS gf180mcu_fd_sc_mcu9t5v0__filltie
X_12856_ _19768_/Q _12854_/Z _12857_/A2 VSS _13238_/VNW VSS VSS gf180mcu_fd_sc_mcu9t5v0__nor2_1
XTAP_TAPCELL_ROW_100_3722 VSS VSS gf180mcu_fd_sc_mcu9t5v0__filltie
X_18363_ _18363_/D clkload62/I _18363_/Q VSS VSS VSS VSS gf180mcu_fd_sc_mcu9t5v0__dffq_4
X_11807_ _11807_/A1 _11807_/A2 _11807_/A3 _11809_/A3 VSS VSS VSS VSS gf180mcu_fd_sc_mcu9t5v0__nand3_4
X_15575_ _18036_/I0 _18034_/I0 _18035_/I0 _18032_/I0 _15576_/A3 VSS _15575_/VNW VSS
+ VSS gf180mcu_fd_sc_mcu9t5v0__nor4_1
X_17314_ _18356_/Q _17406_/A2 _17405_/A2 _18372_/Q _17315_/B VSS VSS VSS VSS gf180mcu_fd_sc_mcu9t5v0__aoi22_1
XTAP_TAPCELL_ROW_286_6934 VSS VSS gf180mcu_fd_sc_mcu9t5v0__filltie
XTAP_TAPCELL_ROW_286_6923 VSS VSS gf180mcu_fd_sc_mcu9t5v0__filltie
X_12787_ _19725_/Q _19790_/Q _12948_/S _12787_/Z VSS VSS VSS VSS gf180mcu_fd_sc_mcu9t5v0__mux2_1
X_14526_ _14531_/A1 _14738_/A1 _14526_/Z VSS VSS VSS VSS gf180mcu_fd_sc_mcu9t5v0__xor2_1
XTAP_TAPCELL_ROW_42_2150 VSS VSS gf180mcu_fd_sc_mcu9t5v0__filltie
XTAP_TAPCELL_ROW_286_6945 VSS VSS gf180mcu_fd_sc_mcu9t5v0__filltie
X_18294_ _18294_/D clkload81/I _18294_/Q VSS VSS VSS VSS gf180mcu_fd_sc_mcu9t5v0__dffq_1
X_11738_ _11738_/A1 _11748_/A3 _11739_/B2 VSS VSS VSS VSS gf180mcu_fd_sc_mcu9t5v0__xnor2_1
X_17245_ _20115_/Q wire168/Z _17409_/B _17247_/A2 VSS VSS VSS VSS gf180mcu_fd_sc_mcu9t5v0__oai21_1
XPHY_EDGE_ROW_208_1_Right_792 VSS VSS gf180mcu_fd_sc_mcu9t5v0__endcap
X_11669_ _11654_/C _12649_/A2 _12649_/A3 _11671_/A2 VSS _11671_/VNW VSS VSS gf180mcu_fd_sc_mcu9t5v0__nand3_1
X_14457_ _14465_/A1 _19124_/Q _14466_/A1 VSS VSS VSS VSS gf180mcu_fd_sc_mcu9t5v0__nor2_1
X_17176_ _17176_/A1 _17176_/A2 _17176_/B1 _17176_/B2 _17177_/A2 VSS _17177_/VNW VSS
+ VSS gf180mcu_fd_sc_mcu9t5v0__aoi22_1
X_13408_ _13415_/A1 _13409_/A2 _13625_/A1 VSS _13418_/VNW VSS VSS gf180mcu_fd_sc_mcu9t5v0__nand2_1
X_14388_ _19449_/Q _14766_/A2 _14395_/A1 VSS VSS VSS VSS gf180mcu_fd_sc_mcu9t5v0__nand2_1
X_16127_ _19230_/Q _16750_/A1 _16686_/A3 _16128_/C VSS VSS VSS VSS gf180mcu_fd_sc_mcu9t5v0__and3_1
XTAP_TAPCELL_ROW_55_2500 VSS VSS gf180mcu_fd_sc_mcu9t5v0__filltie
X_13339_ _13336_/Z _13339_/A2 _13339_/Z VSS VSS VSS VSS gf180mcu_fd_sc_mcu9t5v0__xor2_1
Xrst_tree_leaf_20 rst_tree_mid_2/Z _20063_/RN VSS VSS VSS VSS gf180mcu_fd_sc_mcu9t5v0__clkbuf_16
Xrst_tree_leaf_31 rst_tree_mid_3/Z _20052_/RN VSS VSS VSS VSS gf180mcu_fd_sc_mcu9t5v0__clkbuf_16
X_16058_ _16750_/A1 _16674_/A2 _16058_/B _16060_/A2 VSS _16159_/VNW VSS VSS gf180mcu_fd_sc_mcu9t5v0__aoi21_1
Xrst_tree_leaf_53 rst_tree_mid_6/Z _20030_/RN VSS VSS VSS VSS gf180mcu_fd_sc_mcu9t5v0__clkbuf_16
Xrst_tree_leaf_42 rst_tree_mid_5/Z _20041_/RN VSS VSS VSS VSS gf180mcu_fd_sc_mcu9t5v0__clkbuf_16
X_15009_ _15009_/A1 _15008_/B _15010_/I1 VSS _15013_/VNW VSS VSS gf180mcu_fd_sc_mcu9t5v0__xnor2_1
X_19817_ _19817_/D _20073_/RN clkload58/I _19817_/Q VSS VSS VSS VSS gf180mcu_fd_sc_mcu9t5v0__dffsnq_1
X_19748_ _19748_/D _20068_/RN clkload39/I _19748_/Q VSS VSS VSS VSS gf180mcu_fd_sc_mcu9t5v0__dffrnq_1
XTAP_TAPCELL_ROW_49_2326 VSS VSS gf180mcu_fd_sc_mcu9t5v0__filltie
XTAP_TAPCELL_ROW_49_2337 VSS VSS gf180mcu_fd_sc_mcu9t5v0__filltie
X_09501_ _19072_/Q _14730_/S _09511_/B _11075_/A1 VSS _09503_/VNW VSS VSS gf180mcu_fd_sc_mcu9t5v0__aoi21_4
X_19679_ _19679_/D _20063_/RN clkload43/I _19679_/Q VSS VSS VSS VSS gf180mcu_fd_sc_mcu9t5v0__dffrnq_1
XTAP_TAPCELL_ROW_216_5019 VSS VSS gf180mcu_fd_sc_mcu9t5v0__filltie
XTAP_TAPCELL_ROW_216_5008 VSS VSS gf180mcu_fd_sc_mcu9t5v0__filltie
X_09432_ _18694_/Q _18693_/Q _09889_/A2 VSS VSS VSS VSS gf180mcu_fd_sc_mcu9t5v0__nor2_4
X_09363_ _18316_/Q _11735_/A1 VSS VSS VSS VSS gf180mcu_fd_sc_mcu9t5v0__clkinv_1
XTAP_TAPCELL_ROW_252_5989 VSS VSS gf180mcu_fd_sc_mcu9t5v0__filltie
XANTENNA_21 output16/I VSS VSS VSS VSS gf180mcu_fd_sc_mcu9t5v0__antenna
X_09294_ _19221_/Q _16633_/A1 VSS _10915_/VNW VSS VSS gf180mcu_fd_sc_mcu9t5v0__clkinv_1
XANTENNA_10 _11185_/A3 VSS VSS VSS VSS gf180mcu_fd_sc_mcu9t5v0__antenna
XTAP_TAPCELL_ROW_25_1680 VSS VSS gf180mcu_fd_sc_mcu9t5v0__filltie
XTAP_TAPCELL_ROW_21_1555 VSS VSS gf180mcu_fd_sc_mcu9t5v0__filltie
XTAP_TAPCELL_ROW_304_7440 VSS VSS gf180mcu_fd_sc_mcu9t5v0__filltie
XTAP_TAPCELL_ROW_21_1566 VSS VSS gf180mcu_fd_sc_mcu9t5v0__filltie
XTAP_TAPCELL_ROW_300_7315 VSS VSS gf180mcu_fd_sc_mcu9t5v0__filltie
XTAP_TAPCELL_ROW_300_7326 VSS VSS gf180mcu_fd_sc_mcu9t5v0__filltie
XTAP_TAPCELL_ROW_292_7105 VSS VSS gf180mcu_fd_sc_mcu9t5v0__filltie
XPHY_EDGE_ROW_203_2_Right_934 VSS VSS gf180mcu_fd_sc_mcu9t5v0__endcap
XTAP_TAPCELL_ROW_34_1905 VSS VSS gf180mcu_fd_sc_mcu9t5v0__filltie
XTAP_TAPCELL_ROW_34_1916 VSS VSS gf180mcu_fd_sc_mcu9t5v0__filltie
XTAP_TAPCELL_ROW_34_1927 VSS VSS gf180mcu_fd_sc_mcu9t5v0__filltie
XTAP_TAPCELL_ROW_317_7801 VSS VSS gf180mcu_fd_sc_mcu9t5v0__filltie
XTAP_TAPCELL_ROW_19_1495 VSS VSS gf180mcu_fd_sc_mcu9t5v0__filltie
XPHY_EDGE_ROW_169_3_Left_827 VSS VSS gf180mcu_fd_sc_mcu9t5v0__endcap
Xmax_cap34 _16928_/S _16926_/S VSS VSS VSS VSS gf180mcu_fd_sc_mcu9t5v0__clkbuf_16
Xmax_cap23 _17042_/S _17056_/S VSS VSS VSS VSS gf180mcu_fd_sc_mcu9t5v0__clkbuf_16
Xmax_cap45 _16047_/S _16670_/S VSS VSS VSS VSS gf180mcu_fd_sc_mcu9t5v0__clkbuf_16
X_10971_ _18148_/S _10968_/Z _10972_/A2 _10971_/B _19012_/D VSS _10972_/VNW VSS VSS
+ gf180mcu_fd_sc_mcu9t5v0__oai31_1
Xmax_cap78 wire79/Z _15905_/S VSS VSS VSS VSS gf180mcu_fd_sc_mcu9t5v0__clkbuf_8
Xmax_cap67 _16751_/B _16695_/B VSS VSS VSS VSS gf180mcu_fd_sc_mcu9t5v0__clkbuf_8
X_12710_ _12716_/S _12710_/A2 _12711_/B VSS _12710_/VNW VSS VSS gf180mcu_fd_sc_mcu9t5v0__nand2_1
X_13690_ _19460_/Q _13745_/B1 _13692_/A1 VSS VSS VSS VSS gf180mcu_fd_sc_mcu9t5v0__nand2_1
Xmax_cap89 _16679_/B _16730_/C VSS VSS VSS VSS gf180mcu_fd_sc_mcu9t5v0__buf_4
XTAP_TAPCELL_ROW_117_4205 VSS VSS gf180mcu_fd_sc_mcu9t5v0__filltie
X_12641_ _12675_/B _12641_/A2 _12645_/A2 VSS _12641_/VNW VSS VSS gf180mcu_fd_sc_mcu9t5v0__nand2_1
XPHY_EDGE_ROW_165_1_Left_488 VSS VSS gf180mcu_fd_sc_mcu9t5v0__endcap
X_12572_ _12620_/A1 _12620_/A2 _12572_/A3 _12572_/B _19167_/D VSS _12572_/VNW VSS
+ VSS gf180mcu_fd_sc_mcu9t5v0__oai31_1
X_15360_ _19648_/Q _19625_/Q _15362_/A1 _15361_/I1 VSS _15362_/VNW VSS VSS gf180mcu_fd_sc_mcu9t5v0__xnor3_1
X_11523_ _11521_/B _11522_/Z _11523_/B _11527_/A2 VSS VSS VSS VSS gf180mcu_fd_sc_mcu9t5v0__oai21_1
X_15291_ _19735_/Q _15417_/S _15292_/B VSS VSS VSS VSS gf180mcu_fd_sc_mcu9t5v0__nand2_1
X_14311_ _13867_/Z _19384_/Q _14322_/S _19384_/D VSS VSS VSS VSS gf180mcu_fd_sc_mcu9t5v0__mux2_1
X_17030_ _17029_/Z _18506_/Q _17034_/S _18506_/D VSS VSS VSS VSS gf180mcu_fd_sc_mcu9t5v0__mux2_1
X_11454_ _18370_/Q _11537_/S _11538_/B _11454_/C _11461_/A1 VSS VSS VSS VSS gf180mcu_fd_sc_mcu9t5v0__oai211_1
X_14242_ _14252_/A1 _14242_/A2 _14242_/B _14254_/A1 VSS _14253_/VNW VSS VSS gf180mcu_fd_sc_mcu9t5v0__oai21_1
X_10405_ _17358_/A1 _18319_/Q _10408_/A2 VSS VSS VSS VSS gf180mcu_fd_sc_mcu9t5v0__nor2_1
XTAP_TAPCELL_ROW_95_3592 VSS VSS gf180mcu_fd_sc_mcu9t5v0__filltie
Xwire277 wire277/I wire277/Z VSS VSS VSS VSS gf180mcu_fd_sc_mcu9t5v0__clkbuf_4
X_11385_ _18445_/Q _11385_/A2 _11388_/A1 VSS VSS VSS VSS gf180mcu_fd_sc_mcu9t5v0__nor2_1
XTAP_TAPCELL_ROW_262_6274 VSS VSS gf180mcu_fd_sc_mcu9t5v0__filltie
XTAP_TAPCELL_ROW_262_6263 VSS VSS gf180mcu_fd_sc_mcu9t5v0__filltie
XTAP_TAPCELL_ROW_91_3489 VSS VSS gf180mcu_fd_sc_mcu9t5v0__filltie
X_14173_ _13807_/Z _19328_/Q _14266_/S _19328_/D VSS VSS VSS VSS gf180mcu_fd_sc_mcu9t5v0__mux2_1
XTAP_TAPCELL_ROW_91_3478 VSS VSS gf180mcu_fd_sc_mcu9t5v0__filltie
XTAP_TAPCELL_ROW_262_6285 VSS VSS gf180mcu_fd_sc_mcu9t5v0__filltie
X_10336_ _18958_/Q wire165/Z _10652_/B1 _18974_/Q _10337_/A3 VSS _10915_/VNW VSS VSS
+ gf180mcu_fd_sc_mcu9t5v0__aoi22_1
X_18981_ _18981_/D _20069_/RN clkload68/I _18981_/Q VSS VSS VSS VSS gf180mcu_fd_sc_mcu9t5v0__dffrnq_1
X_13124_ _13124_/A1 _13124_/A2 _13540_/B _13124_/B _13129_/B1 VSS VSS VSS VSS gf180mcu_fd_sc_mcu9t5v0__oai31_1
Xload_slew227 _19825_/Q _17260_/S VSS VSS VSS VSS gf180mcu_fd_sc_mcu9t5v0__clkbuf_16
Xload_slew205 _12071_/B _11788_/B VSS _12409_/VNW VSS VSS gf180mcu_fd_sc_mcu9t5v0__clkbuf_8
X_10267_ _19826_/Q _10265_/Z _10267_/B _10272_/A2 VSS VSS VSS VSS gf180mcu_fd_sc_mcu9t5v0__oai21_1
X_13055_ _13055_/A1 _13054_/B _13055_/A3 _13055_/Z VSS _13055_/VNW VSS VSS gf180mcu_fd_sc_mcu9t5v0__and3_1
X_17932_ _18848_/Q _17929_/Z _17933_/A3 VSS VSS VSS VSS gf180mcu_fd_sc_mcu9t5v0__nor2_1
XPHY_EDGE_ROW_303_Right_230 VSS VSS gf180mcu_fd_sc_mcu9t5v0__endcap
X_17863_ _09840_/C _17863_/A2 _17868_/A3 _17864_/A2 VSS VSS VSS VSS gf180mcu_fd_sc_mcu9t5v0__nand3_1
X_12006_ _18906_/Q _12007_/A2 wire213/I _12007_/B VSS VSS VSS VSS gf180mcu_fd_sc_mcu9t5v0__oai21_1
XTAP_TAPCELL_ROW_275_6646 VSS VSS gf180mcu_fd_sc_mcu9t5v0__filltie
XTAP_TAPCELL_ROW_275_6635 VSS VSS gf180mcu_fd_sc_mcu9t5v0__filltie
XTAP_TAPCELL_ROW_275_6624 VSS VSS gf180mcu_fd_sc_mcu9t5v0__filltie
X_10198_ _20047_/Q _09870_/Z _10200_/A1 VSS VSS VSS VSS gf180mcu_fd_sc_mcu9t5v0__nand2_1
X_19602_ _19602_/D _20050_/RN clkload8/I _19602_/Q VSS VSS VSS VSS gf180mcu_fd_sc_mcu9t5v0__dffrnq_1
X_16814_ _18403_/Q _16814_/I1 _16824_/S _18403_/D VSS VSS VSS VSS gf180mcu_fd_sc_mcu9t5v0__mux2_1
X_17794_ _18772_/Q _18759_/Q _18769_/D _18772_/D VSS VSS VSS VSS gf180mcu_fd_sc_mcu9t5v0__mux2_1
X_16745_ _16750_/A1 _16750_/A2 _16672_/B _16745_/B2 _16746_/A3 VSS _16745_/VNW VSS
+ VSS gf180mcu_fd_sc_mcu9t5v0__aoi22_1
X_13957_ _13955_/Z _13958_/A2 _13989_/B VSS VSS VSS VSS gf180mcu_fd_sc_mcu9t5v0__nand2_1
X_19533_ _19533_/D _20045_/RN clkload30/I _19533_/Q VSS VSS VSS VSS gf180mcu_fd_sc_mcu9t5v0__dffrnq_1
X_16676_ _18360_/Q _16676_/I1 _16676_/S _18360_/D VSS _16961_/VNW VSS VSS gf180mcu_fd_sc_mcu9t5v0__mux2_4
X_12908_ _12901_/Z _12904_/Z _12908_/B _12918_/A1 VSS VSS VSS VSS gf180mcu_fd_sc_mcu9t5v0__aoi21_1
X_19464_ _19464_/D _20040_/RN clkload12/I _19464_/Q VSS VSS VSS VSS gf180mcu_fd_sc_mcu9t5v0__dffrnq_1
XTAP_TAPCELL_ROW_44_2201 VSS VSS gf180mcu_fd_sc_mcu9t5v0__filltie
X_18415_ _18415_/D clkload63/I _18415_/Q VSS VSS VSS VSS gf180mcu_fd_sc_mcu9t5v0__dffq_1
X_15627_ _19893_/Q _15677_/B _15623_/Z _15628_/B VSS _15627_/VNW VSS VSS gf180mcu_fd_sc_mcu9t5v0__nand3_1
X_13888_ _19321_/Q _19294_/Q _13928_/A1 VSS _13888_/VNW VSS VSS gf180mcu_fd_sc_mcu9t5v0__nand2_1
X_12839_ _12834_/Z _12839_/A2 _12839_/B _12841_/A2 VSS _12839_/VNW VSS VSS gf180mcu_fd_sc_mcu9t5v0__aoi21_1
X_19395_ _19395_/D _20035_/RN clkload9/I _19395_/Q VSS VSS VSS VSS gf180mcu_fd_sc_mcu9t5v0__dffrnq_1
X_18346_ _18346_/D clkload64/I _18346_/Q VSS VSS VSS VSS gf180mcu_fd_sc_mcu9t5v0__dffq_1
X_15558_ _19872_/Q _19873_/Q _15553_/Z _15558_/Z VSS VSS VSS VSS gf180mcu_fd_sc_mcu9t5v0__and3_1
Xu_transform_scheduler_core.u_fft_scratch_sram.u_lo.g_pin_drive\[7\].u_addr_driver
+ _10810_/ZN u_transform_scheduler_core.u_fft_scratch_sram.u_lo.u_sram/A[7] VSS VSS
+ VSS VSS gf180mcu_fd_sc_mcu9t5v0__buf_8
X_18277_ _18277_/D _18279_/CLK _18277_/Q VSS VSS VSS VSS gf180mcu_fd_sc_mcu9t5v0__dffq_4
X_15489_ _17422_/S _15488_/Z _19831_/D VSS VSS VSS VSS gf180mcu_fd_sc_mcu9t5v0__and2_1
X_14509_ _14731_/A1 _14509_/A2 _14510_/I1 VSS _14510_/VNW VSS VSS gf180mcu_fd_sc_mcu9t5v0__xnor2_1
X_17228_ _18543_/Q _17420_/S _17229_/B VSS VSS VSS VSS gf180mcu_fd_sc_mcu9t5v0__nand2_1
XTAP_TAPCELL_ROW_38_2016 VSS VSS gf180mcu_fd_sc_mcu9t5v0__filltie
XTAP_TAPCELL_ROW_38_2027 VSS VSS gf180mcu_fd_sc_mcu9t5v0__filltie
X_17159_ _20111_/Q _17408_/B _17159_/B _17159_/C _17161_/B1 VSS VSS VSS VSS gf180mcu_fd_sc_mcu9t5v0__aoi211_1
XTAP_TAPCELL_ROW_38_2038 VSS VSS gf180mcu_fd_sc_mcu9t5v0__filltie
X_09981_ _09981_/A1 _09981_/A2 _09981_/B _10005_/A1 VSS _09981_/VNW VSS VSS gf180mcu_fd_sc_mcu9t5v0__aoi21_1
XTAP_TAPCELL_ROW_14_1370 VSS VSS gf180mcu_fd_sc_mcu9t5v0__filltie
XTAP_TAPCELL_ROW_10_1245 VSS VSS gf180mcu_fd_sc_mcu9t5v0__filltie
XTAP_TAPCELL_ROW_14_1381 VSS VSS gf180mcu_fd_sc_mcu9t5v0__filltie
XTAP_TAPCELL_ROW_10_1256 VSS VSS gf180mcu_fd_sc_mcu9t5v0__filltie
XTAP_TAPCELL_ROW_10_1267 VSS VSS gf180mcu_fd_sc_mcu9t5v0__filltie
X_09415_ _11013_/A1 _09768_/A1 _09416_/C VSS VSS VSS VSS gf180mcu_fd_sc_mcu9t5v0__nand2_1
XTAP_TAPCELL_ROW_27_1720 VSS VSS gf180mcu_fd_sc_mcu9t5v0__filltie
XTAP_TAPCELL_ROW_27_1731 VSS VSS gf180mcu_fd_sc_mcu9t5v0__filltie
XTAP_TAPCELL_ROW_23_1606 VSS VSS gf180mcu_fd_sc_mcu9t5v0__filltie
XTAP_TAPCELL_ROW_23_1617 VSS VSS gf180mcu_fd_sc_mcu9t5v0__filltie
X_09346_ _19455_/Q _14454_/A1 VSS VSS VSS VSS gf180mcu_fd_sc_mcu9t5v0__clkinv_1
X_09277_ _20064_/Q _10825_/A1 VSS _10320_/VNW VSS VSS gf180mcu_fd_sc_mcu9t5v0__clkinv_1
XTAP_TAPCELL_ROW_23_1628 VSS VSS gf180mcu_fd_sc_mcu9t5v0__filltie
X_11170_ _18270_/Q _11519_/A2 _11171_/A3 VSS VSS VSS VSS gf180mcu_fd_sc_mcu9t5v0__nand2_1
X_10121_ _18984_/Q _10136_/B1 _10133_/B1 _19015_/Q _18960_/Q wire172/Z _10126_/A1
+ VSS VSS VSS VSS gf180mcu_fd_sc_mcu9t5v0__aoi222_1
XPHY_EDGE_ROW_179_2_Left_691 VSS VSS gf180mcu_fd_sc_mcu9t5v0__endcap
XPHY_EDGE_ROW_204_2_Right_935 VSS VSS gf180mcu_fd_sc_mcu9t5v0__endcap
X_10052_ _10052_/A1 _19881_/Q _10052_/B _10052_/C _10082_/A2 VSS VSS VSS VSS gf180mcu_fd_sc_mcu9t5v0__oai211_1
Xclkbuf_leaf_80_clk_regs clkbuf_3_0_0_clk_regs/Z clkload15/I VSS VSS VSS VSS gf180mcu_fd_sc_mcu9t5v0__clkbuf_8
X_14860_ _19586_/Q _19347_/Q _14900_/S _19586_/D VSS VSS VSS VSS gf180mcu_fd_sc_mcu9t5v0__mux2_1
X_14791_ _19569_/Q _09462_/I _14792_/B VSS VSS VSS VSS gf180mcu_fd_sc_mcu9t5v0__nand2_1
X_13811_ _19318_/Q _19295_/Q _13843_/B2 VSS _13928_/VNW VSS VSS gf180mcu_fd_sc_mcu9t5v0__nand2_1
X_16530_ _16529_/Z _18321_/Q _17054_/S _18321_/D VSS VSS VSS VSS gf180mcu_fd_sc_mcu9t5v0__mux2_4
XTAP_TAPCELL_ROW_84_3293 VSS VSS gf180mcu_fd_sc_mcu9t5v0__filltie
X_13742_ wire199/I _13742_/A2 _13743_/A2 VSS _13742_/VNW VSS VSS gf180mcu_fd_sc_mcu9t5v0__nand2_1
XTAP_TAPCELL_ROW_84_3282 VSS VSS gf180mcu_fd_sc_mcu9t5v0__filltie
X_10954_ _19009_/Q _10953_/Z _10996_/S _19009_/D VSS VSS VSS VSS gf180mcu_fd_sc_mcu9t5v0__mux2_1
X_18200_ _18200_/D clkload82/I _18200_/Q VSS VSS VSS VSS gf180mcu_fd_sc_mcu9t5v0__dffq_1
X_16461_ _19236_/Q _16058_/B _16993_/S _16461_/Z VSS VSS VSS VSS gf180mcu_fd_sc_mcu9t5v0__mux2_1
X_10885_ _10885_/I0 _18981_/Q _18148_/S _18981_/D VSS VSS VSS VSS gf180mcu_fd_sc_mcu9t5v0__mux2_1
X_13673_ _19143_/Q _19109_/Q _14657_/A1 VSS VSS VSS VSS gf180mcu_fd_sc_mcu9t5v0__nand2_1
XTAP_TAPCELL_ROW_80_3179 VSS VSS gf180mcu_fd_sc_mcu9t5v0__filltie
X_16392_ _16391_/Z _18259_/Q _16926_/S _18259_/D VSS VSS VSS VSS gf180mcu_fd_sc_mcu9t5v0__mux2_4
X_15412_ _19697_/Q _19797_/Q _15430_/S _19797_/D VSS VSS VSS VSS gf180mcu_fd_sc_mcu9t5v0__mux2_1
X_19180_ _19180_/D _20140_/RN clkload13/I _19180_/Q VSS VSS VSS VSS gf180mcu_fd_sc_mcu9t5v0__dffrnq_1
X_12624_ _17960_/A1 _12655_/S _19174_/D VSS VSS VSS VSS gf180mcu_fd_sc_mcu9t5v0__nand2_1
XTAP_TAPCELL_ROW_268_6450 VSS VSS gf180mcu_fd_sc_mcu9t5v0__filltie
X_18131_ _18131_/I0 _18952_/Q _18148_/S _18952_/D VSS VSS VSS VSS gf180mcu_fd_sc_mcu9t5v0__mux2_1
XTAP_TAPCELL_ROW_97_3654 VSS VSS gf180mcu_fd_sc_mcu9t5v0__filltie
X_12555_ _19165_/Q _12620_/A1 _12556_/B VSS _14514_/VNW VSS VSS gf180mcu_fd_sc_mcu9t5v0__nand2_1
X_15343_ _15345_/A2 _15343_/A2 _15344_/I1 VSS VSS VSS VSS gf180mcu_fd_sc_mcu9t5v0__xnor2_1
XTAP_TAPCELL_ROW_97_3643 VSS VSS gf180mcu_fd_sc_mcu9t5v0__filltie
X_11506_ _11537_/S _11506_/A2 _11506_/A3 _11507_/C VSS VSS VSS VSS gf180mcu_fd_sc_mcu9t5v0__nand3_1
XTAP_TAPCELL_ROW_264_6325 VSS VSS gf180mcu_fd_sc_mcu9t5v0__filltie
X_18062_ _18062_/I _18100_/A1 VSS VSS VSS VSS gf180mcu_fd_sc_mcu9t5v0__clkinv_1
XTAP_TAPCELL_ROW_93_3529 VSS VSS gf180mcu_fd_sc_mcu9t5v0__filltie
X_17013_ _19253_/Q _16634_/B _17025_/S _17013_/Z VSS VSS VSS VSS gf180mcu_fd_sc_mcu9t5v0__mux2_1
XTAP_TAPCELL_ROW_264_6336 VSS VSS gf180mcu_fd_sc_mcu9t5v0__filltie
X_12486_ _18584_/Q _12723_/B _12486_/B1 _18575_/Q _12487_/A2 VSS _17457_/VNW VSS VSS
+ gf180mcu_fd_sc_mcu9t5v0__oai22_1
X_15274_ _19628_/Q _19605_/Q _19627_/Q _19604_/Q _15277_/A1 VSS _15274_/VNW VSS VSS
+ gf180mcu_fd_sc_mcu9t5v0__oai211_1
X_11437_ _11437_/A1 _11437_/A2 _19097_/D VSS VSS VSS VSS gf180mcu_fd_sc_mcu9t5v0__nand2_1
X_14225_ _14226_/A1 _14224_/Z _14246_/B VSS VSS VSS VSS gf180mcu_fd_sc_mcu9t5v0__nand2_1
X_11368_ _11423_/A1 _11368_/A2 _11368_/A3 _11368_/B _19092_/D VSS VSS VSS VSS gf180mcu_fd_sc_mcu9t5v0__oai31_1
X_14156_ _19179_/Q _14155_/Z _14715_/S _14156_/Z VSS VSS VSS VSS gf180mcu_fd_sc_mcu9t5v0__mux2_1
X_10319_ _18268_/Q _18252_/Q _19825_/Q _10319_/Z VSS VSS VSS VSS gf180mcu_fd_sc_mcu9t5v0__mux2_1
X_13107_ _19726_/Q _13107_/A2 _13145_/C VSS _13107_/VNW VSS VSS gf180mcu_fd_sc_mcu9t5v0__nor2_1
X_11299_ _18279_/Q _11534_/S _11537_/S _11301_/A2 VSS VSS VSS VSS gf180mcu_fd_sc_mcu9t5v0__oai21_1
X_18964_ _18964_/D _20052_/RN clkload67/I _18964_/Q VSS VSS VSS VSS gf180mcu_fd_sc_mcu9t5v0__dffrnq_1
X_14087_ _14088_/A1 _14086_/Z _14110_/A1 VSS VSS VSS VSS gf180mcu_fd_sc_mcu9t5v0__nand2_1
X_13038_ _13039_/A1 _13039_/A2 _13520_/B _13061_/A1 VSS _13049_/VNW VSS VSS gf180mcu_fd_sc_mcu9t5v0__oai21_1
X_18895_ _18895_/D _20047_/RN clkload12/I _18895_/Q VSS VSS VSS VSS gf180mcu_fd_sc_mcu9t5v0__dffrnq_1
X_17915_ _09798_/Z _17915_/A2 _17915_/Z VSS _17916_/VNW VSS VSS gf180mcu_fd_sc_mcu9t5v0__or2_1
X_17846_ _09840_/C _17863_/A2 _17868_/A2 VSS _17868_/VNW VSS VSS gf180mcu_fd_sc_mcu9t5v0__nand2_1
XTAP_TAPCELL_ROW_7_1166 VSS VSS gf180mcu_fd_sc_mcu9t5v0__filltie
XTAP_TAPCELL_ROW_7_1177 VSS VSS gf180mcu_fd_sc_mcu9t5v0__filltie
X_17777_ _17777_/A1 _17779_/A2 _17777_/B _17779_/C _18763_/D VSS _17777_/VNW VSS VSS
+ gf180mcu_fd_sc_mcu9t5v0__aoi211_1
X_19516_ _19516_/D _20028_/RN clkload43/I _19516_/Q VSS VSS VSS VSS gf180mcu_fd_sc_mcu9t5v0__dffrnq_1
XTAP_TAPCELL_ROW_7_1188 VSS VSS gf180mcu_fd_sc_mcu9t5v0__filltie
X_14989_ _19431_/Q _19376_/Q _14992_/A1 _14990_/I1 VSS VSS VSS VSS gf180mcu_fd_sc_mcu9t5v0__xnor3_1
X_16728_ _18372_/Q _16747_/A2 _16747_/A3 _16732_/B VSS _16728_/VNW VSS VSS gf180mcu_fd_sc_mcu9t5v0__nand3_1
X_16659_ _16660_/B _16741_/A2 VSS VSS VSS VSS gf180mcu_fd_sc_mcu9t5v0__clkinv_1
X_19447_ _19447_/D _20023_/RN clkload12/I _19447_/Q VSS VSS VSS VSS gf180mcu_fd_sc_mcu9t5v0__dffrnq_1
XTAP_TAPCELL_ROW_234_5494 VSS VSS gf180mcu_fd_sc_mcu9t5v0__filltie
X_09200_ _19137_/Q _12312_/A1 VSS VSS VSS VSS gf180mcu_fd_sc_mcu9t5v0__clkinv_1
X_19378_ _19378_/D _20018_/RN clkload21/I _19378_/Q VSS VSS VSS VSS gf180mcu_fd_sc_mcu9t5v0__dffrnq_1
X_18329_ _18329_/D clkload63/I _18329_/Q VSS VSS VSS VSS gf180mcu_fd_sc_mcu9t5v0__dffq_1
X_09131_ _19794_/Q _13131_/A2 VSS _15374_/VNW VSS VSS gf180mcu_fd_sc_mcu9t5v0__clkinv_1
Xrebuffer229 _16299_/A1 _16668_/A2 VSS VSS VSS VSS gf180mcu_fd_sc_mcu9t5v0__buf_12
X_09062_ input4/Z _17771_/A1 VSS VSS VSS VSS gf180mcu_fd_sc_mcu9t5v0__clkinv_1
XTAP_TAPCELL_ROW_247_5866 VSS VSS gf180mcu_fd_sc_mcu9t5v0__filltie
XTAP_TAPCELL_ROW_247_5855 VSS VSS gf180mcu_fd_sc_mcu9t5v0__filltie
XTAP_TAPCELL_ROW_16_1410 VSS VSS gf180mcu_fd_sc_mcu9t5v0__filltie
XTAP_TAPCELL_ROW_16_1421 VSS VSS gf180mcu_fd_sc_mcu9t5v0__filltie
X_09964_ _09964_/A1 _10180_/B1 _09964_/A3 _09967_/B1 VSS VSS VSS VSS gf180mcu_fd_sc_mcu9t5v0__nand3_1
X_09895_ _10057_/A2 _15830_/A2 _09898_/C VSS VSS VSS VSS gf180mcu_fd_sc_mcu9t5v0__nor2_2
X_20084_ _20084_/D clkload63/I _20084_/Q VSS VSS VSS VSS gf180mcu_fd_sc_mcu9t5v0__dffq_1
XTAP_TAPCELL_ROW_16_1432 VSS VSS gf180mcu_fd_sc_mcu9t5v0__filltie
XTAP_TAPCELL_ROW_12_1307 VSS VSS gf180mcu_fd_sc_mcu9t5v0__filltie
XTAP_TAPCELL_ROW_12_1318 VSS VSS gf180mcu_fd_sc_mcu9t5v0__filltie
X_10670_ _10693_/B _10803_/C _10669_/Z _10675_/A1 VSS VSS VSS VSS gf180mcu_fd_sc_mcu9t5v0__nand3_1
X_09329_ _19882_/Q _15593_/A1 VSS _15578_/VNW VSS VSS gf180mcu_fd_sc_mcu9t5v0__clkinv_1
XTAP_TAPCELL_ROW_135_4691 VSS VSS gf180mcu_fd_sc_mcu9t5v0__filltie
X_12340_ _18376_/Q _18360_/Q _12340_/S _12340_/Z VSS VSS VSS VSS gf180mcu_fd_sc_mcu9t5v0__mux2_1
X_12271_ _12237_/B _12272_/A2 _12271_/B _12295_/A2 VSS VSS VSS VSS gf180mcu_fd_sc_mcu9t5v0__aoi21_4
XTAP_TAPCELL_ROW_131_4588 VSS VSS gf180mcu_fd_sc_mcu9t5v0__filltie
XTAP_TAPCELL_ROW_131_4577 VSS VSS gf180mcu_fd_sc_mcu9t5v0__filltie
X_11222_ _18209_/Q _18193_/Q _11534_/S _11222_/Z VSS _11223_/VNW VSS VSS gf180mcu_fd_sc_mcu9t5v0__mux2_1
X_14010_ _19295_/Q _14245_/A1 _14012_/B VSS _14053_/VNW VSS VSS gf180mcu_fd_sc_mcu9t5v0__nor2_1
X_11153_ _11153_/A1 _11519_/A2 _11483_/B _11153_/C _11155_/B VSS _16550_/VNW VSS VSS
+ gf180mcu_fd_sc_mcu9t5v0__oai211_1
X_11084_ _18566_/Q wire163/Z _11537_/S VSS _11084_/VNW VSS VSS gf180mcu_fd_sc_mcu9t5v0__nor2_4
X_10104_ _19232_/Q _10138_/A2 _10168_/B1 _19208_/Q _10105_/A2 VSS _10478_/VNW VSS
+ VSS gf180mcu_fd_sc_mcu9t5v0__aoi22_1
X_15961_ _15963_/B1 _15957_/Z _15963_/C _16442_/A2 VSS VSS VSS VSS gf180mcu_fd_sc_mcu9t5v0__oai21_1
X_15892_ _20101_/Q _19236_/Q _15927_/S _20101_/D VSS VSS VSS VSS gf180mcu_fd_sc_mcu9t5v0__mux2_1
XTAP_TAPCELL_ROW_257_6140 VSS VSS gf180mcu_fd_sc_mcu9t5v0__filltie
X_17700_ _18727_/Q _17681_/S _17701_/C VSS VSS VSS VSS gf180mcu_fd_sc_mcu9t5v0__nand2_1
XPHY_EDGE_ROW_205_2_Right_936 VSS VSS gf180mcu_fd_sc_mcu9t5v0__endcap
X_18680_ _18680_/D _20020_/RN clkload55/I _18680_/Q VSS VSS VSS VSS gf180mcu_fd_sc_mcu9t5v0__dffrnq_1
XTAP_TAPCELL_ROW_86_3355 VSS VSS gf180mcu_fd_sc_mcu9t5v0__filltie
X_10035_ _19990_/Q _19989_/Q _19991_/Q _20005_/Q _10037_/A2 VSS VSS VSS VSS gf180mcu_fd_sc_mcu9t5v0__oai31_1
X_14912_ wire108/I _14912_/A2 _14912_/B _19598_/D VSS VSS VSS VSS gf180mcu_fd_sc_mcu9t5v0__aoi21_1
XTAP_TAPCELL_ROW_86_3344 VSS VSS gf180mcu_fd_sc_mcu9t5v0__filltie
XTAP_TAPCELL_ROW_257_6151 VSS VSS gf180mcu_fd_sc_mcu9t5v0__filltie
X_17631_ _17631_/A1 _17747_/A4 _17631_/A3 _17653_/I1 VSS _17631_/VNW VSS VSS gf180mcu_fd_sc_mcu9t5v0__nand3_1
X_14843_ _14849_/A1 _19407_/Q _14843_/A3 _14844_/I1 VSS VSS VSS VSS gf180mcu_fd_sc_mcu9t5v0__xnor3_1
XTAP_TAPCELL_ROW_253_6037 VSS VSS gf180mcu_fd_sc_mcu9t5v0__filltie
XTAP_TAPCELL_ROW_253_6026 VSS VSS gf180mcu_fd_sc_mcu9t5v0__filltie
XTAP_TAPCELL_ROW_253_6015 VSS VSS gf180mcu_fd_sc_mcu9t5v0__filltie
X_17562_ _18664_/Q input7/Z _17739_/A1 VSS VSS VSS VSS gf180mcu_fd_sc_mcu9t5v0__nand2_1
X_14774_ _19562_/Q _19328_/Q wire108/I _19562_/D VSS VSS VSS VSS gf180mcu_fd_sc_mcu9t5v0__mux2_1
XTAP_TAPCELL_ROW_2_1030 VSS VSS gf180mcu_fd_sc_mcu9t5v0__filltie
X_11986_ _14448_/A2 _11985_/B _11986_/B1 _11986_/B2 _19121_/D VSS VSS VSS VSS gf180mcu_fd_sc_mcu9t5v0__oai22_4
X_17493_ _18598_/Q _19239_/Q _17513_/S _18598_/D VSS VSS VSS VSS gf180mcu_fd_sc_mcu9t5v0__mux2_1
X_16513_ _16117_/C _19228_/Q _17055_/S _16513_/Z VSS VSS VSS VSS gf180mcu_fd_sc_mcu9t5v0__mux2_1
XTAP_TAPCELL_ROW_99_3716 VSS VSS gf180mcu_fd_sc_mcu9t5v0__filltie
X_10937_ _18928_/Q _18935_/Q _10940_/B _10937_/Z VSS _10972_/VNW VSS VSS gf180mcu_fd_sc_mcu9t5v0__xor3_1
XTAP_TAPCELL_ROW_99_3705 VSS VSS gf180mcu_fd_sc_mcu9t5v0__filltie
X_19301_ _19301_/D _20069_/RN clkload15/I _19301_/Q VSS VSS VSS VSS gf180mcu_fd_sc_mcu9t5v0__dffrnq_1
X_13725_ _13738_/A2 _13738_/A3 _13726_/A2 VSS VSS VSS VSS gf180mcu_fd_sc_mcu9t5v0__nor2_1
XTAP_TAPCELL_ROW_2_1041 VSS VSS gf180mcu_fd_sc_mcu9t5v0__filltie
X_16444_ _16444_/A1 _16545_/A2 _16971_/S wire28/I VSS _16444_/VNW VSS VSS gf180mcu_fd_sc_mcu9t5v0__oai21_4
X_13656_ _13656_/A1 _20038_/Q _13656_/Z VSS VSS VSS VSS gf180mcu_fd_sc_mcu9t5v0__and2_1
X_19232_ _19232_/D _20064_/RN clkload28/I _19232_/Q VSS VSS VSS VSS gf180mcu_fd_sc_mcu9t5v0__dffrnq_2
X_12607_ _18455_/Q _12607_/A2 _12609_/B1 VSS VSS VSS VSS gf180mcu_fd_sc_mcu9t5v0__nor2_1
X_10868_ _10867_/Z _18973_/Q _18152_/S _18973_/D VSS VSS VSS VSS gf180mcu_fd_sc_mcu9t5v0__mux2_1
X_19163_ _19163_/D _20059_/RN clkload11/I _19163_/Q VSS VSS VSS VSS gf180mcu_fd_sc_mcu9t5v0__dffrnq_1
X_16375_ _16016_/B _19230_/Q _16925_/S _16375_/Z VSS VSS VSS VSS gf180mcu_fd_sc_mcu9t5v0__mux2_1
X_18114_ _18113_/Z _18944_/Q _18152_/S _18944_/D VSS VSS VSS VSS gf180mcu_fd_sc_mcu9t5v0__mux2_1
X_13587_ wire277/Z _13590_/A2 _13586_/Z _13587_/B _19279_/D VSS VSS VSS VSS gf180mcu_fd_sc_mcu9t5v0__oai31_1
X_10799_ _10799_/A1 _10799_/A2 _10799_/B _10800_/A2 VSS VSS VSS VSS gf180mcu_fd_sc_mcu9t5v0__aoi21_1
X_12538_ _18351_/Q _12382_/S _12542_/A2 VSS VSS VSS VSS gf180mcu_fd_sc_mcu9t5v0__nor2_1
X_19094_ _19094_/D _20054_/RN clkload27/I _19094_/Q VSS VSS VSS VSS gf180mcu_fd_sc_mcu9t5v0__dffrnq_1
X_15326_ _19642_/Q _19619_/Q _15326_/Z VSS VSS VSS VSS gf180mcu_fd_sc_mcu9t5v0__or2_1
X_18045_ _18068_/A1 _18066_/A2 _18045_/Z VSS _18067_/VNW VSS VSS gf180mcu_fd_sc_mcu9t5v0__or2_1
X_12469_ _12355_/I _12485_/A2 _12469_/A3 _12469_/B _19154_/D VSS VSS VSS VSS gf180mcu_fd_sc_mcu9t5v0__oai31_1
X_15257_ _19601_/Q _19578_/Q _15259_/B VSS VSS VSS VSS gf180mcu_fd_sc_mcu9t5v0__xnor2_1
X_14208_ _14208_/A1 _14208_/A2 _14208_/Z VSS VSS VSS VSS gf180mcu_fd_sc_mcu9t5v0__xor2_1
XTAP_TAPCELL_ROW_242_5730 VSS VSS gf180mcu_fd_sc_mcu9t5v0__filltie
XTAP_TAPCELL_ROW_71_2934 VSS VSS gf180mcu_fd_sc_mcu9t5v0__filltie
X_15188_ _15188_/A1 _19564_/Q _15188_/B1 _15188_/B2 _15192_/A2 VSS VSS VSS VSS gf180mcu_fd_sc_mcu9t5v0__aoi22_1
XTAP_TAPCELL_ROW_71_2923 VSS VSS gf180mcu_fd_sc_mcu9t5v0__filltie
X_19996_ _19996_/D _20060_/RN _20049_/CLK _19996_/Q VSS VSS VSS VSS gf180mcu_fd_sc_mcu9t5v0__dffsnq_1
XTAP_TAPCELL_ROW_71_2945 VSS VSS gf180mcu_fd_sc_mcu9t5v0__filltie
X_14139_ _19315_/Q _14367_/I0 _14139_/S _19315_/D VSS VSS VSS VSS gf180mcu_fd_sc_mcu9t5v0__mux2_1
X_18947_ _18947_/D _20035_/RN clkload67/I _18947_/Q VSS VSS VSS VSS gf180mcu_fd_sc_mcu9t5v0__dffrnq_1
XTAP_TAPCELL_ROW_9_1217 VSS VSS gf180mcu_fd_sc_mcu9t5v0__filltie
XTAP_TAPCELL_ROW_9_1228 VSS VSS gf180mcu_fd_sc_mcu9t5v0__filltie
XTAP_TAPCELL_ROW_223_5195 VSS VSS gf180mcu_fd_sc_mcu9t5v0__filltie
X_09680_ _09680_/A1 _09680_/A2 _15821_/A1 _09680_/A4 _19996_/D VSS VSS VSS VSS gf180mcu_fd_sc_mcu9t5v0__nand4_1
XTAP_TAPCELL_ROW_52_2399 VSS VSS gf180mcu_fd_sc_mcu9t5v0__filltie
XTAP_TAPCELL_ROW_9_1239 VSS VSS gf180mcu_fd_sc_mcu9t5v0__filltie
X_18878_ _18878_/D _20030_/RN clkload22/I _18878_/Q VSS VSS VSS VSS gf180mcu_fd_sc_mcu9t5v0__dffrnq_1
XTAP_TAPCELL_ROW_69_2885 VSS VSS gf180mcu_fd_sc_mcu9t5v0__filltie
X_17829_ _19036_/Q _18806_/Q _17844_/S _18806_/D VSS VSS VSS VSS gf180mcu_fd_sc_mcu9t5v0__mux2_1
XTAP_TAPCELL_ROW_69_2874 VSS VSS gf180mcu_fd_sc_mcu9t5v0__filltie
XTAP_TAPCELL_ROW_236_5567 VSS VSS gf180mcu_fd_sc_mcu9t5v0__filltie
XTAP_TAPCELL_ROW_236_5556 VSS VSS gf180mcu_fd_sc_mcu9t5v0__filltie
XTAP_TAPCELL_ROW_249_5917 VSS VSS gf180mcu_fd_sc_mcu9t5v0__filltie
XTAP_TAPCELL_ROW_249_5906 VSS VSS gf180mcu_fd_sc_mcu9t5v0__filltie
XTAP_TAPCELL_ROW_249_5928 VSS VSS gf180mcu_fd_sc_mcu9t5v0__filltie
XPHY_EDGE_ROW_178_3_Left_836 VSS VSS gf180mcu_fd_sc_mcu9t5v0__endcap
X_09114_ _19750_/Q _12952_/A2 VSS VSS VSS VSS gf180mcu_fd_sc_mcu9t5v0__clkinv_1
Xclkbuf_leaf_19_clk_regs clkload4/I clkload58/I VSS VSS VSS VSS gf180mcu_fd_sc_mcu9t5v0__clkbuf_8
XTAP_TAPCELL_ROW_320_7863 VSS VSS gf180mcu_fd_sc_mcu9t5v0__filltie
Xmax_cap171 _10133_/A2 _10172_/A2 VSS max_cap171/VNW VSS VSS gf180mcu_fd_sc_mcu9t5v0__buf_4
XTAP_TAPCELL_ROW_320_7874 VSS VSS gf180mcu_fd_sc_mcu9t5v0__filltie
Xmax_cap193 _17322_/A2 _17282_/A2 VSS VSS VSS VSS gf180mcu_fd_sc_mcu9t5v0__buf_8
Xmax_cap182 _12183_/C _12322_/B VSS _16945_/VNW VSS VSS gf180mcu_fd_sc_mcu9t5v0__clkbuf_8
X_20136_ _20136_/D clkload77/I _20136_/Q VSS VSS VSS VSS gf180mcu_fd_sc_mcu9t5v0__dffq_1
XPHY_EDGE_ROW_174_1_Left_497 VSS VSS gf180mcu_fd_sc_mcu9t5v0__endcap
X_09947_ _18821_/Q _18819_/Q _18820_/Q _18817_/Q _09948_/A3 VSS VSS VSS VSS gf180mcu_fd_sc_mcu9t5v0__nor4_1
X_20067_ _20067_/D _20067_/RN clkload50/I _20067_/Q VSS VSS VSS VSS gf180mcu_fd_sc_mcu9t5v0__dffrnq_1
X_09878_ _09878_/A1 _09878_/A2 _10718_/C VSS VSS VSS VSS gf180mcu_fd_sc_mcu9t5v0__or2_2
XTAP_TAPCELL_ROW_124_4381 VSS VSS gf180mcu_fd_sc_mcu9t5v0__filltie
XTAP_TAPCELL_ROW_124_4392 VSS VSS gf180mcu_fd_sc_mcu9t5v0__filltie
X_11840_ _12237_/B _11850_/A2 _11851_/A1 VSS _11840_/VNW VSS VSS gf180mcu_fd_sc_mcu9t5v0__nand2_1
XTAP_TAPCELL_ROW_120_4289 VSS VSS gf180mcu_fd_sc_mcu9t5v0__filltie
XTAP_TAPCELL_ROW_120_4278 VSS VSS gf180mcu_fd_sc_mcu9t5v0__filltie
X_11771_ _18716_/Q wire198/Z _11790_/A1 VSS VSS VSS VSS gf180mcu_fd_sc_mcu9t5v0__nand2_1
X_10722_ _19817_/Q _10722_/A2 _15472_/A1 VSS VSS VSS VSS gf180mcu_fd_sc_mcu9t5v0__nor2_1
X_13510_ _19263_/Q _13304_/B _13513_/B VSS VSS VSS VSS gf180mcu_fd_sc_mcu9t5v0__nand2_1
X_14490_ _14507_/B1 _14722_/A1 _14491_/A2 VSS VSS VSS VSS gf180mcu_fd_sc_mcu9t5v0__xnor2_1
X_10653_ _10654_/A2 _10653_/A2 _10653_/A3 _10654_/B VSS VSS VSS VSS gf180mcu_fd_sc_mcu9t5v0__nand3_1
XTAP_TAPCELL_ROW_133_4639 VSS VSS gf180mcu_fd_sc_mcu9t5v0__filltie
X_13441_ _13441_/A1 _13441_/A2 _13441_/B _13457_/A2 VSS VSS VSS VSS gf180mcu_fd_sc_mcu9t5v0__aoi21_1
XTAP_TAPCELL_ROW_133_4628 VSS VSS gf180mcu_fd_sc_mcu9t5v0__filltie
X_10584_ _17358_/A1 _18326_/Q _10587_/A2 VSS _10587_/VNW VSS VSS gf180mcu_fd_sc_mcu9t5v0__nor2_1
X_16160_ _16722_/A1 _16160_/A2 _16160_/A3 _16160_/B _18177_/D VSS VSS VSS VSS gf180mcu_fd_sc_mcu9t5v0__oai31_4
X_13372_ _19742_/Q _13373_/A2 _13374_/B VSS VSS VSS VSS gf180mcu_fd_sc_mcu9t5v0__xnor2_1
XTAP_TAPCELL_ROW_75_3034 VSS VSS gf180mcu_fd_sc_mcu9t5v0__filltie
X_12323_ _18455_/Q _12315_/S _12325_/B1 VSS VSS VSS VSS gf180mcu_fd_sc_mcu9t5v0__nand2_1
X_16091_ _18166_/Q _16091_/I1 _16643_/S _18166_/D VSS VSS VSS VSS gf180mcu_fd_sc_mcu9t5v0__mux2_4
XTAP_TAPCELL_ROW_75_3056 VSS VSS gf180mcu_fd_sc_mcu9t5v0__filltie
XTAP_TAPCELL_ROW_75_3045 VSS VSS gf180mcu_fd_sc_mcu9t5v0__filltie
Xclkload19 clkload19/I clkload19/ZN VSS VSS VSS VSS gf180mcu_fd_sc_mcu9t5v0__inv_8
X_15111_ _19653_/Q _19493_/Q _15163_/S _19653_/D VSS VSS VSS VSS gf180mcu_fd_sc_mcu9t5v0__mux2_1
X_15042_ _19304_/Q _19389_/Q _15047_/B VSS VSS VSS VSS gf180mcu_fd_sc_mcu9t5v0__and2_1
X_12254_ wire213/I _12254_/A2 _12254_/B1 _12296_/B2 _12311_/B _12255_/B VSS VSS VSS
+ VSS gf180mcu_fd_sc_mcu9t5v0__aoi221_1
X_11205_ _18176_/Q _11520_/B _11538_/B _11205_/C _11212_/A1 VSS _11212_/VNW VSS VSS
+ gf180mcu_fd_sc_mcu9t5v0__oai211_1
X_12185_ _12185_/A1 _12185_/A2 _12195_/A2 VSS VSS VSS VSS gf180mcu_fd_sc_mcu9t5v0__nand2_1
X_19850_ _19850_/D _20042_/RN clkload55/I _19850_/Q VSS VSS VSS VSS gf180mcu_fd_sc_mcu9t5v0__dffrnq_1
XTAP_TAPCELL_ROW_88_3406 VSS VSS gf180mcu_fd_sc_mcu9t5v0__filltie
XTAP_TAPCELL_ROW_259_6202 VSS VSS gf180mcu_fd_sc_mcu9t5v0__filltie
X_11136_ _18697_/Q _12527_/A2 wire208/Z _11136_/B2 wire213/Z _11137_/A3 VSS VSS VSS
+ VSS gf180mcu_fd_sc_mcu9t5v0__aoi221_2
X_19781_ _19781_/D _20037_/RN clkload43/I _19781_/Q VSS VSS VSS VSS gf180mcu_fd_sc_mcu9t5v0__dffrnq_1
X_18801_ _18801_/D _20145_/RN clkload32/I _18801_/Q VSS VSS VSS VSS gf180mcu_fd_sc_mcu9t5v0__dffrnq_1
X_16993_ _19259_/Q _16750_/B _16993_/S _16993_/Z VSS VSS VSS VSS gf180mcu_fd_sc_mcu9t5v0__mux2_1
X_18732_ _18732_/D clkload47/I _18732_/Q VSS VSS VSS VSS gf180mcu_fd_sc_mcu9t5v0__dffq_1
XPHY_EDGE_ROW_206_2_Right_937 VSS VSS gf180mcu_fd_sc_mcu9t5v0__endcap
X_15944_ _16198_/A2 _15954_/B _16234_/A2 _16612_/S VSS VSS VSS VSS gf180mcu_fd_sc_mcu9t5v0__nor3_4
X_11067_ _15581_/B _19068_/Q _11067_/S _19068_/D VSS VSS VSS VSS gf180mcu_fd_sc_mcu9t5v0__mux2_1
X_15875_ _20084_/Q _19234_/Q wire79/Z _20084_/D VSS _16909_/VNW VSS VSS gf180mcu_fd_sc_mcu9t5v0__mux2_1
X_10018_ _18568_/Q _11095_/S _15959_/A1 VSS VSS VSS VSS gf180mcu_fd_sc_mcu9t5v0__nor2_1
X_18663_ _18663_/D _20067_/RN _20049_/CLK _18663_/Q VSS VSS VSS VSS gf180mcu_fd_sc_mcu9t5v0__dffrnq_1
XTAP_TAPCELL_ROW_4_1103 VSS VSS gf180mcu_fd_sc_mcu9t5v0__filltie
X_18594_ _18594_/D clkload74/I _18594_/Q VSS VSS VSS VSS gf180mcu_fd_sc_mcu9t5v0__dffq_1
X_17614_ input5/Z _18677_/Q _17617_/S _18677_/D VSS VSS VSS VSS gf180mcu_fd_sc_mcu9t5v0__mux2_1
Xrst_tree_leaf_5 rst_tree_mid_0/Z _20142_/RN VSS VSS VSS VSS gf180mcu_fd_sc_mcu9t5v0__clkbuf_16
X_14826_ _09462_/I _14826_/A2 _14827_/B _14826_/B _19575_/D VSS VSS VSS VSS gf180mcu_fd_sc_mcu9t5v0__oai31_1
X_17545_ _17580_/I1 _18638_/Q _17571_/S _18638_/D VSS VSS VSS VSS gf180mcu_fd_sc_mcu9t5v0__mux2_1
X_14757_ _19552_/Q _14756_/Z _14764_/B _19552_/D VSS _15170_/VNW VSS VSS gf180mcu_fd_sc_mcu9t5v0__mux2_1
X_13708_ _19146_/Q _19112_/Q _14668_/A1 VSS VSS VSS VSS gf180mcu_fd_sc_mcu9t5v0__nor2_1
XTAP_TAPCELL_ROW_60_2624 VSS VSS gf180mcu_fd_sc_mcu9t5v0__filltie
X_11969_ _18905_/Q _11969_/A2 _11985_/A2 VSS VSS VSS VSS gf180mcu_fd_sc_mcu9t5v0__xnor2_1
XTAP_TAPCELL_ROW_231_5431 VSS VSS gf180mcu_fd_sc_mcu9t5v0__filltie
XTAP_TAPCELL_ROW_231_5420 VSS VSS gf180mcu_fd_sc_mcu9t5v0__filltie
X_14688_ _14688_/A1 _14688_/A2 _14688_/A3 _14688_/B _14691_/A2 VSS _14688_/VNW VSS
+ VSS gf180mcu_fd_sc_mcu9t5v0__oai31_1
XTAP_TAPCELL_ROW_60_2635 VSS VSS gf180mcu_fd_sc_mcu9t5v0__filltie
XTAP_TAPCELL_ROW_60_2646 VSS VSS gf180mcu_fd_sc_mcu9t5v0__filltie
X_17476_ _09517_/I _17476_/A2 _18584_/D VSS VSS VSS VSS gf180mcu_fd_sc_mcu9t5v0__nor2_1
X_16427_ _16427_/I0 _18274_/Q _16958_/S _18274_/D VSS VSS VSS VSS gf180mcu_fd_sc_mcu9t5v0__mux2_4
X_13639_ _13640_/B _13640_/A1 _13640_/A2 _13642_/A1 VSS _13640_/VNW VSS VSS gf180mcu_fd_sc_mcu9t5v0__nor3_1
X_19215_ _19215_/D _20047_/RN clkload27/I _19215_/Q VSS VSS VSS VSS gf180mcu_fd_sc_mcu9t5v0__dffrnq_1
X_16358_ _18243_/Q _16357_/Z _16882_/S _18243_/D VSS VSS VSS VSS gf180mcu_fd_sc_mcu9t5v0__mux2_4
X_19146_ _19146_/D _20042_/RN _19806_/CLK _19146_/Q VSS VSS VSS VSS gf180mcu_fd_sc_mcu9t5v0__dffrnq_1
X_15309_ _19639_/Q _19616_/Q _15314_/B VSS VSS VSS VSS gf180mcu_fd_sc_mcu9t5v0__nand2_1
X_16289_ _19274_/Q _16829_/A2 _16291_/A1 VSS VSS VSS VSS gf180mcu_fd_sc_mcu9t5v0__nand2_1
XTAP_TAPCELL_ROW_229_5360 VSS VSS gf180mcu_fd_sc_mcu9t5v0__filltie
XTAP_TAPCELL_ROW_58_2564 VSS VSS gf180mcu_fd_sc_mcu9t5v0__filltie
XTAP_TAPCELL_ROW_58_2575 VSS VSS gf180mcu_fd_sc_mcu9t5v0__filltie
X_19077_ _19077_/D _20037_/RN clkload26/I _19077_/Q VSS VSS VSS VSS gf180mcu_fd_sc_mcu9t5v0__dffrnq_1
XTAP_TAPCELL_ROW_229_5371 VSS VSS gf180mcu_fd_sc_mcu9t5v0__filltie
X_18028_ _18028_/I0 _18913_/Q _18037_/S _18913_/D VSS VSS VSS VSS gf180mcu_fd_sc_mcu9t5v0__mux2_1
XTAP_TAPCELL_ROW_58_2586 VSS VSS gf180mcu_fd_sc_mcu9t5v0__filltie
XTAP_TAPCELL_ROW_225_5268 VSS VSS gf180mcu_fd_sc_mcu9t5v0__filltie
XTAP_TAPCELL_ROW_225_5257 VSS VSS gf180mcu_fd_sc_mcu9t5v0__filltie
XTAP_TAPCELL_ROW_225_5246 VSS VSS gf180mcu_fd_sc_mcu9t5v0__filltie
X_09801_ _18841_/Q _17912_/A2 _09805_/A1 VSS _17903_/VNW VSS VSS gf180mcu_fd_sc_mcu9t5v0__nor2_1
XPHY_EDGE_ROW_248_Right_175 VSS VSS gf180mcu_fd_sc_mcu9t5v0__endcap
X_19979_ _19979_/D _20043_/RN clkload65/I _19979_/Q VSS VSS VSS VSS gf180mcu_fd_sc_mcu9t5v0__dffrnq_1
Xfanout239 _16670_/S _16602_/S VSS VSS VSS VSS gf180mcu_fd_sc_mcu9t5v0__clkbuf_16
X_09732_ _09916_/B _20070_/Q _09760_/C1 VSS _15964_/VNW VSS VSS gf180mcu_fd_sc_mcu9t5v0__nor2_1
XTAP_TAPCELL_ROW_238_5629 VSS VSS gf180mcu_fd_sc_mcu9t5v0__filltie
XTAP_TAPCELL_ROW_238_5618 VSS VSS gf180mcu_fd_sc_mcu9t5v0__filltie
XTAP_TAPCELL_ROW_238_5607 VSS VSS gf180mcu_fd_sc_mcu9t5v0__filltie
X_09663_ _19913_/Q _20073_/Q _09664_/A2 VSS VSS VSS VSS gf180mcu_fd_sc_mcu9t5v0__nand2_1
X_09594_ _19905_/Q _19906_/Q _19907_/Q _15671_/A2 VSS _09594_/VNW VSS VSS gf180mcu_fd_sc_mcu9t5v0__nor3_1
XPHY_EDGE_ROW_294_Right_221 VSS VSS gf180mcu_fd_sc_mcu9t5v0__endcap
XTAP_TAPCELL_ROW_214_4950 VSS VSS gf180mcu_fd_sc_mcu9t5v0__filltie
XTAP_TAPCELL_ROW_188_1_4764 VSS VSS gf180mcu_fd_sc_mcu9t5v0__filltie
XTAP_TAPCELL_ROW_214_4961 VSS VSS gf180mcu_fd_sc_mcu9t5v0__filltie
XTAP_TAPCELL_ROW_322_7914 VSS VSS gf180mcu_fd_sc_mcu9t5v0__filltie
XTAP_TAPCELL_ROW_210_4847 VSS VSS gf180mcu_fd_sc_mcu9t5v0__filltie
XTAP_TAPCELL_ROW_210_4836 VSS VSS gf180mcu_fd_sc_mcu9t5v0__filltie
XTAP_TAPCELL_ROW_322_7936 VSS VSS gf180mcu_fd_sc_mcu9t5v0__filltie
XTAP_TAPCELL_ROW_322_7925 VSS VSS gf180mcu_fd_sc_mcu9t5v0__filltie
XTAP_TAPCELL_ROW_210_4858 VSS VSS gf180mcu_fd_sc_mcu9t5v0__filltie
XTAP_TAPCELL_ROW_113_4093 VSS VSS gf180mcu_fd_sc_mcu9t5v0__filltie
XTAP_TAPCELL_ROW_113_4082 VSS VSS gf180mcu_fd_sc_mcu9t5v0__filltie
XTAP_TAPCELL_ROW_299_7283 VSS VSS gf180mcu_fd_sc_mcu9t5v0__filltie
XTAP_TAPCELL_ROW_299_7294 VSS VSS gf180mcu_fd_sc_mcu9t5v0__filltie
XTAP_TAPCELL_ROW_126_4454 VSS VSS gf180mcu_fd_sc_mcu9t5v0__filltie
XTAP_TAPCELL_ROW_126_4443 VSS VSS gf180mcu_fd_sc_mcu9t5v0__filltie
X_20119_ _20119_/D clkload74/I _20119_/Q VSS VSS VSS VSS gf180mcu_fd_sc_mcu9t5v0__dffq_1
XPHY_EDGE_ROW_215_Right_142 VSS VSS gf180mcu_fd_sc_mcu9t5v0__endcap
XTAP_TAPCELL_ROW_122_4329 VSS VSS gf180mcu_fd_sc_mcu9t5v0__filltie
X_13990_ _13990_/A1 _13990_/A2 _13990_/B _14022_/A1 VSS _14032_/VNW VSS VSS gf180mcu_fd_sc_mcu9t5v0__oai21_1
X_12941_ _19748_/Q _19813_/Q _12948_/S _12941_/Z VSS _13472_/VNW VSS VSS gf180mcu_fd_sc_mcu9t5v0__mux2_1
X_15660_ _19906_/Q _15659_/I _15661_/A2 VSS VSS VSS VSS gf180mcu_fd_sc_mcu9t5v0__xnor2_1
X_12872_ _19770_/Q _12871_/Z _12889_/C VSS VSS VSS VSS gf180mcu_fd_sc_mcu9t5v0__and2_1
X_11823_ _18240_/Q _12203_/A2 _11827_/A1 VSS _11823_/VNW VSS VSS gf180mcu_fd_sc_mcu9t5v0__nand2_1
XTAP_TAPCELL_ROW_160_1_4750 VSS VSS gf180mcu_fd_sc_mcu9t5v0__filltie
X_14611_ _19191_/Q _19489_/Q _14715_/S _19489_/D VSS VSS VSS VSS gf180mcu_fd_sc_mcu9t5v0__mux2_1
X_17330_ _17412_/A1 _17330_/A2 _17412_/B _17331_/A2 VSS _17330_/VNW VSS VSS gf180mcu_fd_sc_mcu9t5v0__aoi21_1
X_15591_ _15591_/A1 _20042_/D _15597_/B1 _15591_/B2 _19881_/D VSS _15591_/VNW VSS
+ VSS gf180mcu_fd_sc_mcu9t5v0__oai22_1
X_11754_ _18269_/Q _12203_/A2 _12159_/B _11755_/B2 VSS VSS VSS VSS gf180mcu_fd_sc_mcu9t5v0__aoi21_1
X_14542_ _14542_/A1 _19133_/Q _14542_/B _14548_/A3 VSS _14542_/VNW VSS VSS gf180mcu_fd_sc_mcu9t5v0__aoi21_1
X_17261_ _10514_/B _17260_/Z _17263_/B1 VSS VSS VSS VSS gf180mcu_fd_sc_mcu9t5v0__nand2_1
X_11685_ _18154_/Q _12046_/S _11686_/A2 VSS VSS VSS VSS gf180mcu_fd_sc_mcu9t5v0__nand2_1
XTAP_TAPCELL_ROW_77_3107 VSS VSS gf180mcu_fd_sc_mcu9t5v0__filltie
X_10705_ _18840_/Q _18847_/Q _10730_/A1 VSS _10705_/VNW VSS VSS gf180mcu_fd_sc_mcu9t5v0__nand2_1
X_14473_ _14474_/A1 _14474_/A2 _14473_/B _14483_/A1 VSS _14473_/VNW VSS VSS gf180mcu_fd_sc_mcu9t5v0__aoi21_1
X_17192_ _17404_/S _18398_/Q _17194_/A3 VSS VSS VSS VSS gf180mcu_fd_sc_mcu9t5v0__nor2_1
X_10636_ _17404_/S _18216_/Q _10638_/A3 VSS VSS VSS VSS gf180mcu_fd_sc_mcu9t5v0__nor2_1
X_16212_ _16147_/C _19266_/Q _16763_/S _16212_/Z VSS VSS VSS VSS gf180mcu_fd_sc_mcu9t5v0__mux2_1
X_19000_ _19000_/D _19960_/RN clkload70/I _19000_/Q VSS VSS VSS VSS gf180mcu_fd_sc_mcu9t5v0__dffrnq_1
X_13424_ _13435_/A2 _19811_/Q _13441_/B VSS VSS VSS VSS gf180mcu_fd_sc_mcu9t5v0__nor2_1
X_16143_ _19265_/Q _16695_/B _16144_/C VSS VSS VSS VSS gf180mcu_fd_sc_mcu9t5v0__nor2_1
XTAP_TAPCELL_ROW_284_6873 VSS VSS gf180mcu_fd_sc_mcu9t5v0__filltie
XTAP_TAPCELL_ROW_284_6884 VSS VSS gf180mcu_fd_sc_mcu9t5v0__filltie
X_10567_ _17407_/C _10567_/A2 _10567_/B _10570_/B1 VSS VSS VSS VSS gf180mcu_fd_sc_mcu9t5v0__oai21_1
X_13355_ _13497_/A1 _13355_/A2 _13356_/A2 VSS VSS VSS VSS gf180mcu_fd_sc_mcu9t5v0__nor2_1
X_10498_ _20087_/Q wire168/Z _10499_/A2 VSS VSS VSS VSS gf180mcu_fd_sc_mcu9t5v0__nor2_1
XTAP_TAPCELL_ROW_280_6759 VSS VSS gf180mcu_fd_sc_mcu9t5v0__filltie
X_16074_ _18126_/A1 _16672_/A2 _16098_/B _16172_/C VSS VSS VSS VSS gf180mcu_fd_sc_mcu9t5v0__oai21_2
X_12306_ _12237_/B _12306_/A2 _12305_/B _12306_/Z VSS VSS VSS VSS gf180mcu_fd_sc_mcu9t5v0__and3_4
X_13286_ _13286_/I0 _19247_/Q _13304_/B _19247_/D VSS VSS VSS VSS gf180mcu_fd_sc_mcu9t5v0__mux2_1
X_12237_ _12237_/A1 _12226_/Z _12237_/B _12252_/A1 VSS _18109_/VNW VSS VSS gf180mcu_fd_sc_mcu9t5v0__oai21_4
X_19902_ _19902_/D _20030_/RN clkload40/I _19902_/Q VSS VSS VSS VSS gf180mcu_fd_sc_mcu9t5v0__dffrnq_1
X_15025_ _19627_/Q _19378_/Q _20039_/Q _19627_/D VSS VSS VSS VSS gf180mcu_fd_sc_mcu9t5v0__mux2_1
X_19833_ _19833_/D _20025_/RN clkload55/I _19833_/Q VSS VSS VSS VSS gf180mcu_fd_sc_mcu9t5v0__dffrnq_1
XTAP_TAPCELL_ROW_53_2450 VSS VSS gf180mcu_fd_sc_mcu9t5v0__filltie
X_12168_ _18727_/Q wire198/Z _12169_/A2 VSS VSS VSS VSS gf180mcu_fd_sc_mcu9t5v0__nand2_1
XTAP_TAPCELL_ROW_220_5121 VSS VSS gf180mcu_fd_sc_mcu9t5v0__filltie
XTAP_TAPCELL_ROW_220_5110 VSS VSS gf180mcu_fd_sc_mcu9t5v0__filltie
X_16976_ _18479_/Q _16975_/Z _16986_/S _18479_/D VSS VSS VSS VSS gf180mcu_fd_sc_mcu9t5v0__mux2_4
XTAP_TAPCELL_ROW_220_5132 VSS VSS gf180mcu_fd_sc_mcu9t5v0__filltie
X_11119_ _18696_/Q _12527_/A2 wire213/Z _11120_/B VSS _17658_/VNW VSS VSS gf180mcu_fd_sc_mcu9t5v0__aoi21_1
X_19764_ _19764_/D _20020_/RN clkload41/I _19764_/Q VSS VSS VSS VSS gf180mcu_fd_sc_mcu9t5v0__dffrnq_1
XTAP_TAPCELL_ROW_109_3973 VSS VSS gf180mcu_fd_sc_mcu9t5v0__filltie
X_12099_ _12686_/C _12099_/A2 _12099_/B _12311_/B _12100_/B VSS _14720_/VNW VSS VSS
+ gf180mcu_fd_sc_mcu9t5v0__aoi211_1
X_15927_ _20136_/Q _19257_/Q _15927_/S _20136_/D VSS _16775_/VNW VSS VSS gf180mcu_fd_sc_mcu9t5v0__mux2_1
X_18715_ _18715_/D clkload53/I _18715_/Q VSS VSS VSS VSS gf180mcu_fd_sc_mcu9t5v0__dffq_1
XTAP_TAPCELL_ROW_109_3984 VSS VSS gf180mcu_fd_sc_mcu9t5v0__filltie
Xinput6 din[5] input6/Z VSS VSS VSS VSS gf180mcu_fd_sc_mcu9t5v0__clkbuf_2
X_19695_ _19695_/D _20143_/RN clkload29/I _19695_/Q VSS VSS VSS VSS gf180mcu_fd_sc_mcu9t5v0__dffrnq_1
XTAP_TAPCELL_ROW_66_2800 VSS VSS gf180mcu_fd_sc_mcu9t5v0__filltie
XPHY_EDGE_ROW_207_2_Right_938 VSS VSS gf180mcu_fd_sc_mcu9t5v0__endcap
X_18646_ _18646_/D _20050_/RN clkload48/I _18646_/Q VSS VSS VSS VSS gf180mcu_fd_sc_mcu9t5v0__dffrnq_1
XTAP_TAPCELL_ROW_66_2811 VSS VSS gf180mcu_fd_sc_mcu9t5v0__filltie
XTAP_TAPCELL_ROW_105_3859 VSS VSS gf180mcu_fd_sc_mcu9t5v0__filltie
X_15858_ _18563_/Q _15858_/A2 _15933_/A2 _15989_/A4 VSS VSS VSS VSS gf180mcu_fd_sc_mcu9t5v0__nand3_1
XTAP_TAPCELL_ROW_218_5072 VSS VSS gf180mcu_fd_sc_mcu9t5v0__filltie
XTAP_TAPCELL_ROW_218_5061 VSS VSS gf180mcu_fd_sc_mcu9t5v0__filltie
X_15789_ _18024_/I0 _19959_/Q _15802_/S _19959_/D VSS _15789_/VNW VSS VSS gf180mcu_fd_sc_mcu9t5v0__mux2_1
X_14809_ _19572_/Q _14809_/I1 _14900_/S _19572_/D VSS VSS VSS VSS gf180mcu_fd_sc_mcu9t5v0__mux2_1
XTAP_TAPCELL_ROW_47_2265 VSS VSS gf180mcu_fd_sc_mcu9t5v0__filltie
XTAP_TAPCELL_ROW_47_2276 VSS VSS gf180mcu_fd_sc_mcu9t5v0__filltie
XTAP_TAPCELL_ROW_47_2287 VSS VSS gf180mcu_fd_sc_mcu9t5v0__filltie
X_18577_ _18577_/D _20141_/RN clkload11/I _18577_/Q VSS VSS VSS VSS gf180mcu_fd_sc_mcu9t5v0__dffrnq_1
X_17528_ input7/Z _18633_/Q _17529_/S _18633_/D VSS VSS VSS VSS gf180mcu_fd_sc_mcu9t5v0__mux2_1
X_17459_ _17461_/A1 _17477_/A2 _18576_/Q _17460_/A2 VSS _17478_/VNW VSS VSS gf180mcu_fd_sc_mcu9t5v0__aoi21_1
XPHY_EDGE_ROW_317_Right_244 VSS VSS gf180mcu_fd_sc_mcu9t5v0__endcap
XTAP_TAPCELL_ROW_227_5319 VSS VSS gf180mcu_fd_sc_mcu9t5v0__filltie
XTAP_TAPCELL_ROW_227_5308 VSS VSS gf180mcu_fd_sc_mcu9t5v0__filltie
X_19129_ _19129_/D _20025_/RN clkload11/I _19129_/Q VSS VSS VSS VSS gf180mcu_fd_sc_mcu9t5v0__dffrnq_1
XTAP_TAPCELL_ROW_36_1980 VSS VSS gf180mcu_fd_sc_mcu9t5v0__filltie
XTAP_TAPCELL_ROW_290_7055 VSS VSS gf180mcu_fd_sc_mcu9t5v0__filltie
XTAP_TAPCELL_ROW_290_7044 VSS VSS gf180mcu_fd_sc_mcu9t5v0__filltie
XTAP_TAPCELL_ROW_290_7033 VSS VSS gf180mcu_fd_sc_mcu9t5v0__filltie
X_09715_ _10820_/B2 _10822_/A1 _10819_/A2 _10823_/A2 VSS VSS VSS VSS gf180mcu_fd_sc_mcu9t5v0__nor3_1
XTAP_TAPCELL_ROW_32_1855 VSS VSS gf180mcu_fd_sc_mcu9t5v0__filltie
XTAP_TAPCELL_ROW_32_1866 VSS VSS gf180mcu_fd_sc_mcu9t5v0__filltie
XTAP_TAPCELL_ROW_315_7740 VSS VSS gf180mcu_fd_sc_mcu9t5v0__filltie
X_09646_ wire301/Z _09065_/I _09646_/A3 _15820_/B2 VSS _09646_/VNW VSS VSS gf180mcu_fd_sc_mcu9t5v0__nand3_1
XTAP_TAPCELL_ROW_311_7626 VSS VSS gf180mcu_fd_sc_mcu9t5v0__filltie
XTAP_TAPCELL_ROW_311_7615 VSS VSS gf180mcu_fd_sc_mcu9t5v0__filltie
X_09577_ _09820_/A1 _10657_/B _18101_/A2 VSS _09577_/VNW VSS VSS gf180mcu_fd_sc_mcu9t5v0__nand2_1
XTAP_TAPCELL_ROW_212_4909 VSS VSS gf180mcu_fd_sc_mcu9t5v0__filltie
Xclkbuf_leaf_34_clk_regs clkload6/I _20099_/CLK VSS VSS VSS VSS gf180mcu_fd_sc_mcu9t5v0__clkbuf_8
XTAP_TAPCELL_ROW_115_4155 VSS VSS gf180mcu_fd_sc_mcu9t5v0__filltie
XTAP_TAPCELL_ROW_115_4144 VSS VSS gf180mcu_fd_sc_mcu9t5v0__filltie
XTAP_TAPCELL_ROW_115_4133 VSS VSS gf180mcu_fd_sc_mcu9t5v0__filltie
XPHY_EDGE_ROW_14_Right_14 VSS VSS gf180mcu_fd_sc_mcu9t5v0__endcap
XTAP_TAPCELL_ROW_309_7577 VSS VSS gf180mcu_fd_sc_mcu9t5v0__filltie
XTAP_TAPCELL_ROW_309_7566 VSS VSS gf180mcu_fd_sc_mcu9t5v0__filltie
XTAP_TAPCELL_ROW_309_7555 VSS VSS gf180mcu_fd_sc_mcu9t5v0__filltie
X_11470_ _11469_/B _11468_/Z _11470_/B _11474_/A2 VSS VSS VSS VSS gf180mcu_fd_sc_mcu9t5v0__oai21_1
X_10421_ _18993_/Q _10654_/A2 _10421_/B wire160/Z _10423_/B1 VSS VSS VSS VSS gf180mcu_fd_sc_mcu9t5v0__oai211_1
X_10352_ _18285_/Q _17380_/A2 _17380_/B1 _18301_/Q _10353_/B VSS VSS VSS VSS gf180mcu_fd_sc_mcu9t5v0__aoi22_1
X_13140_ _13118_/Z _13140_/A2 _13546_/B _13159_/A2 VSS _13539_/VNW VSS VSS gf180mcu_fd_sc_mcu9t5v0__aoi21_1
XPHY_EDGE_ROW_204_1_Left_527 VSS VSS gf180mcu_fd_sc_mcu9t5v0__endcap
XTAP_TAPCELL_ROW_128_4516 VSS VSS gf180mcu_fd_sc_mcu9t5v0__filltie
XTAP_TAPCELL_ROW_128_4505 VSS VSS gf180mcu_fd_sc_mcu9t5v0__filltie
X_13071_ _19757_/Q _13071_/A2 _13094_/A1 VSS _13071_/VNW VSS VSS gf180mcu_fd_sc_mcu9t5v0__nand2_1
X_10283_ _10654_/A2 _10283_/A2 _10283_/A3 _10284_/B VSS VSS VSS VSS gf180mcu_fd_sc_mcu9t5v0__nand3_1
X_12022_ _18409_/Q _12046_/S _12090_/B _12025_/A2 VSS _12022_/VNW VSS VSS gf180mcu_fd_sc_mcu9t5v0__aoi21_1
XPHY_EDGE_ROW_23_Right_23 VSS VSS gf180mcu_fd_sc_mcu9t5v0__endcap
X_16830_ _16809_/S _16750_/B _16961_/B VSS _16832_/VNW VSS VSS gf180mcu_fd_sc_mcu9t5v0__nand2_4
X_16761_ _16592_/B _19279_/Q _16763_/S _16761_/Z VSS VSS VSS VSS gf180mcu_fd_sc_mcu9t5v0__mux2_1
X_13973_ _14007_/A1 _13973_/A2 _13973_/A3 _13976_/A3 VSS VSS VSS VSS gf180mcu_fd_sc_mcu9t5v0__xnor3_1
X_18500_ _18500_/D _18516_/CLK _18500_/Q VSS VSS VSS VSS gf180mcu_fd_sc_mcu9t5v0__dffq_4
X_15712_ _15726_/S _15703_/Z _15712_/A3 _15712_/B _19919_/D VSS VSS VSS VSS gf180mcu_fd_sc_mcu9t5v0__oai31_1
Xeco7_buf_09450 _09450_/ZN _09454_/A4 VSS VSS VSS VSS gf180mcu_fd_sc_mcu9t5v0__clkbuf_16
X_12924_ _19777_/Q _12923_/Z _12924_/Z VSS _12924_/VNW VSS VSS gf180mcu_fd_sc_mcu9t5v0__or2_1
XTAP_TAPCELL_ROW_273_6585 VSS VSS gf180mcu_fd_sc_mcu9t5v0__filltie
X_16692_ _16747_/A3 _16692_/A2 _16692_/B1 _16741_/B2 _16692_/C _16693_/I1 VSS VSS
+ VSS VSS gf180mcu_fd_sc_mcu9t5v0__aoi221_1
XTAP_TAPCELL_ROW_273_6574 VSS VSS gf180mcu_fd_sc_mcu9t5v0__filltie
X_19480_ _19480_/D _19992_/RN clkload14/I _19480_/Q VSS VSS VSS VSS gf180mcu_fd_sc_mcu9t5v0__dffrnq_1
X_18431_ _18431_/D _18431_/CLK _18431_/Q VSS VSS VSS VSS gf180mcu_fd_sc_mcu9t5v0__dffq_4
X_15643_ _15672_/B _15642_/Z _19899_/D VSS _15643_/VNW VSS VSS gf180mcu_fd_sc_mcu9t5v0__nor2_1
XTAP_TAPCELL_ROW_100_3734 VSS VSS gf180mcu_fd_sc_mcu9t5v0__filltie
X_12855_ _19768_/Q _12854_/Z _12861_/B VSS VSS VSS VSS gf180mcu_fd_sc_mcu9t5v0__and2_1
XTAP_TAPCELL_ROW_100_3723 VSS VSS gf180mcu_fd_sc_mcu9t5v0__filltie
X_18362_ _18362_/D clkload63/I _18362_/Q VSS VSS VSS VSS gf180mcu_fd_sc_mcu9t5v0__dffq_4
X_11806_ _11806_/A1 _11806_/A2 _11808_/B VSS VSS VSS VSS gf180mcu_fd_sc_mcu9t5v0__nand2_1
XTAP_TAPCELL_ROW_100_3745 VSS VSS gf180mcu_fd_sc_mcu9t5v0__filltie
X_15574_ _18033_/I0 _18030_/I0 _18031_/I0 _18029_/I0 _15576_/A2 VSS VSS VSS VSS gf180mcu_fd_sc_mcu9t5v0__nor4_1
X_12786_ _12790_/A1 _12783_/Z _12791_/A1 VSS _17950_/VNW VSS VSS gf180mcu_fd_sc_mcu9t5v0__nand2_1
XPHY_EDGE_ROW_32_Right_32 VSS VSS gf180mcu_fd_sc_mcu9t5v0__endcap
X_17313_ _17399_/A1 _18388_/Q _17315_/A3 VSS _17313_/VNW VSS VSS gf180mcu_fd_sc_mcu9t5v0__nor2_1
XTAP_TAPCELL_ROW_286_6924 VSS VSS gf180mcu_fd_sc_mcu9t5v0__filltie
X_11737_ _11737_/A1 _11737_/A2 _11737_/B _11748_/A3 VSS VSS VSS VSS gf180mcu_fd_sc_mcu9t5v0__aoi21_1
XTAP_TAPCELL_ROW_42_2140 VSS VSS gf180mcu_fd_sc_mcu9t5v0__filltie
X_14525_ _14738_/B _14525_/A2 _14738_/A1 VSS VSS VSS VSS gf180mcu_fd_sc_mcu9t5v0__nor2_1
XTAP_TAPCELL_ROW_42_2151 VSS VSS gf180mcu_fd_sc_mcu9t5v0__filltie
XTAP_TAPCELL_ROW_286_6946 VSS VSS gf180mcu_fd_sc_mcu9t5v0__filltie
XTAP_TAPCELL_ROW_286_6935 VSS VSS gf180mcu_fd_sc_mcu9t5v0__filltie
X_18293_ _18293_/D clkload69/I _18293_/Q VSS VSS VSS VSS gf180mcu_fd_sc_mcu9t5v0__dffq_1
XPHY_EDGE_ROW_199_1_Left_522 VSS VSS gf180mcu_fd_sc_mcu9t5v0__endcap
X_17244_ _20130_/Q _17407_/C _17244_/B1 _17244_/B2 _17408_/B _17247_/A1 VSS VSS VSS
+ VSS gf180mcu_fd_sc_mcu9t5v0__aoi221_1
X_11668_ _12645_/C _11668_/A2 _11668_/A3 _11676_/B VSS VSS VSS VSS gf180mcu_fd_sc_mcu9t5v0__nand3_1
X_14456_ _14456_/A1 _14766_/A2 _14456_/B1 _14456_/B2 _19456_/D VSS _14456_/VNW VSS
+ VSS gf180mcu_fd_sc_mcu9t5v0__aoi22_1
X_17175_ _18477_/Q _17380_/A2 _17380_/B1 _18493_/Q _17275_/C _17176_/B2 VSS VSS VSS
+ VSS gf180mcu_fd_sc_mcu9t5v0__aoi221_1
X_10619_ _17304_/C _10619_/A2 _10620_/C VSS VSS VSS VSS gf180mcu_fd_sc_mcu9t5v0__nand2_1
X_13407_ _13407_/I _13430_/A1 VSS _13407_/VNW VSS VSS gf180mcu_fd_sc_mcu9t5v0__clkinv_1
X_14387_ _14387_/A1 _14387_/A2 _19448_/D VSS VSS VSS VSS gf180mcu_fd_sc_mcu9t5v0__nand2_1
X_11599_ _18845_/Q _09782_/Z _11602_/A1 VSS VSS VSS VSS gf180mcu_fd_sc_mcu9t5v0__nor2_1
X_16126_ _18171_/Q _16747_/A2 _16747_/A3 _16130_/B VSS VSS VSS VSS gf180mcu_fd_sc_mcu9t5v0__nand3_1
X_13338_ _13336_/Z _13339_/A2 _13357_/A2 VSS _13338_/VNW VSS VSS gf180mcu_fd_sc_mcu9t5v0__nor2_1
XTAP_TAPCELL_ROW_55_2501 VSS VSS gf180mcu_fd_sc_mcu9t5v0__filltie
X_16057_ _16057_/A1 _16672_/A2 _16098_/B _16058_/B VSS VSS VSS VSS gf180mcu_fd_sc_mcu9t5v0__oai21_1
Xrst_tree_leaf_32 rst_tree_mid_4/Z _20051_/RN VSS VSS VSS VSS gf180mcu_fd_sc_mcu9t5v0__clkbuf_16
Xrst_tree_leaf_10 rst_tree_mid_1/Z _20073_/RN VSS VSS VSS VSS gf180mcu_fd_sc_mcu9t5v0__clkbuf_16
Xrst_tree_leaf_21 rst_tree_mid_2/Z _20062_/RN VSS VSS VSS VSS gf180mcu_fd_sc_mcu9t5v0__clkbuf_16
Xrst_tree_leaf_43 rst_tree_mid_5/Z _20040_/RN VSS VSS VSS VSS gf180mcu_fd_sc_mcu9t5v0__clkbuf_16
Xrst_tree_leaf_54 rst_tree_mid_6/Z _20029_/RN VSS VSS VSS VSS gf180mcu_fd_sc_mcu9t5v0__clkbuf_16
XPHY_EDGE_ROW_41_Right_41 VSS VSS gf180mcu_fd_sc_mcu9t5v0__endcap
X_15008_ _15015_/A1 _15008_/A2 _15008_/B _15011_/A2 VSS _15015_/VNW VSS VSS gf180mcu_fd_sc_mcu9t5v0__oai21_1
X_13269_ _19769_/Q _13269_/A2 _13290_/A1 VSS _13269_/VNW VSS VSS gf180mcu_fd_sc_mcu9t5v0__nand2_1
X_19816_ _19816_/D _20072_/RN clkload59/I _19816_/Q VSS VSS VSS VSS gf180mcu_fd_sc_mcu9t5v0__dffrnq_2
X_19747_ _19747_/D _20067_/RN clkload39/I _19747_/Q VSS VSS VSS VSS gf180mcu_fd_sc_mcu9t5v0__dffrnq_1
X_16959_ _16959_/A1 _16955_/S _16959_/B _16960_/I0 VSS VSS VSS VSS gf180mcu_fd_sc_mcu9t5v0__oai21_1
XTAP_TAPCELL_ROW_49_2327 VSS VSS gf180mcu_fd_sc_mcu9t5v0__filltie
XTAP_TAPCELL_ROW_49_2338 VSS VSS gf180mcu_fd_sc_mcu9t5v0__filltie
X_09500_ _19072_/Q _14730_/S _17960_/A2 VSS VSS VSS VSS gf180mcu_fd_sc_mcu9t5v0__nand2_1
XPHY_EDGE_ROW_208_2_Right_939 VSS VSS gf180mcu_fd_sc_mcu9t5v0__endcap
XPHY_EDGE_ROW_187_3_Left_845 VSS VSS gf180mcu_fd_sc_mcu9t5v0__endcap
X_19678_ _19678_/D _20062_/RN clkload43/I _19678_/Q VSS VSS VSS VSS gf180mcu_fd_sc_mcu9t5v0__dffrnq_1
XTAP_TAPCELL_ROW_216_5009 VSS VSS gf180mcu_fd_sc_mcu9t5v0__filltie
X_18629_ _18629_/D _20033_/RN clkload48/I _18629_/Q VSS VSS VSS VSS gf180mcu_fd_sc_mcu9t5v0__dffrnq_1
X_09431_ _11013_/A1 _20055_/Q _17631_/A1 VSS VSS VSS VSS gf180mcu_fd_sc_mcu9t5v0__nor2_1
XPHY_EDGE_ROW_50_Right_50 VSS VSS gf180mcu_fd_sc_mcu9t5v0__endcap
X_09362_ _18187_/Q _11131_/A1 VSS VSS VSS VSS gf180mcu_fd_sc_mcu9t5v0__clkinv_1
X_09293_ _19252_/Q _16714_/A1 VSS _17286_/VNW VSS VSS gf180mcu_fd_sc_mcu9t5v0__clkinv_1
XANTENNA_22 output17/I VSS VSS VSS VSS gf180mcu_fd_sc_mcu9t5v0__antenna
XANTENNA_11 _11395_/A3 VSS _11395_/VNW VSS VSS gf180mcu_fd_sc_mcu9t5v0__antenna
Xload_slew111_b _14900_/S wire108/I VSS VSS VSS VSS gf180mcu_fd_sc_mcu9t5v0__clkbuf_16
XTAP_TAPCELL_ROW_25_1670 VSS VSS gf180mcu_fd_sc_mcu9t5v0__filltie
XTAP_TAPCELL_ROW_25_1681 VSS VSS gf180mcu_fd_sc_mcu9t5v0__filltie
XTAP_TAPCELL_ROW_21_1556 VSS VSS gf180mcu_fd_sc_mcu9t5v0__filltie
XTAP_TAPCELL_ROW_304_7441 VSS VSS gf180mcu_fd_sc_mcu9t5v0__filltie
XTAP_TAPCELL_ROW_304_7430 VSS VSS gf180mcu_fd_sc_mcu9t5v0__filltie
XTAP_TAPCELL_ROW_21_1567 VSS VSS gf180mcu_fd_sc_mcu9t5v0__filltie
XTAP_TAPCELL_ROW_300_7316 VSS VSS gf180mcu_fd_sc_mcu9t5v0__filltie
XTAP_TAPCELL_ROW_296_7220 VSS VSS gf180mcu_fd_sc_mcu9t5v0__filltie
XTAP_TAPCELL_ROW_300_7327 VSS VSS gf180mcu_fd_sc_mcu9t5v0__filltie
XTAP_TAPCELL_ROW_292_7106 VSS VSS gf180mcu_fd_sc_mcu9t5v0__filltie
XTAP_TAPCELL_ROW_34_1906 VSS VSS gf180mcu_fd_sc_mcu9t5v0__filltie
XTAP_TAPCELL_ROW_34_1917 VSS VSS gf180mcu_fd_sc_mcu9t5v0__filltie
XTAP_TAPCELL_ROW_34_1928 VSS VSS gf180mcu_fd_sc_mcu9t5v0__filltie
XTAP_TAPCELL_ROW_19_1496 VSS VSS gf180mcu_fd_sc_mcu9t5v0__filltie
Xmax_cap35 _16910_/S _16928_/S VSS VSS VSS VSS gf180mcu_fd_sc_mcu9t5v0__clkbuf_16
Xmax_cap24 _17034_/S _17042_/S VSS VSS VSS VSS gf180mcu_fd_sc_mcu9t5v0__clkbuf_16
Xmax_cap46 _17033_/S _17055_/S VSS VSS VSS VSS gf180mcu_fd_sc_mcu9t5v0__clkbuf_16
X_10970_ _19012_/Q _18148_/S _10971_/B VSS VSS VSS VSS gf180mcu_fd_sc_mcu9t5v0__nand2_1
Xmax_cap57 _16833_/S _16863_/S VSS VSS VSS VSS gf180mcu_fd_sc_mcu9t5v0__clkbuf_16
Xmax_cap68 _16714_/A3 _16751_/A3 VSS VSS VSS VSS gf180mcu_fd_sc_mcu9t5v0__clkbuf_8
X_09629_ wire301/Z _17765_/A1 _09741_/A2 VSS _09630_/VNW VSS VSS gf180mcu_fd_sc_mcu9t5v0__nor2_1
XTAP_TAPCELL_ROW_117_4206 VSS VSS gf180mcu_fd_sc_mcu9t5v0__filltie
X_12640_ _11654_/C _12649_/A3 _12643_/A2 _12641_/A2 VSS VSS VSS VSS gf180mcu_fd_sc_mcu9t5v0__nand3_1
X_12571_ _19167_/Q _12620_/A1 _12572_/B VSS VSS VSS VSS gf180mcu_fd_sc_mcu9t5v0__nand2_1
X_14310_ _14359_/I0 _19383_/Q _14322_/S _19383_/D VSS VSS VSS VSS gf180mcu_fd_sc_mcu9t5v0__mux2_1
X_11522_ _18535_/Q _18519_/Q _18503_/Q _18487_/Q _11524_/S _11485_/C _11522_/Z VSS
+ VSS VSS VSS gf180mcu_fd_sc_mcu9t5v0__mux4_1
X_15290_ _15300_/A2 _15289_/Z _15292_/A2 VSS VSS VSS VSS gf180mcu_fd_sc_mcu9t5v0__nand2_1
XTAP_TAPCELL_ROW_281_6810 VSS VSS gf180mcu_fd_sc_mcu9t5v0__filltie
X_11453_ _11537_/S _11453_/A2 _11453_/A3 _11454_/C VSS VSS VSS VSS gf180mcu_fd_sc_mcu9t5v0__nand3_1
X_14241_ _14241_/A1 _14241_/A2 _14241_/B _14257_/A1 VSS _14257_/VNW VSS VSS gf180mcu_fd_sc_mcu9t5v0__aoi21_1
XTAP_TAPCELL_ROW_95_3582 VSS VSS gf180mcu_fd_sc_mcu9t5v0__filltie
X_10404_ _10459_/C _10404_/A2 _10404_/A3 _10404_/B _10409_/A2 VSS VSS VSS VSS gf180mcu_fd_sc_mcu9t5v0__oai31_1
XTAP_TAPCELL_ROW_145_3_8030 VSS VSS gf180mcu_fd_sc_mcu9t5v0__filltie
Xwire278 wire279/Z wire278/Z VSS VSS VSS VSS gf180mcu_fd_sc_mcu9t5v0__buf_2
XTAP_TAPCELL_ROW_95_3593 VSS VSS gf180mcu_fd_sc_mcu9t5v0__filltie
X_14172_ _14357_/I0 _19327_/Q _14266_/S _19327_/D VSS VSS VSS VSS gf180mcu_fd_sc_mcu9t5v0__mux2_1
X_11384_ _18429_/Q _11176_/C _11388_/C VSS _17170_/VNW VSS VSS gf180mcu_fd_sc_mcu9t5v0__nand2_1
XTAP_TAPCELL_ROW_262_6275 VSS VSS gf180mcu_fd_sc_mcu9t5v0__filltie
XTAP_TAPCELL_ROW_262_6264 VSS VSS gf180mcu_fd_sc_mcu9t5v0__filltie
X_13123_ _12948_/S _13140_/A2 _13124_/B VSS VSS VSS VSS gf180mcu_fd_sc_mcu9t5v0__and2_1
XTAP_TAPCELL_ROW_91_3479 VSS VSS gf180mcu_fd_sc_mcu9t5v0__filltie
XTAP_TAPCELL_ROW_262_6286 VSS VSS gf180mcu_fd_sc_mcu9t5v0__filltie
X_10335_ _18942_/Q wire166/Z _10337_/A2 VSS VSS VSS VSS gf180mcu_fd_sc_mcu9t5v0__nand2_1
X_18980_ _18980_/D _20068_/RN clkload70/I _18980_/Q VSS VSS VSS VSS gf180mcu_fd_sc_mcu9t5v0__dffrnq_1
X_10266_ _18218_/Q _17282_/A2 _17282_/B1 _18234_/Q _10267_/B VSS VSS VSS VSS gf180mcu_fd_sc_mcu9t5v0__aoi22_1
Xload_slew206 _12028_/A1 _12071_/B VSS VSS VSS VSS gf180mcu_fd_sc_mcu9t5v0__clkbuf_8
X_13054_ _13055_/A1 _13055_/A3 _13054_/B _13529_/A2 VSS VSS VSS VSS gf180mcu_fd_sc_mcu9t5v0__aoi21_1
X_17931_ _18848_/Q _17929_/Z _17931_/Z VSS VSS VSS VSS gf180mcu_fd_sc_mcu9t5v0__and2_1
XTAP_TAPCELL_ROW_279_6750 VSS VSS gf180mcu_fd_sc_mcu9t5v0__filltie
X_17862_ _18828_/Q _17859_/Z _17868_/A3 VSS _17867_/VNW VSS VSS gf180mcu_fd_sc_mcu9t5v0__nand2_1
XPHY_EDGE_ROW_140_2_Left_652 VSS VSS gf180mcu_fd_sc_mcu9t5v0__endcap
X_12005_ _18905_/Q _12005_/A2 _12336_/B _12007_/A2 VSS VSS VSS VSS gf180mcu_fd_sc_mcu9t5v0__oai21_1
XTAP_TAPCELL_ROW_275_6636 VSS VSS gf180mcu_fd_sc_mcu9t5v0__filltie
XTAP_TAPCELL_ROW_275_6625 VSS VSS gf180mcu_fd_sc_mcu9t5v0__filltie
X_16813_ _16813_/A1 _16951_/B _16814_/I1 VSS VSS VSS VSS gf180mcu_fd_sc_mcu9t5v0__nand2_1
XTAP_TAPCELL_ROW_106_3910 VSS VSS gf180mcu_fd_sc_mcu9t5v0__filltie
X_10197_ _09870_/Z _09873_/B _15672_/B _10197_/B _20046_/D VSS _10197_/VNW VSS VSS
+ gf180mcu_fd_sc_mcu9t5v0__oai31_1
X_19601_ _19601_/D _20049_/RN clkload16/I _19601_/Q VSS VSS VSS VSS gf180mcu_fd_sc_mcu9t5v0__dffrnq_1
X_17793_ _18771_/Q _18758_/Q _18769_/D _18771_/D VSS VSS VSS VSS gf180mcu_fd_sc_mcu9t5v0__mux2_1
X_16744_ _16959_/A1 _16744_/A2 _16751_/A3 _16746_/A2 VSS VSS VSS VSS gf180mcu_fd_sc_mcu9t5v0__nor3_1
X_13956_ _13956_/A1 _13956_/A2 _13956_/B _13958_/A2 VSS _13956_/VNW VSS VSS gf180mcu_fd_sc_mcu9t5v0__oai21_1
X_19532_ _19532_/D _20044_/RN clkload29/I _19532_/Q VSS VSS VSS VSS gf180mcu_fd_sc_mcu9t5v0__dffrnq_1
X_16675_ _16675_/A1 _16675_/A2 _16675_/A3 _16675_/B _16676_/I1 VSS VSS VSS VSS gf180mcu_fd_sc_mcu9t5v0__oai31_4
X_12907_ _13320_/B _12907_/A2 _12907_/B _19220_/D VSS _12907_/VNW VSS VSS gf180mcu_fd_sc_mcu9t5v0__oai21_1
X_13887_ _13887_/I _13921_/A1 VSS _13887_/VNW VSS VSS gf180mcu_fd_sc_mcu9t5v0__clkinv_1
X_19463_ _19463_/D _20039_/RN clkload12/I _19463_/Q VSS VSS VSS VSS gf180mcu_fd_sc_mcu9t5v0__dffrnq_1
XTAP_TAPCELL_ROW_44_2202 VSS VSS gf180mcu_fd_sc_mcu9t5v0__filltie
X_18414_ _18414_/D clkload62/I _18414_/Q VSS VSS VSS VSS gf180mcu_fd_sc_mcu9t5v0__dffq_1
X_15626_ _15626_/A1 _15626_/A2 _15626_/B _19892_/D VSS _15627_/VNW VSS VSS gf180mcu_fd_sc_mcu9t5v0__aoi21_1
X_12838_ _12837_/Z _19210_/Q _13497_/B _19210_/D VSS VSS VSS VSS gf180mcu_fd_sc_mcu9t5v0__mux2_1
X_19394_ _19394_/D _20034_/RN clkload8/I _19394_/Q VSS VSS VSS VSS gf180mcu_fd_sc_mcu9t5v0__dffrnq_1
X_15557_ _17422_/S _15556_/Z _19872_/D VSS _15557_/VNW VSS VSS gf180mcu_fd_sc_mcu9t5v0__and2_1
X_18345_ _18345_/D clkload53/I _18345_/Q VSS VSS VSS VSS gf180mcu_fd_sc_mcu9t5v0__dffq_1
X_12769_ _19200_/Q _13320_/B _12770_/B VSS VSS VSS VSS gf180mcu_fd_sc_mcu9t5v0__nand2_1
X_18276_ _18276_/D _18518_/CLK _18276_/Q VSS VSS VSS VSS gf180mcu_fd_sc_mcu9t5v0__dffq_4
X_15488_ _19831_/Q _09065_/I _15502_/S _15488_/Z VSS VSS VSS VSS gf180mcu_fd_sc_mcu9t5v0__mux2_1
XPHY_EDGE_ROW_7_Left_331 VSS VSS gf180mcu_fd_sc_mcu9t5v0__endcap
X_14508_ _14513_/A2 _14513_/A3 _14509_/A2 VSS VSS VSS VSS gf180mcu_fd_sc_mcu9t5v0__nor2_1
X_17227_ _19862_/Q _10724_/C _17227_/B _17229_/A3 VSS VSS VSS VSS gf180mcu_fd_sc_mcu9t5v0__oai21_1
X_14439_ _14702_/B _14439_/A2 _14439_/Z VSS _14439_/VNW VSS VSS gf180mcu_fd_sc_mcu9t5v0__or2_1
XTAP_TAPCELL_ROW_38_2017 VSS VSS gf180mcu_fd_sc_mcu9t5v0__filltie
X_17158_ _17158_/A1 _17158_/A2 _17159_/C VSS _17181_/VNW VSS VSS gf180mcu_fd_sc_mcu9t5v0__nor2_1
XTAP_TAPCELL_ROW_38_2028 VSS VSS gf180mcu_fd_sc_mcu9t5v0__filltie
XTAP_TAPCELL_ROW_38_2039 VSS VSS gf180mcu_fd_sc_mcu9t5v0__filltie
X_16109_ _16668_/A1 _16750_/A2 _16730_/A1 VSS VSS VSS VSS gf180mcu_fd_sc_mcu9t5v0__nand2_4
X_09980_ _19221_/Q _09898_/C _10168_/B1 _19205_/Q wire297/Z _19245_/Q _09981_/A2 VSS
+ _09981_/VNW VSS VSS gf180mcu_fd_sc_mcu9t5v0__aoi222_1
X_17089_ _19828_/Q _17089_/A2 _17089_/B1 _17243_/A1 _17089_/C _17091_/A2 VSS VSS VSS
+ VSS gf180mcu_fd_sc_mcu9t5v0__aoi221_1
Xclkbuf_3_2_0_clk_regs clkbuf_0_clk_regs/Z clkload1/I VSS VSS VSS VSS gf180mcu_fd_sc_mcu9t5v0__clkbuf_8
XTAP_TAPCELL_ROW_14_1360 VSS VSS gf180mcu_fd_sc_mcu9t5v0__filltie
XTAP_TAPCELL_ROW_14_1371 VSS VSS gf180mcu_fd_sc_mcu9t5v0__filltie
XTAP_TAPCELL_ROW_10_1246 VSS VSS gf180mcu_fd_sc_mcu9t5v0__filltie
XTAP_TAPCELL_ROW_10_1257 VSS VSS gf180mcu_fd_sc_mcu9t5v0__filltie
XTAP_TAPCELL_ROW_10_1268 VSS VSS gf180mcu_fd_sc_mcu9t5v0__filltie
X_09414_ _20026_/Q _20025_/Q _20024_/Q _09416_/B VSS VSS VSS VSS gf180mcu_fd_sc_mcu9t5v0__nor3_1
XTAP_TAPCELL_ROW_151_3_8051 VSS VSS gf180mcu_fd_sc_mcu9t5v0__filltie
XTAP_TAPCELL_ROW_27_1721 VSS VSS gf180mcu_fd_sc_mcu9t5v0__filltie
XTAP_TAPCELL_ROW_27_1732 VSS VSS gf180mcu_fd_sc_mcu9t5v0__filltie
XTAP_TAPCELL_ROW_23_1607 VSS VSS gf180mcu_fd_sc_mcu9t5v0__filltie
X_09345_ _19472_/Q _14593_/A1 VSS _14593_/VNW VSS VSS gf180mcu_fd_sc_mcu9t5v0__clkinv_1
X_09276_ _20062_/Q _10820_/B2 VSS VSS VSS VSS gf180mcu_fd_sc_mcu9t5v0__clkinv_1
XTAP_TAPCELL_ROW_23_1618 VSS VSS gf180mcu_fd_sc_mcu9t5v0__filltie
XPHY_EDGE_ROW_307_Left_630 VSS VSS gf180mcu_fd_sc_mcu9t5v0__endcap
X_10120_ _10028_/B _10141_/A2 _10131_/B VSS _10141_/VNW VSS VSS gf180mcu_fd_sc_mcu9t5v0__nor2_1
X_10051_ _10178_/A1 _10051_/A2 _10051_/A3 _10052_/C VSS VSS VSS VSS gf180mcu_fd_sc_mcu9t5v0__nand3_1
XTAP_TAPCELL_ROW_270_6500 VSS VSS gf180mcu_fd_sc_mcu9t5v0__filltie
X_13810_ _13810_/A1 _13810_/A2 _13837_/A1 VSS VSS VSS VSS gf180mcu_fd_sc_mcu9t5v0__nand2_1
X_14790_ _14790_/A1 _14788_/Z _14792_/A2 VSS VSS VSS VSS gf180mcu_fd_sc_mcu9t5v0__xnor2_1
X_10953_ _18931_/Q _10953_/A2 _10953_/Z VSS _10953_/VNW VSS VSS gf180mcu_fd_sc_mcu9t5v0__xor2_1
XTAP_TAPCELL_ROW_84_3294 VSS VSS gf180mcu_fd_sc_mcu9t5v0__filltie
X_13741_ _13748_/A1 _14675_/A1 _13742_/A2 VSS VSS VSS VSS gf180mcu_fd_sc_mcu9t5v0__xnor2_1
XTAP_TAPCELL_ROW_84_3283 VSS VSS gf180mcu_fd_sc_mcu9t5v0__filltie
XTAP_TAPCELL_ROW_255_6090 VSS VSS gf180mcu_fd_sc_mcu9t5v0__filltie
XTAP_TAPCELL_ROW_80_3169 VSS VSS gf180mcu_fd_sc_mcu9t5v0__filltie
X_16460_ _18288_/Q _16459_/Z _16986_/S _18288_/D VSS _17327_/VNW VSS VSS gf180mcu_fd_sc_mcu9t5v0__mux2_4
X_10884_ _16428_/A1 _18147_/S _10892_/B _10885_/I0 VSS VSS VSS VSS gf180mcu_fd_sc_mcu9t5v0__oai21_1
X_13672_ _13675_/A1 _13675_/A2 _13676_/A1 VSS _13672_/VNW VSS VSS gf180mcu_fd_sc_mcu9t5v0__nand2_1
X_16391_ _16167_/B _19238_/Q _16925_/S _16391_/Z VSS VSS VSS VSS gf180mcu_fd_sc_mcu9t5v0__mux2_1
X_15411_ _19696_/Q _19796_/Q _15430_/S _19796_/D VSS VSS VSS VSS gf180mcu_fd_sc_mcu9t5v0__mux2_1
X_12623_ _12655_/S _17477_/A2 VSS VSS VSS VSS gf180mcu_fd_sc_mcu9t5v0__clkinv_1
XTAP_TAPCELL_ROW_268_6451 VSS VSS gf180mcu_fd_sc_mcu9t5v0__filltie
XTAP_TAPCELL_ROW_268_6440 VSS VSS gf180mcu_fd_sc_mcu9t5v0__filltie
X_18130_ _18130_/A1 _18147_/S _18132_/B _18131_/I0 VSS VSS VSS VSS gf180mcu_fd_sc_mcu9t5v0__oai21_1
XTAP_TAPCELL_ROW_97_3655 VSS VSS gf180mcu_fd_sc_mcu9t5v0__filltie
X_12554_ wire175/Z wire278/Z _12618_/B _12556_/A3 VSS _12554_/VNW VSS VSS gf180mcu_fd_sc_mcu9t5v0__aoi21_1
X_15342_ _15345_/A1 _15345_/A3 _15343_/A2 VSS _15352_/VNW VSS VSS gf180mcu_fd_sc_mcu9t5v0__nor2_1
XTAP_TAPCELL_ROW_97_3644 VSS VSS gf180mcu_fd_sc_mcu9t5v0__filltie
X_11505_ _18406_/Q _11509_/A2 _11506_/A3 VSS VSS VSS VSS gf180mcu_fd_sc_mcu9t5v0__nand2_1
XTAP_TAPCELL_ROW_264_6326 VSS VSS gf180mcu_fd_sc_mcu9t5v0__filltie
X_18061_ _18060_/B _18079_/A1 _18062_/I VSS _18061_/VNW VSS VSS gf180mcu_fd_sc_mcu9t5v0__nor2_1
X_15273_ _19633_/Q _19610_/Q _15283_/C VSS _15273_/VNW VSS VSS gf180mcu_fd_sc_mcu9t5v0__nor2_1
X_17012_ _18497_/Q _17011_/Z _17020_/S _18497_/D VSS VSS VSS VSS gf180mcu_fd_sc_mcu9t5v0__mux2_4
XTAP_TAPCELL_ROW_264_6337 VSS VSS gf180mcu_fd_sc_mcu9t5v0__filltie
X_12485_ _12355_/I _12485_/A2 _12485_/A3 _12485_/B _19156_/D VSS VSS VSS VSS gf180mcu_fd_sc_mcu9t5v0__oai31_1
X_14224_ _14245_/C _14246_/A2 _14224_/Z VSS VSS VSS VSS gf180mcu_fd_sc_mcu9t5v0__xor2_1
X_11436_ _19097_/Q _11541_/A2 _11437_/A2 VSS VSS VSS VSS gf180mcu_fd_sc_mcu9t5v0__nand2_1
X_11367_ _19092_/Q _11423_/A1 _11368_/B VSS VSS VSS VSS gf180mcu_fd_sc_mcu9t5v0__nand2_1
X_14155_ _19478_/Q _19486_/Q _14165_/S _14155_/Z VSS VSS VSS VSS gf180mcu_fd_sc_mcu9t5v0__mux2_1
X_18963_ _18963_/D _20051_/RN clkload67/I _18963_/Q VSS VSS VSS VSS gf180mcu_fd_sc_mcu9t5v0__dffrnq_1
X_10318_ _18284_/Q _17282_/A2 _17255_/B1 _18300_/Q _17275_/C _10326_/A2 VSS VSS VSS
+ VSS gf180mcu_fd_sc_mcu9t5v0__aoi221_1
X_13106_ _13106_/A1 _13106_/A2 _13106_/B _13145_/B1 VSS VSS VSS VSS gf180mcu_fd_sc_mcu9t5v0__oai21_1
X_14086_ _14081_/Z _14116_/A2 _14086_/Z VSS _14088_/VNW VSS VSS gf180mcu_fd_sc_mcu9t5v0__xor2_1
X_11298_ _18263_/Q _11509_/A2 _11301_/A1 VSS _11942_/VNW VSS VSS gf180mcu_fd_sc_mcu9t5v0__nor2_1
X_13037_ _19723_/Q _13035_/I _13520_/B VSS wire174/VNW VSS VSS gf180mcu_fd_sc_mcu9t5v0__xnor2_1
X_17914_ _18842_/Q _17894_/I _17917_/A1 VSS _17914_/VNW VSS VSS gf180mcu_fd_sc_mcu9t5v0__nand2_1
X_10249_ _18832_/Q _17872_/A1 _10657_/C VSS VSS VSS VSS gf180mcu_fd_sc_mcu9t5v0__nand2_1
X_18894_ _18894_/D _20046_/RN clkload10/I _18894_/Q VSS VSS VSS VSS gf180mcu_fd_sc_mcu9t5v0__dffrnq_1
XTAP_TAPCELL_ROW_240_5680 VSS VSS gf180mcu_fd_sc_mcu9t5v0__filltie
X_17845_ _19052_/Q _18822_/Q _17845_/S _18822_/D VSS _17845_/VNW VSS VSS gf180mcu_fd_sc_mcu9t5v0__mux2_1
X_17776_ _18763_/Q _17779_/A2 _17777_/B VSS VSS VSS VSS gf180mcu_fd_sc_mcu9t5v0__nor2_1
XTAP_TAPCELL_ROW_7_1167 VSS VSS gf180mcu_fd_sc_mcu9t5v0__filltie
X_16727_ _16114_/Z _16727_/A2 _16727_/A3 _16727_/B _18371_/D VSS VSS VSS VSS gf180mcu_fd_sc_mcu9t5v0__oai31_4
X_19515_ _19515_/D _19963_/RN clkload37/I _19515_/Q VSS VSS VSS VSS gf180mcu_fd_sc_mcu9t5v0__dffrnq_1
XTAP_TAPCELL_ROW_7_1178 VSS VSS gf180mcu_fd_sc_mcu9t5v0__filltie
X_14988_ _19431_/Q _19376_/Q _14992_/A2 VSS _15073_/VNW VSS VSS gf180mcu_fd_sc_mcu9t5v0__nor2_1
X_13939_ _13940_/A2 _13937_/Z _13952_/A2 VSS VSS VSS VSS gf180mcu_fd_sc_mcu9t5v0__nor2_1
X_16658_ _16658_/A1 _16672_/A2 _16672_/B _16660_/B VSS VSS VSS VSS gf180mcu_fd_sc_mcu9t5v0__oai21_4
X_19446_ _19446_/D _20022_/RN clkload12/I _19446_/Q VSS VSS VSS VSS gf180mcu_fd_sc_mcu9t5v0__dffrnq_1
X_16589_ input4/Z _18781_/Q _16619_/S _16589_/Z VSS VSS VSS VSS gf180mcu_fd_sc_mcu9t5v0__mux2_1
XTAP_TAPCELL_ROW_234_5495 VSS VSS gf180mcu_fd_sc_mcu9t5v0__filltie
X_15609_ _15618_/A1 _15629_/B _15609_/B _19888_/D VSS VSS VSS VSS gf180mcu_fd_sc_mcu9t5v0__oai21_1
X_19377_ _19377_/D _20145_/RN clkload9/I _19377_/Q VSS VSS VSS VSS gf180mcu_fd_sc_mcu9t5v0__dffrnq_1
X_18328_ _18328_/D _18328_/CLK _18328_/Q VSS VSS VSS VSS gf180mcu_fd_sc_mcu9t5v0__dffq_4
X_09130_ _19728_/Q _13144_/A1 VSS VSS VSS VSS gf180mcu_fd_sc_mcu9t5v0__clkinv_1
X_09061_ input5/Z _17773_/A1 VSS VSS VSS VSS gf180mcu_fd_sc_mcu9t5v0__clkinv_1
X_18259_ _18259_/D clkload80/I _18259_/Q VSS VSS VSS VSS gf180mcu_fd_sc_mcu9t5v0__dffq_1
XTAP_TAPCELL_ROW_247_5867 VSS VSS gf180mcu_fd_sc_mcu9t5v0__filltie
XTAP_TAPCELL_ROW_247_5856 VSS VSS gf180mcu_fd_sc_mcu9t5v0__filltie
X_09963_ _18791_/Q _10154_/A2 _10154_/B _09964_/A3 VSS _09963_/VNW VSS VSS gf180mcu_fd_sc_mcu9t5v0__oai21_1
XPHY_EDGE_ROW_4_Right_4 VSS VSS gf180mcu_fd_sc_mcu9t5v0__endcap
XTAP_TAPCELL_ROW_16_1411 VSS VSS gf180mcu_fd_sc_mcu9t5v0__filltie
XTAP_TAPCELL_ROW_16_1422 VSS VSS gf180mcu_fd_sc_mcu9t5v0__filltie
X_20083_ _20083_/D clkload60/I _20083_/Q VSS VSS VSS VSS gf180mcu_fd_sc_mcu9t5v0__dffq_1
X_09894_ _19992_/Q _19993_/Q _15830_/A2 VSS VSS VSS VSS gf180mcu_fd_sc_mcu9t5v0__nand2_1
XTAP_TAPCELL_ROW_16_1433 VSS VSS gf180mcu_fd_sc_mcu9t5v0__filltie
XTAP_TAPCELL_ROW_12_1308 VSS VSS gf180mcu_fd_sc_mcu9t5v0__filltie
XTAP_TAPCELL_ROW_12_1319 VSS VSS gf180mcu_fd_sc_mcu9t5v0__filltie
XPHY_EDGE_ROW_180_2_Right_911 VSS VSS gf180mcu_fd_sc_mcu9t5v0__endcap
X_09328_ _19208_/Q _18128_/A1 VSS VSS VSS VSS gf180mcu_fd_sc_mcu9t5v0__clkinv_1
XTAP_TAPCELL_ROW_135_4692 VSS VSS gf180mcu_fd_sc_mcu9t5v0__filltie
X_09259_ _19192_/Q _10187_/A2 VSS _14141_/VNW VSS VSS gf180mcu_fd_sc_mcu9t5v0__clkinv_1
X_12270_ _12270_/A1 _12270_/A2 _12270_/B1 _12261_/B _12271_/B VSS VSS VSS VSS gf180mcu_fd_sc_mcu9t5v0__aoi22_1
XTAP_TAPCELL_ROW_131_4589 VSS VSS gf180mcu_fd_sc_mcu9t5v0__filltie
XTAP_TAPCELL_ROW_131_4578 VSS VSS gf180mcu_fd_sc_mcu9t5v0__filltie
X_11221_ _11469_/B _11220_/Z _11221_/B _11225_/A2 VSS VSS VSS VSS gf180mcu_fd_sc_mcu9t5v0__oai21_1
XPHY_EDGE_ROW_146_1_Left_469 VSS VSS gf180mcu_fd_sc_mcu9t5v0__endcap
X_11152_ _18333_/Q _11519_/A2 _11153_/C VSS VSS VSS VSS gf180mcu_fd_sc_mcu9t5v0__nand2_1
XPHY_EDGE_ROW_79_Left_403 VSS VSS gf180mcu_fd_sc_mcu9t5v0__endcap
X_10103_ _10103_/A1 _10103_/A2 _10103_/A3 _10107_/B1 VSS VSS VSS VSS gf180mcu_fd_sc_mcu9t5v0__nand3_1
X_11083_ _18568_/Q wire175/I _12382_/S VSS _17721_/VNW VSS VSS gf180mcu_fd_sc_mcu9t5v0__nand2_2
X_15960_ _15962_/B1 _15962_/B2 _15962_/C _16443_/A3 VSS VSS VSS VSS gf180mcu_fd_sc_mcu9t5v0__aoi21_4
X_15891_ _20100_/Q _19235_/Q _15928_/S _20100_/D VSS VSS VSS VSS gf180mcu_fd_sc_mcu9t5v0__mux2_1
XTAP_TAPCELL_ROW_257_6130 VSS VSS gf180mcu_fd_sc_mcu9t5v0__filltie
XPHY_EDGE_ROW_201_3_Left_859 VSS VSS gf180mcu_fd_sc_mcu9t5v0__endcap
X_10034_ _20009_/Q _10034_/A2 _10178_/A1 VSS _15789_/VNW VSS VSS gf180mcu_fd_sc_mcu9t5v0__nor2_1
XTAP_TAPCELL_ROW_86_3345 VSS VSS gf180mcu_fd_sc_mcu9t5v0__filltie
X_14911_ _14911_/A1 _14909_/Z _14912_/A2 VSS VSS VSS VSS gf180mcu_fd_sc_mcu9t5v0__xnor2_1
XTAP_TAPCELL_ROW_86_3334 VSS VSS gf180mcu_fd_sc_mcu9t5v0__filltie
XTAP_TAPCELL_ROW_257_6141 VSS VSS gf180mcu_fd_sc_mcu9t5v0__filltie
XPHY_EDGE_ROW_175_3_Right_290 VSS VSS gf180mcu_fd_sc_mcu9t5v0__endcap
XTAP_TAPCELL_ROW_86_3356 VSS VSS gf180mcu_fd_sc_mcu9t5v0__filltie
X_17630_ _09517_/I _17649_/S _17653_/I0 VSS _17653_/VNW VSS VSS gf180mcu_fd_sc_mcu9t5v0__nand2_1
X_14842_ _19341_/Q _19407_/Q _14842_/Z VSS _14845_/VNW VSS VSS gf180mcu_fd_sc_mcu9t5v0__or2_1
XTAP_TAPCELL_ROW_253_6038 VSS VSS gf180mcu_fd_sc_mcu9t5v0__filltie
XTAP_TAPCELL_ROW_253_6027 VSS VSS gf180mcu_fd_sc_mcu9t5v0__filltie
XTAP_TAPCELL_ROW_253_6016 VSS VSS gf180mcu_fd_sc_mcu9t5v0__filltie
X_17561_ _17561_/A1 _17561_/A2 _17701_/A1 VSS _17735_/VNW VSS VSS gf180mcu_fd_sc_mcu9t5v0__nand2_1
X_14773_ _19561_/Q _19327_/Q _15148_/S _19561_/D VSS _14773_/VNW VSS VSS gf180mcu_fd_sc_mcu9t5v0__mux2_1
X_19300_ _19300_/D _20068_/RN clkload14/I _19300_/Q VSS VSS VSS VSS gf180mcu_fd_sc_mcu9t5v0__dffrnq_1
XTAP_TAPCELL_ROW_2_1031 VSS VSS gf180mcu_fd_sc_mcu9t5v0__filltie
X_11985_ _12548_/A1 _11985_/A2 _11985_/B _11986_/B2 VSS VSS VSS VSS gf180mcu_fd_sc_mcu9t5v0__oai21_1
XPHY_EDGE_ROW_88_Left_412 VSS VSS gf180mcu_fd_sc_mcu9t5v0__endcap
X_17492_ _18597_/Q _19238_/Q _17513_/S _18597_/D VSS VSS VSS VSS gf180mcu_fd_sc_mcu9t5v0__mux2_1
X_16512_ _16512_/A1 _16512_/A2 _17055_/S _17034_/S VSS VSS VSS VSS gf180mcu_fd_sc_mcu9t5v0__aoi21_4
XTAP_TAPCELL_ROW_99_3717 VSS VSS gf180mcu_fd_sc_mcu9t5v0__filltie
X_10936_ _10936_/A1 _10969_/A1 _10936_/B _10940_/B VSS VSS VSS VSS gf180mcu_fd_sc_mcu9t5v0__oai21_1
XTAP_TAPCELL_ROW_99_3706 VSS VSS gf180mcu_fd_sc_mcu9t5v0__filltie
X_13724_ _13724_/A1 _19112_/Q _13724_/B1 _14662_/A1 _13724_/C _13738_/A3 VSS _13733_/VNW
+ VSS VSS gf180mcu_fd_sc_mcu9t5v0__aoi221_1
XTAP_TAPCELL_ROW_2_1042 VSS VSS gf180mcu_fd_sc_mcu9t5v0__filltie
X_10867_ _19236_/Q _19230_/Q _18117_/S _10867_/Z VSS _16051_/VNW VSS VSS gf180mcu_fd_sc_mcu9t5v0__mux2_1
X_16443_ _16443_/A1 _16443_/A2 _16443_/A3 _16545_/A2 VSS VSS VSS VSS gf180mcu_fd_sc_mcu9t5v0__nand3_4
X_19231_ _19231_/D _20063_/RN clkload25/I _19231_/Q VSS VSS VSS VSS gf180mcu_fd_sc_mcu9t5v0__dffrnq_2
X_13655_ _19457_/Q _13745_/B1 _13658_/A1 VSS _15144_/VNW VSS VSS gf180mcu_fd_sc_mcu9t5v0__nand2_1
X_12606_ _18407_/Q wire163/Z _12609_/A3 VSS VSS VSS VSS gf180mcu_fd_sc_mcu9t5v0__nor2_1
X_19162_ _19162_/D _20058_/RN clkload10/I _19162_/Q VSS VSS VSS VSS gf180mcu_fd_sc_mcu9t5v0__dffrnq_1
X_18113_ _19207_/Q _19201_/Q _18117_/S _18113_/Z VSS _18113_/VNW VSS VSS gf180mcu_fd_sc_mcu9t5v0__mux2_1
X_16374_ _16373_/Z _18250_/Q _16910_/S _18250_/D VSS _16566_/VNW VSS VSS gf180mcu_fd_sc_mcu9t5v0__mux2_1
X_13586_ _13586_/A1 _13585_/B _13586_/A3 _13586_/Z VSS VSS VSS VSS gf180mcu_fd_sc_mcu9t5v0__and3_1
X_10798_ _18844_/Q _10798_/A2 _10798_/Z VSS VSS VSS VSS gf180mcu_fd_sc_mcu9t5v0__xor2_1
X_19093_ _19093_/D _20053_/RN clkload22/I _19093_/Q VSS VSS VSS VSS gf180mcu_fd_sc_mcu9t5v0__dffrnq_1
X_12537_ _12628_/A1 _12620_/A1 _12537_/A3 _12537_/B _19163_/D VSS VSS VSS VSS gf180mcu_fd_sc_mcu9t5v0__oai31_1
X_15325_ _19642_/Q _19619_/Q _15330_/B VSS VSS VSS VSS gf180mcu_fd_sc_mcu9t5v0__and2_1
X_18044_ _18926_/Q _18923_/Q _18044_/B _18066_/A2 VSS VSS VSS VSS gf180mcu_fd_sc_mcu9t5v0__oai21_1
X_12468_ _19154_/Q _12355_/I _12469_/B VSS VSS VSS VSS gf180mcu_fd_sc_mcu9t5v0__nand2_1
X_15256_ _19730_/Q _15256_/I1 _15364_/S _19730_/D VSS VSS VSS VSS gf180mcu_fd_sc_mcu9t5v0__mux2_1
X_11419_ _18367_/Q _11176_/C _11526_/B _11420_/B2 VSS VSS VSS VSS gf180mcu_fd_sc_mcu9t5v0__aoi21_1
XPHY_EDGE_ROW_229_Right_156 VSS VSS gf180mcu_fd_sc_mcu9t5v0__endcap
XPHY_EDGE_ROW_196_3_Left_854 VSS VSS gf180mcu_fd_sc_mcu9t5v0__endcap
X_15187_ _19587_/Q _15187_/A2 _15187_/B1 _19586_/Q _15188_/B2 VSS VSS VSS VSS gf180mcu_fd_sc_mcu9t5v0__aoi22_1
X_14207_ _14208_/A1 _14208_/A2 _14217_/A1 VSS _14207_/VNW VSS VSS gf180mcu_fd_sc_mcu9t5v0__nand2_1
XPHY_EDGE_ROW_97_Left_421 VSS VSS gf180mcu_fd_sc_mcu9t5v0__endcap
X_12399_ _18302_/Q _12608_/A2 wire146/Z _12400_/B2 VSS VSS VSS VSS gf180mcu_fd_sc_mcu9t5v0__oai21_1
XTAP_TAPCELL_ROW_242_5720 VSS VSS gf180mcu_fd_sc_mcu9t5v0__filltie
XTAP_TAPCELL_ROW_71_2935 VSS VSS gf180mcu_fd_sc_mcu9t5v0__filltie
X_14138_ _14183_/A1 _14137_/I _14367_/I0 VSS VSS VSS VSS gf180mcu_fd_sc_mcu9t5v0__xnor2_2
XTAP_TAPCELL_ROW_71_2924 VSS VSS gf180mcu_fd_sc_mcu9t5v0__filltie
XTAP_TAPCELL_ROW_242_5731 VSS VSS gf180mcu_fd_sc_mcu9t5v0__filltie
X_19995_ _19995_/D _20059_/RN clkload65/I _19995_/Q VSS VSS VSS VSS gf180mcu_fd_sc_mcu9t5v0__dffrnq_1
XTAP_TAPCELL_ROW_71_2946 VSS VSS gf180mcu_fd_sc_mcu9t5v0__filltie
X_18946_ _18946_/D _20034_/RN clkload67/I _18946_/Q VSS VSS VSS VSS gf180mcu_fd_sc_mcu9t5v0__dffrnq_1
XPHY_EDGE_ROW_186_1_Right_770 VSS VSS gf180mcu_fd_sc_mcu9t5v0__endcap
X_14069_ _14069_/A1 _14055_/Z _14069_/B _14070_/I VSS VSS VSS VSS gf180mcu_fd_sc_mcu9t5v0__aoi21_1
XTAP_TAPCELL_ROW_9_1218 VSS VSS gf180mcu_fd_sc_mcu9t5v0__filltie
XPHY_EDGE_ROW_275_Right_202 VSS VSS gf180mcu_fd_sc_mcu9t5v0__endcap
XTAP_TAPCELL_ROW_223_5196 VSS VSS gf180mcu_fd_sc_mcu9t5v0__filltie
X_18877_ _18877_/D _20029_/RN clkload23/I _18877_/Q VSS VSS VSS VSS gf180mcu_fd_sc_mcu9t5v0__dffrnq_1
XTAP_TAPCELL_ROW_9_1229 VSS VSS gf180mcu_fd_sc_mcu9t5v0__filltie
X_17828_ _19035_/Q _18805_/Q _17845_/S _18805_/D VSS VSS VSS VSS gf180mcu_fd_sc_mcu9t5v0__mux2_1
XTAP_TAPCELL_ROW_69_2886 VSS VSS gf180mcu_fd_sc_mcu9t5v0__filltie
XTAP_TAPCELL_ROW_69_2875 VSS VSS gf180mcu_fd_sc_mcu9t5v0__filltie
X_17759_ _18755_/Q _18790_/Q _17421_/S _17779_/C VSS VSS VSS VSS gf180mcu_fd_sc_mcu9t5v0__nor3_1
XTAP_TAPCELL_ROW_236_5568 VSS VSS gf180mcu_fd_sc_mcu9t5v0__filltie
XTAP_TAPCELL_ROW_236_5557 VSS VSS gf180mcu_fd_sc_mcu9t5v0__filltie
X_19429_ _19429_/D _20069_/RN clkload21/I _19429_/Q VSS VSS VSS VSS gf180mcu_fd_sc_mcu9t5v0__dffrnq_1
XTAP_TAPCELL_ROW_249_5918 VSS VSS gf180mcu_fd_sc_mcu9t5v0__filltie
XTAP_TAPCELL_ROW_249_5907 VSS VSS gf180mcu_fd_sc_mcu9t5v0__filltie
X_09113_ _19718_/Q _12735_/B VSS VSS VSS VSS gf180mcu_fd_sc_mcu9t5v0__clkinv_1
XTAP_TAPCELL_ROW_249_5929 VSS VSS gf180mcu_fd_sc_mcu9t5v0__filltie
Xmax_cap161 _12383_/S _12608_/A2 VSS VSS VSS VSS gf180mcu_fd_sc_mcu9t5v0__buf_4
Xmax_cap150 wire283/Z _11526_/B VSS VSS VSS VSS gf180mcu_fd_sc_mcu9t5v0__clkbuf_8
XTAP_TAPCELL_ROW_320_7875 VSS VSS gf180mcu_fd_sc_mcu9t5v0__filltie
Xmax_cap194 _17380_/A2 _17322_/A2 VSS _16858_/VNW VSS VSS gf180mcu_fd_sc_mcu9t5v0__buf_8
XTAP_TAPCELL_ROW_320_7864 VSS VSS gf180mcu_fd_sc_mcu9t5v0__filltie
Xmax_cap183 _12183_/C _12347_/C VSS VSS VSS VSS gf180mcu_fd_sc_mcu9t5v0__clkbuf_8
Xclkbuf_leaf_59_clk_regs clkload1/I clkload30/I VSS VSS VSS VSS gf180mcu_fd_sc_mcu9t5v0__clkbuf_8
X_20135_ _20135_/D clkload74/I _20135_/Q VSS VSS VSS VSS gf180mcu_fd_sc_mcu9t5v0__dffq_1
X_09946_ _18818_/Q _18815_/Q _18816_/Q _18814_/Q _09948_/A2 VSS _09946_/VNW VSS VSS
+ gf180mcu_fd_sc_mcu9t5v0__nor4_1
X_20066_ _20066_/D _20066_/RN clkload50/I _20066_/Q VSS VSS VSS VSS gf180mcu_fd_sc_mcu9t5v0__dffrnq_1
X_09877_ _09878_/A1 _09878_/A2 wire282/I VSS VSS VSS VSS gf180mcu_fd_sc_mcu9t5v0__nor2_2
XPHY_EDGE_ROW_79_Right_79 VSS VSS gf180mcu_fd_sc_mcu9t5v0__endcap
XTAP_TAPCELL_ROW_124_4393 VSS VSS gf180mcu_fd_sc_mcu9t5v0__filltie
XTAP_TAPCELL_ROW_124_4382 VSS VSS gf180mcu_fd_sc_mcu9t5v0__filltie
XPHY_EDGE_ROW_249_Left_572 VSS VSS gf180mcu_fd_sc_mcu9t5v0__endcap
XTAP_TAPCELL_ROW_81_3220 VSS VSS gf180mcu_fd_sc_mcu9t5v0__filltie
XTAP_TAPCELL_ROW_120_4279 VSS VSS gf180mcu_fd_sc_mcu9t5v0__filltie
XPHY_EDGE_ROW_181_2_Right_912 VSS VSS gf180mcu_fd_sc_mcu9t5v0__endcap
X_11770_ _18896_/Q _11770_/A2 _11791_/A2 VSS VSS VSS VSS gf180mcu_fd_sc_mcu9t5v0__xnor2_1
X_10721_ _19827_/Q _17322_/A2 _10722_/A2 VSS VSS VSS VSS gf180mcu_fd_sc_mcu9t5v0__xnor2_1
X_13440_ _19778_/Q _19812_/Q _13440_/Z VSS VSS VSS VSS gf180mcu_fd_sc_mcu9t5v0__xor2_1
X_10652_ _18970_/Q wire165/Z _10652_/B1 _18986_/Q _10653_/A3 VSS VSS VSS VSS gf180mcu_fd_sc_mcu9t5v0__aoi22_1
XTAP_TAPCELL_ROW_79_3160 VSS VSS gf180mcu_fd_sc_mcu9t5v0__filltie
XTAP_TAPCELL_ROW_133_4629 VSS VSS gf180mcu_fd_sc_mcu9t5v0__filltie
X_10583_ _10459_/C _10583_/A2 _10583_/A3 _10583_/B _10592_/A2 VSS VSS VSS VSS gf180mcu_fd_sc_mcu9t5v0__oai31_1
X_13371_ _13371_/I _13395_/A1 VSS _13614_/VNW VSS VSS gf180mcu_fd_sc_mcu9t5v0__clkinv_1
X_12322_ _18423_/Q _12315_/S _12322_/B _12325_/A2 VSS _12322_/VNW VSS VSS gf180mcu_fd_sc_mcu9t5v0__aoi21_1
X_16090_ _16675_/A1 _16090_/A2 _16090_/A3 _16090_/B _16091_/I1 VSS VSS VSS VSS gf180mcu_fd_sc_mcu9t5v0__oai31_1
XPHY_EDGE_ROW_258_Left_581 VSS VSS gf180mcu_fd_sc_mcu9t5v0__endcap
XPHY_EDGE_ROW_88_Right_88 VSS VSS gf180mcu_fd_sc_mcu9t5v0__endcap
XTAP_TAPCELL_ROW_75_3057 VSS VSS gf180mcu_fd_sc_mcu9t5v0__filltie
XTAP_TAPCELL_ROW_75_3046 VSS VSS gf180mcu_fd_sc_mcu9t5v0__filltie
XTAP_TAPCELL_ROW_75_3035 VSS VSS gf180mcu_fd_sc_mcu9t5v0__filltie
X_15110_ _19652_/Q _19492_/Q _15163_/S _19652_/D VSS _15110_/VNW VSS VSS gf180mcu_fd_sc_mcu9t5v0__mux2_1
X_12253_ wire208/Z _12272_/A2 _12252_/Z _12254_/B1 VSS VSS VSS VSS gf180mcu_fd_sc_mcu9t5v0__nand3_1
X_15041_ _15041_/A1 _15041_/A2 _15041_/B _15047_/A1 VSS VSS VSS VSS gf180mcu_fd_sc_mcu9t5v0__oai21_1
X_11204_ _11520_/B _11204_/A2 _11204_/A3 _11205_/C VSS _11204_/VNW VSS VSS gf180mcu_fd_sc_mcu9t5v0__nand3_1
X_12184_ _12183_/C _12179_/Z _12184_/B _12261_/B _12185_/A2 VSS VSS VSS VSS gf180mcu_fd_sc_mcu9t5v0__oai211_1
X_16992_ _18487_/Q _16991_/Z wire28/Z _18487_/D VSS VSS VSS VSS gf180mcu_fd_sc_mcu9t5v0__mux2_1
XTAP_TAPCELL_ROW_259_6203 VSS VSS gf180mcu_fd_sc_mcu9t5v0__filltie
X_19780_ _19780_/D _20036_/RN clkload42/I _19780_/Q VSS VSS VSS VSS gf180mcu_fd_sc_mcu9t5v0__dffrnq_1
XTAP_TAPCELL_ROW_88_3407 VSS VSS gf180mcu_fd_sc_mcu9t5v0__filltie
X_18800_ _18800_/D _20144_/RN clkload31/I _18800_/Q VSS VSS VSS VSS gf180mcu_fd_sc_mcu9t5v0__dffrnq_1
X_11135_ _18861_/Q _12689_/C _11137_/A2 VSS _17974_/VNW VSS VSS gf180mcu_fd_sc_mcu9t5v0__nor2_1
X_15943_ _15989_/A3 _15966_/A3 _15988_/B VSS VSS VSS VSS gf180mcu_fd_sc_mcu9t5v0__or2_4
X_18731_ _18731_/D clkload47/I _18731_/Q VSS VSS VSS VSS gf180mcu_fd_sc_mcu9t5v0__dffq_1
X_11066_ _18036_/I0 _19067_/Q _11067_/S _19067_/D VSS VSS VSS VSS gf180mcu_fd_sc_mcu9t5v0__mux2_1
X_10017_ _10659_/C _10715_/A1 _10017_/B _10042_/A2 VSS _10841_/VNW VSS VSS gf180mcu_fd_sc_mcu9t5v0__oai21_1
XPHY_EDGE_ROW_97_Right_97 VSS VSS gf180mcu_fd_sc_mcu9t5v0__endcap
X_15874_ _20083_/Q _19233_/Q _15905_/S _20083_/D VSS VSS VSS VSS gf180mcu_fd_sc_mcu9t5v0__mux2_1
XPHY_EDGE_ROW_267_Left_590 VSS VSS gf180mcu_fd_sc_mcu9t5v0__endcap
X_18662_ _18662_/D _20066_/RN clkload65/I _18662_/Q VSS VSS VSS VSS gf180mcu_fd_sc_mcu9t5v0__dffrnq_1
XTAP_TAPCELL_ROW_4_1104 VSS VSS gf180mcu_fd_sc_mcu9t5v0__filltie
X_18593_ _18593_/D clkload63/I _18593_/Q VSS VSS VSS VSS gf180mcu_fd_sc_mcu9t5v0__dffq_1
X_17613_ input4/Z _18676_/Q _17617_/S _18676_/D VSS _17613_/VNW VSS VSS gf180mcu_fd_sc_mcu9t5v0__mux2_1
XPHY_EDGE_ROW_176_3_Right_291 VSS VSS gf180mcu_fd_sc_mcu9t5v0__endcap
X_14825_ _19575_/Q _09462_/I _14826_/B VSS _14827_/VNW VSS VSS gf180mcu_fd_sc_mcu9t5v0__nand2_1
X_17544_ _17692_/A1 _17733_/A1 _17580_/I1 VSS VSS VSS VSS gf180mcu_fd_sc_mcu9t5v0__nand2_1
Xrst_tree_leaf_6 rst_tree_mid_0/Z _20141_/RN VSS VSS VSS VSS gf180mcu_fd_sc_mcu9t5v0__clkbuf_16
XTAP_TAPCELL_ROW_64_2750 VSS VSS gf180mcu_fd_sc_mcu9t5v0__filltie
X_14756_ _14756_/A1 _14758_/A2 _14756_/Z VSS VSS VSS VSS gf180mcu_fd_sc_mcu9t5v0__xor2_1
Xeco15_sk2_0 eco15_sk2_0/I _18361_/CLK VSS VSS VSS VSS gf180mcu_fd_sc_mcu9t5v0__clkbuf_16
X_13707_ _13724_/B1 _14662_/A1 _13724_/C _13711_/A1 VSS VSS VSS VSS gf180mcu_fd_sc_mcu9t5v0__aoi21_1
X_11968_ _12336_/B _12005_/A2 _11969_/A2 VSS VSS VSS VSS gf180mcu_fd_sc_mcu9t5v0__nand2_1
XTAP_TAPCELL_ROW_231_5432 VSS VSS gf180mcu_fd_sc_mcu9t5v0__filltie
XTAP_TAPCELL_ROW_231_5421 VSS VSS gf180mcu_fd_sc_mcu9t5v0__filltie
X_10919_ _10919_/I0 _18998_/Q _18148_/S _18998_/D VSS VSS VSS VSS gf180mcu_fd_sc_mcu9t5v0__mux2_1
X_11899_ _11909_/A1 _11909_/A2 _11902_/A1 VSS VSS VSS VSS gf180mcu_fd_sc_mcu9t5v0__nor2_1
XTAP_TAPCELL_ROW_231_5410 VSS VSS gf180mcu_fd_sc_mcu9t5v0__filltie
X_19214_ _19214_/D _20046_/RN clkload25/I _19214_/Q VSS VSS VSS VSS gf180mcu_fd_sc_mcu9t5v0__dffrnq_1
XTAP_TAPCELL_ROW_60_2625 VSS VSS gf180mcu_fd_sc_mcu9t5v0__filltie
X_14687_ _19151_/Q _19117_/Q _14688_/B VSS _14687_/VNW VSS VSS gf180mcu_fd_sc_mcu9t5v0__nand2_1
XTAP_TAPCELL_ROW_60_2636 VSS VSS gf180mcu_fd_sc_mcu9t5v0__filltie
X_17475_ wire198/I _17475_/A2 _18584_/Q _17476_/A2 VSS VSS VSS VSS gf180mcu_fd_sc_mcu9t5v0__aoi21_1
X_16426_ _16426_/A1 _16809_/S _16426_/B _16427_/I0 VSS VSS VSS VSS gf180mcu_fd_sc_mcu9t5v0__oai21_4
X_13638_ _19747_/Q _13638_/A2 _13640_/A2 VSS VSS VSS VSS gf180mcu_fd_sc_mcu9t5v0__nor2_1
X_16357_ _19238_/Q _16167_/B _16881_/S _16357_/Z VSS VSS VSS VSS gf180mcu_fd_sc_mcu9t5v0__mux2_4
X_13569_ _19275_/Q _13497_/B _13572_/B VSS VSS VSS VSS gf180mcu_fd_sc_mcu9t5v0__nand2_1
X_19145_ _19145_/D _20041_/RN clkload11/I _19145_/Q VSS VSS VSS VSS gf180mcu_fd_sc_mcu9t5v0__dffrnq_1
XPHY_EDGE_ROW_240_Right_167 VSS VSS gf180mcu_fd_sc_mcu9t5v0__endcap
X_15308_ _15307_/Z _19738_/Q _15417_/S _19738_/D VSS VSS VSS VSS gf180mcu_fd_sc_mcu9t5v0__mux2_1
X_19076_ _19076_/D _20036_/RN clkload24/I _19076_/Q VSS VSS VSS VSS gf180mcu_fd_sc_mcu9t5v0__dffrnq_1
X_16288_ _16288_/A1 _16832_/A2 _16434_/B _16287_/Z _18214_/D VSS VSS VSS VSS gf180mcu_fd_sc_mcu9t5v0__aoi22_1
XTAP_TAPCELL_ROW_58_2565 VSS VSS gf180mcu_fd_sc_mcu9t5v0__filltie
X_18027_ _18027_/I0 _18912_/Q _18037_/S _18912_/D VSS VSS VSS VSS gf180mcu_fd_sc_mcu9t5v0__mux2_1
XTAP_TAPCELL_ROW_229_5372 VSS VSS gf180mcu_fd_sc_mcu9t5v0__filltie
XTAP_TAPCELL_ROW_229_5361 VSS VSS gf180mcu_fd_sc_mcu9t5v0__filltie
X_15239_ _15247_/B1 _15247_/B2 _15242_/B VSS VSS VSS VSS gf180mcu_fd_sc_mcu9t5v0__nor2_1
XTAP_TAPCELL_ROW_58_2576 VSS VSS gf180mcu_fd_sc_mcu9t5v0__filltie
XTAP_TAPCELL_ROW_58_2587 VSS VSS gf180mcu_fd_sc_mcu9t5v0__filltie
XTAP_TAPCELL_ROW_225_5258 VSS VSS gf180mcu_fd_sc_mcu9t5v0__filltie
XTAP_TAPCELL_ROW_225_5247 VSS VSS gf180mcu_fd_sc_mcu9t5v0__filltie
Xu_transform_scheduler_core.u_fft_scratch_sram.u_lo.g_pin_drive\[7\].u_data_driver
+ _10452_/ZN u_transform_scheduler_core.u_fft_scratch_sram.u_lo.u_sram/D[7] VSS VSS
+ VSS VSS gf180mcu_fd_sc_mcu9t5v0__buf_8
XTAP_TAPCELL_ROW_225_5269 VSS VSS gf180mcu_fd_sc_mcu9t5v0__filltie
X_19978_ _19978_/D _20042_/RN clkload66/I _19978_/Q VSS VSS VSS VSS gf180mcu_fd_sc_mcu9t5v0__dffrnq_1
X_09800_ _18841_/Q _17912_/A2 _09805_/B VSS VSS VSS VSS gf180mcu_fd_sc_mcu9t5v0__nand2_1
X_09731_ _20064_/Q _10821_/B _10823_/A2 _10826_/B VSS _10241_/VNW VSS VSS gf180mcu_fd_sc_mcu9t5v0__nand3_1
X_18929_ _18929_/D _20145_/RN clkload39/I _18929_/Q VSS VSS VSS VSS gf180mcu_fd_sc_mcu9t5v0__dffrnq_1
XPHY_EDGE_ROW_187_1_Right_771 VSS VSS gf180mcu_fd_sc_mcu9t5v0__endcap
XTAP_TAPCELL_ROW_238_5619 VSS VSS gf180mcu_fd_sc_mcu9t5v0__filltie
XTAP_TAPCELL_ROW_238_5608 VSS VSS gf180mcu_fd_sc_mcu9t5v0__filltie
X_09662_ _09662_/I0 _20001_/Q _09662_/S _20001_/D VSS VSS VSS VSS gf180mcu_fd_sc_mcu9t5v0__mux2_1
X_09593_ _15598_/S _20042_/D VSS _09593_/VNW VSS VSS gf180mcu_fd_sc_mcu9t5v0__clkinv_1
XTAP_TAPCELL_ROW_30_1794 VSS VSS gf180mcu_fd_sc_mcu9t5v0__filltie
XTAP_TAPCELL_ROW_313_7690 VSS VSS gf180mcu_fd_sc_mcu9t5v0__filltie
XTAP_TAPCELL_ROW_214_4962 VSS VSS gf180mcu_fd_sc_mcu9t5v0__filltie
XTAP_TAPCELL_ROW_214_4951 VSS VSS gf180mcu_fd_sc_mcu9t5v0__filltie
XTAP_TAPCELL_ROW_210_4848 VSS VSS gf180mcu_fd_sc_mcu9t5v0__filltie
XTAP_TAPCELL_ROW_210_4837 VSS VSS gf180mcu_fd_sc_mcu9t5v0__filltie
XTAP_TAPCELL_ROW_322_7937 VSS VSS gf180mcu_fd_sc_mcu9t5v0__filltie
XTAP_TAPCELL_ROW_322_7926 VSS VSS gf180mcu_fd_sc_mcu9t5v0__filltie
XTAP_TAPCELL_ROW_322_7915 VSS VSS gf180mcu_fd_sc_mcu9t5v0__filltie
XTAP_TAPCELL_ROW_210_4859 VSS VSS gf180mcu_fd_sc_mcu9t5v0__filltie
XTAP_TAPCELL_ROW_113_4094 VSS VSS gf180mcu_fd_sc_mcu9t5v0__filltie
XTAP_TAPCELL_ROW_113_4083 VSS VSS gf180mcu_fd_sc_mcu9t5v0__filltie
XTAP_TAPCELL_ROW_299_7284 VSS VSS gf180mcu_fd_sc_mcu9t5v0__filltie
XTAP_TAPCELL_ROW_299_7295 VSS VSS gf180mcu_fd_sc_mcu9t5v0__filltie
X_20118_ _20118_/D clkload75/I _20118_/Q VSS VSS VSS VSS gf180mcu_fd_sc_mcu9t5v0__dffq_1
XTAP_TAPCELL_ROW_126_4455 VSS VSS gf180mcu_fd_sc_mcu9t5v0__filltie
XTAP_TAPCELL_ROW_126_4444 VSS VSS gf180mcu_fd_sc_mcu9t5v0__filltie
X_09929_ _09929_/I _09930_/C VSS VSS VSS VSS gf180mcu_fd_sc_mcu9t5v0__clkinv_1
XPHY_EDGE_ROW_130_Right_130 VSS VSS gf180mcu_fd_sc_mcu9t5v0__endcap
X_20049_ _20049_/D _20049_/RN _20049_/CLK _20049_/Q VSS VSS VSS VSS gf180mcu_fd_sc_mcu9t5v0__dffrnq_1
X_12940_ _12940_/I0 _19225_/Q _13419_/B _19225_/D VSS VSS VSS VSS gf180mcu_fd_sc_mcu9t5v0__mux2_1
X_12871_ _19738_/Q _19803_/Q _13244_/B _12871_/Z VSS VSS VSS VSS gf180mcu_fd_sc_mcu9t5v0__mux2_1
X_11822_ _18320_/Q _12324_/B _11822_/B _12320_/C _11829_/A2 VSS _11822_/VNW VSS VSS
+ gf180mcu_fd_sc_mcu9t5v0__oai211_1
X_14610_ _19190_/Q _19488_/Q _14715_/S _19488_/D VSS _14610_/VNW VSS VSS gf180mcu_fd_sc_mcu9t5v0__mux2_1
X_15590_ _18025_/I0 _15596_/A2 _15591_/B2 VSS _15597_/VNW VSS VSS gf180mcu_fd_sc_mcu9t5v0__nor2_1
X_11753_ _18253_/Q _12315_/S _11755_/B1 VSS VSS VSS VSS gf180mcu_fd_sc_mcu9t5v0__nand2_1
XPHY_EDGE_ROW_182_2_Right_913 VSS VSS gf180mcu_fd_sc_mcu9t5v0__endcap
X_14541_ _14542_/A1 _19133_/Q _14548_/A2 VSS _14541_/VNW VSS VSS gf180mcu_fd_sc_mcu9t5v0__nor2_1
X_17260_ _18529_/Q _18513_/Q _17260_/S _17260_/Z VSS VSS VSS VSS gf180mcu_fd_sc_mcu9t5v0__mux2_1
X_11684_ _18170_/Q _12181_/A2 _11686_/A1 VSS VSS VSS VSS gf180mcu_fd_sc_mcu9t5v0__nand2_1
X_10704_ _18555_/Q _10796_/A2 _17416_/I0 _17075_/A1 wire282/I _10719_/A1 VSS VSS VSS
+ VSS gf180mcu_fd_sc_mcu9t5v0__aoi221_4
XTAP_TAPCELL_ROW_77_3108 VSS VSS gf180mcu_fd_sc_mcu9t5v0__filltie
X_14472_ _14473_/B _14714_/A1 VSS VSS VSS VSS gf180mcu_fd_sc_mcu9t5v0__clkinv_1
X_16211_ _16210_/Z _18190_/Q _16784_/S _18190_/D VSS VSS VSS VSS gf180mcu_fd_sc_mcu9t5v0__mux2_1
X_17191_ _17195_/A1 _18382_/Q _17194_/A2 VSS VSS VSS VSS gf180mcu_fd_sc_mcu9t5v0__nor2_1
X_10635_ _17358_/A1 _18200_/Q _10638_/A2 VSS _10635_/VNW VSS VSS gf180mcu_fd_sc_mcu9t5v0__nor2_1
X_13423_ _13435_/A2 _19811_/Q _13441_/A2 VSS VSS VSS VSS gf180mcu_fd_sc_mcu9t5v0__nand2_1
X_16142_ _16668_/A1 _16686_/A3 _16730_/C _16142_/C _16144_/B VSS VSS VSS VSS gf180mcu_fd_sc_mcu9t5v0__aoi211_1
X_13354_ _13354_/A1 _13354_/A2 _13353_/B _13355_/A2 VSS _13362_/VNW VSS VSS gf180mcu_fd_sc_mcu9t5v0__nor3_1
XTAP_TAPCELL_ROW_40_2090 VSS VSS gf180mcu_fd_sc_mcu9t5v0__filltie
XTAP_TAPCELL_ROW_284_6885 VSS VSS gf180mcu_fd_sc_mcu9t5v0__filltie
X_10566_ _20105_/Q _17407_/C _17408_/B _10567_/B VSS VSS VSS VSS gf180mcu_fd_sc_mcu9t5v0__aoi21_1
XTAP_TAPCELL_ROW_284_6874 VSS VSS gf180mcu_fd_sc_mcu9t5v0__filltie
X_12305_ _12237_/B _12306_/A2 _12305_/B _12330_/A2 VSS _12305_/VNW VSS VSS gf180mcu_fd_sc_mcu9t5v0__aoi21_4
X_16073_ _18163_/Q _16073_/I1 _16670_/S _18163_/D VSS _16073_/VNW VSS VSS gf180mcu_fd_sc_mcu9t5v0__mux2_1
X_10497_ _17407_/C _10497_/A2 _10497_/B wire168/Z _10500_/B1 VSS VSS VSS VSS gf180mcu_fd_sc_mcu9t5v0__oai211_1
X_13285_ _13285_/A1 _13285_/A2 _13286_/I0 VSS VSS VSS VSS gf180mcu_fd_sc_mcu9t5v0__nand2_1
X_19901_ _19901_/D _20029_/RN clkload40/I _19901_/Q VSS VSS VSS VSS gf180mcu_fd_sc_mcu9t5v0__dffrnq_1
X_12236_ _18917_/Q _12257_/B _12254_/A2 VSS _15228_/VNW VSS VSS gf180mcu_fd_sc_mcu9t5v0__xnor2_1
X_15024_ _19626_/Q _15024_/I1 _15163_/S _19626_/D VSS VSS VSS VSS gf180mcu_fd_sc_mcu9t5v0__mux2_1
X_12167_ wire208/Z _12195_/A1 _12166_/Z _12169_/A1 VSS VSS VSS VSS gf180mcu_fd_sc_mcu9t5v0__nand3_1
X_19832_ _19832_/D _19960_/RN clkload51/I _19832_/Q VSS VSS VSS VSS gf180mcu_fd_sc_mcu9t5v0__dffrnq_1
XTAP_TAPCELL_ROW_53_2440 VSS VSS gf180mcu_fd_sc_mcu9t5v0__filltie
XTAP_TAPCELL_ROW_53_2451 VSS VSS gf180mcu_fd_sc_mcu9t5v0__filltie
XTAP_TAPCELL_ROW_220_5122 VSS VSS gf180mcu_fd_sc_mcu9t5v0__filltie
X_11118_ _18566_/Q _18170_/Q _11428_/B _11117_/Z wire283/I _11120_/A3 VSS VSS VSS
+ VSS gf180mcu_fd_sc_mcu9t5v0__aoi221_1
XTAP_TAPCELL_ROW_220_5111 VSS VSS gf180mcu_fd_sc_mcu9t5v0__filltie
X_16975_ _19250_/Q _16614_/B _16991_/S _16975_/Z VSS _16975_/VNW VSS VSS gf180mcu_fd_sc_mcu9t5v0__mux2_1
XTAP_TAPCELL_ROW_220_5133 VSS VSS gf180mcu_fd_sc_mcu9t5v0__filltie
X_12098_ _12098_/A1 _12098_/A2 wire213/Z _12099_/B VSS VSS VSS VSS gf180mcu_fd_sc_mcu9t5v0__aoi21_2
X_19763_ _19763_/D _20019_/RN clkload41/I _19763_/Q VSS VSS VSS VSS gf180mcu_fd_sc_mcu9t5v0__dffrnq_1
XTAP_TAPCELL_ROW_109_3974 VSS VSS gf180mcu_fd_sc_mcu9t5v0__filltie
X_15926_ _20135_/Q _19256_/Q _15928_/S _20135_/D VSS VSS VSS VSS gf180mcu_fd_sc_mcu9t5v0__mux2_1
X_18714_ _18714_/D clkload53/I _18714_/Q VSS VSS VSS VSS gf180mcu_fd_sc_mcu9t5v0__dffq_1
XTAP_TAPCELL_ROW_109_3985 VSS VSS gf180mcu_fd_sc_mcu9t5v0__filltie
X_11049_ _18035_/I0 _19050_/Q _11051_/S _19050_/D VSS VSS VSS VSS gf180mcu_fd_sc_mcu9t5v0__mux2_1
X_19694_ _19694_/D _20142_/RN clkload29/I _19694_/Q VSS VSS VSS VSS gf180mcu_fd_sc_mcu9t5v0__dffrnq_1
XTAP_TAPCELL_ROW_66_2801 VSS VSS gf180mcu_fd_sc_mcu9t5v0__filltie
Xclkbuf_leaf_4_clk_regs clkload0/I clkload20/I VSS VSS VSS VSS gf180mcu_fd_sc_mcu9t5v0__clkbuf_8
Xinput7 din[6] input7/Z VSS VSS VSS VSS gf180mcu_fd_sc_mcu9t5v0__clkbuf_2
X_15857_ _20057_/Q _15857_/A2 _15933_/A2 VSS VSS VSS VSS gf180mcu_fd_sc_mcu9t5v0__nor2_1
X_18645_ _18645_/D _20049_/RN clkload48/I _18645_/Q VSS VSS VSS VSS gf180mcu_fd_sc_mcu9t5v0__dffrnq_1
XPHY_EDGE_ROW_177_3_Right_292 VSS VSS gf180mcu_fd_sc_mcu9t5v0__endcap
X_14808_ _19401_/Q _19338_/Q _14811_/A1 _14809_/I1 VSS VSS VSS VSS gf180mcu_fd_sc_mcu9t5v0__xnor3_1
XTAP_TAPCELL_ROW_218_5073 VSS VSS gf180mcu_fd_sc_mcu9t5v0__filltie
XTAP_TAPCELL_ROW_218_5062 VSS VSS gf180mcu_fd_sc_mcu9t5v0__filltie
X_15788_ _18023_/I0 _19958_/Q _15802_/S _19958_/D VSS VSS VSS VSS gf180mcu_fd_sc_mcu9t5v0__mux2_1
XTAP_TAPCELL_ROW_47_2266 VSS VSS gf180mcu_fd_sc_mcu9t5v0__filltie
XTAP_TAPCELL_ROW_47_2277 VSS VSS gf180mcu_fd_sc_mcu9t5v0__filltie
XTAP_TAPCELL_ROW_47_2288 VSS VSS gf180mcu_fd_sc_mcu9t5v0__filltie
X_18576_ _18576_/D _20140_/RN clkload28/I _18576_/Q VSS VSS VSS VSS gf180mcu_fd_sc_mcu9t5v0__dffrnq_1
X_17527_ input6/Z _18632_/Q _17529_/S _18632_/D VSS VSS VSS VSS gf180mcu_fd_sc_mcu9t5v0__mux2_1
X_14739_ _14739_/A1 _14741_/A2 _14739_/Z VSS _14740_/VNW VSS VSS gf180mcu_fd_sc_mcu9t5v0__xor2_1
X_17458_ _17462_/A1 _17458_/A2 _18575_/D VSS VSS VSS VSS gf180mcu_fd_sc_mcu9t5v0__nor2_1
X_16409_ _16409_/A1 wire33/I _16408_/Z _16409_/B2 _18266_/D VSS VSS VSS VSS gf180mcu_fd_sc_mcu9t5v0__aoi22_1
XPHY_EDGE_ROW_25_Left_349 VSS VSS gf180mcu_fd_sc_mcu9t5v0__endcap
X_17389_ _20122_/Q wire168/Z _17409_/B _17389_/C _17391_/A2 VSS VSS VSS VSS gf180mcu_fd_sc_mcu9t5v0__oai211_1
X_19128_ _19128_/D _19960_/RN clkload10/I _19128_/Q VSS VSS VSS VSS gf180mcu_fd_sc_mcu9t5v0__dffrnq_1
XTAP_TAPCELL_ROW_227_5309 VSS VSS gf180mcu_fd_sc_mcu9t5v0__filltie
X_19059_ _19059_/D _20019_/RN clkload33/I _19059_/Q VSS VSS VSS VSS gf180mcu_fd_sc_mcu9t5v0__dffrnq_1
XTAP_TAPCELL_ROW_302_7380 VSS VSS gf180mcu_fd_sc_mcu9t5v0__filltie
XPHY_EDGE_ROW_159_3_Left_817 VSS VSS gf180mcu_fd_sc_mcu9t5v0__endcap
XPHY_EDGE_ROW_136_1_Right_793 VSS VSS gf180mcu_fd_sc_mcu9t5v0__endcap
XPHY_EDGE_ROW_34_Left_358 VSS VSS gf180mcu_fd_sc_mcu9t5v0__endcap
XTAP_TAPCELL_ROW_36_1970 VSS VSS gf180mcu_fd_sc_mcu9t5v0__filltie
XTAP_TAPCELL_ROW_36_1981 VSS VSS gf180mcu_fd_sc_mcu9t5v0__filltie
XTAP_TAPCELL_ROW_290_7045 VSS VSS gf180mcu_fd_sc_mcu9t5v0__filltie
XTAP_TAPCELL_ROW_290_7034 VSS VSS gf180mcu_fd_sc_mcu9t5v0__filltie
X_09714_ _10820_/B2 _10819_/A2 _10821_/A2 VSS VSS VSS VSS gf180mcu_fd_sc_mcu9t5v0__nor2_1
XPHY_EDGE_ROW_188_1_Right_772 VSS VSS gf180mcu_fd_sc_mcu9t5v0__endcap
XTAP_TAPCELL_ROW_32_1856 VSS VSS gf180mcu_fd_sc_mcu9t5v0__filltie
XTAP_TAPCELL_ROW_32_1867 VSS VSS gf180mcu_fd_sc_mcu9t5v0__filltie
XTAP_TAPCELL_ROW_315_7741 VSS VSS gf180mcu_fd_sc_mcu9t5v0__filltie
XTAP_TAPCELL_ROW_290_7056 VSS VSS gf180mcu_fd_sc_mcu9t5v0__filltie
XTAP_TAPCELL_ROW_315_7730 VSS VSS gf180mcu_fd_sc_mcu9t5v0__filltie
X_09645_ wire301/Z _09065_/I _17599_/A1 VSS _09645_/VNW VSS VSS gf180mcu_fd_sc_mcu9t5v0__nand2_1
XTAP_TAPCELL_ROW_311_7627 VSS VSS gf180mcu_fd_sc_mcu9t5v0__filltie
XTAP_TAPCELL_ROW_311_7616 VSS VSS gf180mcu_fd_sc_mcu9t5v0__filltie
XPHY_EDGE_ROW_155_1_Left_478 VSS VSS gf180mcu_fd_sc_mcu9t5v0__endcap
X_09576_ _09768_/A2 _09832_/A3 _11016_/A2 VSS _09576_/VNW VSS VSS gf180mcu_fd_sc_mcu9t5v0__nor2_1
Xu_transform_scheduler_core.u_fft_scratch_sram.u_lo.g_pin_drive\[2\].u_addr_driver
+ _10696_/ZN u_transform_scheduler_core.u_fft_scratch_sram.u_lo.u_sram/A[2] VSS VSS
+ VSS VSS gf180mcu_fd_sc_mcu9t5v0__buf_8
XPHY_EDGE_ROW_43_Left_367 VSS VSS gf180mcu_fd_sc_mcu9t5v0__endcap
XTAP_TAPCELL_ROW_115_4145 VSS VSS gf180mcu_fd_sc_mcu9t5v0__filltie
XTAP_TAPCELL_ROW_115_4134 VSS VSS gf180mcu_fd_sc_mcu9t5v0__filltie
XTAP_TAPCELL_ROW_309_7578 VSS VSS gf180mcu_fd_sc_mcu9t5v0__filltie
XTAP_TAPCELL_ROW_309_7567 VSS VSS gf180mcu_fd_sc_mcu9t5v0__filltie
XTAP_TAPCELL_ROW_309_7556 VSS VSS gf180mcu_fd_sc_mcu9t5v0__filltie
X_10420_ _10654_/A2 _10420_/A2 _10420_/A3 _10421_/B VSS _10420_/VNW VSS VSS gf180mcu_fd_sc_mcu9t5v0__nand3_1
XTAP_TAPCELL_ROW_115_4156 VSS VSS gf180mcu_fd_sc_mcu9t5v0__filltie
Xclkbuf_leaf_74_clk_regs clkload0/I clkload28/I VSS VSS VSS VSS gf180mcu_fd_sc_mcu9t5v0__clkbuf_8
X_10351_ _17260_/S _18333_/Q _10351_/B _10353_/A2 VSS VSS VSS VSS gf180mcu_fd_sc_mcu9t5v0__oai21_1
X_10282_ _18956_/Q wire165/Z _10652_/B1 _18972_/Q _10283_/A3 VSS VSS VSS VSS gf180mcu_fd_sc_mcu9t5v0__aoi22_1
XTAP_TAPCELL_ROW_128_4506 VSS VSS gf180mcu_fd_sc_mcu9t5v0__filltie
X_13070_ _13073_/A1 _13529_/A2 _13075_/A1 VSS _13070_/VNW VSS VSS gf180mcu_fd_sc_mcu9t5v0__nor2_1
Xhold_dlya_din0 input1/Z _09065_/I VSS VSS VSS VSS gf180mcu_fd_sc_mcu9t5v0__dlyb_4
X_12021_ _18425_/Q _12181_/A2 _12025_/A1 VSS VSS VSS VSS gf180mcu_fd_sc_mcu9t5v0__nand2_1
XPHY_EDGE_ROW_52_Left_376 VSS VSS gf180mcu_fd_sc_mcu9t5v0__endcap
X_16760_ _16759_/Z _18379_/Q _16784_/S _18379_/D VSS _16760_/VNW VSS VSS gf180mcu_fd_sc_mcu9t5v0__mux2_1
X_13972_ _13973_/A2 _13973_/A3 _13972_/Z VSS _14045_/VNW VSS VSS gf180mcu_fd_sc_mcu9t5v0__and2_1
X_15711_ _19919_/Q _15726_/S _15712_/B VSS VSS VSS VSS gf180mcu_fd_sc_mcu9t5v0__nand2_1
X_12923_ _19745_/Q _19810_/Q _12948_/S _12923_/Z VSS _12931_/VNW VSS VSS gf180mcu_fd_sc_mcu9t5v0__mux2_1
XTAP_TAPCELL_ROW_273_6586 VSS VSS gf180mcu_fd_sc_mcu9t5v0__filltie
XTAP_TAPCELL_ROW_273_6575 VSS VSS gf180mcu_fd_sc_mcu9t5v0__filltie
X_18430_ _18430_/D _18431_/CLK _18430_/Q VSS VSS VSS VSS gf180mcu_fd_sc_mcu9t5v0__dffq_4
X_16691_ _19279_/Q _16695_/B _16692_/C VSS VSS VSS VSS gf180mcu_fd_sc_mcu9t5v0__nor2_1
X_15642_ _19899_/Q _15640_/B _15642_/Z VSS VSS VSS VSS gf180mcu_fd_sc_mcu9t5v0__xor2_1
XTAP_TAPCELL_ROW_100_3735 VSS VSS gf180mcu_fd_sc_mcu9t5v0__filltie
X_12854_ _19736_/Q _19801_/Q _13244_/B _12854_/Z VSS _12858_/VNW VSS VSS gf180mcu_fd_sc_mcu9t5v0__mux2_1
XTAP_TAPCELL_ROW_100_3724 VSS VSS gf180mcu_fd_sc_mcu9t5v0__filltie
X_11805_ _12347_/C _11800_/Z _11805_/B _12348_/C _11806_/A2 VSS _11805_/VNW VSS VSS
+ gf180mcu_fd_sc_mcu9t5v0__oai211_1
X_18361_ _18361_/D _18361_/CLK _18361_/Q VSS VSS VSS VSS gf180mcu_fd_sc_mcu9t5v0__dffq_4
XTAP_TAPCELL_ROW_100_3746 VSS VSS gf180mcu_fd_sc_mcu9t5v0__filltie
X_15573_ _18025_/I0 _18022_/I0 _18023_/I0 _15572_/Z _15576_/A1 VSS _15573_/VNW VSS
+ VSS gf180mcu_fd_sc_mcu9t5v0__nand4_1
X_12785_ _12784_/Z _19202_/Q _13320_/B _19202_/D VSS VSS VSS VSS gf180mcu_fd_sc_mcu9t5v0__mux2_1
XPHY_EDGE_ROW_61_Left_385 VSS VSS gf180mcu_fd_sc_mcu9t5v0__endcap
X_17312_ _17260_/S _18404_/Q _17315_/A2 VSS _17315_/VNW VSS VSS gf180mcu_fd_sc_mcu9t5v0__nor2_1
X_18292_ _18292_/D clkload80/I _18292_/Q VSS VSS VSS VSS gf180mcu_fd_sc_mcu9t5v0__dffq_1
XTAP_TAPCELL_ROW_286_6925 VSS VSS gf180mcu_fd_sc_mcu9t5v0__filltie
X_11736_ _12092_/B _11732_/Z _11736_/B _11736_/C _11737_/B VSS VSS VSS VSS gf180mcu_fd_sc_mcu9t5v0__aoi211_1
XPHY_EDGE_ROW_183_2_Right_914 VSS VSS gf180mcu_fd_sc_mcu9t5v0__endcap
XTAP_TAPCELL_ROW_42_2130 VSS VSS gf180mcu_fd_sc_mcu9t5v0__filltie
XTAP_TAPCELL_ROW_42_2141 VSS VSS gf180mcu_fd_sc_mcu9t5v0__filltie
X_14524_ _19166_/Q _19132_/Q _14525_/A2 VSS VSS VSS VSS gf180mcu_fd_sc_mcu9t5v0__nor2_1
XTAP_TAPCELL_ROW_286_6947 VSS VSS gf180mcu_fd_sc_mcu9t5v0__filltie
XTAP_TAPCELL_ROW_286_6936 VSS VSS gf180mcu_fd_sc_mcu9t5v0__filltie
X_17243_ _17243_/A1 _17243_/A2 _17243_/B1 _17243_/B2 _17407_/C _17244_/B2 VSS VSS
+ VSS VSS gf180mcu_fd_sc_mcu9t5v0__aoi221_1
X_11667_ _11654_/C _12635_/B _11667_/B1 _12652_/A2 _12664_/C _11668_/A3 VSS VSS VSS
+ VSS gf180mcu_fd_sc_mcu9t5v0__oai221_1
X_14455_ _14455_/A1 _19122_/Q _14455_/B _14456_/B2 VSS VSS VSS VSS gf180mcu_fd_sc_mcu9t5v0__oai21_1
X_17174_ _10514_/B _17173_/Z _17176_/B1 VSS _17174_/VNW VSS VSS gf180mcu_fd_sc_mcu9t5v0__nand2_1
X_10618_ _10643_/A1 _10618_/A2 _10618_/B1 _10643_/B2 _10618_/C1 _19828_/Q _10619_/A2
+ VSS _12473_/VNW VSS VSS gf180mcu_fd_sc_mcu9t5v0__aoi222_1
X_13406_ _19744_/Q _13409_/A2 _13407_/I VSS _13407_/VNW VSS VSS gf180mcu_fd_sc_mcu9t5v0__nand2_1
X_14386_ _19448_/Q _14715_/S _14387_/A2 VSS VSS VSS VSS gf180mcu_fd_sc_mcu9t5v0__nand2_1
X_11598_ _17900_/B2 _11581_/Z _11600_/C _11639_/A2 VSS _11598_/VNW VSS VSS gf180mcu_fd_sc_mcu9t5v0__oai21_1
X_10549_ _18598_/Q _17306_/C _10549_/B1 _10549_/B2 _10648_/C _10550_/A3 VSS VSS VSS
+ VSS gf180mcu_fd_sc_mcu9t5v0__aoi221_1
X_16125_ _16722_/A1 _16125_/A2 _16125_/A3 _16125_/B _18170_/D VSS VSS VSS VSS gf180mcu_fd_sc_mcu9t5v0__oai31_4
XTAP_TAPCELL_ROW_55_2502 VSS VSS gf180mcu_fd_sc_mcu9t5v0__filltie
X_13337_ _13337_/A1 _13337_/A2 _13337_/B _13339_/A2 VSS _13337_/VNW VSS VSS gf180mcu_fd_sc_mcu9t5v0__aoi21_1
X_16056_ _19268_/Q _16675_/A1 _16060_/B VSS VSS VSS VSS gf180mcu_fd_sc_mcu9t5v0__nand2_1
Xrst_tree_leaf_22 rst_tree_mid_2/Z _20061_/RN VSS VSS VSS VSS gf180mcu_fd_sc_mcu9t5v0__clkbuf_16
Xrst_tree_leaf_11 rst_tree_mid_1/Z _20072_/RN VSS VSS VSS VSS gf180mcu_fd_sc_mcu9t5v0__clkbuf_16
XPHY_EDGE_ROW_70_Left_394 VSS VSS gf180mcu_fd_sc_mcu9t5v0__endcap
Xrst_tree_leaf_44 rst_tree_mid_5/Z _20039_/RN VSS VSS VSS VSS gf180mcu_fd_sc_mcu9t5v0__clkbuf_16
Xrst_tree_leaf_33 rst_tree_mid_4/Z _20050_/RN VSS VSS VSS VSS gf180mcu_fd_sc_mcu9t5v0__clkbuf_16
Xrst_tree_leaf_55 rst_tree_mid_6/Z _20028_/RN VSS VSS VSS VSS gf180mcu_fd_sc_mcu9t5v0__clkbuf_16
X_15007_ _19377_/Q _19434_/Q _15008_/B VSS VSS VSS VSS gf180mcu_fd_sc_mcu9t5v0__xor2_1
X_13268_ _13271_/A1 _13271_/A2 _13272_/A1 VSS _13271_/VNW VSS VSS gf180mcu_fd_sc_mcu9t5v0__nor2_1
X_12219_ _12237_/B _12237_/A1 _12227_/A1 VSS _12219_/VNW VSS VSS gf180mcu_fd_sc_mcu9t5v0__nand2_1
X_13199_ _13497_/A1 _13199_/A2 _13497_/B _13200_/B2 VSS _13226_/VNW VSS VSS gf180mcu_fd_sc_mcu9t5v0__aoi21_1
X_19815_ _19815_/D _20071_/RN clkload43/I _19815_/Q VSS VSS VSS VSS gf180mcu_fd_sc_mcu9t5v0__dffrnq_1
X_16958_ _16958_/I0 _18470_/Q _16958_/S _18470_/D VSS VSS VSS VSS gf180mcu_fd_sc_mcu9t5v0__mux2_4
XTAP_TAPCELL_ROW_139_3_8010 VSS VSS gf180mcu_fd_sc_mcu9t5v0__filltie
X_19746_ _19746_/D _20066_/RN clkload39/I _19746_/Q VSS VSS VSS VSS gf180mcu_fd_sc_mcu9t5v0__dffrnq_1
X_15909_ _20118_/Q _19254_/Q wire79/Z _20118_/D VSS VSS VSS VSS gf180mcu_fd_sc_mcu9t5v0__mux2_1
Xu_transform_scheduler_core.u_fft_scratch_sram.u_hi.g_pin_drive\[4\].u_addr_driver
+ _10743_/ZN u_transform_scheduler_core.u_fft_scratch_sram.u_hi.u_sram/A[4] VSS VSS
+ VSS VSS gf180mcu_fd_sc_mcu9t5v0__buf_8
XTAP_TAPCELL_ROW_49_2317 VSS VSS gf180mcu_fd_sc_mcu9t5v0__filltie
XTAP_TAPCELL_ROW_49_2328 VSS VSS gf180mcu_fd_sc_mcu9t5v0__filltie
XTAP_TAPCELL_ROW_49_2339 VSS VSS gf180mcu_fd_sc_mcu9t5v0__filltie
X_16889_ _19256_/Q _16654_/B _16893_/S _16889_/Z VSS _17019_/VNW VSS VSS gf180mcu_fd_sc_mcu9t5v0__mux2_1
X_19677_ _19677_/D _20061_/RN _19680_/CLK _19677_/Q VSS VSS VSS VSS gf180mcu_fd_sc_mcu9t5v0__dffrnq_1
X_09430_ _09887_/A1 _18692_/Q _18754_/Q _09430_/Z VSS VSS VSS VSS gf180mcu_fd_sc_mcu9t5v0__and3_4
X_18628_ _18628_/D _09246_/I clkload52/I _18628_/Q VSS VSS VSS VSS gf180mcu_fd_sc_mcu9t5v0__dffrnq_1
X_09361_ _18299_/Q _12376_/A1 VSS VSS VSS VSS gf180mcu_fd_sc_mcu9t5v0__clkinv_1
XPHY_EDGE_ROW_178_3_Right_293 VSS VSS gf180mcu_fd_sc_mcu9t5v0__endcap
X_18559_ _18559_/D _20059_/RN clkload22/I _18559_/Q VSS VSS VSS VSS gf180mcu_fd_sc_mcu9t5v0__dffrnq_1
X_09292_ _19220_/Q _16627_/A1 VSS VSS VSS VSS gf180mcu_fd_sc_mcu9t5v0__clkinv_1
XANTENNA_23 output18/I VSS VSS VSS VSS gf180mcu_fd_sc_mcu9t5v0__antenna
XANTENNA_12 _11435_/B2 VSS VSS VSS VSS gf180mcu_fd_sc_mcu9t5v0__antenna
XTAP_TAPCELL_ROW_25_1660 VSS VSS gf180mcu_fd_sc_mcu9t5v0__filltie
XTAP_TAPCELL_ROW_25_1671 VSS VSS gf180mcu_fd_sc_mcu9t5v0__filltie
XTAP_TAPCELL_ROW_25_1682 VSS VSS gf180mcu_fd_sc_mcu9t5v0__filltie
XTAP_TAPCELL_ROW_304_7442 VSS VSS gf180mcu_fd_sc_mcu9t5v0__filltie
XTAP_TAPCELL_ROW_304_7431 VSS VSS gf180mcu_fd_sc_mcu9t5v0__filltie
XTAP_TAPCELL_ROW_304_7420 VSS VSS gf180mcu_fd_sc_mcu9t5v0__filltie
XTAP_TAPCELL_ROW_110_4020 VSS VSS gf180mcu_fd_sc_mcu9t5v0__filltie
XTAP_TAPCELL_ROW_21_1557 VSS VSS gf180mcu_fd_sc_mcu9t5v0__filltie
XTAP_TAPCELL_ROW_21_1568 VSS VSS gf180mcu_fd_sc_mcu9t5v0__filltie
XTAP_TAPCELL_ROW_296_7221 VSS VSS gf180mcu_fd_sc_mcu9t5v0__filltie
XTAP_TAPCELL_ROW_300_7328 VSS VSS gf180mcu_fd_sc_mcu9t5v0__filltie
XTAP_TAPCELL_ROW_296_7210 VSS VSS gf180mcu_fd_sc_mcu9t5v0__filltie
XTAP_TAPCELL_ROW_300_7317 VSS VSS gf180mcu_fd_sc_mcu9t5v0__filltie
XPHY_EDGE_ROW_169_2_Left_681 VSS VSS gf180mcu_fd_sc_mcu9t5v0__endcap
XTAP_TAPCELL_ROW_34_1907 VSS VSS gf180mcu_fd_sc_mcu9t5v0__filltie
XTAP_TAPCELL_ROW_34_1918 VSS VSS gf180mcu_fd_sc_mcu9t5v0__filltie
XTAP_TAPCELL_ROW_292_7107 VSS VSS gf180mcu_fd_sc_mcu9t5v0__filltie
XTAP_TAPCELL_ROW_19_1497 VSS VSS gf180mcu_fd_sc_mcu9t5v0__filltie
XTAP_TAPCELL_ROW_34_1929 VSS VSS gf180mcu_fd_sc_mcu9t5v0__filltie
Xmax_cap25 _16496_/S _17026_/S VSS VSS VSS VSS gf180mcu_fd_sc_mcu9t5v0__buf_4
Xmax_cap36 _16910_/S _16924_/S VSS VSS VSS VSS gf180mcu_fd_sc_mcu9t5v0__buf_4
XPHY_EDGE_ROW_189_1_Right_773 VSS VSS gf180mcu_fd_sc_mcu9t5v0__endcap
Xmax_cap69 _16477_/A2 _16750_/A2 VSS VSS VSS VSS gf180mcu_fd_sc_mcu9t5v0__clkbuf_16
Xmax_cap58 _16798_/S _16828_/S VSS VSS VSS VSS gf180mcu_fd_sc_mcu9t5v0__clkbuf_8
X_09628_ input4/Z _09635_/A2 _09675_/A1 VSS _09723_/VNW VSS VSS gf180mcu_fd_sc_mcu9t5v0__nand2_1
XTAP_TAPCELL_ROW_176_1_4758 VSS VSS gf180mcu_fd_sc_mcu9t5v0__filltie
X_09559_ _20028_/Q _20031_/Q _09951_/A2 VSS VSS VSS VSS gf180mcu_fd_sc_mcu9t5v0__nor2_1
XTAP_TAPCELL_ROW_165_3_8100 VSS VSS gf180mcu_fd_sc_mcu9t5v0__filltie
XTAP_TAPCELL_ROW_117_4207 VSS VSS gf180mcu_fd_sc_mcu9t5v0__filltie
X_12570_ wire175/Z _12570_/A2 _12618_/B _12572_/A3 VSS _12570_/VNW VSS VSS gf180mcu_fd_sc_mcu9t5v0__aoi21_1
X_11521_ _11521_/A1 _11521_/A2 _11521_/B _11521_/C _11523_/B VSS _11521_/VNW VSS VSS
+ gf180mcu_fd_sc_mcu9t5v0__oai211_1
Xwire213 wire213/I wire213/Z VSS VSS VSS VSS gf180mcu_fd_sc_mcu9t5v0__buf_8
XTAP_TAPCELL_ROW_281_6811 VSS VSS gf180mcu_fd_sc_mcu9t5v0__filltie
XTAP_TAPCELL_ROW_281_6800 VSS VSS gf180mcu_fd_sc_mcu9t5v0__filltie
X_11452_ _18402_/Q _11509_/A2 _11453_/A3 VSS VSS VSS VSS gf180mcu_fd_sc_mcu9t5v0__nand2_1
X_14240_ _14240_/A1 _14240_/A2 _14240_/B _14259_/A1 VSS _14240_/VNW VSS VSS gf180mcu_fd_sc_mcu9t5v0__aoi21_1
Xwire279 wire279/I wire279/Z VSS VSS VSS VSS gf180mcu_fd_sc_mcu9t5v0__clkbuf_2
XTAP_TAPCELL_ROW_266_6390 VSS VSS gf180mcu_fd_sc_mcu9t5v0__filltie
X_10403_ _18223_/Q _17282_/A2 _17282_/B1 _18239_/Q _10404_/B VSS VSS VSS VSS gf180mcu_fd_sc_mcu9t5v0__aoi22_1
XTAP_TAPCELL_ROW_95_3594 VSS VSS gf180mcu_fd_sc_mcu9t5v0__filltie
X_11383_ _19094_/Q _11423_/A1 _11395_/B VSS _11383_/VNW VSS VSS gf180mcu_fd_sc_mcu9t5v0__nand2_1
X_14171_ _13772_/Z _19326_/Q _14266_/S _19326_/D VSS VSS VSS VSS gf180mcu_fd_sc_mcu9t5v0__mux2_1
XTAP_TAPCELL_ROW_95_3583 VSS VSS gf180mcu_fd_sc_mcu9t5v0__filltie
XTAP_TAPCELL_ROW_262_6265 VSS VSS gf180mcu_fd_sc_mcu9t5v0__filltie
X_10334_ _18540_/Q wire81/Z wire282/Z _10340_/A2 VSS VSS VSS VSS gf180mcu_fd_sc_mcu9t5v0__aoi21_1
XTAP_TAPCELL_ROW_145_3_8031 VSS VSS gf180mcu_fd_sc_mcu9t5v0__filltie
X_13122_ _13124_/A1 _13124_/A2 _13540_/B _13140_/A2 VSS _13122_/VNW VSS VSS gf180mcu_fd_sc_mcu9t5v0__oai21_1
XTAP_TAPCELL_ROW_262_6287 VSS VSS gf180mcu_fd_sc_mcu9t5v0__filltie
XTAP_TAPCELL_ROW_262_6276 VSS VSS gf180mcu_fd_sc_mcu9t5v0__filltie
Xload_slew218 _17399_/A1 _17358_/A1 VSS _11239_/VNW VSS VSS gf180mcu_fd_sc_mcu9t5v0__clkbuf_8
X_10265_ _16409_/A1 _11688_/I1 _19825_/Q _10265_/Z VSS VSS VSS VSS gf180mcu_fd_sc_mcu9t5v0__mux2_1
X_13053_ _19755_/Q _13053_/A2 _13053_/B1 _13053_/B2 _13055_/A3 VSS _13053_/VNW VSS
+ VSS gf180mcu_fd_sc_mcu9t5v0__oai22_1
X_17930_ _17923_/I _17930_/A2 _17929_/Z _17930_/B _18847_/D VSS _17930_/VNW VSS VSS
+ gf180mcu_fd_sc_mcu9t5v0__oai31_1
Xload_slew207 _12028_/A1 _12618_/B VSS VSS VSS VSS gf180mcu_fd_sc_mcu9t5v0__clkbuf_16
XTAP_TAPCELL_ROW_279_6751 VSS VSS gf180mcu_fd_sc_mcu9t5v0__filltie
XTAP_TAPCELL_ROW_279_6740 VSS VSS gf180mcu_fd_sc_mcu9t5v0__filltie
X_17861_ _17868_/A2 _17861_/A2 _17859_/Z _17864_/A1 _17861_/B2 _18827_/D VSS VSS VSS
+ VSS gf180mcu_fd_sc_mcu9t5v0__oai32_1
X_10196_ _20045_/Q _20046_/Q _15677_/B _10197_/B VSS _10197_/VNW VSS VSS gf180mcu_fd_sc_mcu9t5v0__nand3_1
X_12004_ wire208/I _12004_/A2 _12004_/B _12008_/A2 VSS VSS VSS VSS gf180mcu_fd_sc_mcu9t5v0__aoi21_4
XTAP_TAPCELL_ROW_275_6637 VSS VSS gf180mcu_fd_sc_mcu9t5v0__filltie
XTAP_TAPCELL_ROW_275_6626 VSS VSS gf180mcu_fd_sc_mcu9t5v0__filltie
X_16812_ _16809_/S _16641_/B _16951_/B VSS VSS VSS VSS gf180mcu_fd_sc_mcu9t5v0__nand2_1
XTAP_TAPCELL_ROW_106_3911 VSS VSS gf180mcu_fd_sc_mcu9t5v0__filltie
XTAP_TAPCELL_ROW_106_3900 VSS VSS gf180mcu_fd_sc_mcu9t5v0__filltie
X_19600_ _19600_/D _20048_/RN clkload17/I _19600_/Q VSS VSS VSS VSS gf180mcu_fd_sc_mcu9t5v0__dffrnq_1
X_17792_ _18770_/Q _18757_/Q _18769_/D _18770_/D VSS VSS VSS VSS gf180mcu_fd_sc_mcu9t5v0__mux2_1
X_19531_ _19531_/D _20043_/RN clkload29/I _19531_/Q VSS VSS VSS VSS gf180mcu_fd_sc_mcu9t5v0__dffrnq_1
X_16743_ _19290_/Q _16695_/B _16746_/B VSS _16743_/VNW VSS VSS gf180mcu_fd_sc_mcu9t5v0__or2_1
X_13955_ _13955_/A1 _13992_/A1 _13955_/Z VSS VSS VSS VSS gf180mcu_fd_sc_mcu9t5v0__xor2_1
X_16674_ _16750_/A1 _16674_/A2 _16750_/B _16675_/A3 VSS VSS VSS VSS gf180mcu_fd_sc_mcu9t5v0__aoi21_4
X_12906_ _19220_/Q _13320_/B _12907_/B VSS _12906_/VNW VSS VSS gf180mcu_fd_sc_mcu9t5v0__nand2_1
X_13886_ _13917_/B2 _13917_/B1 _13887_/I VSS VSS VSS VSS gf180mcu_fd_sc_mcu9t5v0__xor2_1
X_19462_ _19462_/D _20038_/RN clkload12/I _19462_/Q VSS VSS VSS VSS gf180mcu_fd_sc_mcu9t5v0__dffrnq_1
X_18413_ _18413_/D clkload60/I _18413_/Q VSS VSS VSS VSS gf180mcu_fd_sc_mcu9t5v0__dffq_4
X_15625_ _19893_/Q _15629_/B _15625_/A3 _15626_/A2 VSS VSS VSS VSS gf180mcu_fd_sc_mcu9t5v0__nand3_1
X_12837_ _19764_/Q _12833_/Z _12839_/A2 _12837_/Z VSS VSS VSS VSS gf180mcu_fd_sc_mcu9t5v0__xor3_1
XTAP_TAPCELL_ROW_44_2203 VSS VSS gf180mcu_fd_sc_mcu9t5v0__filltie
X_19393_ _19393_/D _20033_/RN clkload8/I _19393_/Q VSS VSS VSS VSS gf180mcu_fd_sc_mcu9t5v0__dffrnq_1
X_18344_ _18344_/D clkload81/I _18344_/Q VSS VSS VSS VSS gf180mcu_fd_sc_mcu9t5v0__dffq_1
X_15556_ _19872_/Q _15553_/Z _15556_/Z VSS VSS VSS VSS gf180mcu_fd_sc_mcu9t5v0__xor2_1
XTAP_TAPCELL_ROW_251_5980 VSS VSS gf180mcu_fd_sc_mcu9t5v0__filltie
X_12768_ _12781_/A1 _12781_/A2 _12770_/A2 VSS VSS VSS VSS gf180mcu_fd_sc_mcu9t5v0__xnor2_1
X_18275_ _18275_/D clkload79/I _18275_/Q VSS VSS VSS VSS gf180mcu_fd_sc_mcu9t5v0__dffq_1
X_15487_ _19830_/Q _10211_/Z _15502_/S VSS VSS VSS VSS gf180mcu_fd_sc_mcu9t5v0__nor2_1
X_11719_ _11720_/A1 _11748_/A2 _12071_/B _11720_/B VSS VSS VSS VSS gf180mcu_fd_sc_mcu9t5v0__aoi21_1
XPHY_EDGE_ROW_184_2_Right_915 VSS VSS gf180mcu_fd_sc_mcu9t5v0__endcap
X_12699_ _12699_/A1 _12699_/A2 _12699_/Z VSS _12706_/VNW VSS VSS gf180mcu_fd_sc_mcu9t5v0__xor2_1
X_14507_ _14507_/A1 _19129_/Q _14507_/B1 _14722_/A1 _14507_/C _14513_/A3 VSS VSS VSS
+ VSS gf180mcu_fd_sc_mcu9t5v0__aoi221_1
X_17226_ _10724_/C _17226_/A2 _17226_/A3 _17227_/B VSS VSS VSS VSS gf180mcu_fd_sc_mcu9t5v0__nand3_1
X_14438_ _14702_/B _14439_/A2 _14702_/A1 VSS VSS VSS VSS gf180mcu_fd_sc_mcu9t5v0__nor2_1
X_17157_ _20126_/Q _17326_/A1 wire168/I _17158_/A2 VSS VSS VSS VSS gf180mcu_fd_sc_mcu9t5v0__oai21_1
XTAP_TAPCELL_ROW_38_2018 VSS VSS gf180mcu_fd_sc_mcu9t5v0__filltie
X_16108_ _16700_/A2 _16714_/A3 _16741_/B2 VSS VSS VSS VSS gf180mcu_fd_sc_mcu9t5v0__nor2_4
XTAP_TAPCELL_ROW_38_2029 VSS VSS gf180mcu_fd_sc_mcu9t5v0__filltie
X_14369_ _19439_/Q _14715_/S _14370_/A2 VSS VSS VSS VSS gf180mcu_fd_sc_mcu9t5v0__nand2_1
X_17088_ _19826_/Q _17088_/A2 _17088_/A3 _17088_/B _17089_/B1 VSS VSS VSS VSS gf180mcu_fd_sc_mcu9t5v0__oai31_1
X_16039_ _15996_/B _16039_/A2 _16039_/A3 _16039_/B _16040_/I1 VSS VSS VSS VSS gf180mcu_fd_sc_mcu9t5v0__oai31_1
XTAP_TAPCELL_ROW_245_5795 VSS VSS gf180mcu_fd_sc_mcu9t5v0__filltie
XTAP_TAPCELL_ROW_171_3_8121 VSS VSS gf180mcu_fd_sc_mcu9t5v0__filltie
XTAP_TAPCELL_ROW_14_1361 VSS VSS gf180mcu_fd_sc_mcu9t5v0__filltie
XPHY_EDGE_ROW_108_Left_432 VSS VSS gf180mcu_fd_sc_mcu9t5v0__endcap
X_19729_ _19729_/D _20049_/RN clkload15/I _19729_/Q VSS VSS VSS VSS gf180mcu_fd_sc_mcu9t5v0__dffrnq_1
XTAP_TAPCELL_ROW_14_1372 VSS VSS gf180mcu_fd_sc_mcu9t5v0__filltie
XPHY_EDGE_ROW_212_Left_535 VSS VSS gf180mcu_fd_sc_mcu9t5v0__endcap
XTAP_TAPCELL_ROW_10_1247 VSS VSS gf180mcu_fd_sc_mcu9t5v0__filltie
XTAP_TAPCELL_ROW_10_1258 VSS VSS gf180mcu_fd_sc_mcu9t5v0__filltie
XTAP_TAPCELL_ROW_10_1269 VSS VSS gf180mcu_fd_sc_mcu9t5v0__filltie
X_09413_ _18834_/Q _09413_/A2 _09820_/A1 _09416_/A2 VSS VSS VSS VSS gf180mcu_fd_sc_mcu9t5v0__nand3_4
XPHY_EDGE_ROW_179_3_Right_294 VSS VSS gf180mcu_fd_sc_mcu9t5v0__endcap
XTAP_TAPCELL_ROW_151_3_8052 VSS VSS gf180mcu_fd_sc_mcu9t5v0__filltie
XTAP_TAPCELL_ROW_27_1722 VSS VSS gf180mcu_fd_sc_mcu9t5v0__filltie
XTAP_TAPCELL_ROW_27_1733 VSS VSS gf180mcu_fd_sc_mcu9t5v0__filltie
XTAP_TAPCELL_ROW_23_1608 VSS VSS gf180mcu_fd_sc_mcu9t5v0__filltie
X_09344_ _19454_/Q _14447_/A1 VSS _11962_/VNW VSS VSS gf180mcu_fd_sc_mcu9t5v0__clkinv_1
Xdelaybuf_2_core_clk delaybuf_2_core_clk/I delaybuf_3_core_clk/I VSS VSS VSS VSS gf180mcu_fd_sc_mcu9t5v0__clkbuf_16
X_09275_ _20060_/Q _10816_/A1 VSS VSS VSS VSS gf180mcu_fd_sc_mcu9t5v0__clkinv_1
XPHY_EDGE_ROW_117_Left_441 VSS VSS gf180mcu_fd_sc_mcu9t5v0__endcap
XTAP_TAPCELL_ROW_23_1619 VSS VSS gf180mcu_fd_sc_mcu9t5v0__filltie
XPHY_EDGE_ROW_221_Left_544 VSS VSS gf180mcu_fd_sc_mcu9t5v0__endcap
XPHY_EDGE_ROW_289_Right_216 VSS VSS gf180mcu_fd_sc_mcu9t5v0__endcap
X_10050_ _20000_/Q _19960_/Q _19968_/Q _20004_/Q _19984_/Q _19998_/Q _10051_/A3 VSS
+ VSS VSS VSS gf180mcu_fd_sc_mcu9t5v0__aoi222_1
XPHY_EDGE_ROW_126_Left_450 VSS VSS gf180mcu_fd_sc_mcu9t5v0__endcap
XPHY_EDGE_ROW_230_Left_553 VSS VSS gf180mcu_fd_sc_mcu9t5v0__endcap
XTAP_TAPCELL_ROW_270_6501 VSS VSS gf180mcu_fd_sc_mcu9t5v0__filltie
XTAP_TAPCELL_ROW_255_6080 VSS VSS gf180mcu_fd_sc_mcu9t5v0__filltie
X_10952_ _10952_/A1 _10952_/A2 _10952_/B _10953_/A2 VSS _10986_/VNW VSS VSS gf180mcu_fd_sc_mcu9t5v0__oai21_1
XTAP_TAPCELL_ROW_84_3295 VSS VSS gf180mcu_fd_sc_mcu9t5v0__filltie
X_13740_ _19148_/Q _19114_/Q _14675_/A1 VSS _17825_/VNW VSS VSS gf180mcu_fd_sc_mcu9t5v0__xnor2_1
XTAP_TAPCELL_ROW_84_3284 VSS VSS gf180mcu_fd_sc_mcu9t5v0__filltie
XTAP_TAPCELL_ROW_255_6091 VSS VSS gf180mcu_fd_sc_mcu9t5v0__filltie
X_10883_ _10883_/I0 _18980_/Q _18148_/S _18980_/D VSS VSS VSS VSS gf180mcu_fd_sc_mcu9t5v0__mux2_1
X_13671_ _13931_/A1 _14166_/B _14374_/A1 _13671_/B2 _19293_/D VSS VSS VSS VSS gf180mcu_fd_sc_mcu9t5v0__aoi22_1
X_15410_ _19695_/Q _19795_/Q _15430_/S _19795_/D VSS _15410_/VNW VSS VSS gf180mcu_fd_sc_mcu9t5v0__mux2_1
X_16390_ _16389_/Z _18258_/Q _16926_/S _18258_/D VSS VSS VSS VSS gf180mcu_fd_sc_mcu9t5v0__mux2_4
X_12622_ _12622_/A1 _12622_/A2 _12655_/S VSS _17477_/VNW VSS VSS gf180mcu_fd_sc_mcu9t5v0__nand2_1
X_12553_ wire146/Z _12553_/A2 _12553_/A3 _12553_/B1 _12553_/B2 wire279/I VSS VSS VSS
+ VSS gf180mcu_fd_sc_mcu9t5v0__oai32_1
XTAP_TAPCELL_ROW_268_6452 VSS VSS gf180mcu_fd_sc_mcu9t5v0__filltie
XTAP_TAPCELL_ROW_268_6441 VSS VSS gf180mcu_fd_sc_mcu9t5v0__filltie
XTAP_TAPCELL_ROW_268_6430 VSS VSS gf180mcu_fd_sc_mcu9t5v0__filltie
XTAP_TAPCELL_ROW_97_3656 VSS VSS gf180mcu_fd_sc_mcu9t5v0__filltie
X_15341_ _19643_/Q _19620_/Q _19644_/Q _19621_/Q _15341_/C _15345_/A3 VSS VSS VSS
+ VSS gf180mcu_fd_sc_mcu9t5v0__aoi221_1
XTAP_TAPCELL_ROW_97_3645 VSS VSS gf180mcu_fd_sc_mcu9t5v0__filltie
X_11504_ _18390_/Q _11534_/S _11506_/A2 VSS VSS VSS VSS gf180mcu_fd_sc_mcu9t5v0__nand2_1
X_18060_ _18060_/A1 _18060_/A2 _18060_/B _18925_/D VSS VSS VSS VSS gf180mcu_fd_sc_mcu9t5v0__aoi21_1
X_15272_ _19634_/Q _19611_/Q _15283_/B VSS _15272_/VNW VSS VSS gf180mcu_fd_sc_mcu9t5v0__xnor2_1
X_17011_ _19252_/Q _16628_/B _17023_/S _17011_/Z VSS VSS VSS VSS gf180mcu_fd_sc_mcu9t5v0__mux2_1
XTAP_TAPCELL_ROW_264_6338 VSS VSS gf180mcu_fd_sc_mcu9t5v0__filltie
XTAP_TAPCELL_ROW_264_6327 VSS VSS gf180mcu_fd_sc_mcu9t5v0__filltie
X_12484_ _19156_/Q _12355_/I _12485_/B VSS _12484_/VNW VSS VSS gf180mcu_fd_sc_mcu9t5v0__nand2_1
X_14223_ _19323_/Q _14223_/A2 _14246_/A2 VSS VSS VSS VSS gf180mcu_fd_sc_mcu9t5v0__nand2_1
X_11435_ _18882_/Q _12028_/C _11488_/B _11435_/B2 _11540_/C _11437_/A1 VSS VSS VSS
+ VSS gf180mcu_fd_sc_mcu9t5v0__oai221_1
X_11366_ _18705_/Q _12527_/A2 wire208/Z _11366_/B2 wire213/Z _11368_/A3 VSS VSS VSS
+ VSS gf180mcu_fd_sc_mcu9t5v0__aoi221_2
X_14154_ _19319_/Q _14153_/Z _19192_/D _19319_/D VSS VSS VSS VSS gf180mcu_fd_sc_mcu9t5v0__mux2_1
X_18962_ _18962_/D _20050_/RN clkload67/I _18962_/Q VSS VSS VSS VSS gf180mcu_fd_sc_mcu9t5v0__dffrnq_1
X_11297_ _18247_/Q wire136/Z _11301_/C VSS VSS VSS VSS gf180mcu_fd_sc_mcu9t5v0__nand2_1
X_10317_ _19825_/Q _18332_/Q _10317_/B _10514_/B _10326_/A1 VSS VSS VSS VSS gf180mcu_fd_sc_mcu9t5v0__oai211_1
X_13105_ _13184_/A1 _13124_/A2 _13104_/Z _13105_/Z VSS VSS VSS VSS gf180mcu_fd_sc_mcu9t5v0__or3_1
X_14085_ _14085_/A1 _14085_/A2 _14116_/A2 VSS VSS VSS VSS gf180mcu_fd_sc_mcu9t5v0__xnor2_1
X_10248_ _18537_/Q wire81/Z wire282/Z _10261_/A2 VSS VSS VSS VSS gf180mcu_fd_sc_mcu9t5v0__aoi21_1
X_13036_ _19723_/Q _13035_/I _13525_/A1 VSS wire174/VNW VSS VSS gf180mcu_fd_sc_mcu9t5v0__nor2_1
X_17913_ _17913_/A1 _17894_/I _17912_/Z _17913_/B _18841_/D VSS VSS VSS VSS gf180mcu_fd_sc_mcu9t5v0__oai31_1
X_18893_ _18893_/D _20045_/RN clkload10/I _18893_/Q VSS VSS VSS VSS gf180mcu_fd_sc_mcu9t5v0__dffrnq_1
XTAP_TAPCELL_ROW_240_5681 VSS VSS gf180mcu_fd_sc_mcu9t5v0__filltie
XTAP_TAPCELL_ROW_240_5670 VSS VSS gf180mcu_fd_sc_mcu9t5v0__filltie
X_17844_ _19051_/Q _18821_/Q _17844_/S _18821_/D VSS VSS VSS VSS gf180mcu_fd_sc_mcu9t5v0__mux2_1
X_10179_ _10179_/A1 _18822_/Q _10179_/B _10180_/B2 VSS _17845_/VNW VSS VSS gf180mcu_fd_sc_mcu9t5v0__oai21_1
X_17775_ _17775_/A1 _17779_/A2 _17775_/B _17779_/C _18762_/D VSS VSS VSS VSS gf180mcu_fd_sc_mcu9t5v0__aoi211_1
XTAP_TAPCELL_ROW_7_1168 VSS VSS gf180mcu_fd_sc_mcu9t5v0__filltie
X_14987_ _19431_/Q _19376_/Q _14992_/B VSS _14987_/VNW VSS VSS gf180mcu_fd_sc_mcu9t5v0__nand2_1
X_16726_ _19286_/Q _16751_/B _16727_/A3 VSS _16739_/VNW VSS VSS gf180mcu_fd_sc_mcu9t5v0__nor2_1
X_19514_ _19514_/D _20026_/RN clkload44/I _19514_/Q VSS VSS VSS VSS gf180mcu_fd_sc_mcu9t5v0__dffrnq_1
X_13938_ _13940_/A2 _13937_/Z _13952_/B VSS VSS VSS VSS gf180mcu_fd_sc_mcu9t5v0__nand2_1
XTAP_TAPCELL_ROW_7_1179 VSS VSS gf180mcu_fd_sc_mcu9t5v0__filltie
X_19445_ _19445_/D _20021_/RN clkload12/I _19445_/Q VSS VSS VSS VSS gf180mcu_fd_sc_mcu9t5v0__dffrnq_1
X_16657_ _19257_/Q _16751_/A2 wire71/Z _16662_/A2 VSS VSS VSS VSS gf180mcu_fd_sc_mcu9t5v0__nor3_1
X_13869_ _13869_/A1 _13866_/Z _13869_/B _13906_/A1 VSS VSS VSS VSS gf180mcu_fd_sc_mcu9t5v0__aoi21_1
X_16588_ _19279_/Q _15996_/B _16594_/B VSS VSS VSS VSS gf180mcu_fd_sc_mcu9t5v0__nand2_1
X_15608_ _15608_/A1 _15608_/A2 _15657_/B _15629_/B _15609_/B VSS VSS VSS VSS gf180mcu_fd_sc_mcu9t5v0__oai211_1
X_19376_ _19376_/D _20144_/RN clkload8/I _19376_/Q VSS VSS VSS VSS gf180mcu_fd_sc_mcu9t5v0__dffrnq_1
X_15539_ _19857_/Q wire301/Z _15551_/S _19857_/D VSS _15539_/VNW VSS VSS gf180mcu_fd_sc_mcu9t5v0__mux2_1
X_18327_ _18327_/D _18328_/CLK _18327_/Q VSS VSS VSS VSS gf180mcu_fd_sc_mcu9t5v0__dffq_4
XTAP_TAPCELL_ROW_234_5496 VSS VSS gf180mcu_fd_sc_mcu9t5v0__filltie
X_18258_ _18258_/D _18291_/CLK _18258_/Q VSS VSS VSS VSS gf180mcu_fd_sc_mcu9t5v0__dffq_1
X_09060_ input6/Z _17775_/A1 VSS _09060_/VNW VSS VSS gf180mcu_fd_sc_mcu9t5v0__clkinv_1
XPHY_EDGE_ROW_168_3_Left_826 VSS VSS gf180mcu_fd_sc_mcu9t5v0__endcap
XPHY_EDGE_ROW_185_2_Right_916 VSS VSS gf180mcu_fd_sc_mcu9t5v0__endcap
X_17209_ input7/Z _10648_/C _10821_/B _17226_/A2 VSS VSS VSS VSS gf180mcu_fd_sc_mcu9t5v0__nand3_1
X_18189_ _18189_/D clkload72/I _18189_/Q VSS VSS VSS VSS gf180mcu_fd_sc_mcu9t5v0__dffq_1
XTAP_TAPCELL_ROW_247_5857 VSS VSS gf180mcu_fd_sc_mcu9t5v0__filltie
XTAP_TAPCELL_ROW_247_5868 VSS VSS gf180mcu_fd_sc_mcu9t5v0__filltie
X_09962_ _18806_/Q _09961_/Z _10154_/A2 VSS VSS VSS VSS gf180mcu_fd_sc_mcu9t5v0__nor2_1
XPHY_EDGE_ROW_164_1_Left_487 VSS VSS gf180mcu_fd_sc_mcu9t5v0__endcap
XTAP_TAPCELL_ROW_16_1412 VSS VSS gf180mcu_fd_sc_mcu9t5v0__filltie
X_20082_ _20082_/D clkload57/I _20082_/Q VSS VSS VSS VSS gf180mcu_fd_sc_mcu9t5v0__dffq_1
X_09893_ _15834_/A1 _15832_/A1 _10057_/A2 VSS VSS VSS VSS gf180mcu_fd_sc_mcu9t5v0__nand2_1
XTAP_TAPCELL_ROW_16_1423 VSS VSS gf180mcu_fd_sc_mcu9t5v0__filltie
XTAP_TAPCELL_ROW_16_1434 VSS VSS gf180mcu_fd_sc_mcu9t5v0__filltie
XTAP_TAPCELL_ROW_12_1309 VSS VSS gf180mcu_fd_sc_mcu9t5v0__filltie
X_09327_ _19240_/Q _16432_/A1 VSS _09327_/VNW VSS VSS gf180mcu_fd_sc_mcu9t5v0__clkinv_1
XTAP_TAPCELL_ROW_135_4693 VSS VSS gf180mcu_fd_sc_mcu9t5v0__filltie
XTAP_TAPCELL_ROW_135_4682 VSS VSS gf180mcu_fd_sc_mcu9t5v0__filltie
XTAP_TAPCELL_ROW_92_3520 VSS VSS gf180mcu_fd_sc_mcu9t5v0__filltie
X_09258_ _20037_/Q _13656_/A1 VSS VSS VSS VSS gf180mcu_fd_sc_mcu9t5v0__clkinv_8
XTAP_TAPCELL_ROW_131_4579 VSS VSS gf180mcu_fd_sc_mcu9t5v0__filltie
X_09189_ _19127_/Q _14487_/A2 VSS _09189_/VNW VSS VSS gf180mcu_fd_sc_mcu9t5v0__clkinv_1
X_11220_ _18337_/Q _18321_/Q _18305_/Q _18289_/Q _11534_/S wire136/Z _11220_/Z VSS
+ VSS VSS VSS gf180mcu_fd_sc_mcu9t5v0__mux4_1
X_11151_ _11321_/A2 _11151_/A2 _11151_/A3 _11151_/B _19076_/D VSS VSS VSS VSS gf180mcu_fd_sc_mcu9t5v0__oai31_1
X_10102_ _18959_/Q wire172/Z _10169_/B1 _18983_/Q _10102_/C _10103_/A3 VSS _18144_/VNW
+ VSS VSS gf180mcu_fd_sc_mcu9t5v0__aoi221_1
X_11082_ _15939_/B _09395_/I wire163/I VSS VSS VSS VSS gf180mcu_fd_sc_mcu9t5v0__nor2_2
X_15890_ _20099_/Q _19234_/Q _15928_/S _20099_/D VSS VSS VSS VSS gf180mcu_fd_sc_mcu9t5v0__mux2_1
XTAP_TAPCELL_ROW_257_6131 VSS VSS gf180mcu_fd_sc_mcu9t5v0__filltie
XTAP_TAPCELL_ROW_86_3346 VSS VSS gf180mcu_fd_sc_mcu9t5v0__filltie
X_14910_ _14911_/A1 _14909_/Z _14918_/A1 VSS VSS VSS VSS gf180mcu_fd_sc_mcu9t5v0__nand2_1
X_10033_ _10180_/B1 _10033_/A2 _10033_/A3 _10038_/B VSS _10033_/VNW VSS VSS gf180mcu_fd_sc_mcu9t5v0__nand3_1
XTAP_TAPCELL_ROW_86_3335 VSS VSS gf180mcu_fd_sc_mcu9t5v0__filltie
XTAP_TAPCELL_ROW_257_6142 VSS VSS gf180mcu_fd_sc_mcu9t5v0__filltie
XTAP_TAPCELL_ROW_86_3357 VSS VSS gf180mcu_fd_sc_mcu9t5v0__filltie
X_14841_ _19341_/Q _19407_/Q _14846_/A3 VSS _14845_/VNW VSS VSS gf180mcu_fd_sc_mcu9t5v0__nand2_1
XTAP_TAPCELL_ROW_253_6039 VSS VSS gf180mcu_fd_sc_mcu9t5v0__filltie
XTAP_TAPCELL_ROW_253_6028 VSS VSS gf180mcu_fd_sc_mcu9t5v0__filltie
XTAP_TAPCELL_ROW_253_6017 VSS VSS gf180mcu_fd_sc_mcu9t5v0__filltie
X_17560_ _18664_/Q _17569_/A2 _17561_/A2 VSS _17560_/VNW VSS VSS gf180mcu_fd_sc_mcu9t5v0__nor2_1
X_16511_ _16511_/A1 _16107_/B _16106_/C _16511_/A4 _17033_/S VSS VSS VSS VSS gf180mcu_fd_sc_mcu9t5v0__and4_4
X_11984_ wire208/I _11984_/A2 _12004_/B _11986_/B1 VSS VSS VSS VSS gf180mcu_fd_sc_mcu9t5v0__aoi21_4
X_14772_ _19560_/Q _19326_/Q wire108/I _19560_/D VSS VSS VSS VSS gf180mcu_fd_sc_mcu9t5v0__mux2_1
X_17491_ _18596_/Q _19237_/Q _17513_/S _18596_/D VSS VSS VSS VSS gf180mcu_fd_sc_mcu9t5v0__mux2_1
XTAP_TAPCELL_ROW_99_3718 VSS VSS gf180mcu_fd_sc_mcu9t5v0__filltie
X_10935_ _10967_/A1 _19005_/Q _18148_/S _19005_/D VSS VSS VSS VSS gf180mcu_fd_sc_mcu9t5v0__mux2_1
XTAP_TAPCELL_ROW_99_3707 VSS VSS gf180mcu_fd_sc_mcu9t5v0__filltie
XTAP_TAPCELL_ROW_2_1032 VSS VSS gf180mcu_fd_sc_mcu9t5v0__filltie
X_13723_ _13724_/A1 _19112_/Q _13738_/A2 VSS VSS VSS VSS gf180mcu_fd_sc_mcu9t5v0__nor2_1
XTAP_TAPCELL_ROW_2_1043 VSS VSS gf180mcu_fd_sc_mcu9t5v0__filltie
X_16442_ _16442_/A1 _16442_/A2 _16512_/A2 VSS _16442_/VNW VSS VSS gf180mcu_fd_sc_mcu9t5v0__nor2_1
XPHY_EDGE_ROW_221_Right_148 VSS VSS gf180mcu_fd_sc_mcu9t5v0__endcap
X_10866_ _10865_/Z _18972_/Q _18152_/S _18972_/D VSS VSS VSS VSS gf180mcu_fd_sc_mcu9t5v0__mux2_1
X_19230_ _19230_/D _20062_/RN clkload25/I _19230_/Q VSS VSS VSS VSS gf180mcu_fd_sc_mcu9t5v0__dffrnq_2
X_13654_ _20037_/Q _20038_/Q _13745_/B1 VSS VSS VSS VSS gf180mcu_fd_sc_mcu9t5v0__nor2_1
X_12605_ _18359_/Q _12613_/A2 _12609_/A2 VSS VSS VSS VSS gf180mcu_fd_sc_mcu9t5v0__nor2_1
X_16373_ _16009_/B _19229_/Q _16897_/S _16373_/Z VSS VSS VSS VSS gf180mcu_fd_sc_mcu9t5v0__mux2_1
X_19161_ _19161_/D _20057_/RN clkload28/I _19161_/Q VSS VSS VSS VSS gf180mcu_fd_sc_mcu9t5v0__dffrnq_1
X_18112_ _18111_/Z _18943_/Q _18152_/S _18943_/D VSS VSS VSS VSS gf180mcu_fd_sc_mcu9t5v0__mux2_1
X_13585_ _13586_/A1 _13586_/A3 _13585_/B _13590_/A2 VSS VSS VSS VSS gf180mcu_fd_sc_mcu9t5v0__aoi21_1
X_10797_ _10797_/A1 _10797_/A2 _10797_/B _10798_/A2 VSS VSS VSS VSS gf180mcu_fd_sc_mcu9t5v0__oai21_1
X_15324_ _15324_/A1 _15324_/A2 _15324_/A3 _15324_/B _15330_/A1 VSS _15324_/VNW VSS
+ VSS gf180mcu_fd_sc_mcu9t5v0__oai31_1
X_19092_ _19092_/D _20052_/RN clkload23/I _19092_/Q VSS VSS VSS VSS gf180mcu_fd_sc_mcu9t5v0__dffrnq_1
X_12536_ _19163_/Q _12620_/A1 _12537_/B VSS _14722_/VNW VSS VSS gf180mcu_fd_sc_mcu9t5v0__nand2_1
X_18043_ _18926_/Q _18063_/A1 _18064_/A2 VSS VSS VSS VSS gf180mcu_fd_sc_mcu9t5v0__nand2_1
X_12467_ wire175/Z _12467_/A2 _12618_/B _12469_/A3 VSS _12467_/VNW VSS VSS gf180mcu_fd_sc_mcu9t5v0__aoi21_1
X_15255_ _19600_/Q _19577_/Q _15255_/A3 _15256_/I1 VSS VSS VSS VSS gf180mcu_fd_sc_mcu9t5v0__xnor3_1
X_11418_ _18383_/Q _11509_/A2 _11428_/B _11418_/C _11420_/B1 VSS _17278_/VNW VSS VSS
+ gf180mcu_fd_sc_mcu9t5v0__oai211_1
X_15186_ _15187_/B1 _19586_/Q _15186_/B1 _15186_/B2 _15186_/C _15188_/B1 VSS VSS VSS
+ VSS gf180mcu_fd_sc_mcu9t5v0__oai221_1
X_14206_ _14190_/I _14219_/A2 _14208_/A2 VSS VSS VSS VSS gf180mcu_fd_sc_mcu9t5v0__xnor2_1
X_12398_ _18254_/Q _12607_/A2 _12400_/B1 VSS _12398_/VNW VSS VSS gf180mcu_fd_sc_mcu9t5v0__nor2_1
XTAP_TAPCELL_ROW_242_5721 VSS VSS gf180mcu_fd_sc_mcu9t5v0__filltie
X_14137_ _14137_/I _14183_/A2 VSS _14137_/VNW VSS VSS gf180mcu_fd_sc_mcu9t5v0__clkinv_1
XTAP_TAPCELL_ROW_71_2925 VSS VSS gf180mcu_fd_sc_mcu9t5v0__filltie
X_11349_ _18378_/Q _11385_/A2 _11428_/B _11349_/C _11351_/B1 VSS VSS VSS VSS gf180mcu_fd_sc_mcu9t5v0__oai211_1
XTAP_TAPCELL_ROW_242_5732 VSS VSS gf180mcu_fd_sc_mcu9t5v0__filltie
X_19994_ _19994_/D _20058_/RN clkload65/I _19994_/Q VSS VSS VSS VSS gf180mcu_fd_sc_mcu9t5v0__dffrnq_1
XTAP_TAPCELL_ROW_71_2947 VSS VSS gf180mcu_fd_sc_mcu9t5v0__filltie
XTAP_TAPCELL_ROW_71_2936 VSS VSS gf180mcu_fd_sc_mcu9t5v0__filltie
X_18945_ _18945_/D _20033_/RN clkload71/I _18945_/Q VSS VSS VSS VSS gf180mcu_fd_sc_mcu9t5v0__dffrnq_1
X_14068_ _14068_/A1 _14060_/Z _14068_/B _14102_/A1 VSS VSS VSS VSS gf180mcu_fd_sc_mcu9t5v0__aoi21_1
XTAP_TAPCELL_ROW_9_1219 VSS VSS gf180mcu_fd_sc_mcu9t5v0__filltie
XTAP_TAPCELL_ROW_223_5197 VSS VSS gf180mcu_fd_sc_mcu9t5v0__filltie
X_13019_ _13019_/A1 _13020_/A2 _13521_/A1 VSS VSS VSS VSS gf180mcu_fd_sc_mcu9t5v0__nand2_1
X_18876_ _18876_/D _20028_/RN clkload22/I _18876_/Q VSS VSS VSS VSS gf180mcu_fd_sc_mcu9t5v0__dffrnq_1
X_17827_ _19034_/Q _18804_/Q _17845_/S _18804_/D VSS VSS VSS VSS gf180mcu_fd_sc_mcu9t5v0__mux2_1
XTAP_TAPCELL_ROW_69_2887 VSS VSS gf180mcu_fd_sc_mcu9t5v0__filltie
XTAP_TAPCELL_ROW_69_2876 VSS VSS gf180mcu_fd_sc_mcu9t5v0__filltie
X_17758_ _18755_/Q _18790_/Q _17421_/S _17758_/Z VSS VSS VSS VSS gf180mcu_fd_sc_mcu9t5v0__or3_1
X_16709_ _16709_/A1 _16744_/A2 _16714_/A3 _16710_/B VSS VSS VSS VSS gf180mcu_fd_sc_mcu9t5v0__nor3_1
XTAP_TAPCELL_ROW_236_5569 VSS VSS gf180mcu_fd_sc_mcu9t5v0__filltie
XTAP_TAPCELL_ROW_236_5558 VSS VSS gf180mcu_fd_sc_mcu9t5v0__filltie
XTAP_TAPCELL_ROW_236_5547 VSS VSS gf180mcu_fd_sc_mcu9t5v0__filltie
X_17689_ _17689_/A1 _17673_/S _17689_/B _17689_/C _18723_/D VSS VSS VSS VSS gf180mcu_fd_sc_mcu9t5v0__oai211_1
XPHY_EDGE_ROW_178_2_Left_690 VSS VSS gf180mcu_fd_sc_mcu9t5v0__endcap
X_19428_ _19428_/D _20068_/RN clkload21/I _19428_/Q VSS VSS VSS VSS gf180mcu_fd_sc_mcu9t5v0__dffrnq_1
XTAP_TAPCELL_ROW_249_5908 VSS VSS gf180mcu_fd_sc_mcu9t5v0__filltie
X_19359_ _19359_/D _20063_/RN clkload8/I _19359_/Q VSS VSS VSS VSS gf180mcu_fd_sc_mcu9t5v0__dffrnq_1
X_09112_ _19717_/Q _12843_/A1 VSS VSS VSS VSS gf180mcu_fd_sc_mcu9t5v0__clkinv_1
XTAP_TAPCELL_ROW_249_5919 VSS VSS gf180mcu_fd_sc_mcu9t5v0__filltie
XPHY_EDGE_ROW_186_2_Right_917 VSS VSS gf180mcu_fd_sc_mcu9t5v0__endcap
XTAP_TAPCELL_ROW_212_4890 VSS VSS gf180mcu_fd_sc_mcu9t5v0__filltie
XPHY_EDGE_ROW_111_Right_111 VSS VSS gf180mcu_fd_sc_mcu9t5v0__endcap
Xmax_cap162 _11091_/B _12616_/A2 VSS VSS VSS VSS gf180mcu_fd_sc_mcu9t5v0__clkbuf_8
Xmax_cap151 _12615_/A2 _12607_/A2 VSS VSS VSS VSS gf180mcu_fd_sc_mcu9t5v0__clkbuf_8
XPHY_EDGE_ROW_197_2_Left_709 VSS VSS gf180mcu_fd_sc_mcu9t5v0__endcap
XTAP_TAPCELL_ROW_320_7876 VSS VSS gf180mcu_fd_sc_mcu9t5v0__filltie
Xmax_cap195 _17380_/A2 _17406_/A2 VSS VSS VSS VSS gf180mcu_fd_sc_mcu9t5v0__buf_8
XTAP_TAPCELL_ROW_320_7865 VSS VSS gf180mcu_fd_sc_mcu9t5v0__filltie
Xmax_cap184 _12183_/C _12090_/B VSS VSS VSS VSS gf180mcu_fd_sc_mcu9t5v0__clkbuf_8
Xmax_cap173 wire174/Z _11051_/S VSS max_cap173/VNW VSS VSS gf180mcu_fd_sc_mcu9t5v0__clkbuf_8
X_20134_ _20134_/D clkload74/I _20134_/Q VSS VSS VSS VSS gf180mcu_fd_sc_mcu9t5v0__dffq_1
X_09945_ _18813_/Q _18812_/Q _18811_/Q _09944_/Z _09948_/A1 VSS _09945_/VNW VSS VSS
+ gf180mcu_fd_sc_mcu9t5v0__nand4_1
X_20065_ _20065_/D _20065_/RN clkload50/I _20065_/Q VSS VSS VSS VSS gf180mcu_fd_sc_mcu9t5v0__dffrnq_1
X_09876_ _10657_/B _09876_/A2 _09876_/A3 _09878_/A2 VSS VSS VSS VSS gf180mcu_fd_sc_mcu9t5v0__nor3_1
XTAP_TAPCELL_ROW_138_3_8006 VSS VSS gf180mcu_fd_sc_mcu9t5v0__filltie
Xclkbuf_leaf_28_clk_regs clkload3/I clkload53/I VSS VSS VSS VSS gf180mcu_fd_sc_mcu9t5v0__clkbuf_8
XTAP_TAPCELL_ROW_124_4394 VSS VSS gf180mcu_fd_sc_mcu9t5v0__filltie
XTAP_TAPCELL_ROW_124_4383 VSS VSS gf180mcu_fd_sc_mcu9t5v0__filltie
XTAP_TAPCELL_ROW_81_3221 VSS VSS gf180mcu_fd_sc_mcu9t5v0__filltie
XTAP_TAPCELL_ROW_81_3210 VSS VSS gf180mcu_fd_sc_mcu9t5v0__filltie
XTAP_TAPCELL_ROW_120_4269 VSS VSS gf180mcu_fd_sc_mcu9t5v0__filltie
X_10720_ _10648_/C _20061_/Q _10724_/A2 VSS _10720_/VNW VSS VSS gf180mcu_fd_sc_mcu9t5v0__nand2_1
X_10651_ _18954_/Q wire166/Z _10653_/A2 VSS _16733_/VNW VSS VSS gf180mcu_fd_sc_mcu9t5v0__nand2_1
XTAP_TAPCELL_ROW_79_3150 VSS VSS gf180mcu_fd_sc_mcu9t5v0__filltie
X_10582_ _18166_/Q _17406_/A2 _17405_/A2 _18182_/Q _10583_/B VSS VSS VSS VSS gf180mcu_fd_sc_mcu9t5v0__aoi22_1
X_13370_ _19742_/Q _13373_/A2 _13371_/I VSS _13394_/VNW VSS VSS gf180mcu_fd_sc_mcu9t5v0__nand2_1
XTAP_TAPCELL_ROW_79_3161 VSS VSS gf180mcu_fd_sc_mcu9t5v0__filltie
X_12321_ _18439_/Q _12345_/A2 _12325_/A1 VSS _17386_/VNW VSS VSS gf180mcu_fd_sc_mcu9t5v0__nand2_1
XTAP_TAPCELL_ROW_75_3058 VSS VSS gf180mcu_fd_sc_mcu9t5v0__filltie
XTAP_TAPCELL_ROW_75_3047 VSS VSS gf180mcu_fd_sc_mcu9t5v0__filltie
XTAP_TAPCELL_ROW_75_3036 VSS VSS gf180mcu_fd_sc_mcu9t5v0__filltie
X_12252_ _12252_/A1 _12252_/A2 _12252_/Z VSS _12252_/VNW VSS VSS gf180mcu_fd_sc_mcu9t5v0__or2_1
X_15040_ _19637_/Q _15040_/I1 _20039_/Q _19637_/D VSS _15040_/VNW VSS VSS gf180mcu_fd_sc_mcu9t5v0__mux2_1
X_11203_ _18208_/Q _11519_/A2 _11204_/A3 VSS _11204_/VNW VSS VSS gf180mcu_fd_sc_mcu9t5v0__nand2_1
X_12183_ _12183_/A1 _12183_/A2 _12183_/B _12183_/C _12184_/B VSS _15906_/VNW VSS VSS
+ gf180mcu_fd_sc_mcu9t5v0__oai211_1
X_16991_ _19258_/Q _16668_/B _16991_/S _16991_/Z VSS VSS VSS VSS gf180mcu_fd_sc_mcu9t5v0__mux2_1
X_11134_ wire283/I _11134_/A2 _11134_/B1 _11134_/B2 _11136_/B2 VSS VSS VSS VSS gf180mcu_fd_sc_mcu9t5v0__aoi22_1
XTAP_TAPCELL_ROW_259_6204 VSS VSS gf180mcu_fd_sc_mcu9t5v0__filltie
XTAP_TAPCELL_ROW_88_3408 VSS VSS gf180mcu_fd_sc_mcu9t5v0__filltie
X_15942_ _15989_/A3 _15966_/A3 _16234_/A2 VSS VSS VSS VSS gf180mcu_fd_sc_mcu9t5v0__nor2_4
X_18730_ _18730_/D clkload47/I _18730_/Q VSS VSS VSS VSS gf180mcu_fd_sc_mcu9t5v0__dffq_1
X_11065_ _18035_/I0 _19066_/Q _11067_/S _19066_/D VSS _11065_/VNW VSS VSS gf180mcu_fd_sc_mcu9t5v0__mux2_1
X_18661_ _18661_/D _20065_/RN clkload66/I _18661_/Q VSS VSS VSS VSS gf180mcu_fd_sc_mcu9t5v0__dffrnq_1
X_10016_ _18568_/Q _10064_/S _10016_/B _10016_/C _10017_/B VSS VSS VSS VSS gf180mcu_fd_sc_mcu9t5v0__oai211_1
XTAP_TAPCELL_ROW_51_2390 VSS VSS gf180mcu_fd_sc_mcu9t5v0__filltie
X_15873_ _20082_/Q _19232_/Q _15905_/S _20082_/D VSS VSS VSS VSS gf180mcu_fd_sc_mcu9t5v0__mux2_1
XTAP_TAPCELL_ROW_4_1105 VSS VSS gf180mcu_fd_sc_mcu9t5v0__filltie
X_18592_ _18592_/D _20129_/CLK _18592_/Q VSS VSS VSS VSS gf180mcu_fd_sc_mcu9t5v0__dffq_1
X_17612_ wire300/Z _18675_/Q _17617_/S _18675_/D VSS VSS VSS VSS gf180mcu_fd_sc_mcu9t5v0__mux2_1
X_14824_ _14824_/A1 _14822_/Z _14827_/B VSS VSS VSS VSS gf180mcu_fd_sc_mcu9t5v0__and2_1
X_17543_ _18664_/Q input4/Z _17733_/A1 VSS VSS VSS VSS gf180mcu_fd_sc_mcu9t5v0__nand2_1
Xrst_tree_leaf_7 rst_tree_mid_0/Z _20140_/RN VSS VSS VSS VSS gf180mcu_fd_sc_mcu9t5v0__clkbuf_16
X_11967_ _11967_/A1 _11966_/B _11967_/B1 _11967_/B2 _19120_/D VSS VSS VSS VSS gf180mcu_fd_sc_mcu9t5v0__aoi22_4
XTAP_TAPCELL_ROW_64_2740 VSS VSS gf180mcu_fd_sc_mcu9t5v0__filltie
X_14755_ _19170_/Q _19136_/Q _14755_/B _14758_/A2 VSS VSS VSS VSS gf180mcu_fd_sc_mcu9t5v0__aoi21_1
Xeco15_sk2_1 eco15_sk2_1/I _18453_/CLK VSS VSS VSS VSS gf180mcu_fd_sc_mcu9t5v0__clkbuf_16
X_10918_ _16953_/A1 _18147_/S _10924_/B _10919_/I0 VSS VSS VSS VSS gf180mcu_fd_sc_mcu9t5v0__oai21_1
X_13706_ _19145_/Q _13706_/A2 _13724_/C VSS VSS VSS VSS gf180mcu_fd_sc_mcu9t5v0__nor2_1
XTAP_TAPCELL_ROW_64_2751 VSS VSS gf180mcu_fd_sc_mcu9t5v0__filltie
X_17474_ _09517_/I _17474_/A2 _18583_/D VSS VSS VSS VSS gf180mcu_fd_sc_mcu9t5v0__nor2_1
X_11898_ _12261_/B _11898_/A2 _11898_/A3 _11898_/B _11909_/A2 VSS VSS VSS VSS gf180mcu_fd_sc_mcu9t5v0__oai31_2
XTAP_TAPCELL_ROW_231_5433 VSS VSS gf180mcu_fd_sc_mcu9t5v0__filltie
XTAP_TAPCELL_ROW_231_5422 VSS VSS gf180mcu_fd_sc_mcu9t5v0__filltie
X_16425_ _16425_/I0 _18273_/Q _16958_/S _18273_/D VSS _16425_/VNW VSS VSS gf180mcu_fd_sc_mcu9t5v0__mux2_4
XTAP_TAPCELL_ROW_231_5411 VSS VSS gf180mcu_fd_sc_mcu9t5v0__filltie
X_19213_ _19213_/D _20045_/RN clkload25/I _19213_/Q VSS VSS VSS VSS gf180mcu_fd_sc_mcu9t5v0__dffrnq_1
XTAP_TAPCELL_ROW_60_2626 VSS VSS gf180mcu_fd_sc_mcu9t5v0__filltie
X_14686_ _19533_/Q _14686_/I1 _14704_/S _19533_/D VSS VSS VSS VSS gf180mcu_fd_sc_mcu9t5v0__mux2_1
XTAP_TAPCELL_ROW_60_2637 VSS VSS gf180mcu_fd_sc_mcu9t5v0__filltie
X_10849_ _19227_/Q _18147_/S _10860_/B VSS VSS VSS VSS gf180mcu_fd_sc_mcu9t5v0__nand2_1
X_13637_ _19290_/Q _13497_/B _13642_/B VSS _13637_/VNW VSS VSS gf180mcu_fd_sc_mcu9t5v0__nand2_1
X_16356_ _18242_/Q _16355_/Z _16892_/S _18242_/D VSS VSS VSS VSS gf180mcu_fd_sc_mcu9t5v0__mux2_4
X_13568_ _13568_/A1 _13568_/A2 _13568_/B _19274_/D VSS _15395_/VNW VSS VSS gf180mcu_fd_sc_mcu9t5v0__oai21_1
X_19144_ _19144_/D _20040_/RN clkload10/I _19144_/Q VSS VSS VSS VSS gf180mcu_fd_sc_mcu9t5v0__dffrnq_1
X_16287_ _16824_/S _16287_/A2 _16287_/Z VSS VSS VSS VSS gf180mcu_fd_sc_mcu9t5v0__and2_1
X_12519_ _18742_/Q _12527_/A2 _12543_/B1 _12519_/B2 _12521_/A3 VSS VSS VSS VSS gf180mcu_fd_sc_mcu9t5v0__aoi22_2
X_15307_ _19638_/Q _19615_/Q _15311_/A1 _15307_/Z VSS VSS VSS VSS gf180mcu_fd_sc_mcu9t5v0__xor3_1
X_19075_ _19075_/D _20035_/RN clkload23/I _19075_/Q VSS VSS VSS VSS gf180mcu_fd_sc_mcu9t5v0__dffrnq_1
X_15238_ _15247_/B1 _15247_/B2 _15238_/Z VSS _15238_/VNW VSS VSS gf180mcu_fd_sc_mcu9t5v0__and2_1
X_18026_ _18026_/I0 _18911_/Q _18037_/S _18911_/D VSS VSS VSS VSS gf180mcu_fd_sc_mcu9t5v0__mux2_1
XTAP_TAPCELL_ROW_58_2566 VSS VSS gf180mcu_fd_sc_mcu9t5v0__filltie
X_13499_ _19260_/Q _13304_/B _13500_/B VSS VSS VSS VSS gf180mcu_fd_sc_mcu9t5v0__nand2_1
XTAP_TAPCELL_ROW_229_5373 VSS VSS gf180mcu_fd_sc_mcu9t5v0__filltie
XTAP_TAPCELL_ROW_229_5362 VSS VSS gf180mcu_fd_sc_mcu9t5v0__filltie
XTAP_TAPCELL_ROW_144_3_8027 VSS VSS gf180mcu_fd_sc_mcu9t5v0__filltie
XTAP_TAPCELL_ROW_58_2577 VSS VSS gf180mcu_fd_sc_mcu9t5v0__filltie
XTAP_TAPCELL_ROW_58_2588 VSS VSS gf180mcu_fd_sc_mcu9t5v0__filltie
XTAP_TAPCELL_ROW_225_5259 VSS VSS gf180mcu_fd_sc_mcu9t5v0__filltie
XTAP_TAPCELL_ROW_225_5248 VSS VSS gf180mcu_fd_sc_mcu9t5v0__filltie
X_15169_ _19711_/Q _19551_/Q wire108/Z _19711_/D VSS _15169_/VNW VSS VSS gf180mcu_fd_sc_mcu9t5v0__mux2_1
X_19977_ _19977_/D _20041_/RN clkload66/I _19977_/Q VSS VSS VSS VSS gf180mcu_fd_sc_mcu9t5v0__dffrnq_1
X_09730_ _09730_/I _20020_/D VSS VSS VSS VSS gf180mcu_fd_sc_mcu9t5v0__clkinv_1
X_18928_ _18928_/D _20144_/RN clkload39/I _18928_/Q VSS VSS VSS VSS gf180mcu_fd_sc_mcu9t5v0__dffrnq_1
XTAP_TAPCELL_ROW_238_5609 VSS VSS gf180mcu_fd_sc_mcu9t5v0__filltie
X_09661_ _17769_/A1 _09675_/A1 _15691_/C _17601_/A1 _09662_/I0 VSS _09661_/VNW VSS
+ VSS gf180mcu_fd_sc_mcu9t5v0__nor4_1
X_18859_ _18859_/D _20139_/RN clkload23/I _18859_/Q VSS VSS VSS VSS gf180mcu_fd_sc_mcu9t5v0__dffrnq_1
X_09592_ _20043_/Q _20054_/Q _15598_/S VSS _09592_/VNW VSS VSS gf180mcu_fd_sc_mcu9t5v0__nand2_1
XTAP_TAPCELL_ROW_30_1795 VSS VSS gf180mcu_fd_sc_mcu9t5v0__filltie
XTAP_TAPCELL_ROW_313_7691 VSS VSS gf180mcu_fd_sc_mcu9t5v0__filltie
XTAP_TAPCELL_ROW_313_7680 VSS VSS gf180mcu_fd_sc_mcu9t5v0__filltie
XTAP_TAPCELL_ROW_214_4963 VSS VSS gf180mcu_fd_sc_mcu9t5v0__filltie
XTAP_TAPCELL_ROW_214_4952 VSS VSS gf180mcu_fd_sc_mcu9t5v0__filltie
XTAP_TAPCELL_ROW_210_4838 VSS VSS gf180mcu_fd_sc_mcu9t5v0__filltie
XTAP_TAPCELL_ROW_322_7938 VSS VSS gf180mcu_fd_sc_mcu9t5v0__filltie
XTAP_TAPCELL_ROW_322_7927 VSS VSS gf180mcu_fd_sc_mcu9t5v0__filltie
XTAP_TAPCELL_ROW_322_7916 VSS VSS gf180mcu_fd_sc_mcu9t5v0__filltie
XTAP_TAPCELL_ROW_210_4849 VSS VSS gf180mcu_fd_sc_mcu9t5v0__filltie
XPHY_EDGE_ROW_187_2_Right_918 VSS VSS gf180mcu_fd_sc_mcu9t5v0__endcap
XTAP_TAPCELL_ROW_113_4084 VSS VSS gf180mcu_fd_sc_mcu9t5v0__filltie
XTAP_TAPCELL_ROW_113_4095 VSS VSS gf180mcu_fd_sc_mcu9t5v0__filltie
XTAP_TAPCELL_ROW_299_7296 VSS VSS gf180mcu_fd_sc_mcu9t5v0__filltie
XTAP_TAPCELL_ROW_299_7285 VSS VSS gf180mcu_fd_sc_mcu9t5v0__filltie
X_20117_ _20117_/D clkload76/I _20117_/Q VSS VSS VSS VSS gf180mcu_fd_sc_mcu9t5v0__dffq_1
X_09928_ _19260_/Q _10165_/A2 _10166_/A2 _19268_/Q _10166_/B1 _19284_/Q _09929_/I
+ VSS _09928_/VNW VSS VSS gf180mcu_fd_sc_mcu9t5v0__aoi222_1
XTAP_TAPCELL_ROW_126_4456 VSS VSS gf180mcu_fd_sc_mcu9t5v0__filltie
XTAP_TAPCELL_ROW_126_4445 VSS VSS gf180mcu_fd_sc_mcu9t5v0__filltie
XTAP_TAPCELL_ROW_126_4434 VSS VSS gf180mcu_fd_sc_mcu9t5v0__filltie
XTAP_TAPCELL_ROW_157_3_8072 VSS VSS gf180mcu_fd_sc_mcu9t5v0__filltie
X_20048_ _20048_/D _20048_/RN clkload41/I _20048_/Q VSS VSS VSS VSS gf180mcu_fd_sc_mcu9t5v0__dffrnq_1
X_09859_ _20033_/Q _09859_/A2 _17075_/A2 VSS VSS VSS VSS gf180mcu_fd_sc_mcu9t5v0__nand2_1
X_12870_ _12870_/A1 _12870_/A2 _12870_/B _12889_/A1 VSS VSS VSS VSS gf180mcu_fd_sc_mcu9t5v0__oai21_1
X_11821_ _12324_/B _11821_/A2 _11821_/A3 _11822_/B VSS _16494_/VNW VSS VSS gf180mcu_fd_sc_mcu9t5v0__nand3_1
X_14540_ _19168_/Q _19134_/Q _14540_/Z VSS VSS VSS VSS gf180mcu_fd_sc_mcu9t5v0__xor2_1
X_11752_ _18221_/Q _12315_/S _12322_/B _11755_/A2 VSS VSS VSS VSS gf180mcu_fd_sc_mcu9t5v0__aoi21_1
X_10703_ _20030_/Q _10703_/A2 _10703_/B _17416_/I0 VSS VSS VSS VSS gf180mcu_fd_sc_mcu9t5v0__oai21_4
X_11683_ _11706_/B _11706_/A1 _11698_/A1 VSS _17546_/VNW VSS VSS gf180mcu_fd_sc_mcu9t5v0__nor2_1
XTAP_TAPCELL_ROW_150_3_8048 VSS VSS gf180mcu_fd_sc_mcu9t5v0__filltie
XPHY_EDGE_ROW_189_1_Left_512 VSS VSS gf180mcu_fd_sc_mcu9t5v0__endcap
XTAP_TAPCELL_ROW_77_3109 VSS VSS gf180mcu_fd_sc_mcu9t5v0__filltie
X_14471_ _19160_/Q _19126_/Q _14473_/B VSS _14474_/VNW VSS VSS gf180mcu_fd_sc_mcu9t5v0__xor2_1
X_16210_ _16142_/C _19265_/Q _16783_/S _16210_/Z VSS VSS VSS VSS gf180mcu_fd_sc_mcu9t5v0__mux2_1
X_17190_ _17198_/A1 _17190_/A2 _17190_/A3 _17190_/B _17199_/A2 VSS _17190_/VNW VSS
+ VSS gf180mcu_fd_sc_mcu9t5v0__oai31_1
X_10634_ _10459_/C _10634_/A2 _10634_/A3 _10634_/B _10643_/A2 VSS _11314_/VNW VSS
+ VSS gf180mcu_fd_sc_mcu9t5v0__oai31_1
X_13422_ _13422_/A1 _13422_/A2 _13422_/A3 _13422_/B _13441_/A1 VSS _13422_/VNW VSS
+ VSS gf180mcu_fd_sc_mcu9t5v0__oai31_1
X_16141_ _19233_/Q _16730_/C _16144_/A2 VSS VSS VSS VSS gf180mcu_fd_sc_mcu9t5v0__nor2_1
X_13353_ _13354_/A1 _13354_/A2 _13353_/B _13375_/A2 VSS VSS VSS VSS gf180mcu_fd_sc_mcu9t5v0__oai21_1
XTAP_TAPCELL_ROW_40_2080 VSS VSS gf180mcu_fd_sc_mcu9t5v0__filltie
XTAP_TAPCELL_ROW_284_6886 VSS VSS gf180mcu_fd_sc_mcu9t5v0__filltie
XTAP_TAPCELL_ROW_284_6875 VSS VSS gf180mcu_fd_sc_mcu9t5v0__filltie
X_12304_ _12299_/Z _12303_/Z _12348_/C _12305_/B VSS _17365_/VNW VSS VSS gf180mcu_fd_sc_mcu9t5v0__mux2_1
X_10565_ _10643_/B2 _10565_/A2 _10565_/B1 _10643_/A1 _19828_/Q _10565_/C2 _10567_/A2
+ VSS VSS VSS VSS gf180mcu_fd_sc_mcu9t5v0__aoi222_1
Xeco6_buf_15979 _15979_/ZN _16750_/A1 VSS VSS VSS VSS gf180mcu_fd_sc_mcu9t5v0__clkbuf_16
XTAP_TAPCELL_ROW_40_2091 VSS VSS gf180mcu_fd_sc_mcu9t5v0__filltie
X_16072_ _15996_/B _16072_/A2 _16072_/A3 _16072_/B _16073_/I1 VSS VSS VSS VSS gf180mcu_fd_sc_mcu9t5v0__oai31_1
X_10496_ _20102_/Q _17407_/C _10497_/B VSS _10496_/VNW VSS VSS gf180mcu_fd_sc_mcu9t5v0__nand2_1
X_13284_ _12734_/Z _13283_/Z _13285_/A2 VSS _13300_/VNW VSS VSS gf180mcu_fd_sc_mcu9t5v0__nand2_1
X_19900_ _19900_/D _20028_/RN clkload40/I _19900_/Q VSS VSS VSS VSS gf180mcu_fd_sc_mcu9t5v0__dffrnq_1
X_12235_ _12235_/A1 _12235_/A2 _12235_/B _12257_/B VSS VSS VSS VSS gf180mcu_fd_sc_mcu9t5v0__aoi21_1
X_15023_ _19437_/Q _15022_/Z _15024_/I1 VSS VSS VSS VSS gf180mcu_fd_sc_mcu9t5v0__xnor2_1
X_12166_ _12166_/A1 _12166_/A2 _12166_/Z VSS VSS VSS VSS gf180mcu_fd_sc_mcu9t5v0__or2_1
X_19831_ _19831_/D _20023_/RN clkload55/I _19831_/Q VSS VSS VSS VSS gf180mcu_fd_sc_mcu9t5v0__dffrnq_1
XTAP_TAPCELL_ROW_53_2430 VSS VSS gf180mcu_fd_sc_mcu9t5v0__filltie
XTAP_TAPCELL_ROW_53_2441 VSS VSS gf180mcu_fd_sc_mcu9t5v0__filltie
XTAP_TAPCELL_ROW_53_2452 VSS VSS gf180mcu_fd_sc_mcu9t5v0__filltie
X_11117_ _18202_/Q _18186_/Q _11403_/S _11117_/Z VSS _15954_/VNW VSS VSS gf180mcu_fd_sc_mcu9t5v0__mux2_1
XTAP_TAPCELL_ROW_220_5112 VSS VSS gf180mcu_fd_sc_mcu9t5v0__filltie
X_16974_ _18478_/Q _16973_/Z _16986_/S _18478_/D VSS VSS VSS VSS gf180mcu_fd_sc_mcu9t5v0__mux2_4
XTAP_TAPCELL_ROW_220_5134 VSS VSS gf180mcu_fd_sc_mcu9t5v0__filltie
XTAP_TAPCELL_ROW_220_5123 VSS VSS gf180mcu_fd_sc_mcu9t5v0__filltie
X_12097_ wire208/Z _12097_/A2 _12096_/Z _12098_/A2 VSS VSS VSS VSS gf180mcu_fd_sc_mcu9t5v0__nand3_1
X_19762_ _19762_/D _20018_/RN clkload42/I _19762_/Q VSS VSS VSS VSS gf180mcu_fd_sc_mcu9t5v0__dffrnq_1
X_15925_ _20134_/Q _19255_/Q _15928_/S _20134_/D VSS VSS VSS VSS gf180mcu_fd_sc_mcu9t5v0__mux2_1
X_18713_ _18713_/D clkload48/I _18713_/Q VSS VSS VSS VSS gf180mcu_fd_sc_mcu9t5v0__dffq_1
XPHY_EDGE_ROW_177_3_Left_835 VSS VSS gf180mcu_fd_sc_mcu9t5v0__endcap
XTAP_TAPCELL_ROW_109_3986 VSS VSS gf180mcu_fd_sc_mcu9t5v0__filltie
XTAP_TAPCELL_ROW_109_3975 VSS VSS gf180mcu_fd_sc_mcu9t5v0__filltie
X_19693_ _19693_/D _20141_/RN clkload30/I _19693_/Q VSS VSS VSS VSS gf180mcu_fd_sc_mcu9t5v0__dffrnq_1
X_11048_ _18034_/I0 _19049_/Q _11051_/S _19049_/D VSS VSS VSS VSS gf180mcu_fd_sc_mcu9t5v0__mux2_1
Xinput8 din[7] input8/Z VSS VSS VSS VSS gf180mcu_fd_sc_mcu9t5v0__clkbuf_2
X_18644_ _18644_/D _20048_/RN clkload65/I _18644_/Q VSS VSS VSS VSS gf180mcu_fd_sc_mcu9t5v0__dffrnq_1
X_15856_ _19195_/Q _15929_/A2 _15941_/A3 _15857_/A2 VSS VSS VSS VSS gf180mcu_fd_sc_mcu9t5v0__nand3_1
XTAP_TAPCELL_ROW_66_2802 VSS VSS gf180mcu_fd_sc_mcu9t5v0__filltie
X_14807_ _19401_/Q _19338_/Q _14811_/A2 VSS VSS VSS VSS gf180mcu_fd_sc_mcu9t5v0__nand2_1
XTAP_TAPCELL_ROW_218_5063 VSS VSS gf180mcu_fd_sc_mcu9t5v0__filltie
XTAP_TAPCELL_ROW_218_5052 VSS VSS gf180mcu_fd_sc_mcu9t5v0__filltie
X_15787_ _18022_/I0 _19957_/Q _15802_/S _19957_/D VSS VSS VSS VSS gf180mcu_fd_sc_mcu9t5v0__mux2_1
XTAP_TAPCELL_ROW_47_2267 VSS VSS gf180mcu_fd_sc_mcu9t5v0__filltie
X_18575_ _18575_/D _20139_/RN clkload28/I _18575_/Q VSS VSS VSS VSS gf180mcu_fd_sc_mcu9t5v0__dffrnq_1
XTAP_TAPCELL_ROW_47_2278 VSS VSS gf180mcu_fd_sc_mcu9t5v0__filltie
X_12999_ _12999_/I _13022_/A1 VSS VSS VSS VSS gf180mcu_fd_sc_mcu9t5v0__clkinv_1
XTAP_TAPCELL_ROW_218_5074 VSS VSS gf180mcu_fd_sc_mcu9t5v0__filltie
X_17526_ input5/Z _18631_/Q _17529_/S _18631_/D VSS VSS VSS VSS gf180mcu_fd_sc_mcu9t5v0__mux2_1
X_14738_ _14738_/A1 _14738_/A2 _14738_/B _14741_/A2 VSS VSS VSS VSS gf180mcu_fd_sc_mcu9t5v0__aoi21_1
XPHY_EDGE_ROW_173_1_Left_496 VSS VSS gf180mcu_fd_sc_mcu9t5v0__endcap
X_14669_ _13722_/Z _14671_/A2 _14670_/I0 VSS _14669_/VNW VSS VSS gf180mcu_fd_sc_mcu9t5v0__xnor2_1
X_17457_ _17461_/A1 _17475_/A2 _18575_/Q _17458_/A2 VSS _17457_/VNW VSS VSS gf180mcu_fd_sc_mcu9t5v0__aoi21_1
X_17388_ _17407_/C _17388_/A2 _17388_/B wire168/Z _17389_/C VSS _17388_/VNW VSS VSS
+ gf180mcu_fd_sc_mcu9t5v0__oai211_1
X_16408_ _16408_/I0 _16408_/I1 _16787_/S _16408_/Z VSS VSS VSS VSS gf180mcu_fd_sc_mcu9t5v0__mux2_1
X_16339_ _19229_/Q _16009_/B _16871_/S _16339_/Z VSS VSS VSS VSS gf180mcu_fd_sc_mcu9t5v0__mux2_1
X_19127_ _19127_/D _20023_/RN clkload10/I _19127_/Q VSS VSS VSS VSS gf180mcu_fd_sc_mcu9t5v0__dffrnq_1
XTAP_TAPCELL_ROW_163_3_8093 VSS VSS gf180mcu_fd_sc_mcu9t5v0__filltie
X_19058_ _19058_/D _20018_/RN clkload13/I _19058_/Q VSS VSS VSS VSS gf180mcu_fd_sc_mcu9t5v0__dffrnq_1
X_18009_ _18025_/I0 _18894_/Q _18021_/S _18894_/D VSS _18009_/VNW VSS VSS gf180mcu_fd_sc_mcu9t5v0__mux2_1
XTAP_TAPCELL_ROW_302_7381 VSS VSS gf180mcu_fd_sc_mcu9t5v0__filltie
XTAP_TAPCELL_ROW_302_7370 VSS VSS gf180mcu_fd_sc_mcu9t5v0__filltie
XTAP_TAPCELL_ROW_36_1960 VSS VSS gf180mcu_fd_sc_mcu9t5v0__filltie
XTAP_TAPCELL_ROW_294_7160 VSS VSS gf180mcu_fd_sc_mcu9t5v0__filltie
XTAP_TAPCELL_ROW_36_1971 VSS VSS gf180mcu_fd_sc_mcu9t5v0__filltie
XTAP_TAPCELL_ROW_36_1982 VSS VSS gf180mcu_fd_sc_mcu9t5v0__filltie
XTAP_TAPCELL_ROW_290_7046 VSS VSS gf180mcu_fd_sc_mcu9t5v0__filltie
XTAP_TAPCELL_ROW_315_7720 VSS VSS gf180mcu_fd_sc_mcu9t5v0__filltie
XTAP_TAPCELL_ROW_290_7035 VSS VSS gf180mcu_fd_sc_mcu9t5v0__filltie
X_09713_ _20060_/Q _20059_/Q _20061_/Q _10819_/A2 VSS _09713_/VNW VSS VSS gf180mcu_fd_sc_mcu9t5v0__nand3_1
XTAP_TAPCELL_ROW_121_4320 VSS VSS gf180mcu_fd_sc_mcu9t5v0__filltie
XTAP_TAPCELL_ROW_32_1857 VSS VSS gf180mcu_fd_sc_mcu9t5v0__filltie
XTAP_TAPCELL_ROW_32_1868 VSS VSS gf180mcu_fd_sc_mcu9t5v0__filltie
XTAP_TAPCELL_ROW_315_7742 VSS VSS gf180mcu_fd_sc_mcu9t5v0__filltie
XTAP_TAPCELL_ROW_290_7057 VSS VSS gf180mcu_fd_sc_mcu9t5v0__filltie
XTAP_TAPCELL_ROW_315_7731 VSS VSS gf180mcu_fd_sc_mcu9t5v0__filltie
X_09644_ _15824_/B2 _15824_/A1 _19991_/Q _20005_/Q _09647_/B VSS VSS VSS VSS gf180mcu_fd_sc_mcu9t5v0__oai31_1
XTAP_TAPCELL_ROW_311_7617 VSS VSS gf180mcu_fd_sc_mcu9t5v0__filltie
XPHY_EDGE_ROW_208_2_Left_720 VSS VSS gf180mcu_fd_sc_mcu9t5v0__endcap
XTAP_TAPCELL_ROW_311_7628 VSS VSS gf180mcu_fd_sc_mcu9t5v0__filltie
X_09575_ _10715_/C _10806_/B _09575_/B _10657_/B VSS _10930_/VNW VSS VSS gf180mcu_fd_sc_mcu9t5v0__aoi21_1
XTAP_TAPCELL_ROW_119_4260 VSS VSS gf180mcu_fd_sc_mcu9t5v0__filltie
XTAP_TAPCELL_ROW_115_4146 VSS VSS gf180mcu_fd_sc_mcu9t5v0__filltie
XTAP_TAPCELL_ROW_115_4135 VSS VSS gf180mcu_fd_sc_mcu9t5v0__filltie
XTAP_TAPCELL_ROW_309_7579 VSS VSS gf180mcu_fd_sc_mcu9t5v0__filltie
XTAP_TAPCELL_ROW_309_7568 VSS VSS gf180mcu_fd_sc_mcu9t5v0__filltie
XTAP_TAPCELL_ROW_309_7557 VSS VSS gf180mcu_fd_sc_mcu9t5v0__filltie
XTAP_TAPCELL_ROW_115_4157 VSS VSS gf180mcu_fd_sc_mcu9t5v0__filltie
X_10350_ _17260_/S _11153_/A1 _10351_/B VSS VSS VSS VSS gf180mcu_fd_sc_mcu9t5v0__nand2_1
X_10281_ _18940_/Q wire166/Z _10283_/A2 VSS VSS VSS VSS gf180mcu_fd_sc_mcu9t5v0__nand2_1
XPHY_EDGE_ROW_188_2_Right_919 VSS VSS gf180mcu_fd_sc_mcu9t5v0__endcap
XTAP_TAPCELL_ROW_128_4507 VSS VSS gf180mcu_fd_sc_mcu9t5v0__filltie
X_12020_ _12092_/B _12018_/Z _12020_/B _12208_/C _12026_/A2 VSS VSS VSS VSS gf180mcu_fd_sc_mcu9t5v0__aoi211_1
Xhold_dlya_din1 input2/Z wire301/I VSS VSS VSS VSS gf180mcu_fd_sc_mcu9t5v0__dlya_4
Xclkbuf_leaf_43_clk_regs clkload6/I clkload80/I VSS _11867_/VNW VSS VSS gf180mcu_fd_sc_mcu9t5v0__clkbuf_8
X_13971_ _13973_/A2 _13973_/A3 _14007_/B VSS VSS VSS VSS gf180mcu_fd_sc_mcu9t5v0__or2_1
XTAP_TAPCELL_ROW_277_6690 VSS VSS gf180mcu_fd_sc_mcu9t5v0__filltie
X_16690_ _19247_/Q _16730_/C _16692_/B1 VSS VSS VSS VSS gf180mcu_fd_sc_mcu9t5v0__nor2_1
X_15710_ _19919_/Q _15704_/Z _15710_/B _15712_/A3 VSS _15710_/VNW VSS VSS gf180mcu_fd_sc_mcu9t5v0__aoi21_1
X_12922_ _12930_/A1 _12930_/A2 _12926_/A2 VSS VSS VSS VSS gf180mcu_fd_sc_mcu9t5v0__nand2_1
XTAP_TAPCELL_ROW_273_6576 VSS VSS gf180mcu_fd_sc_mcu9t5v0__filltie
XTAP_TAPCELL_ROW_273_6565 VSS VSS gf180mcu_fd_sc_mcu9t5v0__filltie
X_15641_ _19899_/Q _15640_/B _15645_/A2 VSS VSS VSS VSS gf180mcu_fd_sc_mcu9t5v0__nor2_1
XTAP_TAPCELL_ROW_104_3850 VSS VSS gf180mcu_fd_sc_mcu9t5v0__filltie
XTAP_TAPCELL_ROW_273_6587 VSS VSS gf180mcu_fd_sc_mcu9t5v0__filltie
X_12853_ _12845_/Z _12853_/A2 _12853_/B _12861_/A1 VSS VSS VSS VSS gf180mcu_fd_sc_mcu9t5v0__oai21_1
XTAP_TAPCELL_ROW_100_3725 VSS VSS gf180mcu_fd_sc_mcu9t5v0__filltie
X_18360_ _18360_/D clkload77/I _18360_/Q VSS VSS VSS VSS gf180mcu_fd_sc_mcu9t5v0__dffq_1
X_11804_ _11804_/A1 _11804_/A2 _11804_/B _12347_/C _11805_/B VSS VSS VSS VSS gf180mcu_fd_sc_mcu9t5v0__oai211_1
XTAP_TAPCELL_ROW_100_3736 VSS VSS gf180mcu_fd_sc_mcu9t5v0__filltie
X_15572_ _18028_/I0 _18026_/I0 _18027_/I0 _18024_/I0 _15572_/Z VSS VSS VSS VSS gf180mcu_fd_sc_mcu9t5v0__and4_1
X_12784_ _12784_/A1 _12783_/Z _12784_/Z VSS VSS VSS VSS gf180mcu_fd_sc_mcu9t5v0__and2_1
X_18291_ _18291_/D _18291_/CLK _18291_/Q VSS VSS VSS VSS gf180mcu_fd_sc_mcu9t5v0__dffq_1
X_17311_ _18548_/Q _17394_/A2 _17331_/B VSS VSS VSS VSS gf180mcu_fd_sc_mcu9t5v0__nand2_1
X_11735_ _11735_/A1 _12116_/C _11735_/B1 _11735_/B2 _12092_/B _11736_/B VSS VSS VSS
+ VSS gf180mcu_fd_sc_mcu9t5v0__aoi221_1
XTAP_TAPCELL_ROW_42_2131 VSS VSS gf180mcu_fd_sc_mcu9t5v0__filltie
XTAP_TAPCELL_ROW_42_2142 VSS VSS gf180mcu_fd_sc_mcu9t5v0__filltie
X_14523_ _19166_/Q _19132_/Q _14738_/B VSS VSS VSS VSS gf180mcu_fd_sc_mcu9t5v0__and2_1
XTAP_TAPCELL_ROW_286_6948 VSS VSS gf180mcu_fd_sc_mcu9t5v0__filltie
XTAP_TAPCELL_ROW_286_6937 VSS VSS gf180mcu_fd_sc_mcu9t5v0__filltie
X_17242_ _18352_/Q _17282_/A2 _17282_/B1 _18368_/Q _17406_/C _17243_/B2 VSS VSS VSS
+ VSS gf180mcu_fd_sc_mcu9t5v0__aoi221_1
XTAP_TAPCELL_ROW_286_6926 VSS VSS gf180mcu_fd_sc_mcu9t5v0__filltie
X_14454_ _14454_/A1 _14766_/A2 _14454_/B1 _14456_/B1 _19455_/D VSS VSS VSS VSS gf180mcu_fd_sc_mcu9t5v0__aoi22_1
X_13405_ _19776_/Q _19810_/Q _13405_/A3 _13409_/A2 VSS VSS VSS VSS gf180mcu_fd_sc_mcu9t5v0__xnor3_1
X_11666_ _12665_/B _11666_/A2 _12645_/B2 _11668_/A2 VSS _11676_/VNW VSS VSS gf180mcu_fd_sc_mcu9t5v0__nand3_1
X_17173_ _18525_/Q _18509_/Q _17260_/S _17173_/Z VSS VSS VSS VSS gf180mcu_fd_sc_mcu9t5v0__mux2_1
X_10617_ _10459_/C _10617_/A2 _10617_/A3 _10617_/B _10618_/B1 VSS VSS VSS VSS gf180mcu_fd_sc_mcu9t5v0__oai31_1
X_14385_ _13744_/C _14385_/A2 _19447_/D VSS _14385_/VNW VSS VSS gf180mcu_fd_sc_mcu9t5v0__nor2_1
X_11597_ _11611_/B _11593_/Z _11595_/Z _12632_/C VSS _11603_/VNW VSS VSS gf180mcu_fd_sc_mcu9t5v0__nand3_1
X_10548_ _17306_/C _10548_/A2 _10549_/B2 VSS VSS VSS VSS gf180mcu_fd_sc_mcu9t5v0__nor2_1
X_16124_ _19261_/Q _16751_/B _16125_/A3 VSS VSS VSS VSS gf180mcu_fd_sc_mcu9t5v0__nor2_1
XTAP_TAPCELL_ROW_55_2503 VSS VSS gf180mcu_fd_sc_mcu9t5v0__filltie
X_13336_ _19740_/Q _19772_/Q _13336_/Z VSS VSS VSS VSS gf180mcu_fd_sc_mcu9t5v0__xor2_1
X_16055_ _18160_/Q _16055_/I1 _16670_/S _18160_/D VSS VSS VSS VSS gf180mcu_fd_sc_mcu9t5v0__mux2_1
X_13267_ _13267_/I0 _19246_/Q _13304_/B _19246_/D VSS _13573_/VNW VSS VSS gf180mcu_fd_sc_mcu9t5v0__mux2_1
Xrst_tree_leaf_12 rst_tree_mid_1/Z _20071_/RN VSS VSS VSS VSS gf180mcu_fd_sc_mcu9t5v0__clkbuf_16
Xrst_tree_leaf_23 rst_tree_mid_2/Z _20060_/RN VSS VSS VSS VSS gf180mcu_fd_sc_mcu9t5v0__clkbuf_16
X_10479_ _18980_/Q _10804_/A2 wire165/Z _18964_/Q _10480_/A3 VSS VSS VSS VSS gf180mcu_fd_sc_mcu9t5v0__aoi22_1
Xrst_tree_leaf_56 rst_tree_mid_7/Z _19963_/RN VSS VSS VSS VSS gf180mcu_fd_sc_mcu9t5v0__clkbuf_16
Xrst_tree_leaf_34 rst_tree_mid_4/Z _20049_/RN VSS VSS VSS VSS gf180mcu_fd_sc_mcu9t5v0__clkbuf_16
Xrst_tree_leaf_45 rst_tree_mid_5/Z _20038_/RN VSS VSS VSS VSS gf180mcu_fd_sc_mcu9t5v0__clkbuf_16
X_12218_ _12235_/A1 _12235_/A2 _12232_/A2 VSS VSS VSS VSS gf180mcu_fd_sc_mcu9t5v0__xnor2_1
X_15006_ _19377_/Q _19434_/Q _15011_/A1 VSS _15006_/VNW VSS VSS gf180mcu_fd_sc_mcu9t5v0__nand2_1
X_13198_ _13198_/A1 _13198_/A2 _13214_/A1 _13199_/A2 VSS VSS VSS VSS gf180mcu_fd_sc_mcu9t5v0__xnor3_1
X_12149_ _18912_/Q _12172_/A3 _12217_/B _12150_/A2 VSS VSS VSS VSS gf180mcu_fd_sc_mcu9t5v0__oai21_1
X_19814_ _19814_/D _20070_/RN clkload30/I _19814_/Q VSS VSS VSS VSS gf180mcu_fd_sc_mcu9t5v0__dffrnq_1
X_16957_ _16957_/A1 _16809_/S _16957_/B _16958_/I0 VSS _16957_/VNW VSS VSS gf180mcu_fd_sc_mcu9t5v0__oai21_1
XTAP_TAPCELL_ROW_139_3_8011 VSS VSS gf180mcu_fd_sc_mcu9t5v0__filltie
X_19745_ _19745_/D _20065_/RN clkload37/I _19745_/Q VSS VSS VSS VSS gf180mcu_fd_sc_mcu9t5v0__dffrnq_1
X_15908_ _20117_/Q _19253_/Q _15912_/S _20117_/D VSS _17286_/VNW VSS VSS gf180mcu_fd_sc_mcu9t5v0__mux2_1
XTAP_TAPCELL_ROW_49_2318 VSS VSS gf180mcu_fd_sc_mcu9t5v0__filltie
XTAP_TAPCELL_ROW_49_2329 VSS VSS gf180mcu_fd_sc_mcu9t5v0__filltie
X_16888_ _18436_/Q _16887_/Z wire38/Z _18436_/D VSS VSS VSS VSS gf180mcu_fd_sc_mcu9t5v0__mux2_1
X_19676_ _19676_/D _20060_/RN clkload43/I _19676_/Q VSS VSS VSS VSS gf180mcu_fd_sc_mcu9t5v0__dffrnq_1
X_15839_ _20143_/Q _15850_/A2 _15840_/A2 VSS VSS VSS VSS gf180mcu_fd_sc_mcu9t5v0__nand2_1
X_18627_ _18627_/D _20031_/RN clkload48/I _18627_/Q VSS VSS VSS VSS gf180mcu_fd_sc_mcu9t5v0__dffrnq_1
X_09360_ _18234_/Q _11115_/A1 VSS _16582_/VNW VSS VSS gf180mcu_fd_sc_mcu9t5v0__clkinv_1
X_18558_ _18558_/D _20058_/RN clkload38/I _18558_/Q VSS VSS VSS VSS gf180mcu_fd_sc_mcu9t5v0__dffrnq_1
X_17509_ _18614_/Q _19255_/Q _17513_/S _18614_/D VSS VSS VSS VSS gf180mcu_fd_sc_mcu9t5v0__mux2_1
X_09291_ _19251_/Q _16709_/A1 VSS VSS VSS VSS gf180mcu_fd_sc_mcu9t5v0__clkinv_1
X_18489_ _18489_/D clkload52/I _18489_/Q VSS VSS VSS VSS gf180mcu_fd_sc_mcu9t5v0__dffq_1
XANTENNA_13 _11791_/B VSS VSS VSS VSS gf180mcu_fd_sc_mcu9t5v0__antenna
XANTENNA_24 output19/I VSS VSS VSS VSS gf180mcu_fd_sc_mcu9t5v0__antenna
XTAP_TAPCELL_ROW_25_1661 VSS VSS gf180mcu_fd_sc_mcu9t5v0__filltie
XTAP_TAPCELL_ROW_25_1672 VSS VSS gf180mcu_fd_sc_mcu9t5v0__filltie
XTAP_TAPCELL_ROW_21_1547 VSS VSS gf180mcu_fd_sc_mcu9t5v0__filltie
XTAP_TAPCELL_ROW_25_1683 VSS VSS gf180mcu_fd_sc_mcu9t5v0__filltie
XTAP_TAPCELL_ROW_304_7432 VSS VSS gf180mcu_fd_sc_mcu9t5v0__filltie
XTAP_TAPCELL_ROW_304_7421 VSS VSS gf180mcu_fd_sc_mcu9t5v0__filltie
XTAP_TAPCELL_ROW_110_4021 VSS VSS gf180mcu_fd_sc_mcu9t5v0__filltie
XTAP_TAPCELL_ROW_110_4010 VSS VSS gf180mcu_fd_sc_mcu9t5v0__filltie
XTAP_TAPCELL_ROW_21_1558 VSS VSS gf180mcu_fd_sc_mcu9t5v0__filltie
XTAP_TAPCELL_ROW_21_1569 VSS VSS gf180mcu_fd_sc_mcu9t5v0__filltie
XTAP_TAPCELL_ROW_304_7443 VSS VSS gf180mcu_fd_sc_mcu9t5v0__filltie
XTAP_TAPCELL_ROW_300_7307 VSS VSS gf180mcu_fd_sc_mcu9t5v0__filltie
XTAP_TAPCELL_ROW_300_7329 VSS VSS gf180mcu_fd_sc_mcu9t5v0__filltie
XTAP_TAPCELL_ROW_296_7222 VSS VSS gf180mcu_fd_sc_mcu9t5v0__filltie
XTAP_TAPCELL_ROW_300_7318 VSS VSS gf180mcu_fd_sc_mcu9t5v0__filltie
XTAP_TAPCELL_ROW_296_7211 VSS VSS gf180mcu_fd_sc_mcu9t5v0__filltie
XTAP_TAPCELL_ROW_296_7200 VSS VSS gf180mcu_fd_sc_mcu9t5v0__filltie
XPHY_EDGE_ROW_285_Left_608 VSS VSS gf180mcu_fd_sc_mcu9t5v0__endcap
XTAP_TAPCELL_ROW_34_1908 VSS VSS gf180mcu_fd_sc_mcu9t5v0__filltie
XTAP_TAPCELL_ROW_34_1919 VSS VSS gf180mcu_fd_sc_mcu9t5v0__filltie
XTAP_TAPCELL_ROW_292_7108 VSS VSS gf180mcu_fd_sc_mcu9t5v0__filltie
XTAP_TAPCELL_ROW_19_1498 VSS VSS gf180mcu_fd_sc_mcu9t5v0__filltie
Xmax_cap26 _17006_/S _17024_/S VSS VSS VSS VSS gf180mcu_fd_sc_mcu9t5v0__clkbuf_16
XPHY_EDGE_ROW_294_Left_617 VSS VSS gf180mcu_fd_sc_mcu9t5v0__endcap
Xmax_cap48 _16477_/ZN _17023_/S VSS VSS VSS VSS gf180mcu_fd_sc_mcu9t5v0__clkbuf_16
Xmax_cap59 _16824_/S _16798_/S VSS VSS VSS VSS gf180mcu_fd_sc_mcu9t5v0__clkbuf_8
X_09627_ input8/Z _17777_/A1 input6/Z input5/Z _09635_/A2 VSS _09634_/VNW VSS VSS
+ gf180mcu_fd_sc_mcu9t5v0__nor4_1
X_09558_ _09558_/I _20051_/D VSS VSS VSS VSS gf180mcu_fd_sc_mcu9t5v0__clkinv_1
XTAP_TAPCELL_ROW_165_3_8101 VSS VSS gf180mcu_fd_sc_mcu9t5v0__filltie
XTAP_TAPCELL_ROW_117_4208 VSS VSS gf180mcu_fd_sc_mcu9t5v0__filltie
X_11520_ _18471_/Q _11524_/S _11520_/B _11521_/A2 VSS VSS VSS VSS gf180mcu_fd_sc_mcu9t5v0__oai21_1
X_09489_ _19069_/Q _14475_/B _09489_/B1 _12694_/A1 _09492_/B VSS VSS VSS VSS gf180mcu_fd_sc_mcu9t5v0__aoi22_1
XTAP_TAPCELL_ROW_281_6801 VSS VSS gf180mcu_fd_sc_mcu9t5v0__filltie
X_11451_ _18386_/Q _11534_/S _11453_/A2 VSS VSS VSS VSS gf180mcu_fd_sc_mcu9t5v0__nand2_1
XTAP_TAPCELL_ROW_266_6391 VSS VSS gf180mcu_fd_sc_mcu9t5v0__filltie
X_10402_ _17404_/S _18271_/Q _10404_/A3 VSS VSS VSS VSS gf180mcu_fd_sc_mcu9t5v0__nor2_1
XTAP_TAPCELL_ROW_266_6380 VSS VSS gf180mcu_fd_sc_mcu9t5v0__filltie
XTAP_TAPCELL_ROW_95_3595 VSS VSS gf180mcu_fd_sc_mcu9t5v0__filltie
X_11382_ _11423_/A1 _11382_/A2 _11382_/A3 _11382_/B _19093_/D VSS _17625_/VNW VSS
+ VSS gf180mcu_fd_sc_mcu9t5v0__oai31_1
X_14170_ _14355_/I0 _19325_/Q _14266_/S _19325_/D VSS VSS VSS VSS gf180mcu_fd_sc_mcu9t5v0__mux2_1
XTAP_TAPCELL_ROW_95_3584 VSS VSS gf180mcu_fd_sc_mcu9t5v0__filltie
X_10333_ _19851_/Q _10724_/C _10416_/B _10333_/C _10340_/A1 VSS VSS VSS VSS gf180mcu_fd_sc_mcu9t5v0__oai211_4
XTAP_TAPCELL_ROW_262_6266 VSS VSS gf180mcu_fd_sc_mcu9t5v0__filltie
XTAP_TAPCELL_ROW_145_3_8032 VSS VSS gf180mcu_fd_sc_mcu9t5v0__filltie
X_13121_ _13118_/Z _13121_/A2 _13541_/A2 VSS VSS VSS VSS gf180mcu_fd_sc_mcu9t5v0__nand2_1
XTAP_TAPCELL_ROW_262_6288 VSS VSS gf180mcu_fd_sc_mcu9t5v0__filltie
XTAP_TAPCELL_ROW_262_6277 VSS VSS gf180mcu_fd_sc_mcu9t5v0__filltie
Xload_slew219 _17378_/A1 _17195_/A1 VSS VSS VSS VSS gf180mcu_fd_sc_mcu9t5v0__clkbuf_8
XTAP_TAPCELL_ROW_279_6730 VSS VSS gf180mcu_fd_sc_mcu9t5v0__filltie
X_10264_ _18282_/Q _17282_/A2 _17282_/B1 _18298_/Q _10514_/B _10263_/Z _10273_/A2
+ VSS VSS VSS VSS gf180mcu_fd_sc_mcu9t5v0__aoi222_1
X_13052_ _19756_/Q _19790_/Q _13054_/B VSS VSS VSS VSS gf180mcu_fd_sc_mcu9t5v0__xor2_1
XTAP_TAPCELL_ROW_279_6752 VSS VSS gf180mcu_fd_sc_mcu9t5v0__filltie
XTAP_TAPCELL_ROW_279_6741 VSS VSS gf180mcu_fd_sc_mcu9t5v0__filltie
X_12003_ _12003_/A1 _12003_/A2 _12004_/A2 VSS _12003_/VNW VSS VSS gf180mcu_fd_sc_mcu9t5v0__xnor2_4
X_17860_ _18827_/Q _17856_/Z _17865_/A2 VSS VSS VSS VSS gf180mcu_fd_sc_mcu9t5v0__nand2_1
X_10195_ _20045_/Q _09873_/B _15672_/B _10201_/B _20045_/D VSS VSS VSS VSS gf180mcu_fd_sc_mcu9t5v0__oai31_1
XTAP_TAPCELL_ROW_275_6638 VSS VSS gf180mcu_fd_sc_mcu9t5v0__filltie
XTAP_TAPCELL_ROW_275_6627 VSS VSS gf180mcu_fd_sc_mcu9t5v0__filltie
X_16811_ _19286_/Q _16815_/A2 _16813_/A1 VSS _16811_/VNW VSS VSS gf180mcu_fd_sc_mcu9t5v0__nand2_1
XTAP_TAPCELL_ROW_106_3901 VSS VSS gf180mcu_fd_sc_mcu9t5v0__filltie
X_17791_ _17758_/Z _17791_/A2 _18768_/D VSS VSS VSS VSS gf180mcu_fd_sc_mcu9t5v0__and2_1
X_19530_ _19530_/D _20042_/RN clkload32/I _19530_/Q VSS VSS VSS VSS gf180mcu_fd_sc_mcu9t5v0__dffrnq_1
X_16742_ _18374_/Q _16742_/I1 _16753_/S _18374_/D VSS _16824_/VNW VSS VSS gf180mcu_fd_sc_mcu9t5v0__mux2_4
X_13954_ _13955_/A1 _13992_/A1 _13954_/Z VSS VSS VSS VSS gf180mcu_fd_sc_mcu9t5v0__or2_1
X_16673_ _19259_/Q _16751_/A2 wire71/Z _16675_/A2 VSS VSS VSS VSS gf180mcu_fd_sc_mcu9t5v0__nor3_4
X_12905_ _19774_/Q _12901_/Z _12902_/Z _12907_/A2 VSS VSS VSS VSS gf180mcu_fd_sc_mcu9t5v0__xnor3_1
X_19461_ _19461_/D _20037_/RN clkload12/I _19461_/Q VSS VSS VSS VSS gf180mcu_fd_sc_mcu9t5v0__dffrnq_1
X_13885_ _13885_/A1 _13885_/A2 _13917_/B1 VSS VSS VSS VSS gf180mcu_fd_sc_mcu9t5v0__xnor2_1
X_18412_ _18412_/D clkload60/I _18412_/Q VSS VSS VSS VSS gf180mcu_fd_sc_mcu9t5v0__dffq_1
X_15624_ _15677_/B _15623_/Z _15626_/B VSS VSS VSS VSS gf180mcu_fd_sc_mcu9t5v0__nand2_1
X_12836_ _12836_/A1 _12836_/A2 _12836_/B _12839_/A2 VSS _12836_/VNW VSS VSS gf180mcu_fd_sc_mcu9t5v0__oai21_1
XTAP_TAPCELL_ROW_44_2204 VSS VSS gf180mcu_fd_sc_mcu9t5v0__filltie
X_19392_ _19392_/D _09246_/I clkload21/I _19392_/Q VSS VSS VSS VSS gf180mcu_fd_sc_mcu9t5v0__dffrnq_1
X_15555_ _15566_/A1 _15553_/Z _15555_/A3 _19871_/D VSS VSS VSS VSS gf180mcu_fd_sc_mcu9t5v0__nor3_1
X_18343_ _18343_/D clkload69/I _18343_/Q VSS VSS VSS VSS gf180mcu_fd_sc_mcu9t5v0__dffq_1
XTAP_TAPCELL_ROW_251_5981 VSS VSS gf180mcu_fd_sc_mcu9t5v0__filltie
XTAP_TAPCELL_ROW_251_5970 VSS VSS gf180mcu_fd_sc_mcu9t5v0__filltie
X_14506_ _14507_/A1 _19129_/Q _14513_/A2 VSS VSS VSS VSS gf180mcu_fd_sc_mcu9t5v0__nor2_1
X_12767_ _12781_/C _12771_/A2 _12781_/A2 VSS VSS VSS VSS gf180mcu_fd_sc_mcu9t5v0__nor2_1
X_18274_ _18274_/D clkload80/I _18274_/Q VSS VSS VSS VSS gf180mcu_fd_sc_mcu9t5v0__dffq_4
X_11718_ _11718_/A1 _11718_/A2 _11718_/B1 _12153_/B _11748_/A2 VSS VSS VSS VSS gf180mcu_fd_sc_mcu9t5v0__aoi22_4
X_15486_ _15486_/A1 _15486_/A2 _19830_/D VSS VSS VSS VSS gf180mcu_fd_sc_mcu9t5v0__nor2_1
X_12698_ _17881_/A1 _12698_/A2 _12699_/A2 VSS _14385_/VNW VSS VSS gf180mcu_fd_sc_mcu9t5v0__nor2_1
X_17225_ _18609_/Q _17409_/B _17225_/B _17225_/C _17226_/A3 VSS VSS VSS VSS gf180mcu_fd_sc_mcu9t5v0__oai211_1
X_11649_ _11654_/C _12670_/A2 _11649_/B _12664_/C _11652_/A2 VSS _12635_/VNW VSS VSS
+ gf180mcu_fd_sc_mcu9t5v0__aoi211_1
X_14437_ _19155_/Q _19121_/Q _14439_/A2 VSS _14440_/VNW VSS VSS gf180mcu_fd_sc_mcu9t5v0__nor2_1
X_17156_ _17156_/A1 _17156_/A2 _17177_/B _17158_/A1 VSS VSS VSS VSS gf180mcu_fd_sc_mcu9t5v0__aoi21_1
X_14368_ _14590_/B _19438_/Q _14715_/S _19438_/D VSS VSS VSS VSS gf180mcu_fd_sc_mcu9t5v0__mux2_1
X_16107_ _16107_/A1 _16107_/A2 _16107_/B _16107_/C _16714_/A3 VSS VSS VSS VSS gf180mcu_fd_sc_mcu9t5v0__oai211_4
XTAP_TAPCELL_ROW_38_2019 VSS VSS gf180mcu_fd_sc_mcu9t5v0__filltie
X_13319_ _19739_/Q _19771_/Q _13337_/A1 _13320_/A2 VSS VSS VSS VSS gf180mcu_fd_sc_mcu9t5v0__xnor3_1
X_17087_ _18409_/Q _17282_/A2 _17282_/B1 _18425_/Q _17088_/B VSS VSS VSS VSS gf180mcu_fd_sc_mcu9t5v0__aoi22_1
X_14299_ _14366_/I0 _19372_/Q _14304_/S _19372_/D VSS _14966_/VNW VSS VSS gf180mcu_fd_sc_mcu9t5v0__mux2_1
X_16038_ _19233_/Q _16744_/A2 wire71/I _16039_/A3 VSS VSS VSS VSS gf180mcu_fd_sc_mcu9t5v0__nor3_1
XTAP_TAPCELL_ROW_245_5796 VSS VSS gf180mcu_fd_sc_mcu9t5v0__filltie
Xclkbuf_1_0__f_clk clkbuf_0_clk/Z clkbuf_1_0__f_clk/Z VSS VSS VSS VSS gf180mcu_fd_sc_mcu9t5v0__clkbuf_16
XTAP_TAPCELL_ROW_171_3_8122 VSS VSS gf180mcu_fd_sc_mcu9t5v0__filltie
X_17989_ _18875_/Q _18022_/I0 _17997_/S _18875_/D VSS VSS VSS VSS gf180mcu_fd_sc_mcu9t5v0__mux2_1
XTAP_TAPCELL_ROW_14_1362 VSS VSS gf180mcu_fd_sc_mcu9t5v0__filltie
XTAP_TAPCELL_ROW_14_1373 VSS VSS gf180mcu_fd_sc_mcu9t5v0__filltie
X_19728_ _19728_/D _20048_/RN clkload31/I _19728_/Q VSS VSS VSS VSS gf180mcu_fd_sc_mcu9t5v0__dffrnq_1
X_19659_ _19659_/D _20043_/RN clkload29/I _19659_/Q VSS VSS VSS VSS gf180mcu_fd_sc_mcu9t5v0__dffrnq_1
XTAP_TAPCELL_ROW_10_1248 VSS VSS gf180mcu_fd_sc_mcu9t5v0__filltie
XTAP_TAPCELL_ROW_10_1259 VSS VSS gf180mcu_fd_sc_mcu9t5v0__filltie
XPHY_EDGE_ROW_203_1_Left_526 VSS VSS gf180mcu_fd_sc_mcu9t5v0__endcap
X_09412_ _18832_/Q _18830_/Q _18831_/Q _09768_/A2 VSS VSS VSS VSS gf180mcu_fd_sc_mcu9t5v0__nand3_1
XPHY_EDGE_ROW_281_Right_208 VSS VSS gf180mcu_fd_sc_mcu9t5v0__endcap
XTAP_TAPCELL_ROW_27_1712 VSS VSS gf180mcu_fd_sc_mcu9t5v0__filltie
XTAP_TAPCELL_ROW_27_1723 VSS VSS gf180mcu_fd_sc_mcu9t5v0__filltie
X_09343_ _19471_/Q _14586_/A1 VSS VSS VSS VSS gf180mcu_fd_sc_mcu9t5v0__clkinv_1
XTAP_TAPCELL_ROW_27_1734 VSS VSS gf180mcu_fd_sc_mcu9t5v0__filltie
XTAP_TAPCELL_ROW_151_3_8053 VSS VSS gf180mcu_fd_sc_mcu9t5v0__filltie
X_09274_ _19991_/Q _15825_/B VSS VSS VSS VSS gf180mcu_fd_sc_mcu9t5v0__clkinv_1
XTAP_TAPCELL_ROW_23_1609 VSS VSS gf180mcu_fd_sc_mcu9t5v0__filltie
XTAP_TAPCELL_ROW_90_3470 VSS VSS gf180mcu_fd_sc_mcu9t5v0__filltie
XPHY_EDGE_ROW_198_1_Left_521 VSS VSS gf180mcu_fd_sc_mcu9t5v0__endcap
XTAP_TAPCELL_ROW_270_6502 VSS VSS gf180mcu_fd_sc_mcu9t5v0__filltie
XTAP_TAPCELL_ROW_255_6070 VSS VSS gf180mcu_fd_sc_mcu9t5v0__filltie
X_10951_ _19008_/Q _10950_/Z _10996_/S _19008_/D VSS VSS VSS VSS gf180mcu_fd_sc_mcu9t5v0__mux2_1
XTAP_TAPCELL_ROW_84_3285 VSS VSS gf180mcu_fd_sc_mcu9t5v0__filltie
XTAP_TAPCELL_ROW_255_6092 VSS VSS gf180mcu_fd_sc_mcu9t5v0__filltie
XTAP_TAPCELL_ROW_255_6081 VSS VSS gf180mcu_fd_sc_mcu9t5v0__filltie
XTAP_TAPCELL_ROW_84_3296 VSS VSS gf180mcu_fd_sc_mcu9t5v0__filltie
X_13670_ _14715_/S _13670_/A2 _14166_/B _13671_/B2 VSS VSS VSS VSS gf180mcu_fd_sc_mcu9t5v0__aoi21_1
X_10882_ _16426_/A1 _18147_/S _10892_/B _10883_/I0 VSS VSS VSS VSS gf180mcu_fd_sc_mcu9t5v0__oai21_1
X_12621_ _18585_/Q _12689_/A2 _12618_/B _18576_/Q _12689_/C _12622_/A2 VSS VSS VSS
+ VSS gf180mcu_fd_sc_mcu9t5v0__oai221_1
XPHY_EDGE_ROW_125_Right_125 VSS VSS gf180mcu_fd_sc_mcu9t5v0__endcap
X_12552_ _18496_/Q _12383_/S wire146/Z _12553_/B2 VSS VSS VSS VSS gf180mcu_fd_sc_mcu9t5v0__oai21_1
XTAP_TAPCELL_ROW_268_6442 VSS VSS gf180mcu_fd_sc_mcu9t5v0__filltie
XTAP_TAPCELL_ROW_268_6431 VSS VSS gf180mcu_fd_sc_mcu9t5v0__filltie
XTAP_TAPCELL_ROW_97_3657 VSS VSS gf180mcu_fd_sc_mcu9t5v0__filltie
X_15340_ _19645_/Q _19622_/Q _15345_/A2 VSS VSS VSS VSS gf180mcu_fd_sc_mcu9t5v0__xnor2_1
XTAP_TAPCELL_ROW_97_3646 VSS VSS gf180mcu_fd_sc_mcu9t5v0__filltie
XTAP_TAPCELL_ROW_268_6453 VSS VSS gf180mcu_fd_sc_mcu9t5v0__filltie
XTAP_TAPCELL_ROW_264_6317 VSS VSS gf180mcu_fd_sc_mcu9t5v0__filltie
X_11503_ _11503_/A1 _11503_/A2 _19102_/D VSS _11503_/VNW VSS VSS gf180mcu_fd_sc_mcu9t5v0__nand2_1
X_12483_ wire175/Z wire291/Z _12618_/B _12485_/A3 VSS VSS VSS VSS gf180mcu_fd_sc_mcu9t5v0__aoi21_1
X_15271_ _19634_/Q _19611_/Q _15271_/Z VSS _15272_/VNW VSS VSS gf180mcu_fd_sc_mcu9t5v0__and2_1
X_17010_ _18496_/Q _17009_/Z _17020_/S _18496_/D VSS _17235_/VNW VSS VSS gf180mcu_fd_sc_mcu9t5v0__mux2_4
XTAP_TAPCELL_ROW_264_6339 VSS VSS gf180mcu_fd_sc_mcu9t5v0__filltie
X_11434_ _11526_/B _11434_/A2 _11434_/B _11788_/B _11435_/B2 VSS VSS VSS VSS gf180mcu_fd_sc_mcu9t5v0__aoi211_2
XTAP_TAPCELL_ROW_264_6328 VSS VSS gf180mcu_fd_sc_mcu9t5v0__filltie
X_14222_ _19322_/Q _19301_/Q _14245_/C VSS _14245_/VNW VSS VSS gf180mcu_fd_sc_mcu9t5v0__nand2_1
XPHY_EDGE_ROW_186_3_Left_844 VSS VSS gf180mcu_fd_sc_mcu9t5v0__endcap
X_11365_ _11359_/B _11365_/A2 _11365_/A3 _11365_/B _11366_/B2 VSS _11365_/VNW VSS
+ VSS gf180mcu_fd_sc_mcu9t5v0__oai31_2
X_14153_ _19178_/Q _14152_/Z _14715_/S _14153_/Z VSS VSS VSS VSS gf180mcu_fd_sc_mcu9t5v0__mux2_1
X_18961_ _18961_/D _20049_/RN clkload70/I _18961_/Q VSS VSS VSS VSS gf180mcu_fd_sc_mcu9t5v0__dffrnq_1
X_10316_ _19825_/Q _11735_/A1 _10317_/B VSS VSS VSS VSS gf180mcu_fd_sc_mcu9t5v0__nand2_1
X_11296_ _11296_/A1 _11296_/A2 _19086_/D VSS VSS VSS VSS gf180mcu_fd_sc_mcu9t5v0__nand2_1
X_13104_ _13104_/A1 _13104_/A2 _13103_/B _13104_/Z VSS VSS VSS VSS gf180mcu_fd_sc_mcu9t5v0__and3_1
X_14084_ _19297_/Q _14245_/A1 _14085_/A1 _14116_/B VSS VSS VSS VSS gf180mcu_fd_sc_mcu9t5v0__nor3_1
X_10247_ _19848_/Q _10724_/C _10416_/B _10247_/C _10261_/A1 VSS VSS VSS VSS gf180mcu_fd_sc_mcu9t5v0__oai211_4
X_13035_ _13035_/I _13050_/A2 VSS VSS VSS VSS gf180mcu_fd_sc_mcu9t5v0__clkinv_1
X_17912_ _18841_/Q _17912_/A2 _17912_/A3 _17912_/Z VSS VSS VSS VSS gf180mcu_fd_sc_mcu9t5v0__xor3_1
XTAP_TAPCELL_ROW_240_5660 VSS VSS gf180mcu_fd_sc_mcu9t5v0__filltie
X_18892_ _18892_/D _20044_/RN clkload10/I _18892_/Q VSS VSS VSS VSS gf180mcu_fd_sc_mcu9t5v0__dffrnq_1
XTAP_TAPCELL_ROW_240_5682 VSS VSS gf180mcu_fd_sc_mcu9t5v0__filltie
XTAP_TAPCELL_ROW_240_5671 VSS VSS gf180mcu_fd_sc_mcu9t5v0__filltie
X_10178_ _10178_/A1 _10178_/A2 _10181_/A1 VSS VSS VSS VSS gf180mcu_fd_sc_mcu9t5v0__nand2_1
X_17843_ _19050_/Q _18820_/Q _17845_/S _18820_/D VSS VSS VSS VSS gf180mcu_fd_sc_mcu9t5v0__mux2_1
X_17774_ _18762_/Q _17779_/A2 _17775_/B VSS VSS VSS VSS gf180mcu_fd_sc_mcu9t5v0__nor2_1
X_14986_ _19430_/Q _19375_/Q _14986_/B _14992_/A1 VSS _15068_/VNW VSS VSS gf180mcu_fd_sc_mcu9t5v0__aoi21_1
X_16725_ _16730_/A1 _16641_/B _16725_/B _16725_/C _16727_/A2 VSS VSS VSS VSS gf180mcu_fd_sc_mcu9t5v0__aoi211_4
X_19513_ _19513_/D _20025_/RN clkload45/I _19513_/Q VSS VSS VSS VSS gf180mcu_fd_sc_mcu9t5v0__dffrnq_1
X_13937_ _13927_/Z _13960_/A2 _13937_/Z VSS VSS VSS VSS gf180mcu_fd_sc_mcu9t5v0__xor2_1
XTAP_TAPCELL_ROW_7_1169 VSS VSS gf180mcu_fd_sc_mcu9t5v0__filltie
X_19444_ _19444_/D _20020_/RN clkload12/I _19444_/Q VSS VSS VSS VSS gf180mcu_fd_sc_mcu9t5v0__dffrnq_1
X_16656_ _18357_/Q _16656_/I1 _16670_/S _18357_/D VSS _16656_/VNW VSS VSS gf180mcu_fd_sc_mcu9t5v0__mux2_1
X_13868_ _19308_/Q _13867_/Z _14139_/S _19308_/D VSS _14984_/VNW VSS VSS gf180mcu_fd_sc_mcu9t5v0__mux2_1
X_16587_ _18347_/Q _16587_/I1 _16602_/S _18347_/D VSS VSS VSS VSS gf180mcu_fd_sc_mcu9t5v0__mux2_4
X_15607_ _19888_/Q _15618_/A3 _15608_/A2 VSS VSS VSS VSS gf180mcu_fd_sc_mcu9t5v0__xnor2_1
X_12819_ _12819_/I0 _19207_/Q _13497_/B _19207_/D VSS VSS VSS VSS gf180mcu_fd_sc_mcu9t5v0__mux2_1
X_13799_ _19294_/Q _19318_/Q _13823_/B2 VSS _13799_/VNW VSS VSS gf180mcu_fd_sc_mcu9t5v0__nand2_1
X_19375_ _19375_/D _20143_/RN _19633_/CLK _19375_/Q VSS VSS VSS VSS gf180mcu_fd_sc_mcu9t5v0__dffrnq_1
X_18326_ _18326_/D _18328_/CLK _18326_/Q VSS VSS VSS VSS gf180mcu_fd_sc_mcu9t5v0__dffq_4
X_15538_ _19856_/Q _09065_/I _15544_/S _19856_/D VSS VSS VSS VSS gf180mcu_fd_sc_mcu9t5v0__mux2_1
XTAP_TAPCELL_ROW_234_5497 VSS VSS gf180mcu_fd_sc_mcu9t5v0__filltie
X_15469_ _19825_/Q _15469_/I1 _15471_/S _19825_/D VSS VSS VSS VSS gf180mcu_fd_sc_mcu9t5v0__mux2_1
X_18257_ _18257_/D clkload70/I _18257_/Q VSS VSS VSS VSS gf180mcu_fd_sc_mcu9t5v0__dffq_1
X_17208_ _20030_/Q _17394_/A2 _17208_/A3 _17208_/B _18542_/D VSS _17208_/VNW VSS VSS
+ gf180mcu_fd_sc_mcu9t5v0__oai31_1
X_18188_ _18188_/D clkload64/I _18188_/Q VSS VSS VSS VSS gf180mcu_fd_sc_mcu9t5v0__dffq_1
XTAP_TAPCELL_ROW_247_5858 VSS VSS gf180mcu_fd_sc_mcu9t5v0__filltie
X_17139_ _17225_/B _17139_/A2 _17412_/B _17140_/B VSS VSS VSS VSS gf180mcu_fd_sc_mcu9t5v0__aoi21_1
XTAP_TAPCELL_ROW_247_5869 VSS VSS gf180mcu_fd_sc_mcu9t5v0__filltie
X_09961_ _09961_/A1 _09961_/A2 _09961_/A3 _09961_/Z VSS _09961_/VNW VSS VSS gf180mcu_fd_sc_mcu9t5v0__and3_1
X_20081_ _20081_/D clkload59/I _20081_/Q VSS VSS VSS VSS gf180mcu_fd_sc_mcu9t5v0__dffq_1
XTAP_TAPCELL_ROW_16_1413 VSS VSS gf180mcu_fd_sc_mcu9t5v0__filltie
X_09892_ _19220_/Q _09981_/B _09939_/A1 VSS VSS VSS VSS gf180mcu_fd_sc_mcu9t5v0__nor2_1
XTAP_TAPCELL_ROW_16_1424 VSS VSS gf180mcu_fd_sc_mcu9t5v0__filltie
XTAP_TAPCELL_ROW_16_1435 VSS VSS gf180mcu_fd_sc_mcu9t5v0__filltie
X_09326_ _19232_/Q _13031_/A1 VSS VSS VSS VSS gf180mcu_fd_sc_mcu9t5v0__clkinv_1
XTAP_TAPCELL_ROW_135_4683 VSS VSS gf180mcu_fd_sc_mcu9t5v0__filltie
X_09257_ _20036_/Q _14353_/A1 VSS VSS VSS VSS gf180mcu_fd_sc_mcu9t5v0__clkinv_1
XTAP_TAPCELL_ROW_92_3510 VSS VSS gf180mcu_fd_sc_mcu9t5v0__filltie
XTAP_TAPCELL_ROW_135_4694 VSS VSS gf180mcu_fd_sc_mcu9t5v0__filltie
XTAP_TAPCELL_ROW_92_3521 VSS VSS gf180mcu_fd_sc_mcu9t5v0__filltie
X_09188_ _19126_/Q _14480_/A2 VSS VSS VSS VSS gf180mcu_fd_sc_mcu9t5v0__clkinv_1
X_11150_ _18698_/Q wire198/Z wire208/Z _11150_/B2 wire213/Z _11151_/A3 VSS VSS VSS
+ VSS gf180mcu_fd_sc_mcu9t5v0__aoi221_4
Xu_transform_scheduler_core.u_fft_scratch_sram.u_lo.g_pin_drive\[2\].u_data_driver
+ eco6_buf_10314/Z u_transform_scheduler_core.u_fft_scratch_sram.u_lo.u_sram/D[2]
+ VSS VSS VSS VSS gf180mcu_fd_sc_mcu9t5v0__buf_8
X_10101_ _10101_/I _10102_/C VSS VSS VSS VSS gf180mcu_fd_sc_mcu9t5v0__clkinv_1
X_11081_ _18201_/Q _11519_/A2 _11087_/A1 VSS VSS VSS VSS gf180mcu_fd_sc_mcu9t5v0__nand2_1
X_10032_ _18809_/Q _10153_/A2 _10153_/B _10033_/A3 VSS _10046_/VNW VSS VSS gf180mcu_fd_sc_mcu9t5v0__oai21_1
XTAP_TAPCELL_ROW_86_3336 VSS VSS gf180mcu_fd_sc_mcu9t5v0__filltie
XPHY_EDGE_ROW_243_Right_170 VSS VSS gf180mcu_fd_sc_mcu9t5v0__endcap
XTAP_TAPCELL_ROW_257_6143 VSS VSS gf180mcu_fd_sc_mcu9t5v0__filltie
XTAP_TAPCELL_ROW_257_6132 VSS VSS gf180mcu_fd_sc_mcu9t5v0__filltie
XTAP_TAPCELL_ROW_86_3358 VSS VSS gf180mcu_fd_sc_mcu9t5v0__filltie
XTAP_TAPCELL_ROW_86_3347 VSS VSS gf180mcu_fd_sc_mcu9t5v0__filltie
X_14840_ _14846_/A2 _14840_/A2 _14843_/A3 VSS VSS VSS VSS gf180mcu_fd_sc_mcu9t5v0__nand2_1
XTAP_TAPCELL_ROW_253_6029 VSS VSS gf180mcu_fd_sc_mcu9t5v0__filltie
XTAP_TAPCELL_ROW_253_6018 VSS VSS gf180mcu_fd_sc_mcu9t5v0__filltie
X_14771_ _19559_/Q _19325_/Q _15148_/S _19559_/D VSS VSS VSS VSS gf180mcu_fd_sc_mcu9t5v0__mux2_1
X_16510_ _18312_/Q _16509_/Z _17026_/S _18312_/D VSS VSS VSS VSS gf180mcu_fd_sc_mcu9t5v0__mux2_1
X_11983_ _11983_/A1 _11988_/A2 _11983_/ZN VSS _12293_/VNW VSS VSS gf180mcu_fd_sc_mcu9t5v0__xnor2_4
X_13722_ _13722_/A1 _14671_/B _13722_/Z VSS _14669_/VNW VSS VSS gf180mcu_fd_sc_mcu9t5v0__or2_1
X_17490_ _18595_/Q _19236_/Q _17511_/S _18595_/D VSS VSS VSS VSS gf180mcu_fd_sc_mcu9t5v0__mux2_1
X_10934_ _10936_/A1 _10933_/I _10967_/A1 VSS VSS VSS VSS gf180mcu_fd_sc_mcu9t5v0__xnor2_1
XTAP_TAPCELL_ROW_99_3708 VSS VSS gf180mcu_fd_sc_mcu9t5v0__filltie
XTAP_TAPCELL_ROW_2_1033 VSS VSS gf180mcu_fd_sc_mcu9t5v0__filltie
XTAP_TAPCELL_ROW_2_1044 VSS VSS gf180mcu_fd_sc_mcu9t5v0__filltie
X_10865_ _19229_/Q _19235_/Q _18151_/S _10865_/Z VSS VSS VSS VSS gf180mcu_fd_sc_mcu9t5v0__mux2_1
X_16441_ _16668_/A2 _16477_/A1 _16971_/S VSS VSS VSS VSS gf180mcu_fd_sc_mcu9t5v0__nand2_4
X_13653_ _20036_/Q _13656_/A1 _20038_/Q _14286_/A2 VSS _14141_/VNW VSS VSS gf180mcu_fd_sc_mcu9t5v0__nor3_2
X_16372_ _16371_/Z _18249_/Q _16910_/S _18249_/D VSS VSS VSS VSS gf180mcu_fd_sc_mcu9t5v0__mux2_1
X_12604_ _12620_/A1 _12620_/A2 _12604_/A3 _12604_/B _19171_/D VSS VSS VSS VSS gf180mcu_fd_sc_mcu9t5v0__oai31_1
X_13584_ _19279_/Q _13304_/B _13587_/B VSS VSS VSS VSS gf180mcu_fd_sc_mcu9t5v0__nand2_1
X_19160_ _19160_/D _19992_/RN clkload28/I _19160_/Q VSS VSS VSS VSS gf180mcu_fd_sc_mcu9t5v0__dffrnq_1
X_18111_ _19206_/Q _19200_/Q _18117_/S _18111_/Z VSS VSS VSS VSS gf180mcu_fd_sc_mcu9t5v0__mux2_1
X_12535_ _18744_/Q wire198/Z _12543_/B1 _12535_/B2 _12537_/A3 VSS VSS VSS VSS gf180mcu_fd_sc_mcu9t5v0__aoi22_1
X_15323_ _19741_/Q _15323_/I1 _15364_/S _19741_/D VSS _15323_/VNW VSS VSS gf180mcu_fd_sc_mcu9t5v0__mux2_1
X_10796_ _18559_/Q _10796_/A2 _17420_/I0 _17075_/A1 _10810_/A2 VSS VSS VSS VSS gf180mcu_fd_sc_mcu9t5v0__aoi22_4
XTAP_TAPCELL_ROW_62_2690 VSS VSS gf180mcu_fd_sc_mcu9t5v0__filltie
X_19091_ _19091_/D _20051_/RN clkload22/I _19091_/Q VSS VSS VSS VSS gf180mcu_fd_sc_mcu9t5v0__dffrnq_1
X_12466_ _12616_/B _12466_/A2 _12466_/A3 _12466_/B1 _12466_/B2 _12467_/A2 VSS VSS
+ VSS VSS gf180mcu_fd_sc_mcu9t5v0__oai32_4
X_18042_ _18924_/Q _18042_/A2 _18928_/Q _18046_/A1 VSS VSS VSS VSS gf180mcu_fd_sc_mcu9t5v0__aoi21_1
X_15254_ _19600_/Q _15258_/B2 _15260_/A1 VSS VSS VSS VSS gf180mcu_fd_sc_mcu9t5v0__nand2_1
X_12397_ _18206_/Q _12582_/A2 _12400_/A3 VSS VSS VSS VSS gf180mcu_fd_sc_mcu9t5v0__nor2_1
X_11417_ _18399_/Q _11403_/S _11418_/C VSS VSS VSS VSS gf180mcu_fd_sc_mcu9t5v0__or2_1
X_15185_ _15185_/A1 _19562_/Q _15186_/C VSS VSS VSS VSS gf180mcu_fd_sc_mcu9t5v0__nand2_1
X_14205_ _14205_/A1 _14203_/Z _14219_/A2 VSS VSS VSS VSS gf180mcu_fd_sc_mcu9t5v0__xnor2_1
X_11348_ _18394_/Q _11403_/S _11349_/C VSS _11692_/VNW VSS VSS gf180mcu_fd_sc_mcu9t5v0__or2_1
X_14136_ _14136_/A1 _14134_/Z _14137_/I VSS VSS VSS VSS gf180mcu_fd_sc_mcu9t5v0__xnor2_1
XTAP_TAPCELL_ROW_71_2926 VSS VSS gf180mcu_fd_sc_mcu9t5v0__filltie
XTAP_TAPCELL_ROW_242_5733 VSS VSS gf180mcu_fd_sc_mcu9t5v0__filltie
XTAP_TAPCELL_ROW_242_5722 VSS VSS gf180mcu_fd_sc_mcu9t5v0__filltie
X_19993_ _19993_/D _20057_/RN clkload65/I _19993_/Q VSS VSS VSS VSS gf180mcu_fd_sc_mcu9t5v0__dffrnq_1
XTAP_TAPCELL_ROW_71_2948 VSS VSS gf180mcu_fd_sc_mcu9t5v0__filltie
XTAP_TAPCELL_ROW_71_2937 VSS VSS gf180mcu_fd_sc_mcu9t5v0__filltie
X_11279_ _11537_/S _11277_/Z wire283/Z _11280_/B2 VSS _11279_/VNW VSS VSS gf180mcu_fd_sc_mcu9t5v0__aoi21_1
X_18944_ _18944_/D _09246_/I clkload71/I _18944_/Q VSS VSS VSS VSS gf180mcu_fd_sc_mcu9t5v0__dffrnq_1
X_14067_ _19313_/Q _14365_/I0 _14139_/S _19313_/D VSS VSS VSS VSS gf180mcu_fd_sc_mcu9t5v0__mux2_1
Xelec_buf_12379 _12379_/ZN _12380_/A3 VSS VSS VSS VSS gf180mcu_fd_sc_mcu9t5v0__clkbuf_4
XTAP_TAPCELL_ROW_223_5198 VSS VSS gf180mcu_fd_sc_mcu9t5v0__filltie
X_13018_ _13018_/I _13039_/A1 VSS _13018_/VNW VSS VSS gf180mcu_fd_sc_mcu9t5v0__clkinv_1
X_18875_ _18875_/D _19963_/RN clkload22/I _18875_/Q VSS VSS VSS VSS gf180mcu_fd_sc_mcu9t5v0__dffrnq_1
X_17826_ _19033_/Q _18803_/Q _17845_/S _18803_/D VSS VSS VSS VSS gf180mcu_fd_sc_mcu9t5v0__mux2_1
XTAP_TAPCELL_ROW_69_2877 VSS VSS gf180mcu_fd_sc_mcu9t5v0__filltie
X_17757_ _18755_/Q _17756_/Z _17760_/A1 VSS _17757_/VNW VSS VSS gf180mcu_fd_sc_mcu9t5v0__nand2_1
XTAP_TAPCELL_ROW_69_2888 VSS VSS gf180mcu_fd_sc_mcu9t5v0__filltie
X_14969_ _20039_/D _14969_/A2 _14969_/B _19616_/D VSS VSS VSS VSS gf180mcu_fd_sc_mcu9t5v0__aoi21_1
X_16708_ _18368_/Q _16747_/A2 _16747_/A3 _16712_/B VSS VSS VSS VSS gf180mcu_fd_sc_mcu9t5v0__nand3_1
XTAP_TAPCELL_ROW_236_5559 VSS VSS gf180mcu_fd_sc_mcu9t5v0__filltie
XTAP_TAPCELL_ROW_236_5548 VSS VSS gf180mcu_fd_sc_mcu9t5v0__filltie
X_17688_ _18723_/Q _17673_/S _17689_/C VSS VSS VSS VSS gf180mcu_fd_sc_mcu9t5v0__nand2_1
X_16639_ _16639_/A1 _16042_/S _16672_/B _16641_/B VSS VSS VSS VSS gf180mcu_fd_sc_mcu9t5v0__oai21_4
X_19427_ _19427_/D _20067_/RN clkload20/I _19427_/Q VSS VSS VSS VSS gf180mcu_fd_sc_mcu9t5v0__dffrnq_1
X_19358_ _19358_/D _20062_/RN clkload17/I _19358_/Q VSS VSS VSS VSS gf180mcu_fd_sc_mcu9t5v0__dffrnq_1
X_18309_ _18309_/D clkload69/I _18309_/Q VSS VSS VSS VSS gf180mcu_fd_sc_mcu9t5v0__dffq_1
Xu_transform_scheduler_core.u_fft_scratch_sram.u_hi.g_pin_drive\[4\].u_data_driver
+ _10578_/ZN u_transform_scheduler_core.u_fft_scratch_sram.u_hi.u_sram/D[4] VSS VSS
+ VSS VSS gf180mcu_fd_sc_mcu9t5v0__buf_8
XTAP_TAPCELL_ROW_249_5909 VSS VSS gf180mcu_fd_sc_mcu9t5v0__filltie
Xrst_tree_root rst_n rst_tree_root/Z VSS VSS VSS VSS gf180mcu_fd_sc_mcu9t5v0__clkbuf_16
X_09111_ _19784_/Q _12960_/A1 VSS _12844_/VNW VSS VSS gf180mcu_fd_sc_mcu9t5v0__clkinv_1
X_19289_ _19289_/D _20057_/RN clkload39/I _19289_/Q VSS VSS VSS VSS gf180mcu_fd_sc_mcu9t5v0__dffrnq_1
XTAP_TAPCELL_ROW_212_4891 VSS VSS gf180mcu_fd_sc_mcu9t5v0__filltie
Xmax_cap141 _12645_/C _12716_/S VSS VSS VSS VSS gf180mcu_fd_sc_mcu9t5v0__clkbuf_3
XTAP_TAPCELL_ROW_320_7877 VSS VSS gf180mcu_fd_sc_mcu9t5v0__filltie
XTAP_TAPCELL_ROW_320_7866 VSS VSS gf180mcu_fd_sc_mcu9t5v0__filltie
Xmax_cap196 _15608_/A1 _15672_/B VSS VSS VSS VSS gf180mcu_fd_sc_mcu9t5v0__buf_4
Xmax_cap185 _12340_/S _12315_/S VSS VSS VSS VSS gf180mcu_fd_sc_mcu9t5v0__clkbuf_16
X_20133_ _20133_/D clkload75/I _20133_/Q VSS VSS VSS VSS gf180mcu_fd_sc_mcu9t5v0__dffq_1
XTAP_TAPCELL_ROW_148_1_4744 VSS VSS gf180mcu_fd_sc_mcu9t5v0__filltie
X_09944_ _18809_/Q _18810_/Q _18807_/Q _18808_/Q _09944_/Z VSS _10111_/VNW VSS VSS
+ gf180mcu_fd_sc_mcu9t5v0__and4_1
X_20064_ _20064_/D _20064_/RN clkload58/I _20064_/Q VSS VSS VSS VSS gf180mcu_fd_sc_mcu9t5v0__dffrnq_1
X_09875_ _09875_/A1 _09875_/A2 _09876_/A3 VSS VSS VSS VSS gf180mcu_fd_sc_mcu9t5v0__nor2_1
XTAP_TAPCELL_ROW_138_3_8007 VSS VSS gf180mcu_fd_sc_mcu9t5v0__filltie
XTAP_TAPCELL_ROW_124_4395 VSS VSS gf180mcu_fd_sc_mcu9t5v0__filltie
XTAP_TAPCELL_ROW_124_4384 VSS VSS gf180mcu_fd_sc_mcu9t5v0__filltie
XTAP_TAPCELL_ROW_81_3200 VSS VSS gf180mcu_fd_sc_mcu9t5v0__filltie
XTAP_TAPCELL_ROW_81_3222 VSS VSS gf180mcu_fd_sc_mcu9t5v0__filltie
XTAP_TAPCELL_ROW_81_3211 VSS VSS gf180mcu_fd_sc_mcu9t5v0__filltie
Xclkbuf_leaf_68_clk_regs clkload2/I clkload44/I VSS VSS VSS VSS gf180mcu_fd_sc_mcu9t5v0__clkbuf_8
X_10650_ _18552_/Q wire80/Z _10650_/B1 _10650_/B2 _10656_/A2 VSS VSS VSS VSS gf180mcu_fd_sc_mcu9t5v0__aoi22_4
X_09309_ _19992_/Q _15827_/B VSS _09309_/VNW VSS VSS gf180mcu_fd_sc_mcu9t5v0__clkinv_1
XTAP_TAPCELL_ROW_79_3151 VSS VSS gf180mcu_fd_sc_mcu9t5v0__filltie
X_10581_ _17404_/S _18214_/Q _10583_/A3 VSS VSS VSS VSS gf180mcu_fd_sc_mcu9t5v0__nor2_1
XTAP_TAPCELL_ROW_79_3162 VSS VSS gf180mcu_fd_sc_mcu9t5v0__filltie
X_12320_ _18519_/Q _12324_/B _12320_/B _12320_/C _12327_/A2 VSS VSS VSS VSS gf180mcu_fd_sc_mcu9t5v0__oai211_1
XTAP_TAPCELL_ROW_75_3048 VSS VSS gf180mcu_fd_sc_mcu9t5v0__filltie
XTAP_TAPCELL_ROW_75_3037 VSS VSS gf180mcu_fd_sc_mcu9t5v0__filltie
X_12251_ _12252_/A1 _12252_/A2 _12272_/A2 VSS VSS VSS VSS gf180mcu_fd_sc_mcu9t5v0__nand2_4
X_11202_ _18192_/Q _11524_/S _11204_/A2 VSS VSS VSS VSS gf180mcu_fd_sc_mcu9t5v0__nand2_1
X_12182_ _18512_/Q _12320_/C _12183_/B VSS VSS VSS VSS gf180mcu_fd_sc_mcu9t5v0__nand2_1
X_11133_ _18171_/Q _11098_/B wire283/I _11134_/B2 VSS VSS VSS VSS gf180mcu_fd_sc_mcu9t5v0__aoi21_1
XTAP_TAPCELL_ROW_259_6205 VSS VSS gf180mcu_fd_sc_mcu9t5v0__filltie
X_16990_ _18486_/Q _16989_/Z _16990_/S _18486_/D VSS VSS VSS VSS gf180mcu_fd_sc_mcu9t5v0__mux2_4
XTAP_TAPCELL_ROW_88_3409 VSS VSS gf180mcu_fd_sc_mcu9t5v0__filltie
X_15941_ _19195_/Q _20056_/Q _15941_/A3 _15966_/A3 VSS VSS VSS VSS gf180mcu_fd_sc_mcu9t5v0__nand3_1
X_11064_ _18034_/I0 _19065_/Q _11067_/S _19065_/D VSS _11064_/VNW VSS VSS gf180mcu_fd_sc_mcu9t5v0__mux2_1
X_10015_ _10064_/S _17481_/A1 _10016_/C VSS VSS VSS VSS gf180mcu_fd_sc_mcu9t5v0__nand2_1
X_18660_ _18660_/D _20064_/RN clkload66/I _18660_/Q VSS VSS VSS VSS gf180mcu_fd_sc_mcu9t5v0__dffrnq_1
XTAP_TAPCELL_ROW_51_2380 VSS VSS gf180mcu_fd_sc_mcu9t5v0__filltie
XTAP_TAPCELL_ROW_51_2391 VSS VSS gf180mcu_fd_sc_mcu9t5v0__filltie
X_15872_ _20081_/Q _19231_/Q _15905_/S _20081_/D VSS VSS VSS VSS gf180mcu_fd_sc_mcu9t5v0__mux2_1
X_17611_ wire301/Z _18674_/Q _17617_/S _18674_/D VSS VSS VSS VSS gf180mcu_fd_sc_mcu9t5v0__mux2_1
XTAP_TAPCELL_ROW_4_1106 VSS VSS gf180mcu_fd_sc_mcu9t5v0__filltie
X_18591_ _18591_/D clkload57/I _18591_/Q VSS VSS VSS VSS gf180mcu_fd_sc_mcu9t5v0__dffq_1
X_14823_ _14824_/A1 _14822_/Z _14826_/A2 VSS VSS VSS VSS gf180mcu_fd_sc_mcu9t5v0__nor2_1
X_17542_ _17540_/Z _17542_/A2 _17692_/A1 VSS VSS VSS VSS gf180mcu_fd_sc_mcu9t5v0__nand2_1
X_14754_ _14730_/S _14754_/A2 _14755_/B _14754_/B _19551_/D VSS VSS VSS VSS gf180mcu_fd_sc_mcu9t5v0__oai31_1
Xrst_tree_leaf_8 rst_tree_mid_1/Z _20139_/RN VSS VSS VSS VSS gf180mcu_fd_sc_mcu9t5v0__clkbuf_16
XTAP_TAPCELL_ROW_64_2730 VSS VSS gf180mcu_fd_sc_mcu9t5v0__filltie
X_11966_ wire213/I _11966_/A2 _11966_/B _11967_/B2 VSS VSS VSS VSS gf180mcu_fd_sc_mcu9t5v0__aoi21_1
XTAP_TAPCELL_ROW_64_2741 VSS VSS gf180mcu_fd_sc_mcu9t5v0__filltie
Xeco15_sk2_2 eco15_sk2_2/I _18497_/CLK VSS VSS VSS VSS gf180mcu_fd_sc_mcu9t5v0__clkbuf_16
X_10917_ _10917_/I0 _18997_/Q _18148_/S _18997_/D VSS _10917_/VNW VSS VSS gf180mcu_fd_sc_mcu9t5v0__mux2_1
X_13705_ _14048_/A1 _14166_/B _14380_/A1 _13705_/B2 _19296_/D VSS VSS VSS VSS gf180mcu_fd_sc_mcu9t5v0__aoi22_1
X_14685_ _14688_/A2 _14685_/A2 _14686_/I1 VSS _14687_/VNW VSS VSS gf180mcu_fd_sc_mcu9t5v0__xnor2_1
XTAP_TAPCELL_ROW_64_2752 VSS VSS gf180mcu_fd_sc_mcu9t5v0__filltie
X_17473_ wire198/I _17473_/A2 _18583_/Q _17474_/A2 VSS _17473_/VNW VSS VSS gf180mcu_fd_sc_mcu9t5v0__aoi21_1
X_11897_ _12261_/B _11897_/A2 _11897_/A3 _11898_/B VSS _11897_/VNW VSS VSS gf180mcu_fd_sc_mcu9t5v0__nand3_1
XTAP_TAPCELL_ROW_231_5423 VSS VSS gf180mcu_fd_sc_mcu9t5v0__filltie
X_16424_ _16424_/A1 _16809_/S _16424_/B _16425_/I0 VSS VSS VSS VSS gf180mcu_fd_sc_mcu9t5v0__oai21_1
XTAP_TAPCELL_ROW_231_5412 VSS VSS gf180mcu_fd_sc_mcu9t5v0__filltie
X_13636_ _13043_/I _13640_/A1 _13635_/Z _13636_/B _19289_/D VSS VSS VSS VSS gf180mcu_fd_sc_mcu9t5v0__oai31_1
X_19212_ _19212_/D _20044_/RN clkload25/I _19212_/Q VSS VSS VSS VSS gf180mcu_fd_sc_mcu9t5v0__dffrnq_1
XTAP_TAPCELL_ROW_60_2627 VSS VSS gf180mcu_fd_sc_mcu9t5v0__filltie
XTAP_TAPCELL_ROW_60_2638 VSS VSS gf180mcu_fd_sc_mcu9t5v0__filltie
XTAP_TAPCELL_ROW_231_5434 VSS VSS gf180mcu_fd_sc_mcu9t5v0__filltie
X_10848_ _18833_/Q _18053_/A1 _18117_/S VSS _12229_/VNW VSS VSS gf180mcu_fd_sc_mcu9t5v0__nand2_1
X_16355_ _19237_/Q _16162_/B _16895_/S _16355_/Z VSS VSS VSS VSS gf180mcu_fd_sc_mcu9t5v0__mux2_1
X_13567_ _13615_/B _13571_/A3 _13568_/A2 VSS _13567_/VNW VSS VSS gf180mcu_fd_sc_mcu9t5v0__nand2_1
X_19143_ _19143_/D _20039_/RN clkload15/I _19143_/Q VSS VSS VSS VSS gf180mcu_fd_sc_mcu9t5v0__dffrnq_1
X_10779_ _18843_/Q _18850_/Q _10797_/A2 VSS VSS VSS VSS gf180mcu_fd_sc_mcu9t5v0__xnor2_1
X_12518_ _12541_/B _12518_/A2 _12518_/A3 _12518_/B _12519_/B2 VSS _16250_/VNW VSS
+ VSS gf180mcu_fd_sc_mcu9t5v0__oai31_2
X_16286_ _16182_/B _16809_/S _16434_/B VSS VSS VSS VSS gf180mcu_fd_sc_mcu9t5v0__nand2_4
X_13498_ _16961_/A1 _13497_/B _13498_/B1 _13498_/B2 _19259_/D VSS _13498_/VNW VSS
+ VSS gf180mcu_fd_sc_mcu9t5v0__aoi22_1
X_15306_ _19638_/Q _19615_/Q _15306_/Z VSS _15306_/VNW VSS VSS gf180mcu_fd_sc_mcu9t5v0__and2_1
X_19074_ _19074_/D _20034_/RN clkload23/I _19074_/Q VSS VSS VSS VSS gf180mcu_fd_sc_mcu9t5v0__dffrnq_1
X_12449_ _18308_/Q _12616_/A2 _12616_/B _12450_/B2 VSS VSS VSS VSS gf180mcu_fd_sc_mcu9t5v0__oai21_1
X_15237_ _15237_/A1 _15237_/A2 _15237_/B _15247_/B2 VSS _15237_/VNW VSS VSS gf180mcu_fd_sc_mcu9t5v0__aoi21_1
X_18025_ _18025_/I0 _18910_/Q _18037_/S _18910_/D VSS VSS VSS VSS gf180mcu_fd_sc_mcu9t5v0__mux2_1
XTAP_TAPCELL_ROW_229_5374 VSS VSS gf180mcu_fd_sc_mcu9t5v0__filltie
XTAP_TAPCELL_ROW_229_5363 VSS VSS gf180mcu_fd_sc_mcu9t5v0__filltie
XTAP_TAPCELL_ROW_144_3_8028 VSS VSS gf180mcu_fd_sc_mcu9t5v0__filltie
XTAP_TAPCELL_ROW_58_2567 VSS VSS gf180mcu_fd_sc_mcu9t5v0__filltie
XTAP_TAPCELL_ROW_58_2578 VSS VSS gf180mcu_fd_sc_mcu9t5v0__filltie
XTAP_TAPCELL_ROW_58_2589 VSS VSS gf180mcu_fd_sc_mcu9t5v0__filltie
XTAP_TAPCELL_ROW_225_5249 VSS VSS gf180mcu_fd_sc_mcu9t5v0__filltie
X_15168_ _19710_/Q _19550_/Q wire108/Z _19710_/D VSS _15168_/VNW VSS VSS gf180mcu_fd_sc_mcu9t5v0__mux2_1
X_19976_ _19976_/D _20040_/RN clkload66/I _19976_/Q VSS VSS VSS VSS gf180mcu_fd_sc_mcu9t5v0__dffrnq_1
XPHY_EDGE_ROW_149_3_Left_807 VSS VSS gf180mcu_fd_sc_mcu9t5v0__endcap
X_15099_ _15099_/A1 _15099_/A2 _15099_/A3 _15100_/C VSS _15099_/VNW VSS VSS gf180mcu_fd_sc_mcu9t5v0__nand3_1
X_14119_ _19322_/Q _19299_/Q _14192_/A1 VSS VSS VSS VSS gf180mcu_fd_sc_mcu9t5v0__nand2_1
X_18927_ _18927_/D _20143_/RN clkload39/I _18927_/Q VSS VSS VSS VSS gf180mcu_fd_sc_mcu9t5v0__dffrnq_1
X_09660_ _17767_/A1 _17765_/A1 _17601_/A1 VSS _09660_/VNW VSS VSS gf180mcu_fd_sc_mcu9t5v0__nand2_1
X_18858_ _18858_/D _20138_/RN clkload44/I _18858_/Q VSS VSS VSS VSS gf180mcu_fd_sc_mcu9t5v0__dffrnq_1
X_18789_ _18789_/D _20069_/RN clkload51/I _18789_/Q VSS VSS VSS VSS gf180mcu_fd_sc_mcu9t5v0__dffrnq_1
X_17809_ _18787_/Q _18766_/Q _18769_/D _18787_/D VSS _17809_/VNW VSS VSS gf180mcu_fd_sc_mcu9t5v0__mux2_1
X_09591_ _19017_/Q _09591_/A2 _11013_/B _20041_/D VSS _09591_/VNW VSS VSS gf180mcu_fd_sc_mcu9t5v0__aoi21_1
XPHY_EDGE_ROW_145_1_Left_468 VSS VSS gf180mcu_fd_sc_mcu9t5v0__endcap
XTAP_TAPCELL_ROW_30_1796 VSS VSS gf180mcu_fd_sc_mcu9t5v0__filltie
XTAP_TAPCELL_ROW_313_7681 VSS VSS gf180mcu_fd_sc_mcu9t5v0__filltie
XTAP_TAPCELL_ROW_313_7670 VSS VSS gf180mcu_fd_sc_mcu9t5v0__filltie
XTAP_TAPCELL_ROW_214_4964 VSS VSS gf180mcu_fd_sc_mcu9t5v0__filltie
XTAP_TAPCELL_ROW_214_4953 VSS VSS gf180mcu_fd_sc_mcu9t5v0__filltie
XTAP_TAPCELL_ROW_214_4942 VSS VSS gf180mcu_fd_sc_mcu9t5v0__filltie
XPHY_EDGE_ROW_200_3_Left_858 VSS VSS gf180mcu_fd_sc_mcu9t5v0__endcap
XTAP_TAPCELL_ROW_132_4620 VSS VSS gf180mcu_fd_sc_mcu9t5v0__filltie
XTAP_TAPCELL_ROW_210_4839 VSS VSS gf180mcu_fd_sc_mcu9t5v0__filltie
XTAP_TAPCELL_ROW_322_7939 VSS VSS gf180mcu_fd_sc_mcu9t5v0__filltie
XTAP_TAPCELL_ROW_322_7928 VSS VSS gf180mcu_fd_sc_mcu9t5v0__filltie
XTAP_TAPCELL_ROW_322_7917 VSS VSS gf180mcu_fd_sc_mcu9t5v0__filltie
XTAP_TAPCELL_ROW_113_4085 VSS VSS gf180mcu_fd_sc_mcu9t5v0__filltie
XTAP_TAPCELL_ROW_177_3_8142 VSS VSS gf180mcu_fd_sc_mcu9t5v0__filltie
XTAP_TAPCELL_ROW_113_4096 VSS VSS gf180mcu_fd_sc_mcu9t5v0__filltie
XTAP_TAPCELL_ROW_299_7297 VSS VSS gf180mcu_fd_sc_mcu9t5v0__filltie
XTAP_TAPCELL_ROW_299_7286 VSS VSS gf180mcu_fd_sc_mcu9t5v0__filltie
X_20116_ _20116_/D clkload74/I _20116_/Q VSS VSS VSS VSS gf180mcu_fd_sc_mcu9t5v0__dffq_1
X_09927_ _10057_/A1 _09927_/A2 _10166_/B1 VSS VSS VSS VSS gf180mcu_fd_sc_mcu9t5v0__nor2_1
XTAP_TAPCELL_ROW_126_4457 VSS VSS gf180mcu_fd_sc_mcu9t5v0__filltie
XTAP_TAPCELL_ROW_126_4446 VSS VSS gf180mcu_fd_sc_mcu9t5v0__filltie
XTAP_TAPCELL_ROW_126_4435 VSS VSS gf180mcu_fd_sc_mcu9t5v0__filltie
XTAP_TAPCELL_ROW_170_3_8118 VSS VSS gf180mcu_fd_sc_mcu9t5v0__filltie
XTAP_TAPCELL_ROW_157_3_8073 VSS VSS gf180mcu_fd_sc_mcu9t5v0__filltie
X_20047_ _20047_/D _20047_/RN clkload41/I _20047_/Q VSS VSS VSS VSS gf180mcu_fd_sc_mcu9t5v0__dffrnq_1
X_09858_ _09858_/I _20034_/D VSS VSS VSS VSS gf180mcu_fd_sc_mcu9t5v0__clkinv_1
X_09789_ _11612_/A1 _09789_/A2 _18848_/Q _09790_/A2 VSS _09789_/VNW VSS VSS gf180mcu_fd_sc_mcu9t5v0__oai21_1
X_11820_ _18304_/Q _12203_/A2 _11821_/A3 VSS VSS VSS VSS gf180mcu_fd_sc_mcu9t5v0__nand2_1
XPHY_EDGE_ROW_195_3_Left_853 VSS VSS gf180mcu_fd_sc_mcu9t5v0__endcap
X_11751_ _18237_/Q _12203_/A2 _11755_/A1 VSS VSS VSS VSS gf180mcu_fd_sc_mcu9t5v0__nand2_1
X_10702_ _19867_/Q _17161_/C _10702_/B _10703_/A2 VSS _10702_/VNW VSS VSS gf180mcu_fd_sc_mcu9t5v0__oai21_4
XTAP_TAPCELL_ROW_150_3_8049 VSS VSS gf180mcu_fd_sc_mcu9t5v0__filltie
X_11682_ _12628_/A1 _11682_/A2 _11700_/B VSS _11700_/VNW VSS VSS gf180mcu_fd_sc_mcu9t5v0__nand2_1
X_14470_ _19160_/Q _19126_/Q _14717_/A1 VSS _14716_/VNW VSS VSS gf180mcu_fd_sc_mcu9t5v0__nand2_1
XTAP_TAPCELL_ROW_288_6990 VSS VSS gf180mcu_fd_sc_mcu9t5v0__filltie
X_10633_ _18232_/Q _17406_/A2 _17405_/A2 _18248_/Q _10634_/B VSS VSS VSS VSS gf180mcu_fd_sc_mcu9t5v0__aoi22_1
X_13421_ _13430_/A1 _13430_/A2 _13431_/A1 VSS VSS VSS VSS gf180mcu_fd_sc_mcu9t5v0__nor2_1
X_16140_ _18173_/Q _16140_/I1 _16707_/S _18173_/D VSS VSS VSS VSS gf180mcu_fd_sc_mcu9t5v0__mux2_4
X_10564_ _10459_/C _10564_/A2 _10564_/A3 _10564_/B _10565_/C2 VSS _10564_/VNW VSS
+ VSS gf180mcu_fd_sc_mcu9t5v0__oai31_1
X_13352_ _13360_/A1 _13352_/A2 _13353_/B VSS VSS VSS VSS gf180mcu_fd_sc_mcu9t5v0__xnor2_1
XTAP_TAPCELL_ROW_40_2070 VSS VSS gf180mcu_fd_sc_mcu9t5v0__filltie
XTAP_TAPCELL_ROW_40_2081 VSS VSS gf180mcu_fd_sc_mcu9t5v0__filltie
X_16071_ _19270_/Q _15996_/B _16072_/B VSS VSS VSS VSS gf180mcu_fd_sc_mcu9t5v0__nand2_1
XTAP_TAPCELL_ROW_284_6887 VSS VSS gf180mcu_fd_sc_mcu9t5v0__filltie
XTAP_TAPCELL_ROW_284_6876 VSS VSS gf180mcu_fd_sc_mcu9t5v0__filltie
X_12303_ _18518_/Q _12300_/Z _12302_/Z _12301_/Z _12345_/B _12299_/S _12303_/Z VSS
+ VSS VSS VSS gf180mcu_fd_sc_mcu9t5v0__mux4_1
XTAP_TAPCELL_ROW_40_2092 VSS VSS gf180mcu_fd_sc_mcu9t5v0__filltie
X_10495_ _10516_/C _10495_/A2 _10495_/B1 _10543_/C _10495_/C _10497_/A2 VSS _10495_/VNW
+ VSS VSS gf180mcu_fd_sc_mcu9t5v0__aoi221_1
X_13283_ _13300_/A1 _13282_/Z _13283_/Z VSS _13283_/VNW VSS VSS gf180mcu_fd_sc_mcu9t5v0__xor2_1
X_15022_ _15022_/I0 _15019_/Z _15022_/S _15022_/Z VSS _15022_/VNW VSS VSS gf180mcu_fd_sc_mcu9t5v0__mux2_1
X_12234_ _12234_/I _19133_/D VSS _14541_/VNW VSS VSS gf180mcu_fd_sc_mcu9t5v0__clkinv_1
X_12165_ _12166_/A1 _12166_/A2 _12195_/A1 VSS VSS VSS VSS gf180mcu_fd_sc_mcu9t5v0__nand2_4
X_19830_ _19830_/D _20022_/RN clkload51/I _19830_/Q VSS VSS VSS VSS gf180mcu_fd_sc_mcu9t5v0__dffrnq_1
XTAP_TAPCELL_ROW_53_2431 VSS VSS gf180mcu_fd_sc_mcu9t5v0__filltie
XTAP_TAPCELL_ROW_53_2442 VSS VSS gf180mcu_fd_sc_mcu9t5v0__filltie
XTAP_TAPCELL_ROW_53_2453 VSS VSS gf180mcu_fd_sc_mcu9t5v0__filltie
X_11116_ _11428_/B _11116_/A2 _11116_/B _11359_/B _11120_/A2 VSS VSS VSS VSS gf180mcu_fd_sc_mcu9t5v0__aoi211_1
XTAP_TAPCELL_ROW_220_5113 VSS VSS gf180mcu_fd_sc_mcu9t5v0__filltie
X_19761_ _19761_/D _20145_/RN clkload42/I _19761_/Q VSS VSS VSS VSS gf180mcu_fd_sc_mcu9t5v0__dffrnq_1
X_16973_ _19249_/Q _16606_/B _16991_/S _16973_/Z VSS VSS VSS VSS gf180mcu_fd_sc_mcu9t5v0__mux2_1
XTAP_TAPCELL_ROW_220_5124 VSS VSS gf180mcu_fd_sc_mcu9t5v0__filltie
X_12096_ _11706_/B _12079_/Z _12095_/B _12096_/Z VSS _12096_/VNW VSS VSS gf180mcu_fd_sc_mcu9t5v0__or3_1
X_18712_ _18712_/D clkload48/I _18712_/Q VSS VSS VSS VSS gf180mcu_fd_sc_mcu9t5v0__dffq_1
X_15924_ _20133_/Q _19254_/Q _15927_/S _20133_/D VSS _15924_/VNW VSS VSS gf180mcu_fd_sc_mcu9t5v0__mux2_1
XTAP_TAPCELL_ROW_109_3987 VSS VSS gf180mcu_fd_sc_mcu9t5v0__filltie
XTAP_TAPCELL_ROW_109_3976 VSS VSS gf180mcu_fd_sc_mcu9t5v0__filltie
X_19692_ _19692_/D _20140_/RN clkload30/I _19692_/Q VSS VSS VSS VSS gf180mcu_fd_sc_mcu9t5v0__dffrnq_1
X_11047_ _18033_/I0 _19048_/Q _11051_/S _19048_/D VSS VSS VSS VSS gf180mcu_fd_sc_mcu9t5v0__mux2_1
X_18643_ _18643_/D _20047_/RN clkload65/I _18643_/Q VSS VSS VSS VSS gf180mcu_fd_sc_mcu9t5v0__dffrnq_1
X_15855_ _15855_/A1 _15855_/A2 _17763_/A3 _15936_/B _15855_/ZN VSS VSS VSS VSS gf180mcu_fd_sc_mcu9t5v0__oai31_4
XTAP_TAPCELL_ROW_66_2803 VSS VSS gf180mcu_fd_sc_mcu9t5v0__filltie
Xinput9 din_valid_i input9/Z VSS VSS VSS VSS gf180mcu_fd_sc_mcu9t5v0__dlyd_1
X_14806_ _14806_/A1 _14802_/Z _14806_/B _14811_/A1 VSS _14806_/VNW VSS VSS gf180mcu_fd_sc_mcu9t5v0__aoi21_1
X_18574_ _18574_/D _20138_/RN clkload28/I _18574_/Q VSS VSS VSS VSS gf180mcu_fd_sc_mcu9t5v0__dffrnq_1
X_15786_ _19980_/Q _19956_/Q _15786_/S _19956_/D VSS VSS VSS VSS gf180mcu_fd_sc_mcu9t5v0__mux2_1
XTAP_TAPCELL_ROW_218_5064 VSS VSS gf180mcu_fd_sc_mcu9t5v0__filltie
X_17525_ input4/Z _18630_/Q _17529_/S _18630_/D VSS VSS VSS VSS gf180mcu_fd_sc_mcu9t5v0__mux2_1
XTAP_TAPCELL_ROW_218_5053 VSS VSS gf180mcu_fd_sc_mcu9t5v0__filltie
XTAP_TAPCELL_ROW_47_2268 VSS VSS gf180mcu_fd_sc_mcu9t5v0__filltie
XTAP_TAPCELL_ROW_47_2279 VSS VSS gf180mcu_fd_sc_mcu9t5v0__filltie
X_12998_ _19721_/Q _13001_/A2 _12999_/I VSS _12998_/VNW VSS VSS gf180mcu_fd_sc_mcu9t5v0__and2_1
XTAP_TAPCELL_ROW_218_5075 VSS VSS gf180mcu_fd_sc_mcu9t5v0__filltie
X_11949_ _18182_/Q _12345_/A2 _11951_/A2 VSS VSS VSS VSS gf180mcu_fd_sc_mcu9t5v0__nand2_1
X_14737_ _19547_/Q _14736_/Z _14764_/B _19547_/D VSS _18031_/VNW VSS VSS gf180mcu_fd_sc_mcu9t5v0__mux2_1
XTAP_TAPCELL_ROW_183_3_8163 VSS VSS gf180mcu_fd_sc_mcu9t5v0__filltie
X_14668_ _14668_/A1 _14668_/A2 _14668_/B _14671_/A2 VSS VSS VSS VSS gf180mcu_fd_sc_mcu9t5v0__oai21_1
X_17456_ _17462_/A1 _17456_/A2 _18574_/D VSS _17456_/VNW VSS VSS gf180mcu_fd_sc_mcu9t5v0__nor2_1
X_17387_ _20137_/Q _17407_/C _17388_/B VSS VSS VSS VSS gf180mcu_fd_sc_mcu9t5v0__nand2_1
X_16407_ _16407_/I0 _18265_/Q _16940_/S _18265_/D VSS VSS VSS VSS gf180mcu_fd_sc_mcu9t5v0__mux2_4
X_13619_ _13620_/B _13620_/A1 _13620_/A2 _13622_/A1 VSS VSS VSS VSS gf180mcu_fd_sc_mcu9t5v0__nor3_1
X_16338_ _18233_/Q _16337_/Z wire38/I _18233_/D VSS _16684_/VNW VSS VSS gf180mcu_fd_sc_mcu9t5v0__mux2_1
X_14599_ _19178_/Q _19477_/Q _14715_/S _19477_/D VSS VSS VSS VSS gf180mcu_fd_sc_mcu9t5v0__mux2_1
X_19126_ _19126_/D _20022_/RN clkload10/I _19126_/Q VSS VSS VSS VSS gf180mcu_fd_sc_mcu9t5v0__dffrnq_1
X_16269_ _19269_/Q _16829_/A2 _16271_/A1 VSS VSS VSS VSS gf180mcu_fd_sc_mcu9t5v0__nand2_1
XTAP_TAPCELL_ROW_163_3_8094 VSS VSS gf180mcu_fd_sc_mcu9t5v0__filltie
XPHY_EDGE_ROW_159_2_Left_671 VSS VSS gf180mcu_fd_sc_mcu9t5v0__endcap
X_19057_ _19057_/D _20145_/RN clkload34/I _19057_/Q VSS VSS VSS VSS gf180mcu_fd_sc_mcu9t5v0__dffrnq_1
X_18008_ _18024_/I0 _18893_/Q _18021_/S _18893_/D VSS VSS VSS VSS gf180mcu_fd_sc_mcu9t5v0__mux2_1
XTAP_TAPCELL_ROW_302_7371 VSS VSS gf180mcu_fd_sc_mcu9t5v0__filltie
XTAP_TAPCELL_ROW_302_7382 VSS VSS gf180mcu_fd_sc_mcu9t5v0__filltie
XTAP_TAPCELL_ROW_36_1961 VSS VSS gf180mcu_fd_sc_mcu9t5v0__filltie
XTAP_TAPCELL_ROW_294_7161 VSS VSS gf180mcu_fd_sc_mcu9t5v0__filltie
XTAP_TAPCELL_ROW_294_7150 VSS VSS gf180mcu_fd_sc_mcu9t5v0__filltie
X_09712_ _20060_/Q _20059_/Q _10818_/A2 VSS _09712_/VNW VSS VSS gf180mcu_fd_sc_mcu9t5v0__nand2_1
X_19959_ _19959_/D _20023_/RN clkload46/I _19959_/Q VSS VSS VSS VSS gf180mcu_fd_sc_mcu9t5v0__dffrnq_1
XTAP_TAPCELL_ROW_36_1972 VSS VSS gf180mcu_fd_sc_mcu9t5v0__filltie
XTAP_TAPCELL_ROW_36_1983 VSS VSS gf180mcu_fd_sc_mcu9t5v0__filltie
XTAP_TAPCELL_ROW_290_7036 VSS VSS gf180mcu_fd_sc_mcu9t5v0__filltie
XTAP_TAPCELL_ROW_121_4310 VSS VSS gf180mcu_fd_sc_mcu9t5v0__filltie
XTAP_TAPCELL_ROW_32_1858 VSS VSS gf180mcu_fd_sc_mcu9t5v0__filltie
XTAP_TAPCELL_ROW_315_7743 VSS VSS gf180mcu_fd_sc_mcu9t5v0__filltie
XTAP_TAPCELL_ROW_290_7058 VSS VSS gf180mcu_fd_sc_mcu9t5v0__filltie
XTAP_TAPCELL_ROW_315_7732 VSS VSS gf180mcu_fd_sc_mcu9t5v0__filltie
XTAP_TAPCELL_ROW_290_7047 VSS VSS gf180mcu_fd_sc_mcu9t5v0__filltie
XTAP_TAPCELL_ROW_315_7721 VSS VSS gf180mcu_fd_sc_mcu9t5v0__filltie
XTAP_TAPCELL_ROW_121_4321 VSS VSS gf180mcu_fd_sc_mcu9t5v0__filltie
X_09643_ _15824_/B2 _19991_/Q _10049_/A1 VSS _09883_/VNW VSS VSS gf180mcu_fd_sc_mcu9t5v0__nor2_1
XTAP_TAPCELL_ROW_32_1869 VSS VSS gf180mcu_fd_sc_mcu9t5v0__filltie
XTAP_TAPCELL_ROW_311_7618 VSS VSS gf180mcu_fd_sc_mcu9t5v0__filltie
X_09574_ _10693_/B _10803_/C wire160/I _09832_/A3 VSS _09574_/VNW VSS VSS gf180mcu_fd_sc_mcu9t5v0__aoi21_1
XTAP_TAPCELL_ROW_311_7629 VSS VSS gf180mcu_fd_sc_mcu9t5v0__filltie
XTAP_TAPCELL_ROW_119_4261 VSS VSS gf180mcu_fd_sc_mcu9t5v0__filltie
XTAP_TAPCELL_ROW_119_4250 VSS VSS gf180mcu_fd_sc_mcu9t5v0__filltie
XTAP_TAPCELL_ROW_115_4136 VSS VSS gf180mcu_fd_sc_mcu9t5v0__filltie
XTAP_TAPCELL_ROW_309_7569 VSS VSS gf180mcu_fd_sc_mcu9t5v0__filltie
XTAP_TAPCELL_ROW_309_7558 VSS VSS gf180mcu_fd_sc_mcu9t5v0__filltie
XTAP_TAPCELL_ROW_115_4158 VSS VSS gf180mcu_fd_sc_mcu9t5v0__filltie
XTAP_TAPCELL_ROW_115_4147 VSS VSS gf180mcu_fd_sc_mcu9t5v0__filltie
X_10280_ _18538_/Q wire81/Z wire282/Z _10286_/A2 VSS _10313_/VNW VSS VSS gf180mcu_fd_sc_mcu9t5v0__aoi21_1
XTAP_TAPCELL_ROW_128_4508 VSS VSS gf180mcu_fd_sc_mcu9t5v0__filltie
Xhold_dlya_din2 input3/Z wire300/I VSS VSS VSS VSS gf180mcu_fd_sc_mcu9t5v0__dlya_4
XTAP_TAPCELL_ROW_142_2_8019 VSS VSS gf180mcu_fd_sc_mcu9t5v0__filltie
X_13970_ _13970_/A1 _19323_/Q _13973_/A3 VSS VSS VSS VSS gf180mcu_fd_sc_mcu9t5v0__nand2_1
XTAP_TAPCELL_ROW_277_6691 VSS VSS gf180mcu_fd_sc_mcu9t5v0__filltie
XTAP_TAPCELL_ROW_277_6680 VSS VSS gf180mcu_fd_sc_mcu9t5v0__filltie
X_12921_ _12921_/I0 _19222_/Q _13419_/B _19222_/D VSS VSS VSS VSS gf180mcu_fd_sc_mcu9t5v0__mux2_1
Xclkbuf_leaf_83_clk_regs clkbuf_3_0_0_clk_regs/Z clkload18/I VSS VSS VSS VSS gf180mcu_fd_sc_mcu9t5v0__clkbuf_8
XTAP_TAPCELL_ROW_273_6577 VSS VSS gf180mcu_fd_sc_mcu9t5v0__filltie
XTAP_TAPCELL_ROW_273_6566 VSS VSS gf180mcu_fd_sc_mcu9t5v0__filltie
Xclkbuf_leaf_12_clk_regs clkload3/I clkload49/I VSS _15725_/VNW VSS VSS gf180mcu_fd_sc_mcu9t5v0__clkbuf_8
XTAP_TAPCELL_ROW_104_3851 VSS VSS gf180mcu_fd_sc_mcu9t5v0__filltie
X_15640_ _15640_/A1 _15640_/A2 _15640_/B _15677_/B _19898_/D VSS VSS VSS VSS gf180mcu_fd_sc_mcu9t5v0__oai211_1
XTAP_TAPCELL_ROW_104_3840 VSS VSS gf180mcu_fd_sc_mcu9t5v0__filltie
XTAP_TAPCELL_ROW_273_6588 VSS VSS gf180mcu_fd_sc_mcu9t5v0__filltie
X_12852_ _12852_/I0 _19213_/Q _13304_/B _19213_/D VSS VSS VSS VSS gf180mcu_fd_sc_mcu9t5v0__mux2_1
XTAP_TAPCELL_ROW_100_3726 VSS VSS gf180mcu_fd_sc_mcu9t5v0__filltie
X_15571_ _19877_/Q _17422_/S _15571_/A3 _19877_/D VSS _15571_/VNW VSS VSS gf180mcu_fd_sc_mcu9t5v0__and3_1
X_11803_ _18319_/Q _12116_/C _11804_/B VSS VSS VSS VSS gf180mcu_fd_sc_mcu9t5v0__nand2_1
XTAP_TAPCELL_ROW_100_3737 VSS VSS gf180mcu_fd_sc_mcu9t5v0__filltie
X_12783_ _12783_/A1 _12782_/B _12783_/A3 _12783_/Z VSS _12783_/VNW VSS VSS gf180mcu_fd_sc_mcu9t5v0__or3_1
X_18290_ _18290_/D clkload80/I _18290_/Q VSS VSS VSS VSS gf180mcu_fd_sc_mcu9t5v0__dffq_1
X_17310_ _17250_/Z _17310_/A2 _17310_/B _18547_/D VSS _17330_/VNW VSS VSS gf180mcu_fd_sc_mcu9t5v0__oai21_4
X_11734_ _18252_/Q _12046_/S _12116_/C _11735_/B2 VSS _17103_/VNW VSS VSS gf180mcu_fd_sc_mcu9t5v0__aoi21_1
XTAP_TAPCELL_ROW_42_2132 VSS VSS gf180mcu_fd_sc_mcu9t5v0__filltie
X_14522_ _14522_/A1 _14517_/Z _14531_/A1 VSS VSS VSS VSS gf180mcu_fd_sc_mcu9t5v0__nor2_1
XTAP_TAPCELL_ROW_286_6949 VSS VSS gf180mcu_fd_sc_mcu9t5v0__filltie
X_17241_ _10514_/B _17240_/Z _17243_/B1 VSS VSS VSS VSS gf180mcu_fd_sc_mcu9t5v0__nand2_1
XTAP_TAPCELL_ROW_286_6938 VSS VSS gf180mcu_fd_sc_mcu9t5v0__filltie
XTAP_TAPCELL_ROW_286_6927 VSS VSS gf180mcu_fd_sc_mcu9t5v0__filltie
X_11665_ _11654_/C _11665_/A2 _12645_/B2 VSS _11665_/VNW VSS VSS gf180mcu_fd_sc_mcu9t5v0__nand2_1
XTAP_TAPCELL_ROW_42_2143 VSS VSS gf180mcu_fd_sc_mcu9t5v0__filltie
X_14453_ _19122_/Q _14590_/B _14624_/S _14456_/B1 VSS VSS VSS VSS gf180mcu_fd_sc_mcu9t5v0__aoi21_1
X_10616_ _18295_/Q _17406_/A2 _17405_/A2 _18311_/Q _10617_/B VSS VSS VSS VSS gf180mcu_fd_sc_mcu9t5v0__aoi22_1
X_13404_ _13422_/A1 _13422_/A3 _13405_/A3 VSS VSS VSS VSS gf180mcu_fd_sc_mcu9t5v0__nor2_1
X_17172_ _18429_/Q _17380_/B1 _17170_/Z _10514_/B _17278_/C _17176_/A2 VSS _17172_/VNW
+ VSS VSS gf180mcu_fd_sc_mcu9t5v0__aoi221_1
X_14384_ _19447_/Q _14546_/S _14385_/A2 VSS _14384_/VNW VSS VSS gf180mcu_fd_sc_mcu9t5v0__nor2_1
X_11596_ _11611_/B _11593_/Z _11595_/Z _11654_/C VSS _11603_/VNW VSS VSS gf180mcu_fd_sc_mcu9t5v0__and3_1
X_10547_ _20089_/Q wire168/Z _10548_/A2 VSS _10547_/VNW VSS VSS gf180mcu_fd_sc_mcu9t5v0__nor2_1
X_16123_ _16009_/B _16730_/A1 _16730_/C _16123_/C _16125_/A2 VSS VSS VSS VSS gf180mcu_fd_sc_mcu9t5v0__aoi211_1
X_13335_ _19740_/Q _13335_/A2 _13357_/A1 VSS VSS VSS VSS gf180mcu_fd_sc_mcu9t5v0__nor2_1
XTAP_TAPCELL_ROW_55_2504 VSS VSS gf180mcu_fd_sc_mcu9t5v0__filltie
X_16054_ _15996_/B _16054_/A2 _16054_/A3 _16054_/B _16055_/I1 VSS VSS VSS VSS gf180mcu_fd_sc_mcu9t5v0__oai31_1
X_10478_ _18948_/Q wire166/Z _10480_/A2 VSS _10478_/VNW VSS VSS gf180mcu_fd_sc_mcu9t5v0__nand2_1
X_13266_ _13244_/B _13264_/Z _13280_/B _13278_/A2 _13266_/B2 _13267_/I0 VSS _13266_/VNW
+ VSS VSS gf180mcu_fd_sc_mcu9t5v0__oai32_1
Xrst_tree_leaf_13 rst_tree_mid_1/Z _20070_/RN VSS VSS VSS VSS gf180mcu_fd_sc_mcu9t5v0__clkbuf_16
Xrst_tree_leaf_35 rst_tree_mid_4/Z _20048_/RN VSS VSS VSS VSS gf180mcu_fd_sc_mcu9t5v0__clkbuf_16
Xrst_tree_leaf_24 rst_tree_mid_3/Z _20059_/RN VSS VSS VSS VSS gf180mcu_fd_sc_mcu9t5v0__clkbuf_16
Xrst_tree_leaf_46 rst_tree_mid_5/Z _20037_/RN VSS VSS VSS VSS gf180mcu_fd_sc_mcu9t5v0__clkbuf_16
X_12217_ _18915_/Q _12217_/A2 _12217_/B _12235_/A2 VSS VSS VSS VSS gf180mcu_fd_sc_mcu9t5v0__oai21_1
X_15005_ _15015_/A1 _15008_/A2 _15009_/A1 VSS _15011_/VNW VSS VSS gf180mcu_fd_sc_mcu9t5v0__nor2_1
X_13197_ _19731_/Q _13198_/A2 _13214_/B VSS _13197_/VNW VSS VSS gf180mcu_fd_sc_mcu9t5v0__nor2_1
Xrst_tree_leaf_57 rst_tree_mid_7/Z _20026_/RN VSS VSS VSS VSS gf180mcu_fd_sc_mcu9t5v0__clkbuf_16
X_19813_ _19813_/D _20069_/RN clkload31/I _19813_/Q VSS VSS VSS VSS gf180mcu_fd_sc_mcu9t5v0__dffrnq_1
X_12148_ _19129_/Q _12147_/Z _12333_/B _19129_/D VSS VSS VSS VSS gf180mcu_fd_sc_mcu9t5v0__mux2_1
X_16956_ _16955_/Z _18469_/Q _16960_/S _18469_/D VSS VSS VSS VSS gf180mcu_fd_sc_mcu9t5v0__mux2_1
X_12079_ _12057_/Z _12106_/A2 _12079_/Z VSS VSS VSS VSS gf180mcu_fd_sc_mcu9t5v0__and2_1
X_19744_ _19744_/D _20064_/RN clkload37/I _19744_/Q VSS VSS VSS VSS gf180mcu_fd_sc_mcu9t5v0__dffrnq_1
XPHY_EDGE_ROW_10_Right_10 VSS VSS gf180mcu_fd_sc_mcu9t5v0__endcap
X_15907_ _20116_/Q _19252_/Q wire79/Z _20116_/D VSS VSS VSS VSS gf180mcu_fd_sc_mcu9t5v0__mux2_1
X_19675_ _19675_/D _20059_/RN clkload37/I _19675_/Q VSS VSS VSS VSS gf180mcu_fd_sc_mcu9t5v0__dffrnq_1
XTAP_TAPCELL_ROW_49_2319 VSS VSS gf180mcu_fd_sc_mcu9t5v0__filltie
X_16887_ _19255_/Q _16647_/B _16893_/S _16887_/Z VSS VSS VSS VSS gf180mcu_fd_sc_mcu9t5v0__mux2_1
X_18626_ _18626_/D _20030_/RN clkload65/I _18626_/Q VSS VSS VSS VSS gf180mcu_fd_sc_mcu9t5v0__dffrnq_1
X_15838_ _20022_/Q _09758_/B _17609_/S VSS VSS VSS VSS gf180mcu_fd_sc_mcu9t5v0__nand2_1
X_15769_ input7/Z _19939_/Q _15770_/S _19939_/D VSS VSS VSS VSS gf180mcu_fd_sc_mcu9t5v0__mux2_1
X_18557_ _18557_/D _20057_/RN clkload22/I _18557_/Q VSS VSS VSS VSS gf180mcu_fd_sc_mcu9t5v0__dffrnq_1
X_17508_ _18613_/Q _19254_/Q _17513_/S _18613_/D VSS VSS VSS VSS gf180mcu_fd_sc_mcu9t5v0__mux2_1
X_18488_ _18488_/D clkload78/I _18488_/Q VSS VSS VSS VSS gf180mcu_fd_sc_mcu9t5v0__dffq_1
X_09290_ _19219_/Q _16621_/A1 VSS VSS VSS VSS gf180mcu_fd_sc_mcu9t5v0__clkinv_1
X_17439_ _17439_/A1 _17439_/A2 _17443_/A2 VSS _17439_/VNW VSS VSS gf180mcu_fd_sc_mcu9t5v0__nor2_1
XANTENNA_14 _12521_/A3 VSS VSS VSS VSS gf180mcu_fd_sc_mcu9t5v0__antenna
XANTENNA_25 output19/I VSS VSS VSS VSS gf180mcu_fd_sc_mcu9t5v0__antenna
XTAP_TAPCELL_ROW_25_1662 VSS VSS gf180mcu_fd_sc_mcu9t5v0__filltie
XTAP_TAPCELL_ROW_25_1673 VSS VSS gf180mcu_fd_sc_mcu9t5v0__filltie
XTAP_TAPCELL_ROW_304_7433 VSS VSS gf180mcu_fd_sc_mcu9t5v0__filltie
XTAP_TAPCELL_ROW_304_7422 VSS VSS gf180mcu_fd_sc_mcu9t5v0__filltie
XTAP_TAPCELL_ROW_110_4011 VSS VSS gf180mcu_fd_sc_mcu9t5v0__filltie
XTAP_TAPCELL_ROW_110_4000 VSS VSS gf180mcu_fd_sc_mcu9t5v0__filltie
XTAP_TAPCELL_ROW_21_1548 VSS VSS gf180mcu_fd_sc_mcu9t5v0__filltie
X_19109_ _19109_/D _20069_/RN clkload10/I _19109_/Q VSS VSS VSS VSS gf180mcu_fd_sc_mcu9t5v0__dffrnq_1
XTAP_TAPCELL_ROW_21_1559 VSS VSS gf180mcu_fd_sc_mcu9t5v0__filltie
XTAP_TAPCELL_ROW_304_7444 VSS VSS gf180mcu_fd_sc_mcu9t5v0__filltie
XTAP_TAPCELL_ROW_296_7223 VSS VSS gf180mcu_fd_sc_mcu9t5v0__filltie
XTAP_TAPCELL_ROW_300_7319 VSS VSS gf180mcu_fd_sc_mcu9t5v0__filltie
XTAP_TAPCELL_ROW_296_7212 VSS VSS gf180mcu_fd_sc_mcu9t5v0__filltie
XTAP_TAPCELL_ROW_300_7308 VSS VSS gf180mcu_fd_sc_mcu9t5v0__filltie
XTAP_TAPCELL_ROW_296_7201 VSS VSS gf180mcu_fd_sc_mcu9t5v0__filltie
XTAP_TAPCELL_ROW_209_4830 VSS VSS gf180mcu_fd_sc_mcu9t5v0__filltie
XTAP_TAPCELL_ROW_34_1909 VSS VSS gf180mcu_fd_sc_mcu9t5v0__filltie
XTAP_TAPCELL_ROW_292_7109 VSS VSS gf180mcu_fd_sc_mcu9t5v0__filltie
XTAP_TAPCELL_ROW_19_1499 VSS VSS gf180mcu_fd_sc_mcu9t5v0__filltie
Xmax_cap27 _16496_/S _16996_/S VSS VSS VSS VSS gf180mcu_fd_sc_mcu9t5v0__clkbuf_16
XPHY_EDGE_ROW_106_Right_106 VSS VSS gf180mcu_fd_sc_mcu9t5v0__endcap
Xmax_cap49 _17003_/S _17025_/S VSS VSS VSS VSS gf180mcu_fd_sc_mcu9t5v0__clkbuf_8
X_09626_ _20007_/Q _09698_/B _09639_/B VSS _09626_/VNW VSS VSS gf180mcu_fd_sc_mcu9t5v0__nand2_1
X_09557_ _20028_/Q _09838_/A2 _09558_/I VSS VSS VSS VSS gf180mcu_fd_sc_mcu9t5v0__nand2_1
XTAP_TAPCELL_ROW_165_3_8102 VSS VSS gf180mcu_fd_sc_mcu9t5v0__filltie
XTAP_TAPCELL_ROW_117_4209 VSS VSS gf180mcu_fd_sc_mcu9t5v0__filltie
X_09488_ _12723_/B _12486_/B1 _12686_/C _12694_/A1 VSS VSS VSS VSS gf180mcu_fd_sc_mcu9t5v0__aoi21_1
XTAP_TAPCELL_ROW_281_6802 VSS VSS gf180mcu_fd_sc_mcu9t5v0__filltie
X_11450_ _11450_/A1 _11450_/A2 _19098_/D VSS _11450_/VNW VSS VSS gf180mcu_fd_sc_mcu9t5v0__nand2_1
XTAP_TAPCELL_ROW_266_6392 VSS VSS gf180mcu_fd_sc_mcu9t5v0__filltie
X_10401_ _17358_/A1 _18255_/Q _10404_/A2 VSS VSS VSS VSS gf180mcu_fd_sc_mcu9t5v0__nor2_1
XTAP_TAPCELL_ROW_266_6381 VSS VSS gf180mcu_fd_sc_mcu9t5v0__filltie
X_11381_ _18706_/Q _12527_/A2 wire208/Z _11381_/B2 wire213/Z _11382_/A3 VSS VSS VSS
+ VSS gf180mcu_fd_sc_mcu9t5v0__aoi221_2
XTAP_TAPCELL_ROW_95_3596 VSS VSS gf180mcu_fd_sc_mcu9t5v0__filltie
XTAP_TAPCELL_ROW_95_3585 VSS VSS gf180mcu_fd_sc_mcu9t5v0__filltie
X_10332_ _10724_/C _10332_/A2 _10332_/A3 _10333_/C VSS VSS VSS VSS gf180mcu_fd_sc_mcu9t5v0__nand3_1
X_13120_ _19727_/Q _13544_/A2 _13540_/B VSS _13122_/VNW VSS VSS gf180mcu_fd_sc_mcu9t5v0__xnor2_1
XTAP_TAPCELL_ROW_262_6289 VSS VSS gf180mcu_fd_sc_mcu9t5v0__filltie
XTAP_TAPCELL_ROW_262_6278 VSS VSS gf180mcu_fd_sc_mcu9t5v0__filltie
XTAP_TAPCELL_ROW_262_6267 VSS VSS gf180mcu_fd_sc_mcu9t5v0__filltie
X_13051_ _13063_/A2 _19790_/Q _13073_/A1 VSS VSS VSS VSS gf180mcu_fd_sc_mcu9t5v0__nor2_1
X_12002_ _12348_/C _11990_/Z _12002_/B _12003_/A2 VSS _16099_/VNW VSS VSS gf180mcu_fd_sc_mcu9t5v0__oai21_1
X_10263_ _18330_/Q _18314_/Q _19825_/Q _10263_/Z VSS VSS VSS VSS gf180mcu_fd_sc_mcu9t5v0__mux2_1
Xload_slew209 _12028_/C _11878_/A1 VSS VSS VSS VSS gf180mcu_fd_sc_mcu9t5v0__clkbuf_8
XTAP_TAPCELL_ROW_279_6753 VSS VSS gf180mcu_fd_sc_mcu9t5v0__filltie
XTAP_TAPCELL_ROW_279_6742 VSS VSS gf180mcu_fd_sc_mcu9t5v0__filltie
XTAP_TAPCELL_ROW_279_6731 VSS VSS gf180mcu_fd_sc_mcu9t5v0__filltie
X_10194_ _10194_/A1 _17625_/A1 _15677_/B VSS _10194_/VNW VSS VSS gf180mcu_fd_sc_mcu9t5v0__nand2_1
X_16810_ _18402_/Q _16809_/Z _16818_/S _18402_/D VSS VSS VSS VSS gf180mcu_fd_sc_mcu9t5v0__mux2_4
XTAP_TAPCELL_ROW_275_6628 VSS VSS gf180mcu_fd_sc_mcu9t5v0__filltie
X_17790_ _18768_/Q _17790_/A2 _17791_/A2 VSS VSS VSS VSS gf180mcu_fd_sc_mcu9t5v0__xnor2_1
XTAP_TAPCELL_ROW_106_3902 VSS VSS gf180mcu_fd_sc_mcu9t5v0__filltie
XTAP_TAPCELL_ROW_275_6639 VSS VSS gf180mcu_fd_sc_mcu9t5v0__filltie
X_16741_ _16741_/A1 _16741_/A2 _16741_/B1 _16741_/B2 _16741_/C _16742_/I1 VSS VSS
+ VSS VSS gf180mcu_fd_sc_mcu9t5v0__aoi221_4
X_13953_ _19316_/Q _19301_/Q _13992_/A1 VSS _13993_/VNW VSS VSS gf180mcu_fd_sc_mcu9t5v0__nand2_1
X_16672_ _16672_/A1 _16672_/A2 _16672_/B _16750_/B VSS VSS VSS VSS gf180mcu_fd_sc_mcu9t5v0__oai21_4
X_12904_ _19774_/Q _12902_/Z _12904_/Z VSS VSS VSS VSS gf180mcu_fd_sc_mcu9t5v0__or2_1
X_13884_ _19319_/Q _19296_/Q _13885_/A2 VSS VSS VSS VSS gf180mcu_fd_sc_mcu9t5v0__nand2_1
X_19460_ _19460_/D _20036_/RN clkload10/I _19460_/Q VSS VSS VSS VSS gf180mcu_fd_sc_mcu9t5v0__dffrnq_1
X_18411_ _18411_/D clkload61/I _18411_/Q VSS VSS VSS VSS gf180mcu_fd_sc_mcu9t5v0__dffq_1
X_15623_ _15626_/A1 _15623_/A2 _15623_/Z VSS VSS VSS VSS gf180mcu_fd_sc_mcu9t5v0__or2_1
X_12835_ _19764_/Q _12833_/Z _12839_/B VSS VSS VSS VSS gf180mcu_fd_sc_mcu9t5v0__and2_1
XTAP_TAPCELL_ROW_44_2205 VSS VSS gf180mcu_fd_sc_mcu9t5v0__filltie
X_19391_ _19391_/D _20031_/RN clkload20/I _19391_/Q VSS VSS VSS VSS gf180mcu_fd_sc_mcu9t5v0__dffrnq_1
X_15554_ _19871_/Q _15551_/S _15555_/A3 VSS VSS VSS VSS gf180mcu_fd_sc_mcu9t5v0__nor2_1
X_18342_ _18342_/D clkload81/I _18342_/Q VSS VSS VSS VSS gf180mcu_fd_sc_mcu9t5v0__dffq_1
XTAP_TAPCELL_ROW_251_5971 VSS VSS gf180mcu_fd_sc_mcu9t5v0__filltie
XTAP_TAPCELL_ROW_251_5960 VSS VSS gf180mcu_fd_sc_mcu9t5v0__filltie
XPHY_EDGE_ROW_158_3_Left_816 VSS VSS gf180mcu_fd_sc_mcu9t5v0__endcap
X_14505_ _14505_/A1 _14731_/B _14731_/A1 VSS _14505_/VNW VSS VSS gf180mcu_fd_sc_mcu9t5v0__nor2_1
X_12766_ _19754_/Q _12763_/Z _12771_/A2 VSS _12766_/VNW VSS VSS gf180mcu_fd_sc_mcu9t5v0__nor2_1
X_11717_ _12116_/C _11716_/Z _11717_/B _11718_/B1 VSS VSS VSS VSS gf180mcu_fd_sc_mcu9t5v0__aoi21_1
XTAP_TAPCELL_ROW_251_5982 VSS VSS gf180mcu_fd_sc_mcu9t5v0__filltie
X_18273_ _18273_/D _18273_/CLK _18273_/Q VSS VSS VSS VSS gf180mcu_fd_sc_mcu9t5v0__dffq_4
X_15485_ _19830_/Q _15504_/A3 _15486_/A2 VSS _15485_/VNW VSS VSS gf180mcu_fd_sc_mcu9t5v0__nor2_1
X_12697_ _17961_/A4 _12682_/C _12722_/A1 VSS _12697_/VNW VSS VSS gf180mcu_fd_sc_mcu9t5v0__nand2_1
X_17224_ _17409_/B _17224_/A2 _17224_/A3 _17225_/C VSS VSS VSS VSS gf180mcu_fd_sc_mcu9t5v0__nand3_1
X_11648_ _11590_/Z _12632_/C _11649_/B VSS _11648_/VNW VSS VSS gf180mcu_fd_sc_mcu9t5v0__nor2_1
X_14436_ _19155_/Q _19121_/Q _14702_/B VSS _14439_/VNW VSS VSS gf180mcu_fd_sc_mcu9t5v0__and2_1
X_17155_ _17155_/A1 _17155_/A2 _17155_/B1 _17155_/B2 _17156_/A2 VSS VSS VSS VSS gf180mcu_fd_sc_mcu9t5v0__aoi22_1
X_11579_ _11579_/A1 _11579_/A2 _19107_/D VSS VSS VSS VSS gf180mcu_fd_sc_mcu9t5v0__nand2_1
X_14367_ _14367_/I0 _19437_/Q _14367_/S _19437_/D VSS VSS VSS VSS gf180mcu_fd_sc_mcu9t5v0__mux2_1
X_16106_ _16106_/A1 _16511_/A1 _16106_/B _16106_/C _16106_/ZN VSS VSS VSS VSS gf180mcu_fd_sc_mcu9t5v0__aoi211_4
X_13318_ _19739_/Q _13318_/A2 _13337_/B VSS _13337_/VNW VSS VSS gf180mcu_fd_sc_mcu9t5v0__nor2_1
XPHY_EDGE_ROW_257_Right_184 VSS VSS gf180mcu_fd_sc_mcu9t5v0__endcap
X_17086_ _19825_/Q _18457_/Q _17088_/A3 VSS _17086_/VNW VSS VSS gf180mcu_fd_sc_mcu9t5v0__nor2_1
XPHY_EDGE_ROW_154_1_Left_477 VSS VSS gf180mcu_fd_sc_mcu9t5v0__endcap
X_14298_ _14365_/I0 _19371_/Q _14304_/S _19371_/D VSS VSS VSS VSS gf180mcu_fd_sc_mcu9t5v0__mux2_1
X_16037_ _16668_/A1 _16628_/A2 _16142_/C _16039_/A2 VSS VSS VSS VSS gf180mcu_fd_sc_mcu9t5v0__aoi21_1
XTAP_TAPCELL_ROW_245_5797 VSS VSS gf180mcu_fd_sc_mcu9t5v0__filltie
X_13249_ _12734_/Z _13265_/A2 _13250_/B2 VSS VSS VSS VSS gf180mcu_fd_sc_mcu9t5v0__nand2_1
XTAP_TAPCELL_ROW_171_3_8123 VSS VSS gf180mcu_fd_sc_mcu9t5v0__filltie
X_17988_ _18855_/Q _17988_/A2 _18004_/S VSS VSS VSS VSS gf180mcu_fd_sc_mcu9t5v0__nor2_2
X_19727_ _19727_/D _20047_/RN clkload17/I _19727_/Q VSS VSS VSS VSS gf180mcu_fd_sc_mcu9t5v0__dffrnq_1
X_16939_ _19248_/Q _16599_/B _16949_/S _16939_/Z VSS VSS VSS VSS gf180mcu_fd_sc_mcu9t5v0__mux2_1
XTAP_TAPCELL_ROW_14_1363 VSS VSS gf180mcu_fd_sc_mcu9t5v0__filltie
XTAP_TAPCELL_ROW_14_1374 VSS VSS gf180mcu_fd_sc_mcu9t5v0__filltie
X_19658_ _19658_/D _20042_/RN clkload29/I _19658_/Q VSS VSS VSS VSS gf180mcu_fd_sc_mcu9t5v0__dffrnq_1
XTAP_TAPCELL_ROW_10_1249 VSS VSS gf180mcu_fd_sc_mcu9t5v0__filltie
X_18609_ _18609_/D _20129_/CLK _18609_/Q VSS VSS VSS VSS gf180mcu_fd_sc_mcu9t5v0__dffq_1
X_09411_ _17879_/B2 _17872_/A1 _17878_/A1 _09820_/A1 VSS VSS VSS VSS gf180mcu_fd_sc_mcu9t5v0__nor3_4
X_19589_ _19589_/D _20037_/RN clkload7/I _19589_/Q VSS VSS VSS VSS gf180mcu_fd_sc_mcu9t5v0__dffrnq_1
X_09342_ _19885_/Q _10180_/A2 VSS _17996_/VNW VSS VSS gf180mcu_fd_sc_mcu9t5v0__clkinv_1
XTAP_TAPCELL_ROW_27_1713 VSS VSS gf180mcu_fd_sc_mcu9t5v0__filltie
XTAP_TAPCELL_ROW_27_1724 VSS VSS gf180mcu_fd_sc_mcu9t5v0__filltie
XTAP_TAPCELL_ROW_27_1735 VSS VSS gf180mcu_fd_sc_mcu9t5v0__filltie
X_09273_ _19989_/Q _15824_/A1 VSS _15824_/VNW VSS VSS gf180mcu_fd_sc_mcu9t5v0__clkinv_1
XPHY_EDGE_ROW_224_Right_151 VSS VSS gf180mcu_fd_sc_mcu9t5v0__endcap
XTAP_TAPCELL_ROW_90_3460 VSS VSS gf180mcu_fd_sc_mcu9t5v0__filltie
XTAP_TAPCELL_ROW_90_3471 VSS VSS gf180mcu_fd_sc_mcu9t5v0__filltie
XTAP_TAPCELL_ROW_270_6503 VSS VSS gf180mcu_fd_sc_mcu9t5v0__filltie
XTAP_TAPCELL_ROW_255_6071 VSS VSS gf180mcu_fd_sc_mcu9t5v0__filltie
X_10950_ _10952_/A1 _10952_/A2 _10950_/Z VSS _10953_/VNW VSS VSS gf180mcu_fd_sc_mcu9t5v0__xor2_1
XTAP_TAPCELL_ROW_84_3286 VSS VSS gf180mcu_fd_sc_mcu9t5v0__filltie
XTAP_TAPCELL_ROW_255_6093 VSS VSS gf180mcu_fd_sc_mcu9t5v0__filltie
XTAP_TAPCELL_ROW_255_6082 VSS VSS gf180mcu_fd_sc_mcu9t5v0__filltie
X_10881_ _19243_/Q _18147_/S _10892_/B VSS VSS VSS VSS gf180mcu_fd_sc_mcu9t5v0__nand2_1
XTAP_TAPCELL_ROW_84_3297 VSS VSS gf180mcu_fd_sc_mcu9t5v0__filltie
X_09609_ _09582_/Z _09609_/A2 _09609_/A3 _09608_/Z _09688_/B VSS VSS VSS VSS gf180mcu_fd_sc_mcu9t5v0__nand4_4
Xwire80 wire81/Z wire80/Z VSS VSS VSS VSS gf180mcu_fd_sc_mcu9t5v0__clkbuf_16
X_12620_ _12620_/A1 _12620_/A2 _12620_/A3 _12620_/B _19173_/D VSS VSS VSS VSS gf180mcu_fd_sc_mcu9t5v0__oai31_1
X_12551_ _18448_/Q _12607_/A2 _12553_/B1 VSS VSS VSS VSS gf180mcu_fd_sc_mcu9t5v0__nor2_1
XTAP_TAPCELL_ROW_268_6443 VSS VSS gf180mcu_fd_sc_mcu9t5v0__filltie
XTAP_TAPCELL_ROW_268_6432 VSS VSS gf180mcu_fd_sc_mcu9t5v0__filltie
XTAP_TAPCELL_ROW_97_3658 VSS VSS gf180mcu_fd_sc_mcu9t5v0__filltie
XTAP_TAPCELL_ROW_97_3647 VSS VSS gf180mcu_fd_sc_mcu9t5v0__filltie
XTAP_TAPCELL_ROW_268_6454 VSS VSS gf180mcu_fd_sc_mcu9t5v0__filltie
X_12482_ _12616_/B _12482_/A2 _12482_/A3 _12482_/B1 _12482_/B2 wire291/I VSS VSS VSS
+ VSS gf180mcu_fd_sc_mcu9t5v0__oai32_2
X_11502_ _19102_/Q _11541_/A2 _11503_/A2 VSS VSS VSS VSS gf180mcu_fd_sc_mcu9t5v0__nand2_1
X_15270_ _19733_/Q _15270_/I1 _15364_/S _19733_/D VSS VSS VSS VSS gf180mcu_fd_sc_mcu9t5v0__mux2_1
X_11433_ _18566_/Q _18368_/Q _11428_/B _11432_/Z _11526_/B _11434_/B VSS VSS VSS VSS
+ gf180mcu_fd_sc_mcu9t5v0__aoi221_1
XTAP_TAPCELL_ROW_264_6329 VSS VSS gf180mcu_fd_sc_mcu9t5v0__filltie
XTAP_TAPCELL_ROW_264_6318 VSS VSS gf180mcu_fd_sc_mcu9t5v0__filltie
X_14221_ _14226_/A1 _14198_/Z _14221_/B _14229_/A2 VSS VSS VSS VSS gf180mcu_fd_sc_mcu9t5v0__aoi21_1
XPHY_EDGE_ROW_49_Left_373 VSS VSS gf180mcu_fd_sc_mcu9t5v0__endcap
X_14152_ _19477_/Q _19485_/Q _14165_/S _14152_/Z VSS VSS VSS VSS gf180mcu_fd_sc_mcu9t5v0__mux2_1
X_11364_ _18427_/Q _11521_/B _11364_/B _11520_/B _11365_/A3 VSS VSS VSS VSS gf180mcu_fd_sc_mcu9t5v0__aoi211_1
X_10315_ _10648_/C _18668_/Q _10821_/B _10332_/A2 VSS VSS VSS VSS gf180mcu_fd_sc_mcu9t5v0__nand3_1
X_18960_ _18960_/D _20048_/RN clkload71/I _18960_/Q VSS VSS VSS VSS gf180mcu_fd_sc_mcu9t5v0__dffrnq_1
X_11295_ _19086_/Q _11321_/A2 _11296_/A2 VSS VSS VSS VSS gf180mcu_fd_sc_mcu9t5v0__nand2_1
X_13103_ _13104_/A1 _13104_/A2 _13103_/B _13124_/A2 VSS _13538_/VNW VSS VSS gf180mcu_fd_sc_mcu9t5v0__aoi21_1
X_14083_ _19297_/Q _14245_/A1 _14085_/A2 VSS VSS VSS VSS gf180mcu_fd_sc_mcu9t5v0__nor2_1
X_10246_ _10724_/C _10246_/A2 _10246_/A3 _10247_/C VSS VSS VSS VSS gf180mcu_fd_sc_mcu9t5v0__nand3_1
X_13034_ _19755_/Q _19789_/Q _13034_/A3 _13035_/I VSS _13525_/VNW VSS VSS gf180mcu_fd_sc_mcu9t5v0__xnor3_1
XTAP_TAPCELL_ROW_73_2990 VSS VSS gf180mcu_fd_sc_mcu9t5v0__filltie
X_18891_ _18891_/D _20043_/RN clkload10/I _18891_/Q VSS VSS VSS VSS gf180mcu_fd_sc_mcu9t5v0__dffrnq_1
X_17911_ _18841_/Q _17894_/I _17913_/B VSS VSS VSS VSS gf180mcu_fd_sc_mcu9t5v0__nand2_1
X_17842_ _19049_/Q _18819_/Q _17844_/S _18819_/D VSS VSS VSS VSS gf180mcu_fd_sc_mcu9t5v0__mux2_1
XTAP_TAPCELL_ROW_240_5683 VSS VSS gf180mcu_fd_sc_mcu9t5v0__filltie
XTAP_TAPCELL_ROW_240_5672 VSS VSS gf180mcu_fd_sc_mcu9t5v0__filltie
XTAP_TAPCELL_ROW_240_5661 VSS VSS gf180mcu_fd_sc_mcu9t5v0__filltie
X_10177_ _20000_/Q _19964_/Q _19972_/Q _20004_/Q _19988_/Q _19998_/Q _10178_/A2 VSS
+ VSS VSS VSS gf180mcu_fd_sc_mcu9t5v0__aoi222_1
XPHY_EDGE_ROW_58_Left_382 VSS VSS gf180mcu_fd_sc_mcu9t5v0__endcap
X_17773_ _17773_/A1 _17773_/A2 _17773_/B _17779_/C _18761_/D VSS VSS VSS VSS gf180mcu_fd_sc_mcu9t5v0__aoi211_1
XTAP_TAPCELL_ROW_156_3_8069 VSS VSS gf180mcu_fd_sc_mcu9t5v0__filltie
X_14985_ _19619_/Q _14984_/Z _20039_/D _19619_/D VSS VSS VSS VSS gf180mcu_fd_sc_mcu9t5v0__mux2_1
X_16724_ _16951_/A1 _16751_/A2 _16751_/A3 _16725_/B VSS VSS VSS VSS gf180mcu_fd_sc_mcu9t5v0__nor3_4
X_19512_ _19512_/D _19960_/RN clkload26/I _19512_/Q VSS VSS VSS VSS gf180mcu_fd_sc_mcu9t5v0__dffrnq_1
X_13936_ _13936_/A1 _13936_/A2 _13960_/A2 VSS VSS VSS VSS gf180mcu_fd_sc_mcu9t5v0__xnor2_1
X_16655_ _15996_/B _16655_/A2 _16655_/A3 _16655_/B _16656_/I1 VSS _16656_/VNW VSS
+ VSS gf180mcu_fd_sc_mcu9t5v0__oai31_1
X_19443_ _19443_/D _20019_/RN clkload10/I _19443_/Q VSS VSS VSS VSS gf180mcu_fd_sc_mcu9t5v0__dffrnq_1
XPHY_EDGE_ROW_168_2_Left_680 VSS VSS gf180mcu_fd_sc_mcu9t5v0__endcap
X_15606_ _19887_/Q _15606_/I1 _15629_/B _19887_/D VSS VSS VSS VSS gf180mcu_fd_sc_mcu9t5v0__mux2_1
X_13867_ _13869_/A1 _13866_/Z _13867_/Z VSS VSS VSS VSS gf180mcu_fd_sc_mcu9t5v0__xor2_1
X_16586_ _15996_/B _16586_/A2 _16586_/A3 _16586_/B _16587_/I1 VSS VSS VSS VSS gf180mcu_fd_sc_mcu9t5v0__oai31_1
X_12818_ _13164_/A2 _12818_/A2 _12815_/Z _12819_/I0 VSS _12818_/VNW VSS VSS gf180mcu_fd_sc_mcu9t5v0__xnor3_1
X_13798_ _19292_/Q _19320_/Q _19293_/Q _19319_/Q _13823_/B1 VSS VSS VSS VSS gf180mcu_fd_sc_mcu9t5v0__aoi22_1
X_19374_ _19374_/D _20142_/RN clkload21/I _19374_/Q VSS VSS VSS VSS gf180mcu_fd_sc_mcu9t5v0__dffrnq_1
X_15537_ _19855_/Q _19838_/Q _15551_/S _19855_/D VSS VSS VSS VSS gf180mcu_fd_sc_mcu9t5v0__mux2_1
X_18325_ _18325_/D _18328_/CLK _18325_/Q VSS VSS VSS VSS gf180mcu_fd_sc_mcu9t5v0__dffq_4
XTAP_TAPCELL_ROW_234_5498 VSS VSS gf180mcu_fd_sc_mcu9t5v0__filltie
X_12749_ _12753_/B _12749_/A2 _12753_/A2 VSS _12749_/VNW VSS VSS gf180mcu_fd_sc_mcu9t5v0__nor2_1
X_18256_ _18256_/D clkload74/I _18256_/Q VSS VSS VSS VSS gf180mcu_fd_sc_mcu9t5v0__dffq_1
X_15468_ _19817_/Q _19825_/Q _15468_/A3 _15469_/I1 VSS VSS VSS VSS gf180mcu_fd_sc_mcu9t5v0__nor3_1
XPHY_EDGE_ROW_67_Left_391 VSS VSS gf180mcu_fd_sc_mcu9t5v0__endcap
X_17207_ _18542_/Q _17394_/A2 _17208_/B VSS VSS VSS VSS gf180mcu_fd_sc_mcu9t5v0__nand2_1
X_14419_ _14419_/I _14696_/A1 VSS VSS VSS VSS gf180mcu_fd_sc_mcu9t5v0__clkinv_1
X_18187_ _18187_/D clkload61/I _18187_/Q VSS VSS VSS VSS gf180mcu_fd_sc_mcu9t5v0__dffq_1
X_15399_ _19684_/Q _19784_/Q _15417_/S _19784_/D VSS VSS VSS VSS gf180mcu_fd_sc_mcu9t5v0__mux2_1
X_17138_ _17159_/B _17138_/A2 _17138_/A3 _17138_/B _17139_/A2 VSS VSS VSS VSS gf180mcu_fd_sc_mcu9t5v0__oai31_1
XTAP_TAPCELL_ROW_247_5859 VSS VSS gf180mcu_fd_sc_mcu9t5v0__filltie
X_17069_ _18531_/Q _16641_/B _17069_/S _18531_/D VSS VSS VSS VSS gf180mcu_fd_sc_mcu9t5v0__mux2_1
X_09960_ _18805_/Q _18803_/Q _18804_/Q _18801_/Q _09961_/A3 VSS VSS VSS VSS gf180mcu_fd_sc_mcu9t5v0__nor4_1
X_20080_ _20080_/D clkload57/I _20080_/Q VSS VSS VSS VSS gf180mcu_fd_sc_mcu9t5v0__dffq_1
X_09891_ _09916_/B _10164_/A1 _09981_/B VSS VSS VSS VSS gf180mcu_fd_sc_mcu9t5v0__or2_1
XTAP_TAPCELL_ROW_16_1414 VSS VSS gf180mcu_fd_sc_mcu9t5v0__filltie
XTAP_TAPCELL_ROW_16_1425 VSS VSS gf180mcu_fd_sc_mcu9t5v0__filltie
XTAP_TAPCELL_ROW_16_1436 VSS VSS gf180mcu_fd_sc_mcu9t5v0__filltie
X_09325_ _19881_/Q _15591_/A1 VSS _09325_/VNW VSS VSS gf180mcu_fd_sc_mcu9t5v0__clkinv_1
XTAP_TAPCELL_ROW_135_4684 VSS VSS gf180mcu_fd_sc_mcu9t5v0__filltie
X_09256_ _20039_/Q _15090_/A2 VSS VSS VSS VSS gf180mcu_fd_sc_mcu9t5v0__clkinv_1
XTAP_TAPCELL_ROW_92_3511 VSS VSS gf180mcu_fd_sc_mcu9t5v0__filltie
XTAP_TAPCELL_ROW_135_4695 VSS VSS gf180mcu_fd_sc_mcu9t5v0__filltie
XTAP_TAPCELL_ROW_92_3500 VSS VSS gf180mcu_fd_sc_mcu9t5v0__filltie
XTAP_TAPCELL_ROW_92_3522 VSS VSS gf180mcu_fd_sc_mcu9t5v0__filltie
X_09187_ _19158_/Q _14465_/A1 VSS VSS VSS VSS gf180mcu_fd_sc_mcu9t5v0__clkinv_1
XTAP_TAPCELL_ROW_77_3090 VSS VSS gf180mcu_fd_sc_mcu9t5v0__filltie
X_10100_ _18967_/Q _09898_/C wire297/Z _18991_/Q _10101_/I VSS VSS VSS VSS gf180mcu_fd_sc_mcu9t5v0__aoi22_1
X_11080_ _18564_/Q _17434_/A2 _11094_/B _11334_/A2 VSS VSS VSS VSS gf180mcu_fd_sc_mcu9t5v0__oai21_4
X_10031_ _18793_/Q _10154_/A2 _10154_/B _10033_/A2 VSS _10033_/VNW VSS VSS gf180mcu_fd_sc_mcu9t5v0__oai21_1
XTAP_TAPCELL_ROW_86_3337 VSS VSS gf180mcu_fd_sc_mcu9t5v0__filltie
XTAP_TAPCELL_ROW_257_6144 VSS VSS gf180mcu_fd_sc_mcu9t5v0__filltie
XTAP_TAPCELL_ROW_257_6133 VSS VSS gf180mcu_fd_sc_mcu9t5v0__filltie
XTAP_TAPCELL_ROW_86_3359 VSS VSS gf180mcu_fd_sc_mcu9t5v0__filltie
XTAP_TAPCELL_ROW_86_3348 VSS VSS gf180mcu_fd_sc_mcu9t5v0__filltie
XTAP_TAPCELL_ROW_253_6019 VSS VSS gf180mcu_fd_sc_mcu9t5v0__filltie
X_14770_ _19558_/Q _19324_/Q wire108/I _19558_/D VSS VSS VSS VSS gf180mcu_fd_sc_mcu9t5v0__mux2_1
X_11982_ _12348_/C _11974_/Z _11982_/B1 _11982_/B2 _11988_/A2 VSS VSS VSS VSS gf180mcu_fd_sc_mcu9t5v0__oai22_1
X_13721_ _13722_/A1 _14671_/B _14671_/A1 VSS _14670_/VNW VSS VSS gf180mcu_fd_sc_mcu9t5v0__nor2_1
X_10933_ _10933_/I _10969_/A1 VSS VSS VSS VSS gf180mcu_fd_sc_mcu9t5v0__clkinv_1
XTAP_TAPCELL_ROW_99_3709 VSS VSS gf180mcu_fd_sc_mcu9t5v0__filltie
XTAP_TAPCELL_ROW_2_1034 VSS VSS gf180mcu_fd_sc_mcu9t5v0__filltie
XTAP_TAPCELL_ROW_2_1045 VSS VSS gf180mcu_fd_sc_mcu9t5v0__filltie
X_10864_ _10863_/Z _18971_/Q _18152_/S _18971_/D VSS VSS VSS VSS gf180mcu_fd_sc_mcu9t5v0__mux2_1
X_16440_ _18568_/Q _15954_/B _16440_/B _16511_/A4 VSS VSS VSS VSS gf180mcu_fd_sc_mcu9t5v0__aoi21_4
X_13652_ _14353_/A1 _13656_/A1 _13652_/B _13733_/A2 VSS VSS VSS VSS gf180mcu_fd_sc_mcu9t5v0__oai21_1
X_16371_ _16117_/C _19228_/Q _16925_/S _16371_/Z VSS _16581_/VNW VSS VSS gf180mcu_fd_sc_mcu9t5v0__mux2_1
X_10795_ _10795_/A1 _10795_/A2 _17420_/I0 VSS VSS VSS VSS gf180mcu_fd_sc_mcu9t5v0__nand2_1
X_12603_ _19171_/Q _12620_/A1 _12604_/B VSS _12603_/VNW VSS VSS gf180mcu_fd_sc_mcu9t5v0__nand2_1
X_13583_ wire277/Z _13583_/A2 _13583_/B _19278_/D VSS VSS VSS VSS gf180mcu_fd_sc_mcu9t5v0__oai21_1
XTAP_TAPCELL_ROW_62_2680 VSS VSS gf180mcu_fd_sc_mcu9t5v0__filltie
X_12534_ _12541_/B _12534_/A2 _12534_/A3 _12534_/B1 _12534_/B2 _12535_/B2 VSS VSS
+ VSS VSS gf180mcu_fd_sc_mcu9t5v0__oai32_2
X_18110_ _18109_/Z _18942_/Q _18152_/S _18942_/D VSS _18110_/VNW VSS VSS gf180mcu_fd_sc_mcu9t5v0__mux2_1
X_19090_ _19090_/D _20050_/RN clkload22/I _19090_/Q VSS VSS VSS VSS gf180mcu_fd_sc_mcu9t5v0__dffrnq_1
XTAP_TAPCELL_ROW_62_2691 VSS VSS gf180mcu_fd_sc_mcu9t5v0__filltie
X_15322_ _15324_/A2 _15322_/A2 _15323_/I1 VSS _15322_/VNW VSS VSS gf180mcu_fd_sc_mcu9t5v0__xnor2_1
X_18041_ _18928_/Q _18924_/Q _18042_/A2 _18046_/B VSS VSS VSS VSS gf180mcu_fd_sc_mcu9t5v0__nand3_1
X_12465_ _18310_/Q _12616_/A2 _12616_/B _12466_/B2 VSS VSS VSS VSS gf180mcu_fd_sc_mcu9t5v0__oai21_1
X_15253_ _19599_/Q _15258_/A2 _15258_/C _15255_/A3 VSS VSS VSS VSS gf180mcu_fd_sc_mcu9t5v0__oai21_1
Xclkbuf_3_1_0_clk_regs clkbuf_0_clk_regs/Z clkload0/I VSS VSS VSS VSS gf180mcu_fd_sc_mcu9t5v0__clkbuf_8
X_12396_ _18158_/Q _12382_/S _12400_/A2 VSS VSS VSS VSS gf180mcu_fd_sc_mcu9t5v0__nor2_1
X_11416_ _11429_/B _11415_/Z _11416_/B _11420_/A2 VSS VSS VSS VSS gf180mcu_fd_sc_mcu9t5v0__oai21_1
X_15184_ _15185_/A1 _19562_/Q _19561_/Q _15184_/B2 _15186_/B2 VSS VSS VSS VSS gf180mcu_fd_sc_mcu9t5v0__oai22_1
X_14204_ _14205_/A1 _14203_/Z _14219_/B VSS VSS VSS VSS gf180mcu_fd_sc_mcu9t5v0__nand2_1
X_11347_ _11429_/B _11345_/Z _11347_/B _11351_/A2 VSS VSS VSS VSS gf180mcu_fd_sc_mcu9t5v0__oai21_1
XTAP_TAPCELL_ROW_242_5712 VSS VSS gf180mcu_fd_sc_mcu9t5v0__filltie
XPHY_EDGE_ROW_195_3_Right_310 VSS VSS gf180mcu_fd_sc_mcu9t5v0__endcap
X_19992_ _19992_/D _19992_/RN clkload65/I _19992_/Q VSS VSS VSS VSS gf180mcu_fd_sc_mcu9t5v0__dffrnq_1
X_14135_ _14136_/A1 _14134_/Z _14183_/B VSS VSS VSS VSS gf180mcu_fd_sc_mcu9t5v0__nor2_1
XTAP_TAPCELL_ROW_242_5734 VSS VSS gf180mcu_fd_sc_mcu9t5v0__filltie
XTAP_TAPCELL_ROW_242_5723 VSS VSS gf180mcu_fd_sc_mcu9t5v0__filltie
XTAP_TAPCELL_ROW_71_2938 VSS VSS gf180mcu_fd_sc_mcu9t5v0__filltie
XTAP_TAPCELL_ROW_71_2927 VSS VSS gf180mcu_fd_sc_mcu9t5v0__filltie
X_18943_ _18943_/D _20031_/RN clkload67/I _18943_/Q VSS VSS VSS VSS gf180mcu_fd_sc_mcu9t5v0__dffrnq_1
X_11278_ _18566_/Q _18181_/Q _11280_/B1 VSS VSS VSS VSS gf180mcu_fd_sc_mcu9t5v0__nand2_1
X_14066_ _14099_/A1 _14066_/A2 _14365_/I0 VSS VSS VSS VSS gf180mcu_fd_sc_mcu9t5v0__xnor2_2
X_10229_ _17195_/A1 _18185_/Q _10232_/A2 VSS VSS VSS VSS gf180mcu_fd_sc_mcu9t5v0__nor2_1
XTAP_TAPCELL_ROW_223_5199 VSS VSS gf180mcu_fd_sc_mcu9t5v0__filltie
X_18874_ _18874_/D _20026_/RN clkload41/I _18874_/Q VSS VSS VSS VSS gf180mcu_fd_sc_mcu9t5v0__dffrnq_1
X_13017_ _19722_/Q _13020_/A2 _13018_/I VSS _13018_/VNW VSS VSS gf180mcu_fd_sc_mcu9t5v0__nand2_1
X_17825_ _19032_/Q _18802_/Q _17845_/S _18802_/D VSS _17825_/VNW VSS VSS gf180mcu_fd_sc_mcu9t5v0__mux2_1
X_17756_ _17807_/S _17780_/A1 _17780_/A2 _17756_/Z VSS VSS VSS VSS gf180mcu_fd_sc_mcu9t5v0__or3_1
XTAP_TAPCELL_ROW_69_2878 VSS VSS gf180mcu_fd_sc_mcu9t5v0__filltie
XTAP_TAPCELL_ROW_69_2867 VSS VSS gf180mcu_fd_sc_mcu9t5v0__filltie
X_16707_ _18367_/Q _16707_/I1 _16707_/S _18367_/D VSS VSS VSS VSS gf180mcu_fd_sc_mcu9t5v0__mux2_4
XTAP_TAPCELL_ROW_69_2889 VSS VSS gf180mcu_fd_sc_mcu9t5v0__filltie
X_14968_ _14968_/A1 _14966_/Z _14969_/A2 VSS _14968_/VNW VSS VSS gf180mcu_fd_sc_mcu9t5v0__xnor2_1
XTAP_TAPCELL_ROW_236_5549 VSS VSS gf180mcu_fd_sc_mcu9t5v0__filltie
X_17687_ _18647_/Q _17743_/B _17689_/B VSS VSS VSS VSS gf180mcu_fd_sc_mcu9t5v0__nand2_1
X_13919_ _13919_/A1 _13919_/A2 _13951_/A2 VSS VSS VSS VSS gf180mcu_fd_sc_mcu9t5v0__xnor2_1
X_14899_ _14899_/A1 _14899_/A2 _14899_/Z VSS VSS VSS VSS gf180mcu_fd_sc_mcu9t5v0__xor2_1
X_16638_ _19286_/Q _16675_/A1 _16642_/B VSS _16638_/VNW VSS VSS gf180mcu_fd_sc_mcu9t5v0__nand2_1
XPHY_EDGE_ROW_8_Right_8 VSS VSS gf180mcu_fd_sc_mcu9t5v0__endcap
X_19426_ _19426_/D _20066_/RN clkload20/I _19426_/Q VSS VSS VSS VSS gf180mcu_fd_sc_mcu9t5v0__dffrnq_1
X_16569_ _16569_/A1 _16562_/Z _16569_/A3 _16569_/B _16571_/A2 VSS _16995_/VNW VSS
+ VSS gf180mcu_fd_sc_mcu9t5v0__oai31_1
X_19357_ _19357_/D _20061_/RN clkload18/I _19357_/Q VSS VSS VSS VSS gf180mcu_fd_sc_mcu9t5v0__dffrnq_1
X_18308_ _18308_/D clkload80/I _18308_/Q VSS VSS VSS VSS gf180mcu_fd_sc_mcu9t5v0__dffq_1
X_09110_ _19719_/Q _12968_/A1 VSS _12972_/VNW VSS VSS gf180mcu_fd_sc_mcu9t5v0__clkinv_1
X_19288_ _19288_/D _19992_/RN clkload39/I _19288_/Q VSS VSS VSS VSS gf180mcu_fd_sc_mcu9t5v0__dffrnq_1
X_18239_ _18239_/D _20099_/CLK _18239_/Q VSS VSS VSS VSS gf180mcu_fd_sc_mcu9t5v0__dffq_1
XTAP_TAPCELL_ROW_212_4892 VSS VSS gf180mcu_fd_sc_mcu9t5v0__filltie
XTAP_TAPCELL_ROW_130_4570 VSS VSS gf180mcu_fd_sc_mcu9t5v0__filltie
Xmax_cap153 _11520_/B _11428_/B VSS VSS VSS VSS gf180mcu_fd_sc_mcu9t5v0__buf_8
Xmax_cap142 _11736_/C _12342_/C VSS VSS VSS VSS gf180mcu_fd_sc_mcu9t5v0__clkbuf_8
XTAP_TAPCELL_ROW_320_7878 VSS VSS gf180mcu_fd_sc_mcu9t5v0__filltie
X_20132_ _20132_/D _20132_/CLK _20132_/Q VSS VSS VSS VSS gf180mcu_fd_sc_mcu9t5v0__dffq_1
XTAP_TAPCELL_ROW_320_7867 VSS VSS gf180mcu_fd_sc_mcu9t5v0__filltie
Xmax_cap164 wire163/I _12582_/A2 VSS VSS VSS VSS gf180mcu_fd_sc_mcu9t5v0__buf_4
Xmax_cap186 _12046_/S _12340_/S VSS VSS VSS VSS gf180mcu_fd_sc_mcu9t5v0__clkbuf_16
X_09943_ _09943_/A1 _09943_/A2 _09943_/A3 _18822_/Q _10179_/A1 _10153_/B VSS _17839_/VNW
+ VSS VSS gf180mcu_fd_sc_mcu9t5v0__oai32_1
XPHY_EDGE_ROW_39_Right_39 VSS VSS gf180mcu_fd_sc_mcu9t5v0__endcap
X_20063_ _20063_/D _20063_/RN clkload57/I _20063_/Q VSS VSS VSS VSS gf180mcu_fd_sc_mcu9t5v0__dffrnq_1
XPHY_EDGE_ROW_209_Left_532 VSS VSS gf180mcu_fd_sc_mcu9t5v0__endcap
X_09874_ _11013_/A1 _10191_/A2 _09876_/A2 VSS VSS VSS VSS gf180mcu_fd_sc_mcu9t5v0__nor2_1
XTAP_TAPCELL_ROW_138_3_8008 VSS VSS gf180mcu_fd_sc_mcu9t5v0__filltie
XTAP_TAPCELL_ROW_124_4396 VSS VSS gf180mcu_fd_sc_mcu9t5v0__filltie
XTAP_TAPCELL_ROW_124_4385 VSS VSS gf180mcu_fd_sc_mcu9t5v0__filltie
XTAP_TAPCELL_ROW_81_3223 VSS VSS gf180mcu_fd_sc_mcu9t5v0__filltie
XTAP_TAPCELL_ROW_81_3212 VSS VSS gf180mcu_fd_sc_mcu9t5v0__filltie
XTAP_TAPCELL_ROW_81_3201 VSS VSS gf180mcu_fd_sc_mcu9t5v0__filltie
XPHY_EDGE_ROW_179_1_Left_502 VSS VSS gf180mcu_fd_sc_mcu9t5v0__endcap
XPHY_EDGE_ROW_218_Left_541 VSS VSS gf180mcu_fd_sc_mcu9t5v0__endcap
XPHY_EDGE_ROW_48_Right_48 VSS VSS gf180mcu_fd_sc_mcu9t5v0__endcap
X_09308_ _18753_/Q _09429_/A3 VSS VSS VSS VSS gf180mcu_fd_sc_mcu9t5v0__clkinv_1
X_10580_ _17358_/A1 _18198_/Q _10583_/A2 VSS VSS VSS VSS gf180mcu_fd_sc_mcu9t5v0__nor2_1
XTAP_TAPCELL_ROW_79_3163 VSS VSS gf180mcu_fd_sc_mcu9t5v0__filltie
XTAP_TAPCELL_ROW_79_3152 VSS VSS gf180mcu_fd_sc_mcu9t5v0__filltie
Xclkbuf_leaf_37_clk_regs clkload6/I clkload74/I VSS VSS VSS VSS gf180mcu_fd_sc_mcu9t5v0__clkbuf_8
X_09239_ _20066_/Q _10829_/A1 VSS VSS VSS VSS gf180mcu_fd_sc_mcu9t5v0__clkinv_1
XTAP_TAPCELL_ROW_75_3049 VSS VSS gf180mcu_fd_sc_mcu9t5v0__filltie
XTAP_TAPCELL_ROW_75_3038 VSS VSS gf180mcu_fd_sc_mcu9t5v0__filltie
X_12250_ _12348_/C _12242_/Z _12250_/B1 _12250_/B2 _12252_/A2 VSS _12250_/VNW VSS
+ VSS gf180mcu_fd_sc_mcu9t5v0__oai22_1
X_12181_ _18448_/Q _12181_/A2 _12208_/C _12183_/A2 VSS VSS VSS VSS gf180mcu_fd_sc_mcu9t5v0__oai21_1
X_11201_ _12028_/C _11201_/A2 _11320_/B1 VSS VSS VSS VSS gf180mcu_fd_sc_mcu9t5v0__nand2_1
X_11132_ _18203_/Q _11403_/S _11428_/B _11132_/C _11134_/B1 VSS VSS VSS VSS gf180mcu_fd_sc_mcu9t5v0__oai211_1
XPHY_EDGE_ROW_57_Right_57 VSS VSS gf180mcu_fd_sc_mcu9t5v0__endcap
XTAP_TAPCELL_ROW_259_6206 VSS VSS gf180mcu_fd_sc_mcu9t5v0__filltie
XPHY_EDGE_ROW_227_Left_550 VSS VSS gf180mcu_fd_sc_mcu9t5v0__endcap
X_15940_ _15954_/B _16198_/A2 _18568_/Q _16443_/A1 VSS VSS VSS VSS gf180mcu_fd_sc_mcu9t5v0__oai21_4
X_11063_ _18033_/I0 _19064_/Q _11067_/S _19064_/D VSS VSS VSS VSS gf180mcu_fd_sc_mcu9t5v0__mux2_1
X_15871_ _20080_/Q _19230_/Q _15905_/S _20080_/D VSS VSS VSS VSS gf180mcu_fd_sc_mcu9t5v0__mux2_1
X_10014_ _15939_/B _11095_/S _17481_/A1 VSS VSS VSS VSS gf180mcu_fd_sc_mcu9t5v0__nand2_1
XPHY_EDGE_ROW_167_3_Left_825 VSS VSS gf180mcu_fd_sc_mcu9t5v0__endcap
XTAP_TAPCELL_ROW_51_2381 VSS VSS gf180mcu_fd_sc_mcu9t5v0__filltie
XTAP_TAPCELL_ROW_8_1210 VSS VSS gf180mcu_fd_sc_mcu9t5v0__filltie
XTAP_TAPCELL_ROW_51_2392 VSS VSS gf180mcu_fd_sc_mcu9t5v0__filltie
X_17610_ _09065_/I _18673_/Q _17617_/S _18673_/D VSS VSS VSS VSS gf180mcu_fd_sc_mcu9t5v0__mux2_1
X_14822_ _19404_/Q _19341_/Q _14822_/Z VSS VSS VSS VSS gf180mcu_fd_sc_mcu9t5v0__xor2_1
X_18590_ _18590_/D clkload59/I _18590_/Q VSS VSS VSS VSS gf180mcu_fd_sc_mcu9t5v0__dffq_1
X_17541_ input4/Z _17541_/A2 _18664_/Q _17542_/A2 VSS VSS VSS VSS gf180mcu_fd_sc_mcu9t5v0__aoi21_1
X_14753_ _19551_/Q _14730_/S _14754_/B VSS VSS VSS VSS gf180mcu_fd_sc_mcu9t5v0__nand2_1
Xrst_tree_leaf_9 rst_tree_mid_1/Z _20138_/RN VSS VSS VSS VSS gf180mcu_fd_sc_mcu9t5v0__clkbuf_16
XTAP_TAPCELL_ROW_64_2731 VSS VSS gf180mcu_fd_sc_mcu9t5v0__filltie
X_11965_ _18904_/Q _11965_/A2 _11966_/A2 VSS VSS VSS VSS gf180mcu_fd_sc_mcu9t5v0__xnor2_1
Xeco15_sk2_3 eco15_sk2_3/I _18369_/CLK VSS VSS VSS VSS gf180mcu_fd_sc_mcu9t5v0__clkbuf_16
X_10916_ _16951_/A1 _18151_/S _10924_/B _10917_/I0 VSS _10916_/VNW VSS VSS gf180mcu_fd_sc_mcu9t5v0__oai21_1
X_13704_ _14715_/S _13704_/A2 _14166_/B _13705_/B2 VSS _13704_/VNW VSS VSS gf180mcu_fd_sc_mcu9t5v0__aoi21_1
X_14684_ _14688_/A1 _14688_/A3 _14685_/A2 VSS VSS VSS VSS gf180mcu_fd_sc_mcu9t5v0__nor2_1
XTAP_TAPCELL_ROW_64_2742 VSS VSS gf180mcu_fd_sc_mcu9t5v0__filltie
XTAP_TAPCELL_ROW_64_2753 VSS VSS gf180mcu_fd_sc_mcu9t5v0__filltie
XPHY_EDGE_ROW_66_Right_66 VSS VSS gf180mcu_fd_sc_mcu9t5v0__endcap
X_17472_ _09517_/I _17472_/A2 _18582_/D VSS VSS VSS VSS gf180mcu_fd_sc_mcu9t5v0__nor2_1
X_11896_ _11896_/A1 _11896_/A2 _11896_/B _12347_/C _11897_/A3 VSS VSS VSS VSS gf180mcu_fd_sc_mcu9t5v0__oai211_1
X_16423_ _16423_/I0 _18272_/Q _16960_/S _18272_/D VSS VSS VSS VSS gf180mcu_fd_sc_mcu9t5v0__mux2_1
XTAP_TAPCELL_ROW_231_5424 VSS VSS gf180mcu_fd_sc_mcu9t5v0__filltie
XTAP_TAPCELL_ROW_231_5413 VSS VSS gf180mcu_fd_sc_mcu9t5v0__filltie
XPHY_EDGE_ROW_163_1_Left_486 VSS VSS gf180mcu_fd_sc_mcu9t5v0__endcap
X_19211_ _19211_/D _20043_/RN clkload40/I _19211_/Q VSS VSS VSS VSS gf180mcu_fd_sc_mcu9t5v0__dffrnq_1
X_13635_ _13635_/A1 _13634_/B _13635_/A3 _13635_/Z VSS _13635_/VNW VSS VSS gf180mcu_fd_sc_mcu9t5v0__and3_1
XTAP_TAPCELL_ROW_60_2628 VSS VSS gf180mcu_fd_sc_mcu9t5v0__filltie
XTAP_TAPCELL_ROW_60_2639 VSS VSS gf180mcu_fd_sc_mcu9t5v0__filltie
XTAP_TAPCELL_ROW_231_5435 VSS VSS gf180mcu_fd_sc_mcu9t5v0__filltie
X_10847_ _18833_/Q _18053_/A1 _18145_/S VSS _10847_/VNW VSS VSS gf180mcu_fd_sc_mcu9t5v0__and2_1
X_19142_ _19142_/D _20038_/RN clkload15/I _19142_/Q VSS VSS VSS VSS gf180mcu_fd_sc_mcu9t5v0__dffrnq_1
X_16354_ _18241_/Q _16353_/Z _16892_/S _18241_/D VSS VSS VSS VSS gf180mcu_fd_sc_mcu9t5v0__mux2_4
X_13566_ _13566_/A1 _13566_/A2 _13566_/B _13571_/A3 VSS _15395_/VNW VSS VSS gf180mcu_fd_sc_mcu9t5v0__oai21_1
X_10778_ _18843_/Q _18850_/Q _10797_/B VSS VSS VSS VSS gf180mcu_fd_sc_mcu9t5v0__nand2_1
X_12517_ _18444_/Q _12607_/A2 _12541_/B _12517_/C _12518_/B VSS VSS VSS VSS gf180mcu_fd_sc_mcu9t5v0__oai211_1
X_16285_ _19273_/Q _16829_/A2 _16287_/A2 VSS VSS VSS VSS gf180mcu_fd_sc_mcu9t5v0__nand2_1
X_13497_ _13497_/A1 _13496_/Z _13497_/B _13498_/B2 VSS VSS VSS VSS gf180mcu_fd_sc_mcu9t5v0__aoi21_1
X_15305_ _19638_/Q _19615_/Q _15311_/B VSS VSS VSS VSS gf180mcu_fd_sc_mcu9t5v0__or2_1
X_19073_ _19073_/D _20033_/RN clkload23/I _19073_/Q VSS VSS VSS VSS gf180mcu_fd_sc_mcu9t5v0__dffrnq_1
X_12448_ _18260_/Q _12615_/A2 _12450_/B1 VSS _12448_/VNW VSS VSS gf180mcu_fd_sc_mcu9t5v0__nor2_1
X_15236_ _15236_/I _15247_/B1 VSS VSS VSS VSS gf180mcu_fd_sc_mcu9t5v0__clkinv_1
X_18024_ _18024_/I0 _18909_/Q _18037_/S _18909_/D VSS _18024_/VNW VSS VSS gf180mcu_fd_sc_mcu9t5v0__mux2_1
XTAP_TAPCELL_ROW_229_5375 VSS VSS gf180mcu_fd_sc_mcu9t5v0__filltie
XTAP_TAPCELL_ROW_229_5364 VSS VSS gf180mcu_fd_sc_mcu9t5v0__filltie
XTAP_TAPCELL_ROW_144_3_8029 VSS VSS gf180mcu_fd_sc_mcu9t5v0__filltie
XPHY_EDGE_ROW_75_Right_75 VSS VSS gf180mcu_fd_sc_mcu9t5v0__endcap
XTAP_TAPCELL_ROW_58_2568 VSS VSS gf180mcu_fd_sc_mcu9t5v0__filltie
XTAP_TAPCELL_ROW_58_2579 VSS VSS gf180mcu_fd_sc_mcu9t5v0__filltie
X_12379_ _18733_/Q _12527_/A2 _12543_/B1 _12379_/B2 _12379_/ZN VSS VSS VSS VSS gf180mcu_fd_sc_mcu9t5v0__aoi22_1
X_15167_ _19709_/Q _19549_/Q wire108/Z _19709_/D VSS VSS VSS VSS gf180mcu_fd_sc_mcu9t5v0__mux2_1
X_19975_ _19975_/D _20039_/RN clkload66/I _19975_/Q VSS VSS VSS VSS gf180mcu_fd_sc_mcu9t5v0__dffrnq_1
XPHY_EDGE_ROW_196_3_Right_311 VSS VSS gf180mcu_fd_sc_mcu9t5v0__endcap
X_14118_ _19321_/Q _19300_/Q _14123_/A1 VSS _14191_/VNW VSS VSS gf180mcu_fd_sc_mcu9t5v0__nand2_1
X_15098_ _15089_/B _15098_/A2 _15098_/A3 _15100_/B VSS _15098_/VNW VSS VSS gf180mcu_fd_sc_mcu9t5v0__and3_1
X_18926_ _18926_/D _20142_/RN clkload38/I _18926_/Q VSS VSS VSS VSS gf180mcu_fd_sc_mcu9t5v0__dffrnq_1
X_14049_ _14080_/A1 _14080_/A2 _14049_/Z VSS _14080_/VNW VSS VSS gf180mcu_fd_sc_mcu9t5v0__xor2_1
X_18857_ _18857_/D _20073_/RN clkload11/I _18857_/Q VSS VSS VSS VSS gf180mcu_fd_sc_mcu9t5v0__dffrnq_1
X_17808_ _18786_/Q _18765_/Q _18769_/D _18786_/D VSS VSS VSS VSS gf180mcu_fd_sc_mcu9t5v0__mux2_1
X_18788_ _18788_/D _20068_/RN clkload49/I _18788_/Q VSS VSS VSS VSS gf180mcu_fd_sc_mcu9t5v0__dffrnq_1
XPHY_EDGE_ROW_84_Right_84 VSS VSS gf180mcu_fd_sc_mcu9t5v0__endcap
X_09590_ _11018_/A1 _09578_/Z _18060_/B _09591_/A2 VSS _09591_/VNW VSS VSS gf180mcu_fd_sc_mcu9t5v0__aoi21_1
X_17739_ _17739_/A1 _17681_/S _17739_/B _18745_/D VSS VSS VSS VSS gf180mcu_fd_sc_mcu9t5v0__oai21_1
XTAP_TAPCELL_ROW_30_1797 VSS VSS gf180mcu_fd_sc_mcu9t5v0__filltie
XTAP_TAPCELL_ROW_313_7682 VSS VSS gf180mcu_fd_sc_mcu9t5v0__filltie
XTAP_TAPCELL_ROW_313_7671 VSS VSS gf180mcu_fd_sc_mcu9t5v0__filltie
X_19409_ _19409_/D _20049_/RN clkload9/I _19409_/Q VSS VSS VSS VSS gf180mcu_fd_sc_mcu9t5v0__dffrnq_1
XTAP_TAPCELL_ROW_197_3_8212 VSS VSS gf180mcu_fd_sc_mcu9t5v0__filltie
XTAP_TAPCELL_ROW_214_4965 VSS VSS gf180mcu_fd_sc_mcu9t5v0__filltie
XTAP_TAPCELL_ROW_214_4954 VSS VSS gf180mcu_fd_sc_mcu9t5v0__filltie
XTAP_TAPCELL_ROW_214_4943 VSS VSS gf180mcu_fd_sc_mcu9t5v0__filltie
XTAP_TAPCELL_ROW_132_4621 VSS VSS gf180mcu_fd_sc_mcu9t5v0__filltie
XTAP_TAPCELL_ROW_132_4610 VSS VSS gf180mcu_fd_sc_mcu9t5v0__filltie
XTAP_TAPCELL_ROW_322_7929 VSS VSS gf180mcu_fd_sc_mcu9t5v0__filltie
XTAP_TAPCELL_ROW_322_7918 VSS VSS gf180mcu_fd_sc_mcu9t5v0__filltie
XPHY_EDGE_ROW_93_Right_93 VSS VSS gf180mcu_fd_sc_mcu9t5v0__endcap
XTAP_TAPCELL_ROW_177_3_8143 VSS VSS gf180mcu_fd_sc_mcu9t5v0__filltie
XTAP_TAPCELL_ROW_113_4097 VSS VSS gf180mcu_fd_sc_mcu9t5v0__filltie
XTAP_TAPCELL_ROW_113_4086 VSS VSS gf180mcu_fd_sc_mcu9t5v0__filltie
XTAP_TAPCELL_ROW_202_3_8230 VSS VSS gf180mcu_fd_sc_mcu9t5v0__filltie
XTAP_TAPCELL_ROW_299_7298 VSS VSS gf180mcu_fd_sc_mcu9t5v0__filltie
XTAP_TAPCELL_ROW_299_7287 VSS VSS gf180mcu_fd_sc_mcu9t5v0__filltie
X_20115_ _20115_/D clkload72/I _20115_/Q VSS VSS VSS VSS gf180mcu_fd_sc_mcu9t5v0__dffq_1
X_09926_ _09926_/A1 _09927_/A2 _10165_/B1 VSS VSS VSS VSS gf180mcu_fd_sc_mcu9t5v0__nor2_1
XTAP_TAPCELL_ROW_126_4447 VSS VSS gf180mcu_fd_sc_mcu9t5v0__filltie
XTAP_TAPCELL_ROW_126_4436 VSS VSS gf180mcu_fd_sc_mcu9t5v0__filltie
XTAP_TAPCELL_ROW_126_4458 VSS VSS gf180mcu_fd_sc_mcu9t5v0__filltie
X_20046_ _20046_/D _20046_/RN clkload40/I _20046_/Q VSS VSS VSS VSS gf180mcu_fd_sc_mcu9t5v0__dffrnq_1
XTAP_TAPCELL_ROW_157_3_8074 VSS VSS gf180mcu_fd_sc_mcu9t5v0__filltie
X_09857_ _20034_/Q _09859_/A2 _09849_/B _20030_/Q _09858_/I VSS VSS VSS VSS gf180mcu_fd_sc_mcu9t5v0__aoi22_1
XTAP_TAPCELL_ROW_170_3_8119 VSS VSS gf180mcu_fd_sc_mcu9t5v0__filltie
X_09788_ _18838_/Q _11600_/C _09789_/A2 VSS VSS VSS VSS gf180mcu_fd_sc_mcu9t5v0__nand2_1
X_11750_ _18173_/Q _18157_/Q _12315_/S _11750_/Z VSS VSS VSS VSS gf180mcu_fd_sc_mcu9t5v0__mux2_4
X_10701_ _17411_/C _10820_/B2 _17231_/A3 _10701_/B _10702_/B VSS VSS VSS VSS gf180mcu_fd_sc_mcu9t5v0__oai31_4
XTAP_TAPCELL_ROW_102_3790 VSS VSS gf180mcu_fd_sc_mcu9t5v0__filltie
X_11681_ _18892_/Q _11681_/A2 _11682_/A2 VSS _11740_/VNW VSS VSS gf180mcu_fd_sc_mcu9t5v0__xnor2_1
XTAP_TAPCELL_ROW_288_6991 VSS VSS gf180mcu_fd_sc_mcu9t5v0__filltie
XTAP_TAPCELL_ROW_288_6980 VSS VSS gf180mcu_fd_sc_mcu9t5v0__filltie
X_10632_ _17404_/S _18280_/Q _10634_/A3 VSS _11314_/VNW VSS VSS gf180mcu_fd_sc_mcu9t5v0__nor2_1
X_13420_ _16951_/A1 _13419_/B _13420_/B1 _13420_/B2 _19254_/D VSS VSS VSS VSS gf180mcu_fd_sc_mcu9t5v0__aoi22_1
X_10563_ _18165_/Q _17406_/A2 _17405_/A2 _18181_/Q _10564_/B VSS _16229_/VNW VSS VSS
+ gf180mcu_fd_sc_mcu9t5v0__aoi22_1
X_13351_ _13375_/A1 _13351_/A2 _13608_/A1 VSS VSS VSS VSS gf180mcu_fd_sc_mcu9t5v0__nand2_1
XTAP_TAPCELL_ROW_40_2071 VSS VSS gf180mcu_fd_sc_mcu9t5v0__filltie
X_16070_ _16668_/A1 _16668_/A2 _16167_/B _16072_/A3 VSS VSS VSS VSS gf180mcu_fd_sc_mcu9t5v0__aoi21_1
XTAP_TAPCELL_ROW_284_6888 VSS VSS gf180mcu_fd_sc_mcu9t5v0__filltie
XTAP_TAPCELL_ROW_284_6877 VSS VSS gf180mcu_fd_sc_mcu9t5v0__filltie
X_12302_ _18502_/Q _18486_/Q _12340_/S _12302_/Z VSS _12302_/VNW VSS VSS gf180mcu_fd_sc_mcu9t5v0__mux2_1
XTAP_TAPCELL_ROW_40_2082 VSS VSS gf180mcu_fd_sc_mcu9t5v0__filltie
XTAP_TAPCELL_ROW_40_2093 VSS VSS gf180mcu_fd_sc_mcu9t5v0__filltie
X_10494_ _10494_/A1 _10494_/A2 _17275_/C _10495_/C VSS _11867_/VNW VSS VSS gf180mcu_fd_sc_mcu9t5v0__aoi21_1
X_15021_ _19625_/Q _15021_/I1 _15163_/S _19625_/D VSS VSS VSS VSS gf180mcu_fd_sc_mcu9t5v0__mux2_1
X_13282_ _19737_/Q _19769_/Q _13282_/Z VSS _13283_/VNW VSS VSS gf180mcu_fd_sc_mcu9t5v0__xor2_1
X_12233_ _19133_/Q _12311_/B _12233_/B _12234_/I VSS _14535_/VNW VSS VSS gf180mcu_fd_sc_mcu9t5v0__aoi21_1
X_12164_ _12164_/A1 _12121_/B _12164_/A3 _12164_/B _12166_/A2 VSS VSS VSS VSS gf180mcu_fd_sc_mcu9t5v0__oai31_4
XTAP_TAPCELL_ROW_53_2432 VSS VSS gf180mcu_fd_sc_mcu9t5v0__filltie
XTAP_TAPCELL_ROW_53_2443 VSS VSS gf180mcu_fd_sc_mcu9t5v0__filltie
X_16972_ _18477_/Q _16971_/Z _16972_/S _18477_/D VSS VSS VSS VSS gf180mcu_fd_sc_mcu9t5v0__mux2_1
X_11115_ _11115_/A1 _11429_/B _11115_/B1 _11115_/B2 _11428_/B _11116_/B VSS VSS VSS
+ VSS gf180mcu_fd_sc_mcu9t5v0__aoi221_1
X_12095_ _11706_/B _12079_/Z _12095_/B _12097_/A2 VSS _12096_/VNW VSS VSS gf180mcu_fd_sc_mcu9t5v0__oai21_1
X_19760_ _19760_/D _20144_/RN clkload42/I _19760_/Q VSS VSS VSS VSS gf180mcu_fd_sc_mcu9t5v0__dffrnq_1
X_15923_ _20132_/Q _19253_/Q _15928_/S _20132_/D VSS _17286_/VNW VSS VSS gf180mcu_fd_sc_mcu9t5v0__mux2_1
XTAP_TAPCELL_ROW_220_5125 VSS VSS gf180mcu_fd_sc_mcu9t5v0__filltie
XTAP_TAPCELL_ROW_220_5114 VSS VSS gf180mcu_fd_sc_mcu9t5v0__filltie
X_18711_ _18711_/D clkload53/I _18711_/Q VSS VSS VSS VSS gf180mcu_fd_sc_mcu9t5v0__dffq_1
X_11046_ _18032_/I0 _19047_/Q wire174/Z _19047_/D VSS VSS VSS VSS gf180mcu_fd_sc_mcu9t5v0__mux2_1
XTAP_TAPCELL_ROW_109_3988 VSS VSS gf180mcu_fd_sc_mcu9t5v0__filltie
XTAP_TAPCELL_ROW_109_3977 VSS VSS gf180mcu_fd_sc_mcu9t5v0__filltie
X_19691_ _19691_/D _20139_/RN clkload29/I _19691_/Q VSS VSS VSS VSS gf180mcu_fd_sc_mcu9t5v0__dffrnq_1
XTAP_TAPCELL_ROW_237_5600 VSS VSS gf180mcu_fd_sc_mcu9t5v0__filltie
X_18642_ _18642_/D _20046_/RN clkload65/I _18642_/Q VSS VSS VSS VSS gf180mcu_fd_sc_mcu9t5v0__dffrnq_1
X_15854_ _15936_/B _15936_/C _15854_/Z VSS VSS VSS VSS gf180mcu_fd_sc_mcu9t5v0__and2_4
XTAP_TAPCELL_ROW_194_1_4767 VSS VSS gf180mcu_fd_sc_mcu9t5v0__filltie
XTAP_TAPCELL_ROW_66_2804 VSS VSS gf180mcu_fd_sc_mcu9t5v0__filltie
X_15785_ _19979_/Q _19955_/Q _15786_/S _19955_/D VSS VSS VSS VSS gf180mcu_fd_sc_mcu9t5v0__mux2_1
X_14805_ _09462_/I _14805_/A2 _14805_/B _19571_/D VSS _14805_/VNW VSS VSS gf180mcu_fd_sc_mcu9t5v0__oai21_1
X_18573_ _18573_/D _20073_/RN clkload28/I _18573_/Q VSS VSS VSS VSS gf180mcu_fd_sc_mcu9t5v0__dffrnq_1
X_17524_ wire300/Z _18629_/Q _17529_/S _18629_/D VSS VSS VSS VSS gf180mcu_fd_sc_mcu9t5v0__mux2_1
XTAP_TAPCELL_ROW_218_5054 VSS VSS gf180mcu_fd_sc_mcu9t5v0__filltie
XPHY_EDGE_ROW_196_2_Left_708 VSS VSS gf180mcu_fd_sc_mcu9t5v0__endcap
XTAP_TAPCELL_ROW_47_2269 VSS VSS gf180mcu_fd_sc_mcu9t5v0__filltie
X_14736_ _14738_/A1 _14738_/A2 _14736_/Z VSS VSS VSS VSS gf180mcu_fd_sc_mcu9t5v0__xor2_1
X_12997_ _12997_/A1 _12996_/B _13001_/A2 VSS _13030_/VNW VSS VSS gf180mcu_fd_sc_mcu9t5v0__xnor2_1
XTAP_TAPCELL_ROW_218_5076 VSS VSS gf180mcu_fd_sc_mcu9t5v0__filltie
XTAP_TAPCELL_ROW_218_5065 VSS VSS gf180mcu_fd_sc_mcu9t5v0__filltie
X_11948_ _14417_/A2 _11985_/B _11948_/B _19119_/D VSS VSS VSS VSS gf180mcu_fd_sc_mcu9t5v0__oai21_4
XTAP_TAPCELL_ROW_183_3_8164 VSS VSS gf180mcu_fd_sc_mcu9t5v0__filltie
X_11879_ wire208/I _11879_/A2 _12004_/B _11880_/A3 VSS VSS VSS VSS gf180mcu_fd_sc_mcu9t5v0__aoi21_1
X_14667_ _14666_/Z _19528_/Q _14670_/S _19528_/D VSS VSS VSS VSS gf180mcu_fd_sc_mcu9t5v0__mux2_1
X_17455_ _17461_/A1 _17473_/A2 _18574_/Q _17456_/A2 VSS VSS VSS VSS gf180mcu_fd_sc_mcu9t5v0__aoi21_1
X_17386_ _10353_/C _17386_/A2 _17386_/B1 _10516_/C _10543_/C _17386_/C2 _17388_/A2
+ VSS _17386_/VNW VSS VSS gf180mcu_fd_sc_mcu9t5v0__aoi222_1
X_16406_ _16406_/A1 _16406_/A2 _16407_/I0 VSS VSS VSS VSS gf180mcu_fd_sc_mcu9t5v0__nand2_4
X_13618_ _19743_/Q _13618_/A2 _13620_/A2 VSS _13618_/VNW VSS VSS gf180mcu_fd_sc_mcu9t5v0__nor2_1
X_14598_ _19177_/Q _19476_/Q _14715_/S _19476_/D VSS _14598_/VNW VSS VSS gf180mcu_fd_sc_mcu9t5v0__mux2_1
X_16337_ _19228_/Q _16117_/C _16871_/S _16337_/Z VSS VSS VSS VSS gf180mcu_fd_sc_mcu9t5v0__mux2_1
X_13549_ _19271_/Q _13419_/B _13552_/B VSS _13549_/VNW VSS VSS gf180mcu_fd_sc_mcu9t5v0__nand2_1
X_19125_ _19125_/D _20021_/RN clkload10/I _19125_/Q VSS VSS VSS VSS gf180mcu_fd_sc_mcu9t5v0__dffrnq_1
X_19056_ _19056_/D _20144_/RN clkload13/I _19056_/Q VSS VSS VSS VSS gf180mcu_fd_sc_mcu9t5v0__dffrnq_1
X_16268_ _18209_/Q _16268_/I1 _16824_/S _18209_/D VSS VSS VSS VSS gf180mcu_fd_sc_mcu9t5v0__mux2_1
XTAP_TAPCELL_ROW_163_3_8095 VSS VSS gf180mcu_fd_sc_mcu9t5v0__filltie
X_18007_ _18023_/I0 _18892_/Q _18021_/S _18892_/D VSS VSS VSS VSS gf180mcu_fd_sc_mcu9t5v0__mux2_1
X_16199_ _16199_/A1 _16512_/A1 _16763_/S _16770_/S VSS VSS VSS VSS gf180mcu_fd_sc_mcu9t5v0__aoi21_4
X_15219_ _15219_/A1 _15219_/A2 _15219_/B _15225_/B VSS VSS VSS VSS gf180mcu_fd_sc_mcu9t5v0__oai21_1
XTAP_TAPCELL_ROW_302_7372 VSS VSS gf180mcu_fd_sc_mcu9t5v0__filltie
XTAP_TAPCELL_ROW_302_7383 VSS VSS gf180mcu_fd_sc_mcu9t5v0__filltie
XPHY_EDGE_ROW_197_3_Right_312 VSS VSS gf180mcu_fd_sc_mcu9t5v0__endcap
XTAP_TAPCELL_ROW_294_7162 VSS VSS gf180mcu_fd_sc_mcu9t5v0__filltie
XTAP_TAPCELL_ROW_294_7151 VSS VSS gf180mcu_fd_sc_mcu9t5v0__filltie
X_09711_ _20143_/Q _09758_/B _17231_/A3 VSS VSS VSS VSS gf180mcu_fd_sc_mcu9t5v0__nand2_4
X_19958_ _19958_/D _20022_/RN clkload26/I _19958_/Q VSS VSS VSS VSS gf180mcu_fd_sc_mcu9t5v0__dffrnq_1
XTAP_TAPCELL_ROW_36_1962 VSS VSS gf180mcu_fd_sc_mcu9t5v0__filltie
XTAP_TAPCELL_ROW_36_1973 VSS VSS gf180mcu_fd_sc_mcu9t5v0__filltie
XTAP_TAPCELL_ROW_36_1984 VSS VSS gf180mcu_fd_sc_mcu9t5v0__filltie
X_19889_ _19889_/D _20145_/RN clkload71/I _19889_/Q VSS VSS VSS VSS gf180mcu_fd_sc_mcu9t5v0__dffrnq_1
XTAP_TAPCELL_ROW_121_4311 VSS VSS gf180mcu_fd_sc_mcu9t5v0__filltie
XTAP_TAPCELL_ROW_121_4300 VSS VSS gf180mcu_fd_sc_mcu9t5v0__filltie
XTAP_TAPCELL_ROW_32_1859 VSS VSS gf180mcu_fd_sc_mcu9t5v0__filltie
X_18909_ _18909_/D _20061_/RN clkload10/I _18909_/Q VSS VSS VSS VSS gf180mcu_fd_sc_mcu9t5v0__dffrnq_1
XTAP_TAPCELL_ROW_315_7744 VSS VSS gf180mcu_fd_sc_mcu9t5v0__filltie
XTAP_TAPCELL_ROW_290_7059 VSS VSS gf180mcu_fd_sc_mcu9t5v0__filltie
XTAP_TAPCELL_ROW_315_7733 VSS VSS gf180mcu_fd_sc_mcu9t5v0__filltie
XTAP_TAPCELL_ROW_290_7048 VSS VSS gf180mcu_fd_sc_mcu9t5v0__filltie
XTAP_TAPCELL_ROW_315_7722 VSS VSS gf180mcu_fd_sc_mcu9t5v0__filltie
XTAP_TAPCELL_ROW_290_7037 VSS VSS gf180mcu_fd_sc_mcu9t5v0__filltie
X_09642_ _09662_/S _15691_/C _09642_/A3 _09642_/B _20006_/D VSS VSS VSS VSS gf180mcu_fd_sc_mcu9t5v0__oai31_1
XTAP_TAPCELL_ROW_121_4322 VSS VSS gf180mcu_fd_sc_mcu9t5v0__filltie
X_09573_ _20026_/Q _09573_/A2 _10806_/B VSS _09573_/VNW VSS VSS gf180mcu_fd_sc_mcu9t5v0__nand2_1
XTAP_TAPCELL_ROW_311_7619 VSS VSS gf180mcu_fd_sc_mcu9t5v0__filltie
XTAP_TAPCELL_ROW_119_4262 VSS VSS gf180mcu_fd_sc_mcu9t5v0__filltie
XTAP_TAPCELL_ROW_119_4251 VSS VSS gf180mcu_fd_sc_mcu9t5v0__filltie
XTAP_TAPCELL_ROW_115_4137 VSS VSS gf180mcu_fd_sc_mcu9t5v0__filltie
XTAP_TAPCELL_ROW_309_7559 VSS VSS gf180mcu_fd_sc_mcu9t5v0__filltie
XTAP_TAPCELL_ROW_115_4148 VSS VSS gf180mcu_fd_sc_mcu9t5v0__filltie
XPHY_EDGE_ROW_12_Left_336 VSS VSS gf180mcu_fd_sc_mcu9t5v0__endcap
XTAP_TAPCELL_ROW_128_4509 VSS VSS gf180mcu_fd_sc_mcu9t5v0__filltie
X_09909_ _19992_/Q _09909_/A2 _15833_/A2 VSS _15830_/VNW VSS VSS gf180mcu_fd_sc_mcu9t5v0__nand2_1
XPHY_EDGE_ROW_21_Left_345 VSS VSS gf180mcu_fd_sc_mcu9t5v0__endcap
XTAP_TAPCELL_ROW_277_6692 VSS VSS gf180mcu_fd_sc_mcu9t5v0__filltie
XTAP_TAPCELL_ROW_277_6681 VSS VSS gf180mcu_fd_sc_mcu9t5v0__filltie
X_20029_ _20029_/D _20029_/RN clkload26/I _20029_/Q VSS VSS VSS VSS gf180mcu_fd_sc_mcu9t5v0__dffrnq_1
X_12920_ _12917_/I _12920_/A2 _12921_/I0 VSS VSS VSS VSS gf180mcu_fd_sc_mcu9t5v0__xnor2_1
XTAP_TAPCELL_ROW_273_6567 VSS VSS gf180mcu_fd_sc_mcu9t5v0__filltie
XTAP_TAPCELL_ROW_104_3852 VSS VSS gf180mcu_fd_sc_mcu9t5v0__filltie
XTAP_TAPCELL_ROW_104_3841 VSS VSS gf180mcu_fd_sc_mcu9t5v0__filltie
X_12851_ _19767_/Q _12845_/Z _12848_/Z _12852_/I0 VSS _12851_/VNW VSS VSS gf180mcu_fd_sc_mcu9t5v0__xnor3_1
XTAP_TAPCELL_ROW_104_3830 VSS VSS gf180mcu_fd_sc_mcu9t5v0__filltie
XTAP_TAPCELL_ROW_273_6589 VSS VSS gf180mcu_fd_sc_mcu9t5v0__filltie
XTAP_TAPCELL_ROW_273_6578 VSS VSS gf180mcu_fd_sc_mcu9t5v0__filltie
X_11802_ _18255_/Q _12345_/A2 _12208_/C _11804_/A2 VSS VSS VSS VSS gf180mcu_fd_sc_mcu9t5v0__oai21_1
X_15570_ _15570_/A1 _15570_/A2 _19876_/D VSS VSS VSS VSS gf180mcu_fd_sc_mcu9t5v0__nor2_1
XTAP_TAPCELL_ROW_100_3738 VSS VSS gf180mcu_fd_sc_mcu9t5v0__filltie
X_12782_ _12783_/A1 _12783_/A3 _12782_/B _12784_/A1 VSS _12783_/VNW VSS VSS gf180mcu_fd_sc_mcu9t5v0__oai21_1
XTAP_TAPCELL_ROW_100_3727 VSS VSS gf180mcu_fd_sc_mcu9t5v0__filltie
X_11733_ _18268_/Q _12203_/A2 _11735_/B1 VSS VSS VSS VSS gf180mcu_fd_sc_mcu9t5v0__nand2_1
Xclkbuf_leaf_52_clk_regs clkload2/I _19680_/CLK VSS VSS VSS VSS gf180mcu_fd_sc_mcu9t5v0__clkbuf_8
X_14521_ _14766_/A2 _14521_/A2 _14521_/B _19464_/D VSS _14521_/VNW VSS VSS gf180mcu_fd_sc_mcu9t5v0__oai21_1
XTAP_TAPCELL_ROW_42_2133 VSS VSS gf180mcu_fd_sc_mcu9t5v0__filltie
XTAP_TAPCELL_ROW_286_6939 VSS VSS gf180mcu_fd_sc_mcu9t5v0__filltie
X_17240_ _18400_/Q _18384_/Q _17404_/S _17240_/Z VSS VSS VSS VSS gf180mcu_fd_sc_mcu9t5v0__mux2_1
XTAP_TAPCELL_ROW_286_6928 VSS VSS gf180mcu_fd_sc_mcu9t5v0__filltie
XPHY_EDGE_ROW_238_Right_165 VSS VSS gf180mcu_fd_sc_mcu9t5v0__endcap
X_11664_ _12632_/C _11675_/A2 _11666_/A2 VSS _11664_/VNW VSS VSS gf180mcu_fd_sc_mcu9t5v0__nand2_1
XTAP_TAPCELL_ROW_42_2144 VSS VSS gf180mcu_fd_sc_mcu9t5v0__filltie
X_14452_ _14452_/A1 _14703_/A1 _14455_/B _14454_/B1 VSS VSS VSS VSS gf180mcu_fd_sc_mcu9t5v0__oai21_1
X_17171_ _18413_/Q _17380_/A2 _17176_/A1 VSS VSS VSS VSS gf180mcu_fd_sc_mcu9t5v0__nand2_1
X_10615_ _17358_/A1 _18327_/Q _10617_/A3 VSS VSS VSS VSS gf180mcu_fd_sc_mcu9t5v0__nor2_1
X_13403_ _13403_/A1 _13403_/A2 _13403_/A3 _13422_/A3 VSS VSS VSS VSS gf180mcu_fd_sc_mcu9t5v0__nor3_1
XPHY_EDGE_ROW_30_Left_354 VSS VSS gf180mcu_fd_sc_mcu9t5v0__endcap
X_16122_ _16408_/I0 _16700_/A2 _16714_/A3 _16123_/C VSS VSS VSS VSS gf180mcu_fd_sc_mcu9t5v0__nor3_1
X_14383_ _13732_/C _14383_/A2 _19446_/D VSS VSS VSS VSS gf180mcu_fd_sc_mcu9t5v0__nor2_1
X_11595_ _17900_/B2 _11594_/Z _11595_/Z VSS _11598_/VNW VSS VSS gf180mcu_fd_sc_mcu9t5v0__or2_1
X_10546_ wire168/Z _10546_/A2 _10546_/A3 _10549_/B1 VSS VSS VSS VSS gf180mcu_fd_sc_mcu9t5v0__nand3_1
X_13334_ _12734_/Z _13354_/A2 _13333_/Z _13334_/Z VSS VSS VSS VSS gf180mcu_fd_sc_mcu9t5v0__or3_1
XTAP_TAPCELL_ROW_55_2505 VSS VSS gf180mcu_fd_sc_mcu9t5v0__filltie
X_16053_ _16668_/A1 _16668_/A2 _16151_/B _16054_/A3 VSS VSS VSS VSS gf180mcu_fd_sc_mcu9t5v0__aoi21_1
X_10477_ _10655_/B _10477_/A2 _10477_/B1 _10477_/B2 _10477_/ZN VSS VSS VSS VSS gf180mcu_fd_sc_mcu9t5v0__aoi22_4
X_13265_ _13265_/A1 _13265_/A2 _13265_/B _13280_/B VSS VSS VSS VSS gf180mcu_fd_sc_mcu9t5v0__aoi21_1
Xrst_tree_leaf_14 rst_tree_mid_1/Z _20069_/RN VSS VSS VSS VSS gf180mcu_fd_sc_mcu9t5v0__clkbuf_16
XPHY_EDGE_ROW_284_Right_211 VSS VSS gf180mcu_fd_sc_mcu9t5v0__endcap
Xrst_tree_leaf_36 rst_tree_mid_4/Z _20047_/RN VSS VSS VSS VSS gf180mcu_fd_sc_mcu9t5v0__clkbuf_16
Xrst_tree_leaf_25 rst_tree_mid_3/Z _20058_/RN VSS VSS VSS VSS gf180mcu_fd_sc_mcu9t5v0__clkbuf_16
Xrst_tree_leaf_47 rst_tree_mid_5/Z _20036_/RN VSS VSS VSS VSS gf180mcu_fd_sc_mcu9t5v0__clkbuf_16
X_12216_ _12311_/B _12216_/A2 _12216_/A3 _12216_/B _19132_/D VSS VSS VSS VSS gf180mcu_fd_sc_mcu9t5v0__oai31_1
X_15004_ _15017_/A1 _15017_/A2 _15008_/A2 VSS _15017_/VNW VSS VSS gf180mcu_fd_sc_mcu9t5v0__nand2_1
X_13196_ _19731_/Q _13198_/A2 _13214_/A2 VSS _13197_/VNW VSS VSS gf180mcu_fd_sc_mcu9t5v0__nand2_1
X_19812_ _19812_/D _20068_/RN clkload43/I _19812_/Q VSS VSS VSS VSS gf180mcu_fd_sc_mcu9t5v0__dffrnq_1
Xrst_tree_leaf_58 rst_tree_mid_7/Z _20025_/RN VSS VSS VSS VSS gf180mcu_fd_sc_mcu9t5v0__clkbuf_16
X_12147_ _12147_/I0 _12147_/I1 _12147_/S _12147_/Z VSS VSS VSS VSS gf180mcu_fd_sc_mcu9t5v0__mux2_1
X_16955_ _19256_/Q _16654_/B _16955_/S _16955_/Z VSS VSS VSS VSS gf180mcu_fd_sc_mcu9t5v0__mux2_1
X_12078_ _18724_/Q _12527_/A2 _12098_/A1 VSS VSS VSS VSS gf180mcu_fd_sc_mcu9t5v0__nand2_1
X_19743_ _19743_/D _20063_/RN clkload9/I _19743_/Q VSS VSS VSS VSS gf180mcu_fd_sc_mcu9t5v0__dffrnq_1
X_15906_ _20115_/Q _19251_/Q wire79/Z _20115_/D VSS _15906_/VNW VSS VSS gf180mcu_fd_sc_mcu9t5v0__mux2_1
X_16886_ _18435_/Q _16885_/Z _16892_/S _18435_/D VSS VSS VSS VSS gf180mcu_fd_sc_mcu9t5v0__mux2_4
X_19674_ _19674_/D _20058_/RN clkload44/I _19674_/Q VSS VSS VSS VSS gf180mcu_fd_sc_mcu9t5v0__dffrnq_1
X_11029_ _19062_/Q _19030_/Q _11051_/S _19030_/D VSS _11029_/VNW VSS VSS gf180mcu_fd_sc_mcu9t5v0__mux2_1
X_18625_ _18625_/D _20029_/RN _20099_/CLK _18625_/Q VSS VSS VSS VSS gf180mcu_fd_sc_mcu9t5v0__dffrnq_1
X_15837_ _15811_/S _15837_/A2 _20144_/D VSS _15837_/VNW VSS VSS gf180mcu_fd_sc_mcu9t5v0__nand2_1
XPHY_EDGE_ROW_170_1_Right_754 VSS VSS gf180mcu_fd_sc_mcu9t5v0__endcap
X_15768_ input6/Z _19938_/Q _15770_/S _19938_/D VSS VSS VSS VSS gf180mcu_fd_sc_mcu9t5v0__mux2_1
X_18556_ _18556_/D _19992_/RN clkload22/I _18556_/Q VSS VSS VSS VSS gf180mcu_fd_sc_mcu9t5v0__dffrnq_1
X_18487_ _18487_/D clkload79/I _18487_/Q VSS VSS VSS VSS gf180mcu_fd_sc_mcu9t5v0__dffq_1
X_17507_ _18612_/Q _19253_/Q _17513_/S _18612_/D VSS _17507_/VNW VSS VSS gf180mcu_fd_sc_mcu9t5v0__mux2_1
X_15699_ _19915_/Q _19916_/Q _19917_/Q _15699_/Z VSS VSS VSS VSS gf180mcu_fd_sc_mcu9t5v0__or3_1
X_14719_ _14715_/S _14720_/B _14717_/Z _14719_/B _19542_/D VSS VSS VSS VSS gf180mcu_fd_sc_mcu9t5v0__oai31_1
X_17438_ _17438_/A1 _17431_/S _17438_/B _17438_/C _18566_/D VSS VSS VSS VSS gf180mcu_fd_sc_mcu9t5v0__aoi211_1
XANTENNA_15 output10/I VSS VSS VSS VSS gf180mcu_fd_sc_mcu9t5v0__antenna
XANTENNA_26 _18033_/I0 VSS VSS VSS VSS gf180mcu_fd_sc_mcu9t5v0__antenna
XTAP_TAPCELL_ROW_25_1663 VSS VSS gf180mcu_fd_sc_mcu9t5v0__filltie
X_17369_ _18616_/Q _17306_/C _17370_/B VSS _17409_/VNW VSS VSS gf180mcu_fd_sc_mcu9t5v0__nand2_1
XTAP_TAPCELL_ROW_25_1674 VSS VSS gf180mcu_fd_sc_mcu9t5v0__filltie
XTAP_TAPCELL_ROW_304_7423 VSS VSS gf180mcu_fd_sc_mcu9t5v0__filltie
XTAP_TAPCELL_ROW_110_4012 VSS VSS gf180mcu_fd_sc_mcu9t5v0__filltie
XTAP_TAPCELL_ROW_110_4001 VSS VSS gf180mcu_fd_sc_mcu9t5v0__filltie
XTAP_TAPCELL_ROW_21_1549 VSS VSS gf180mcu_fd_sc_mcu9t5v0__filltie
X_19108_ _19108_/D _20068_/RN clkload10/I _19108_/Q VSS VSS VSS VSS gf180mcu_fd_sc_mcu9t5v0__dffrnq_1
XTAP_TAPCELL_ROW_304_7434 VSS VSS gf180mcu_fd_sc_mcu9t5v0__filltie
X_19039_ _19039_/D _20063_/RN _19806_/CLK _19039_/Q VSS VSS VSS VSS gf180mcu_fd_sc_mcu9t5v0__dffrnq_1
XTAP_TAPCELL_ROW_296_7213 VSS VSS gf180mcu_fd_sc_mcu9t5v0__filltie
XTAP_TAPCELL_ROW_300_7309 VSS VSS gf180mcu_fd_sc_mcu9t5v0__filltie
XTAP_TAPCELL_ROW_296_7202 VSS VSS gf180mcu_fd_sc_mcu9t5v0__filltie
XTAP_TAPCELL_ROW_209_4831 VSS VSS gf180mcu_fd_sc_mcu9t5v0__filltie
XTAP_TAPCELL_ROW_209_4820 VSS VSS gf180mcu_fd_sc_mcu9t5v0__filltie
XTAP_TAPCELL_ROW_296_7224 VSS VSS gf180mcu_fd_sc_mcu9t5v0__filltie
XPHY_EDGE_ROW_188_1_Left_511 VSS VSS gf180mcu_fd_sc_mcu9t5v0__endcap
XPHY_EDGE_ROW_198_3_Right_313 VSS VSS gf180mcu_fd_sc_mcu9t5v0__endcap
X_09625_ _09625_/I _20008_/D VSS VSS VSS VSS gf180mcu_fd_sc_mcu9t5v0__clkinv_1
Xmax_cap39 wire37/I wire38/I VSS VSS VSS VSS gf180mcu_fd_sc_mcu9t5v0__clkbuf_16
X_09556_ _18828_/Q _18827_/Q _18829_/Q _09556_/A4 _09838_/A2 VSS _17865_/VNW VSS VSS
+ gf180mcu_fd_sc_mcu9t5v0__nor4_1
X_09487_ wire175/Z wire208/I _12486_/B1 VSS _09681_/VNW VSS VSS gf180mcu_fd_sc_mcu9t5v0__nand2_1
XTAP_TAPCELL_ROW_281_6803 VSS VSS gf180mcu_fd_sc_mcu9t5v0__filltie
Xwire216 wire216/I wire216/Z VSS VSS VSS VSS gf180mcu_fd_sc_mcu9t5v0__buf_4
XPHY_EDGE_ROW_176_3_Left_834 VSS VSS gf180mcu_fd_sc_mcu9t5v0__endcap
X_10400_ _18159_/Q _17282_/A2 _17282_/B1 _18175_/Q _10514_/B _10399_/Z _10410_/A2
+ VSS VSS VSS VSS gf180mcu_fd_sc_mcu9t5v0__aoi222_1
XTAP_TAPCELL_ROW_266_6382 VSS VSS gf180mcu_fd_sc_mcu9t5v0__filltie
XTAP_TAPCELL_ROW_95_3597 VSS VSS gf180mcu_fd_sc_mcu9t5v0__filltie
X_11380_ _18878_/Q _12689_/C _11382_/A2 VSS _11380_/VNW VSS VSS gf180mcu_fd_sc_mcu9t5v0__nor2_1
XTAP_TAPCELL_ROW_95_3586 VSS VSS gf180mcu_fd_sc_mcu9t5v0__filltie
X_10331_ _18590_/Q _17409_/B _17225_/B _10331_/C _10332_/A3 VSS VSS VSS VSS gf180mcu_fd_sc_mcu9t5v0__oai211_1
XTAP_TAPCELL_ROW_266_6393 VSS VSS gf180mcu_fd_sc_mcu9t5v0__filltie
XTAP_TAPCELL_ROW_262_6279 VSS VSS gf180mcu_fd_sc_mcu9t5v0__filltie
XTAP_TAPCELL_ROW_262_6268 VSS VSS gf180mcu_fd_sc_mcu9t5v0__filltie
X_10262_ _10648_/C _18666_/Q _10821_/B _10278_/A2 VSS _10278_/VNW VSS VSS gf180mcu_fd_sc_mcu9t5v0__nand3_1
X_13050_ _19723_/Q _13050_/A2 _13061_/A2 VSS _13055_/VNW VSS VSS gf180mcu_fd_sc_mcu9t5v0__nand2_1
X_12001_ _12348_/C _12001_/A2 _12001_/A3 _12002_/B VSS _12001_/VNW VSS VSS gf180mcu_fd_sc_mcu9t5v0__nand3_1
XTAP_TAPCELL_ROW_279_6754 VSS VSS gf180mcu_fd_sc_mcu9t5v0__filltie
XTAP_TAPCELL_ROW_279_6743 VSS VSS gf180mcu_fd_sc_mcu9t5v0__filltie
XTAP_TAPCELL_ROW_279_6732 VSS VSS gf180mcu_fd_sc_mcu9t5v0__filltie
XPHY_EDGE_ROW_172_1_Left_495 VSS VSS gf180mcu_fd_sc_mcu9t5v0__endcap
X_10193_ _20043_/Q _09601_/I _15608_/A1 VSS _10193_/VNW VSS VSS gf180mcu_fd_sc_mcu9t5v0__nor2_1
XTAP_TAPCELL_ROW_275_6629 VSS VSS gf180mcu_fd_sc_mcu9t5v0__filltie
XTAP_TAPCELL_ROW_106_3903 VSS VSS gf180mcu_fd_sc_mcu9t5v0__filltie
X_16740_ _19289_/Q _16751_/B _16741_/C VSS _16824_/VNW VSS VSS gf180mcu_fd_sc_mcu9t5v0__nor2_1
X_13952_ _13952_/A1 _13952_/A2 _13952_/B _13982_/A2 VSS _13952_/VNW VSS VSS gf180mcu_fd_sc_mcu9t5v0__oai21_1
XPHY_EDGE_ROW_307_Right_234 VSS VSS gf180mcu_fd_sc_mcu9t5v0__endcap
X_12903_ _19774_/Q _12902_/Z _12908_/B VSS VSS VSS VSS gf180mcu_fd_sc_mcu9t5v0__and2_1
X_16671_ _19291_/Q _16675_/A1 _16675_/B VSS VSS VSS VSS gf180mcu_fd_sc_mcu9t5v0__nand2_1
X_13883_ _19320_/Q _19296_/Q _13956_/A1 VSS _13956_/VNW VSS VSS gf180mcu_fd_sc_mcu9t5v0__nand2_1
X_18410_ _18410_/D _20129_/CLK _18410_/Q VSS VSS VSS VSS gf180mcu_fd_sc_mcu9t5v0__dffq_1
X_15622_ _15677_/B _15622_/A2 _19891_/D VSS VSS VSS VSS gf180mcu_fd_sc_mcu9t5v0__nand2_1
X_12834_ _19764_/Q _12833_/Z _12834_/Z VSS _13214_/VNW VSS VSS gf180mcu_fd_sc_mcu9t5v0__or2_1
XTAP_TAPCELL_ROW_44_2206 VSS VSS gf180mcu_fd_sc_mcu9t5v0__filltie
X_19390_ _19390_/D _20030_/RN clkload20/I _19390_/Q VSS VSS VSS VSS gf180mcu_fd_sc_mcu9t5v0__dffrnq_1
X_15553_ _19871_/Q _15551_/S _15478_/I _15553_/Z VSS VSS VSS VSS gf180mcu_fd_sc_mcu9t5v0__and3_1
X_18341_ _18341_/D clkload69/I _18341_/Q VSS VSS VSS VSS gf180mcu_fd_sc_mcu9t5v0__dffq_1
XPHY_EDGE_ROW_160_3_Right_275 VSS VSS gf180mcu_fd_sc_mcu9t5v0__endcap
X_12765_ _19754_/Q _12763_/Z _12771_/B VSS VSS VSS VSS gf180mcu_fd_sc_mcu9t5v0__nand2_1
X_18272_ _18272_/D clkload75/I _18272_/Q VSS VSS VSS VSS gf180mcu_fd_sc_mcu9t5v0__dffq_1
X_11716_ _18315_/Q _11715_/Z _12092_/B _11716_/Z VSS _11716_/VNW VSS VSS gf180mcu_fd_sc_mcu9t5v0__mux2_1
XTAP_TAPCELL_ROW_251_5972 VSS VSS gf180mcu_fd_sc_mcu9t5v0__filltie
XTAP_TAPCELL_ROW_251_5961 VSS VSS gf180mcu_fd_sc_mcu9t5v0__filltie
X_14504_ _19164_/Q _19130_/Q _14731_/B VSS _14504_/VNW VSS VSS gf180mcu_fd_sc_mcu9t5v0__and2_1
X_17223_ _20114_/Q _17408_/B _17224_/A3 VSS VSS VSS VSS gf180mcu_fd_sc_mcu9t5v0__nand2_1
XTAP_TAPCELL_ROW_251_5983 VSS VSS gf180mcu_fd_sc_mcu9t5v0__filltie
X_15484_ _15512_/A1 _17422_/S _15486_/A1 VSS _15484_/VNW VSS VSS gf180mcu_fd_sc_mcu9t5v0__nand2_1
X_12696_ _19185_/Q _12724_/C _12700_/B VSS _12696_/VNW VSS VSS gf180mcu_fd_sc_mcu9t5v0__nand2_1
X_11647_ _11621_/Z _12652_/A2 _12649_/A4 VSS _11659_/VNW VSS VSS gf180mcu_fd_sc_mcu9t5v0__nand2_1
X_14435_ _14435_/A1 _14435_/A2 _19453_/D VSS VSS VSS VSS gf180mcu_fd_sc_mcu9t5v0__nand2_1
X_17154_ _17198_/A1 _17154_/A2 _17154_/A3 _17154_/B _17156_/A1 VSS VSS VSS VSS gf180mcu_fd_sc_mcu9t5v0__oai31_1
X_11578_ _19107_/Q _11966_/B _11579_/A2 VSS VSS VSS VSS gf180mcu_fd_sc_mcu9t5v0__nand2_1
X_14366_ _14366_/I0 _19436_/Q _14367_/S _19436_/D VSS VSS VSS VSS gf180mcu_fd_sc_mcu9t5v0__mux2_1
X_10529_ _18982_/Q _10804_/A2 wire166/Z _18950_/Q _10530_/A3 VSS _10531_/VNW VSS VSS
+ gf180mcu_fd_sc_mcu9t5v0__aoi22_1
X_16105_ _16105_/A1 _16198_/B _16197_/C _16199_/A1 _16105_/ZN VSS VSS VSS VSS gf180mcu_fd_sc_mcu9t5v0__nand4_4
X_17085_ _17195_/A1 _18441_/Q _17088_/A2 VSS VSS VSS VSS gf180mcu_fd_sc_mcu9t5v0__nor2_1
X_13317_ _19739_/Q _13318_/A2 _13337_/A2 VSS VSS VSS VSS gf180mcu_fd_sc_mcu9t5v0__nand2_1
X_16036_ _19201_/Q _16035_/Z _16612_/S _16142_/C VSS VSS VSS VSS gf180mcu_fd_sc_mcu9t5v0__mux2_1
X_14297_ _14364_/I0 _19370_/Q _14304_/S _19370_/D VSS VSS VSS VSS gf180mcu_fd_sc_mcu9t5v0__mux2_1
X_13248_ _12843_/B _19766_/Q _13248_/B _13265_/A2 VSS _13248_/VNW VSS VSS gf180mcu_fd_sc_mcu9t5v0__oai21_1
XTAP_TAPCELL_ROW_245_5798 VSS VSS gf180mcu_fd_sc_mcu9t5v0__filltie
X_13179_ _13179_/A1 _13179_/A2 _13185_/B1 VSS _13179_/VNW VSS VSS gf180mcu_fd_sc_mcu9t5v0__nand2_1
X_17987_ _18874_/Q _15581_/B wire128/Z _18874_/D VSS _17987_/VNW VSS VSS gf180mcu_fd_sc_mcu9t5v0__mux2_1
X_19726_ _19726_/D _20046_/RN clkload30/I _19726_/Q VSS VSS VSS VSS gf180mcu_fd_sc_mcu9t5v0__dffrnq_1
X_16938_ _16937_/Z _18460_/Q _16940_/S _18460_/D VSS VSS VSS VSS gf180mcu_fd_sc_mcu9t5v0__mux2_1
XTAP_TAPCELL_ROW_14_1364 VSS VSS gf180mcu_fd_sc_mcu9t5v0__filltie
XTAP_TAPCELL_ROW_14_1375 VSS VSS gf180mcu_fd_sc_mcu9t5v0__filltie
X_16869_ _19246_/Q _16584_/B _16881_/S _16869_/Z VSS VSS VSS VSS gf180mcu_fd_sc_mcu9t5v0__mux2_4
XPHY_EDGE_ROW_171_1_Right_755 VSS VSS gf180mcu_fd_sc_mcu9t5v0__endcap
X_19657_ _19657_/D _20041_/RN clkload37/I _19657_/Q VSS VSS VSS VSS gf180mcu_fd_sc_mcu9t5v0__dffrnq_1
X_18608_ _18608_/D clkload57/I _18608_/Q VSS VSS VSS VSS gf180mcu_fd_sc_mcu9t5v0__dffq_1
X_19588_ _19588_/D _20036_/RN clkload8/I _19588_/Q VSS VSS VSS VSS gf180mcu_fd_sc_mcu9t5v0__dffrnq_1
X_09410_ _19070_/Q _09465_/A3 _14590_/B VSS VSS VSS VSS gf180mcu_fd_sc_mcu9t5v0__or2_2
X_09341_ _19211_/Q _16098_/A1 VSS _09341_/VNW VSS VSS gf180mcu_fd_sc_mcu9t5v0__clkinv_1
X_18539_ _18539_/D _20039_/RN clkload50/I _18539_/Q VSS VSS VSS VSS gf180mcu_fd_sc_mcu9t5v0__dffrnq_1
XTAP_TAPCELL_ROW_27_1714 VSS VSS gf180mcu_fd_sc_mcu9t5v0__filltie
XTAP_TAPCELL_ROW_27_1725 VSS VSS gf180mcu_fd_sc_mcu9t5v0__filltie
XTAP_TAPCELL_ROW_27_1736 VSS VSS gf180mcu_fd_sc_mcu9t5v0__filltie
X_09272_ _19990_/Q _15824_/B2 VSS VSS VSS VSS gf180mcu_fd_sc_mcu9t5v0__clkinv_1
XTAP_TAPCELL_ROW_90_3450 VSS VSS gf180mcu_fd_sc_mcu9t5v0__filltie
XTAP_TAPCELL_ROW_90_3461 VSS VSS gf180mcu_fd_sc_mcu9t5v0__filltie
XPHY_EDGE_ROW_199_3_Right_314 VSS VSS gf180mcu_fd_sc_mcu9t5v0__endcap
XTAP_TAPCELL_ROW_88_3390 VSS VSS gf180mcu_fd_sc_mcu9t5v0__filltie
XTAP_TAPCELL_ROW_270_6504 VSS VSS gf180mcu_fd_sc_mcu9t5v0__filltie
XTAP_TAPCELL_ROW_255_6094 VSS VSS gf180mcu_fd_sc_mcu9t5v0__filltie
XTAP_TAPCELL_ROW_255_6083 VSS VSS gf180mcu_fd_sc_mcu9t5v0__filltie
X_10880_ _10879_/Z _18979_/Q _18152_/S _18979_/D VSS VSS VSS VSS gf180mcu_fd_sc_mcu9t5v0__mux2_1
XTAP_TAPCELL_ROW_255_6072 VSS VSS gf180mcu_fd_sc_mcu9t5v0__filltie
X_09608_ _20071_/Q _18683_/Q _09608_/Z VSS VSS VSS VSS gf180mcu_fd_sc_mcu9t5v0__or2_1
XTAP_TAPCELL_ROW_84_3298 VSS VSS gf180mcu_fd_sc_mcu9t5v0__filltie
XTAP_TAPCELL_ROW_84_3287 VSS VSS gf180mcu_fd_sc_mcu9t5v0__filltie
X_09539_ _20143_/Q _09849_/B _09539_/B _09542_/C VSS VSS VSS VSS gf180mcu_fd_sc_mcu9t5v0__aoi21_1
Xwire81 wire81/I wire81/Z VSS VSS VSS VSS gf180mcu_fd_sc_mcu9t5v0__clkbuf_16
X_12550_ _18400_/Q _12582_/A2 _12553_/A3 VSS VSS VSS VSS gf180mcu_fd_sc_mcu9t5v0__nor2_1
XTAP_TAPCELL_ROW_268_6433 VSS VSS gf180mcu_fd_sc_mcu9t5v0__filltie
XTAP_TAPCELL_ROW_97_3648 VSS VSS gf180mcu_fd_sc_mcu9t5v0__filltie
XTAP_TAPCELL_ROW_97_3637 VSS VSS gf180mcu_fd_sc_mcu9t5v0__filltie
XTAP_TAPCELL_ROW_268_6444 VSS VSS gf180mcu_fd_sc_mcu9t5v0__filltie
X_12481_ _18312_/Q _12616_/A2 _12616_/B _12482_/B2 VSS _12481_/VNW VSS VSS gf180mcu_fd_sc_mcu9t5v0__oai21_1
XTAP_TAPCELL_ROW_97_3659 VSS VSS gf180mcu_fd_sc_mcu9t5v0__filltie
X_11501_ _18887_/Q _11878_/A1 _11488_/B _11501_/B2 _11540_/C _11503_/A1 VSS _18004_/VNW
+ VSS VSS gf180mcu_fd_sc_mcu9t5v0__oai221_1
X_11432_ _18400_/Q _18384_/Q _11524_/S _11432_/Z VSS VSS VSS VSS gf180mcu_fd_sc_mcu9t5v0__mux2_1
XTAP_TAPCELL_ROW_264_6319 VSS VSS gf180mcu_fd_sc_mcu9t5v0__filltie
X_14220_ _14220_/A1 _14220_/A2 _14231_/A1 VSS VSS VSS VSS gf180mcu_fd_sc_mcu9t5v0__nand2_1
X_14151_ _19318_/Q _14150_/Z _19192_/D _19318_/D VSS VSS VSS VSS gf180mcu_fd_sc_mcu9t5v0__mux2_1
X_11363_ _12061_/A1 _11524_/S _11521_/B _11363_/C _11364_/B VSS VSS VSS VSS gf180mcu_fd_sc_mcu9t5v0__aoi211_1
X_13102_ _19726_/Q _13096_/Z _13536_/A1 VSS _13536_/VNW VSS VSS gf180mcu_fd_sc_mcu9t5v0__xnor2_1
XTAP_TAPCELL_ROW_37_2010 VSS VSS gf180mcu_fd_sc_mcu9t5v0__filltie
X_10314_ _10314_/A1 _10314_/A2 _10314_/B1 _10314_/B2 _10314_/ZN VSS VSS VSS VSS gf180mcu_fd_sc_mcu9t5v0__aoi22_4
XTAP_TAPCELL_ROW_201_3_8226 VSS VSS gf180mcu_fd_sc_mcu9t5v0__filltie
XTAP_TAPCELL_ROW_176_3_8139 VSS VSS gf180mcu_fd_sc_mcu9t5v0__filltie
X_11294_ _18872_/Q _11878_/A1 _11320_/B1 _11294_/B2 _11320_/C _11296_/A1 VSS _17984_/VNW
+ VSS VSS gf180mcu_fd_sc_mcu9t5v0__oai221_1
X_14082_ _19322_/Q _19298_/Q _14085_/A1 VSS VSS VSS VSS gf180mcu_fd_sc_mcu9t5v0__nand2_1
X_10245_ _18587_/Q _17409_/B _10245_/B _17225_/B _10246_/A3 VSS VSS VSS VSS gf180mcu_fd_sc_mcu9t5v0__oai211_1
X_18890_ _18890_/D _20042_/RN _19680_/CLK _18890_/Q VSS VSS VSS VSS gf180mcu_fd_sc_mcu9t5v0__dffrnq_1
X_13033_ _19755_/Q _13053_/A2 _13055_/A1 VSS VSS VSS VSS gf180mcu_fd_sc_mcu9t5v0__nand2_1
XTAP_TAPCELL_ROW_73_2991 VSS VSS gf180mcu_fd_sc_mcu9t5v0__filltie
X_17910_ _17910_/A1 _17919_/B1 _17910_/B _18840_/D VSS VSS VSS VSS gf180mcu_fd_sc_mcu9t5v0__oai21_1
XTAP_TAPCELL_ROW_73_2980 VSS VSS gf180mcu_fd_sc_mcu9t5v0__filltie
X_10176_ _10659_/C _10176_/A2 _10176_/B _10176_/C _10182_/A2 VSS _10176_/VNW VSS VSS
+ gf180mcu_fd_sc_mcu9t5v0__aoi211_1
X_17841_ _19048_/Q _18818_/Q _17845_/S _18818_/D VSS VSS VSS VSS gf180mcu_fd_sc_mcu9t5v0__mux2_1
XTAP_TAPCELL_ROW_240_5684 VSS VSS gf180mcu_fd_sc_mcu9t5v0__filltie
XTAP_TAPCELL_ROW_240_5673 VSS VSS gf180mcu_fd_sc_mcu9t5v0__filltie
XTAP_TAPCELL_ROW_240_5662 VSS VSS gf180mcu_fd_sc_mcu9t5v0__filltie
X_17772_ _18761_/Q _17773_/A2 _17773_/B VSS VSS VSS VSS gf180mcu_fd_sc_mcu9t5v0__nor2_1
X_14984_ _14984_/A1 _14984_/A2 _14984_/Z VSS _14984_/VNW VSS VSS gf180mcu_fd_sc_mcu9t5v0__xor2_1
X_16723_ _18371_/Q _16747_/A2 _16741_/A1 _16727_/B VSS _16723_/VNW VSS VSS gf180mcu_fd_sc_mcu9t5v0__nand3_1
X_19511_ _19511_/D _20023_/RN _20054_/CLK _19511_/Q VSS VSS VSS VSS gf180mcu_fd_sc_mcu9t5v0__dffrnq_1
X_13935_ _13936_/A1 _13936_/A2 _13960_/B VSS _13995_/VNW VSS VSS gf180mcu_fd_sc_mcu9t5v0__nand2_1
X_16654_ _16668_/A1 _16668_/A2 _16654_/B _16655_/A3 VSS _16654_/VNW VSS VSS gf180mcu_fd_sc_mcu9t5v0__aoi21_1
X_19442_ _19442_/D _20018_/RN clkload15/I _19442_/Q VSS VSS VSS VSS gf180mcu_fd_sc_mcu9t5v0__dffrnq_1
X_13866_ _13866_/A1 _13866_/A2 _13866_/Z VSS _15216_/VNW VSS VSS gf180mcu_fd_sc_mcu9t5v0__xor2_1
X_15605_ _15608_/A1 _15605_/A2 _15657_/B _15606_/I1 VSS VSS VSS VSS gf180mcu_fd_sc_mcu9t5v0__oai21_1
X_12817_ _19761_/Q _12815_/Z _12822_/A3 VSS _12818_/VNW VSS VSS gf180mcu_fd_sc_mcu9t5v0__nand2_1
X_16585_ _19246_/Q _16700_/A2 wire71/I _16586_/A3 VSS VSS VSS VSS gf180mcu_fd_sc_mcu9t5v0__nor3_1
X_13797_ _19292_/Q _19320_/Q _13800_/A2 VSS VSS VSS VSS gf180mcu_fd_sc_mcu9t5v0__nand2_1
X_19373_ _19373_/D _20141_/RN clkload20/I _19373_/Q VSS VSS VSS VSS gf180mcu_fd_sc_mcu9t5v0__dffrnq_1
X_18324_ _18324_/D _18324_/CLK _18324_/Q VSS VSS VSS VSS gf180mcu_fd_sc_mcu9t5v0__dffq_4
X_15536_ _19854_/Q _19837_/Q _15544_/S _19854_/D VSS _17856_/VNW VSS VSS gf180mcu_fd_sc_mcu9t5v0__mux2_1
XTAP_TAPCELL_ROW_234_5499 VSS VSS gf180mcu_fd_sc_mcu9t5v0__filltie
XPHY_EDGE_ROW_161_3_Right_276 VSS VSS gf180mcu_fd_sc_mcu9t5v0__endcap
X_12748_ _19752_/Q _12746_/Z _12749_/A2 VSS _12958_/VNW VSS VSS gf180mcu_fd_sc_mcu9t5v0__nor2_1
X_15467_ _15472_/A2 _15474_/A3 _15471_/S VSS _15467_/VNW VSS VSS gf180mcu_fd_sc_mcu9t5v0__nand2_1
X_18255_ _18255_/D _20099_/CLK _18255_/Q VSS VSS VSS VSS gf180mcu_fd_sc_mcu9t5v0__dffq_1
X_12679_ _12655_/S _12679_/A2 _12679_/B _19180_/D VSS _12679_/VNW VSS VSS gf180mcu_fd_sc_mcu9t5v0__oai21_1
XTAP_TAPCELL_ROW_22_1600 VSS VSS gf180mcu_fd_sc_mcu9t5v0__filltie
X_17206_ _19861_/Q _17161_/C _17206_/B _17208_/A3 VSS VSS VSS VSS gf180mcu_fd_sc_mcu9t5v0__oai21_1
X_18186_ _18186_/D clkload64/I _18186_/Q VSS VSS VSS VSS gf180mcu_fd_sc_mcu9t5v0__dffq_1
X_14418_ _19153_/Q _19119_/Q _14419_/I VSS VSS VSS VSS gf180mcu_fd_sc_mcu9t5v0__xnor2_1
X_17137_ _20110_/Q wire168/I _17138_/A3 VSS VSS VSS VSS gf180mcu_fd_sc_mcu9t5v0__nor2_1
X_15398_ _19683_/Q _19783_/Q _15417_/S _19783_/D VSS VSS VSS VSS gf180mcu_fd_sc_mcu9t5v0__mux2_1
X_14349_ _14364_/I0 _19420_/Q _14352_/S _19420_/D VSS VSS VSS VSS gf180mcu_fd_sc_mcu9t5v0__mux2_1
X_17068_ _18530_/Q _16634_/B _17069_/S _18530_/D VSS VSS VSS VSS gf180mcu_fd_sc_mcu9t5v0__mux2_1
X_16019_ _18155_/Q _16019_/I1 _16602_/S _18155_/D VSS VSS VSS VSS gf180mcu_fd_sc_mcu9t5v0__mux2_4
X_09890_ _09916_/B _10164_/A1 _10106_/B VSS _09890_/VNW VSS VSS gf180mcu_fd_sc_mcu9t5v0__nor2_1
XTAP_TAPCELL_ROW_16_1415 VSS VSS gf180mcu_fd_sc_mcu9t5v0__filltie
XTAP_TAPCELL_ROW_16_1426 VSS VSS gf180mcu_fd_sc_mcu9t5v0__filltie
XTAP_TAPCELL_ROW_190_3_8190 VSS VSS gf180mcu_fd_sc_mcu9t5v0__filltie
XTAP_TAPCELL_ROW_189_3_8184 VSS VSS gf180mcu_fd_sc_mcu9t5v0__filltie
X_19709_ _19709_/D _20029_/RN clkload37/I _19709_/Q VSS VSS VSS VSS gf180mcu_fd_sc_mcu9t5v0__dffrnq_1
XPHY_EDGE_ROW_172_1_Right_756 VSS VSS gf180mcu_fd_sc_mcu9t5v0__endcap
X_09324_ _19207_/Q _18126_/A1 VSS _16281_/VNW VSS VSS gf180mcu_fd_sc_mcu9t5v0__clkinv_1
X_09255_ _18691_/Q _09887_/A1 VSS VSS VSS VSS gf180mcu_fd_sc_mcu9t5v0__clkinv_4
XTAP_TAPCELL_ROW_135_4696 VSS VSS gf180mcu_fd_sc_mcu9t5v0__filltie
XTAP_TAPCELL_ROW_135_4685 VSS VSS gf180mcu_fd_sc_mcu9t5v0__filltie
XTAP_TAPCELL_ROW_92_3501 VSS VSS gf180mcu_fd_sc_mcu9t5v0__filltie
XTAP_TAPCELL_ROW_92_3523 VSS VSS gf180mcu_fd_sc_mcu9t5v0__filltie
XTAP_TAPCELL_ROW_92_3512 VSS VSS gf180mcu_fd_sc_mcu9t5v0__filltie
X_09186_ _19159_/Q _14462_/A1 VSS VSS VSS VSS gf180mcu_fd_sc_mcu9t5v0__clkinv_1
XTAP_TAPCELL_ROW_77_3091 VSS VSS gf180mcu_fd_sc_mcu9t5v0__filltie
X_10030_ _10030_/A1 _10030_/A2 _10043_/B1 VSS VSS VSS VSS gf180mcu_fd_sc_mcu9t5v0__nand2_1
XTAP_TAPCELL_ROW_257_6145 VSS VSS gf180mcu_fd_sc_mcu9t5v0__filltie
XTAP_TAPCELL_ROW_257_6134 VSS VSS gf180mcu_fd_sc_mcu9t5v0__filltie
XTAP_TAPCELL_ROW_86_3349 VSS VSS gf180mcu_fd_sc_mcu9t5v0__filltie
XTAP_TAPCELL_ROW_86_3338 VSS VSS gf180mcu_fd_sc_mcu9t5v0__filltie
X_11981_ _12345_/B _11981_/A2 _11981_/A3 _12348_/C _11982_/B2 VSS VSS VSS VSS gf180mcu_fd_sc_mcu9t5v0__oai31_1
X_10932_ _18927_/Q _18934_/Q _10933_/I VSS VSS VSS VSS gf180mcu_fd_sc_mcu9t5v0__xor2_1
X_13720_ _13737_/A1 _13720_/A2 _14671_/B VSS VSS VSS VSS gf180mcu_fd_sc_mcu9t5v0__nor2_1
XTAP_TAPCELL_ROW_6_1160 VSS VSS gf180mcu_fd_sc_mcu9t5v0__filltie
XTAP_TAPCELL_ROW_2_1024 VSS VSS gf180mcu_fd_sc_mcu9t5v0__filltie
XTAP_TAPCELL_ROW_2_1035 VSS VSS gf180mcu_fd_sc_mcu9t5v0__filltie
XTAP_TAPCELL_ROW_2_1046 VSS VSS gf180mcu_fd_sc_mcu9t5v0__filltie
X_10863_ _19228_/Q _19234_/Q _18151_/S _10863_/Z VSS VSS VSS VSS gf180mcu_fd_sc_mcu9t5v0__mux2_1
X_13651_ _20037_/Q _20038_/Q _13652_/B VSS VSS VSS VSS gf180mcu_fd_sc_mcu9t5v0__nand2_1
X_10794_ _19824_/Q _10794_/A2 _10389_/C _10795_/A2 VSS VSS VSS VSS gf180mcu_fd_sc_mcu9t5v0__nand3_1
X_16370_ _16370_/A1 _16512_/A1 _16925_/S _16910_/S VSS VSS VSS VSS gf180mcu_fd_sc_mcu9t5v0__aoi21_4
X_12602_ wire175/Z _12602_/A2 _12618_/B _12604_/A3 VSS _12602_/VNW VSS VSS gf180mcu_fd_sc_mcu9t5v0__aoi21_1
X_13582_ _13586_/A3 _13581_/Z _13583_/A2 VSS _13582_/VNW VSS VSS gf180mcu_fd_sc_mcu9t5v0__nand2_1
XPHY_EDGE_ROW_4_Left_328 VSS VSS gf180mcu_fd_sc_mcu9t5v0__endcap
X_12533_ _18494_/Q _12383_/S _12541_/B _12534_/B2 VSS VSS VSS VSS gf180mcu_fd_sc_mcu9t5v0__oai21_1
XTAP_TAPCELL_ROW_62_2681 VSS VSS gf180mcu_fd_sc_mcu9t5v0__filltie
XTAP_TAPCELL_ROW_62_2692 VSS VSS gf180mcu_fd_sc_mcu9t5v0__filltie
X_15321_ _15324_/A1 _15324_/A3 _15322_/A2 VSS VSS VSS VSS gf180mcu_fd_sc_mcu9t5v0__nor2_1
X_18040_ _18929_/Q _18040_/A2 _18040_/Z VSS VSS VSS VSS gf180mcu_fd_sc_mcu9t5v0__xor2_1
X_15252_ _15252_/A1 _15252_/A2 _15252_/B _19729_/D VSS VSS VSS VSS gf180mcu_fd_sc_mcu9t5v0__oai21_1
X_12464_ _18262_/Q _12615_/A2 _12466_/B1 VSS VSS VSS VSS gf180mcu_fd_sc_mcu9t5v0__nor2_1
X_14203_ _14115_/Z _14201_/Z _14203_/Z VSS VSS VSS VSS gf180mcu_fd_sc_mcu9t5v0__xor2_1
X_11415_ _18527_/Q _18511_/Q _18495_/Q _18479_/Q _11403_/S _11485_/C _11415_/Z VSS
+ VSS VSS VSS gf180mcu_fd_sc_mcu9t5v0__mux4_1
X_15183_ _19561_/Q _15184_/B2 _15183_/B1 _15183_/B2 _15183_/C _15186_/B1 VSS VSS VSS
+ VSS gf180mcu_fd_sc_mcu9t5v0__aoi221_1
X_12395_ _19146_/Q _12355_/I _12402_/B VSS _12395_/VNW VSS VSS gf180mcu_fd_sc_mcu9t5v0__nand2_1
X_11346_ _11346_/A1 _11346_/A2 _11429_/B _11346_/C _11347_/B VSS _11346_/VNW VSS VSS
+ gf180mcu_fd_sc_mcu9t5v0__oai211_1
XPHY_EDGE_ROW_202_1_Left_525 VSS VSS gf180mcu_fd_sc_mcu9t5v0__endcap
X_19991_ _19991_/D _20055_/RN _20054_/CLK _19991_/Q VSS VSS VSS VSS gf180mcu_fd_sc_mcu9t5v0__dffrnq_1
X_14134_ _14134_/A1 _14134_/A2 _14134_/Z VSS _14134_/VNW VSS VSS gf180mcu_fd_sc_mcu9t5v0__xor2_1
XTAP_TAPCELL_ROW_242_5735 VSS VSS gf180mcu_fd_sc_mcu9t5v0__filltie
X_18942_ _18942_/D _20030_/RN _20132_/CLK _18942_/Q VSS VSS VSS VSS gf180mcu_fd_sc_mcu9t5v0__dffrnq_1
XTAP_TAPCELL_ROW_242_5724 VSS VSS gf180mcu_fd_sc_mcu9t5v0__filltie
XTAP_TAPCELL_ROW_242_5713 VSS VSS gf180mcu_fd_sc_mcu9t5v0__filltie
XTAP_TAPCELL_ROW_71_2939 VSS VSS gf180mcu_fd_sc_mcu9t5v0__filltie
X_14065_ _14065_/A1 _14099_/B _14066_/A2 VSS VSS VSS VSS gf180mcu_fd_sc_mcu9t5v0__nand2_1
XTAP_TAPCELL_ROW_71_2928 VSS VSS gf180mcu_fd_sc_mcu9t5v0__filltie
X_11277_ _18213_/Q _18197_/Q _11534_/S _11277_/Z VSS _16292_/VNW VSS VSS gf180mcu_fd_sc_mcu9t5v0__mux2_1
X_13016_ _13016_/A1 _13015_/B _13020_/A2 VSS VSS VSS VSS gf180mcu_fd_sc_mcu9t5v0__xnor2_1
X_10228_ _10459_/C _10228_/A2 _10228_/A3 _10228_/B _10233_/A2 VSS VSS VSS VSS gf180mcu_fd_sc_mcu9t5v0__oai31_1
X_18873_ _18873_/D _20025_/RN clkload40/I _18873_/Q VSS VSS VSS VSS gf180mcu_fd_sc_mcu9t5v0__dffrnq_1
X_10159_ _10159_/A1 _10159_/A2 _10159_/B1 _10063_/C output17/I VSS VSS VSS VSS gf180mcu_fd_sc_mcu9t5v0__aoi22_2
X_17824_ _19031_/Q _18801_/Q _17845_/S _18801_/D VSS VSS VSS VSS gf180mcu_fd_sc_mcu9t5v0__mux2_1
X_17755_ _17755_/A1 _18768_/Q _17780_/A2 VSS _17755_/VNW VSS VSS gf180mcu_fd_sc_mcu9t5v0__nand2_1
XTAP_TAPCELL_ROW_69_2868 VSS VSS gf180mcu_fd_sc_mcu9t5v0__filltie
X_14967_ _14968_/A1 _14966_/Z _14971_/A2 VSS _14967_/VNW VSS VSS gf180mcu_fd_sc_mcu9t5v0__nand2_1
X_16706_ _16747_/A3 _16706_/A2 _16706_/B1 _16741_/B2 _16706_/C _16707_/I1 VSS VSS
+ VSS VSS gf180mcu_fd_sc_mcu9t5v0__aoi221_1
XTAP_TAPCELL_ROW_69_2879 VSS VSS gf180mcu_fd_sc_mcu9t5v0__filltie
Xclkbuf_leaf_7_clk_regs clkload0/I clkload23/I VSS clkbuf_leaf_7_clk_regs/VNW VSS
+ VSS gf180mcu_fd_sc_mcu9t5v0__clkbuf_8
X_17686_ _18664_/Q _20034_/RN _17702_/A3 _17743_/B VSS VSS VSS VSS gf180mcu_fd_sc_mcu9t5v0__and3_1
X_14898_ _14899_/A1 _14899_/A2 _14901_/B VSS VSS VSS VSS gf180mcu_fd_sc_mcu9t5v0__nor2_1
X_13918_ _13919_/A1 _13919_/A2 _13951_/B VSS VSS VSS VSS gf180mcu_fd_sc_mcu9t5v0__nand2_1
X_16637_ _18354_/Q _16637_/I1 _16643_/S _18354_/D VSS VSS VSS VSS gf180mcu_fd_sc_mcu9t5v0__mux2_4
X_13849_ _19319_/Q _19295_/Q _13917_/A1 VSS VSS VSS VSS gf180mcu_fd_sc_mcu9t5v0__nand2_1
X_19425_ _19425_/D _20065_/RN clkload21/I _19425_/Q VSS VSS VSS VSS gf180mcu_fd_sc_mcu9t5v0__dffrnq_1
X_16568_ _19276_/Q _16024_/B _16569_/B VSS VSS VSS VSS gf180mcu_fd_sc_mcu9t5v0__or2_1
X_19356_ _19356_/D _20060_/RN clkload18/I _19356_/Q VSS VSS VSS VSS gf180mcu_fd_sc_mcu9t5v0__dffrnq_1
X_18307_ _18307_/D _18324_/CLK _18307_/Q VSS VSS VSS VSS gf180mcu_fd_sc_mcu9t5v0__dffq_4
X_15519_ _15566_/A1 _15519_/A2 _15518_/Z _19843_/D VSS VSS VSS VSS gf180mcu_fd_sc_mcu9t5v0__nor3_1
XPHY_EDGE_ROW_162_3_Right_277 VSS VSS gf180mcu_fd_sc_mcu9t5v0__endcap
XPHY_EDGE_ROW_197_1_Left_520 VSS VSS gf180mcu_fd_sc_mcu9t5v0__endcap
X_16499_ _19238_/Q _16167_/B _17023_/S _16499_/Z VSS VSS VSS VSS gf180mcu_fd_sc_mcu9t5v0__mux2_1
X_19287_ _19287_/D _20055_/RN clkload39/I _19287_/Q VSS VSS VSS VSS gf180mcu_fd_sc_mcu9t5v0__dffrnq_1
X_18238_ _18238_/D _18513_/CLK _18238_/Q VSS VSS VSS VSS gf180mcu_fd_sc_mcu9t5v0__dffq_4
XPHY_EDGE_ROW_304_Left_627 VSS VSS gf180mcu_fd_sc_mcu9t5v0__endcap
X_18169_ _18169_/D clkload63/I _18169_/Q VSS VSS VSS VSS gf180mcu_fd_sc_mcu9t5v0__dffq_4
XTAP_TAPCELL_ROW_212_4893 VSS VSS gf180mcu_fd_sc_mcu9t5v0__filltie
XTAP_TAPCELL_ROW_130_4571 VSS VSS gf180mcu_fd_sc_mcu9t5v0__filltie
XTAP_TAPCELL_ROW_130_4560 VSS VSS gf180mcu_fd_sc_mcu9t5v0__filltie
Xmax_cap132 _11510_/B _11483_/B VSS VSS VSS VSS gf180mcu_fd_sc_mcu9t5v0__clkbuf_4
Xmax_cap143 _12208_/C _12345_/B VSS VSS VSS VSS gf180mcu_fd_sc_mcu9t5v0__clkbuf_8
XTAP_TAPCELL_ROW_320_7879 VSS VSS gf180mcu_fd_sc_mcu9t5v0__filltie
X_20131_ _20131_/D clkload74/I _20131_/Q VSS VSS VSS VSS gf180mcu_fd_sc_mcu9t5v0__dffq_1
XTAP_TAPCELL_ROW_320_7868 VSS VSS gf180mcu_fd_sc_mcu9t5v0__filltie
Xmax_cap154 _11537_/S _11520_/B VSS VSS VSS VSS gf180mcu_fd_sc_mcu9t5v0__clkbuf_12
XTAP_TAPCELL_ROW_320_7857 VSS VSS gf180mcu_fd_sc_mcu9t5v0__filltie
X_09942_ _18819_/Q _18820_/Q _18817_/Q _18818_/Q _09943_/A3 VSS _09946_/VNW VSS VSS
+ gf180mcu_fd_sc_mcu9t5v0__nand4_1
Xmax_cap187 _12181_/A2 _12345_/A2 VSS VSS VSS VSS gf180mcu_fd_sc_mcu9t5v0__buf_8
X_20062_ _20062_/D _20062_/RN clkload58/I _20062_/Q VSS VSS VSS VSS gf180mcu_fd_sc_mcu9t5v0__dffrnq_1
X_09873_ _19903_/Q _09873_/A2 _09873_/B _20043_/Q _10191_/A2 VSS VSS VSS VSS gf180mcu_fd_sc_mcu9t5v0__oai211_1
XPHY_EDGE_ROW_313_Left_636 VSS VSS gf180mcu_fd_sc_mcu9t5v0__endcap
XTAP_TAPCELL_ROW_124_4397 VSS VSS gf180mcu_fd_sc_mcu9t5v0__filltie
XTAP_TAPCELL_ROW_124_4386 VSS VSS gf180mcu_fd_sc_mcu9t5v0__filltie
XPHY_EDGE_ROW_185_3_Left_843 VSS VSS gf180mcu_fd_sc_mcu9t5v0__endcap
XTAP_TAPCELL_ROW_81_3213 VSS VSS gf180mcu_fd_sc_mcu9t5v0__filltie
XTAP_TAPCELL_ROW_81_3202 VSS VSS gf180mcu_fd_sc_mcu9t5v0__filltie
XPHY_EDGE_ROW_173_1_Right_757 VSS VSS gf180mcu_fd_sc_mcu9t5v0__endcap
X_09307_ _19259_/Q _16961_/A1 VSS VSS VSS VSS gf180mcu_fd_sc_mcu9t5v0__clkinv_1
XTAP_TAPCELL_ROW_79_3142 VSS VSS gf180mcu_fd_sc_mcu9t5v0__filltie
XPHY_EDGE_ROW_322_Left_645 VSS VSS gf180mcu_fd_sc_mcu9t5v0__endcap
XTAP_TAPCELL_ROW_79_3164 VSS VSS gf180mcu_fd_sc_mcu9t5v0__filltie
XTAP_TAPCELL_ROW_79_3153 VSS VSS gf180mcu_fd_sc_mcu9t5v0__filltie
X_09238_ _20058_/Q _15858_/A2 VSS VSS VSS VSS gf180mcu_fd_sc_mcu9t5v0__clkinv_1
XTAP_TAPCELL_ROW_75_3039 VSS VSS gf180mcu_fd_sc_mcu9t5v0__filltie
X_09169_ _19141_/Q _13666_/A1 VSS _09169_/VNW VSS VSS gf180mcu_fd_sc_mcu9t5v0__clkinv_1
X_12180_ _18464_/Q _12315_/S _12183_/A1 VSS VSS VSS VSS gf180mcu_fd_sc_mcu9t5v0__nor2_1
X_11200_ _18702_/Q wire198/Z _11201_/A2 VSS VSS VSS VSS gf180mcu_fd_sc_mcu9t5v0__nand2_1
Xclkbuf_leaf_77_clk_regs clkbuf_3_0_0_clk_regs/Z clkload12/I VSS VSS VSS VSS gf180mcu_fd_sc_mcu9t5v0__clkbuf_8
X_11131_ _11131_/A1 _11403_/S _11132_/C VSS _12088_/VNW VSS VSS gf180mcu_fd_sc_mcu9t5v0__nand2_1
X_11062_ _18032_/I0 _19063_/Q _11067_/S _19063_/D VSS VSS VSS VSS gf180mcu_fd_sc_mcu9t5v0__mux2_1
X_10013_ _18568_/Q _18567_/Q _16234_/A1 VSS _17721_/VNW VSS VSS gf180mcu_fd_sc_mcu9t5v0__nor2_1
X_15870_ _20079_/Q _19229_/Q _15905_/S _20079_/D VSS VSS VSS VSS gf180mcu_fd_sc_mcu9t5v0__mux2_1
XTAP_TAPCELL_ROW_8_1200 VSS VSS gf180mcu_fd_sc_mcu9t5v0__filltie
XTAP_TAPCELL_ROW_51_2382 VSS VSS gf180mcu_fd_sc_mcu9t5v0__filltie
XTAP_TAPCELL_ROW_8_1211 VSS VSS gf180mcu_fd_sc_mcu9t5v0__filltie
XTAP_TAPCELL_ROW_51_2393 VSS VSS gf180mcu_fd_sc_mcu9t5v0__filltie
X_14821_ _14821_/A1 _14821_/A2 _14821_/B _14824_/A1 VSS VSS VSS VSS gf180mcu_fd_sc_mcu9t5v0__oai21_1
X_17540_ input4/Z _17541_/A2 _17540_/Z VSS VSS VSS VSS gf180mcu_fd_sc_mcu9t5v0__or2_1
X_14752_ _14752_/A1 _14752_/A2 _14752_/B _14752_/C _14755_/B VSS VSS VSS VSS gf180mcu_fd_sc_mcu9t5v0__aoi211_1
XTAP_TAPCELL_ROW_64_2732 VSS VSS gf180mcu_fd_sc_mcu9t5v0__filltie
X_11964_ _11964_/A1 _11965_/A2 _12005_/A2 VSS _18020_/VNW VSS VSS gf180mcu_fd_sc_mcu9t5v0__nand2_1
X_11895_ _18323_/Q _12320_/C _11896_/B VSS VSS VSS VSS gf180mcu_fd_sc_mcu9t5v0__nand2_1
Xeco15_sk2_4 eco15_sk2_4/I _18370_/CLK VSS VSS VSS VSS gf180mcu_fd_sc_mcu9t5v0__clkbuf_16
X_10915_ _10915_/I0 _18996_/Q _18152_/S _18996_/D VSS _10915_/VNW VSS VSS gf180mcu_fd_sc_mcu9t5v0__mux2_1
X_13703_ _19111_/Q _14501_/S _14764_/B _13703_/C _14380_/A1 VSS VSS VSS VSS gf180mcu_fd_sc_mcu9t5v0__oai211_1
X_14683_ _19149_/Q _19115_/Q _19150_/Q _19116_/Q _14683_/C _14688_/A3 VSS VSS VSS
+ VSS gf180mcu_fd_sc_mcu9t5v0__aoi221_1
XTAP_TAPCELL_ROW_64_2743 VSS VSS gf180mcu_fd_sc_mcu9t5v0__filltie
XTAP_TAPCELL_ROW_64_2754 VSS VSS gf180mcu_fd_sc_mcu9t5v0__filltie
X_17471_ wire198/I _12333_/B _18582_/Q _17472_/A2 VSS VSS VSS VSS gf180mcu_fd_sc_mcu9t5v0__aoi21_1
X_16422_ _16422_/A1 _16955_/S _16422_/B _16423_/I0 VSS _16422_/VNW VSS VSS gf180mcu_fd_sc_mcu9t5v0__oai21_1
XTAP_TAPCELL_ROW_231_5414 VSS VSS gf180mcu_fd_sc_mcu9t5v0__filltie
X_19210_ _19210_/D _20042_/RN clkload40/I _19210_/Q VSS VSS VSS VSS gf180mcu_fd_sc_mcu9t5v0__dffrnq_1
X_10846_ _18060_/A1 _18059_/A2 _18053_/A1 VSS _10980_/VNW VSS VSS gf180mcu_fd_sc_mcu9t5v0__nor2_2
X_13634_ _13635_/A1 _13635_/A3 _13634_/B _13640_/A1 VSS _13635_/VNW VSS VSS gf180mcu_fd_sc_mcu9t5v0__aoi21_1
XTAP_TAPCELL_ROW_60_2629 VSS VSS gf180mcu_fd_sc_mcu9t5v0__filltie
XTAP_TAPCELL_ROW_231_5436 VSS VSS gf180mcu_fd_sc_mcu9t5v0__filltie
XTAP_TAPCELL_ROW_231_5425 VSS VSS gf180mcu_fd_sc_mcu9t5v0__filltie
X_16353_ _19236_/Q _16058_/B _16865_/S _16353_/Z VSS VSS VSS VSS gf180mcu_fd_sc_mcu9t5v0__mux2_1
X_19141_ _19141_/D _20037_/RN clkload16/I _19141_/Q VSS VSS VSS VSS gf180mcu_fd_sc_mcu9t5v0__dffrnq_1
X_13565_ _13566_/B _13566_/A1 _13566_/A2 _13568_/A1 VSS _13565_/VNW VSS VSS gf180mcu_fd_sc_mcu9t5v0__nor3_1
X_15304_ _15304_/A1 _15304_/A2 _15300_/Z _15304_/B _15311_/A1 VSS VSS VSS VSS gf180mcu_fd_sc_mcu9t5v0__oai31_1
X_10777_ _18842_/Q _18849_/Q _10777_/B _10797_/A1 VSS _10777_/VNW VSS VSS gf180mcu_fd_sc_mcu9t5v0__aoi21_1
X_12516_ _12516_/A1 _12607_/A2 _12517_/C VSS VSS VSS VSS gf180mcu_fd_sc_mcu9t5v0__nand2_1
XTAP_TAPCELL_ROW_248_5900 VSS VSS gf180mcu_fd_sc_mcu9t5v0__filltie
X_16284_ _18213_/Q _16284_/I1 _16824_/S _18213_/D VSS VSS VSS VSS gf180mcu_fd_sc_mcu9t5v0__mux2_1
X_13496_ _13496_/A1 _13496_/A2 _13496_/Z VSS VSS VSS VSS gf180mcu_fd_sc_mcu9t5v0__xor2_1
X_19072_ _19072_/D _09246_/I clkload27/I _19072_/Q VSS VSS VSS VSS gf180mcu_fd_sc_mcu9t5v0__dffrnq_1
X_12447_ _18212_/Q wire163/Z _12450_/A3 VSS VSS VSS VSS gf180mcu_fd_sc_mcu9t5v0__nor2_1
XPHY_EDGE_ROW_149_2_Left_661 VSS VSS gf180mcu_fd_sc_mcu9t5v0__endcap
X_15235_ _19597_/Q _19574_/Q _15236_/I VSS _15238_/VNW VSS VSS gf180mcu_fd_sc_mcu9t5v0__xnor2_1
X_18023_ _18023_/I0 _18908_/Q _18037_/S _18908_/D VSS _18023_/VNW VSS VSS gf180mcu_fd_sc_mcu9t5v0__mux2_1
XTAP_TAPCELL_ROW_229_5376 VSS VSS gf180mcu_fd_sc_mcu9t5v0__filltie
XTAP_TAPCELL_ROW_229_5365 VSS VSS gf180mcu_fd_sc_mcu9t5v0__filltie
XTAP_TAPCELL_ROW_58_2569 VSS VSS gf180mcu_fd_sc_mcu9t5v0__filltie
X_15166_ _19708_/Q _19548_/Q wire108/Z _19708_/D VSS VSS VSS VSS gf180mcu_fd_sc_mcu9t5v0__mux2_1
X_12378_ _12541_/B _12378_/A2 _12378_/A3 _12378_/B _12379_/B2 VSS VSS VSS VSS gf180mcu_fd_sc_mcu9t5v0__oai31_1
X_14117_ _14117_/I _14124_/A1 VSS VSS VSS VSS gf180mcu_fd_sc_mcu9t5v0__clkinv_1
X_19974_ _19974_/D _20038_/RN clkload66/I _19974_/Q VSS VSS VSS VSS gf180mcu_fd_sc_mcu9t5v0__dffrnq_1
X_11329_ _18441_/Q _11385_/A2 _11331_/A1 VSS _16008_/VNW VSS VSS gf180mcu_fd_sc_mcu9t5v0__nor2_1
X_15097_ _19647_/Q _15097_/I1 _20039_/Q _19647_/D VSS VSS VSS VSS gf180mcu_fd_sc_mcu9t5v0__mux2_1
X_18925_ _18925_/D _20141_/RN clkload39/I _18925_/Q VSS VSS VSS VSS gf180mcu_fd_sc_mcu9t5v0__dffrnq_1
X_14048_ _14048_/A1 _19323_/Q _14080_/A2 VSS VSS VSS VSS gf180mcu_fd_sc_mcu9t5v0__nand2_1
X_18856_ _18856_/D _20072_/RN clkload35/I _18856_/Q VSS VSS VSS VSS gf180mcu_fd_sc_mcu9t5v0__dffrnq_1
X_17807_ input8/Z _18785_/Q _17807_/S _18785_/D VSS VSS VSS VSS gf180mcu_fd_sc_mcu9t5v0__mux2_1
XTAP_TAPCELL_ROW_292_7090 VSS VSS gf180mcu_fd_sc_mcu9t5v0__filltie
X_15999_ _16004_/B1 _16003_/A2 _16047_/S VSS VSS VSS VSS gf180mcu_fd_sc_mcu9t5v0__nand2_4
X_18787_ _18787_/D _20067_/RN clkload51/I _18787_/Q VSS VSS VSS VSS gf180mcu_fd_sc_mcu9t5v0__dffrnq_1
X_17738_ _18745_/Q _17681_/S _17739_/B VSS VSS VSS VSS gf180mcu_fd_sc_mcu9t5v0__nand2_1
XTAP_TAPCELL_ROW_30_1798 VSS VSS gf180mcu_fd_sc_mcu9t5v0__filltie
XTAP_TAPCELL_ROW_313_7683 VSS VSS gf180mcu_fd_sc_mcu9t5v0__filltie
XTAP_TAPCELL_ROW_313_7672 VSS VSS gf180mcu_fd_sc_mcu9t5v0__filltie
X_17669_ _18632_/Q _18708_/Q _17685_/S _18708_/D VSS VSS VSS VSS gf180mcu_fd_sc_mcu9t5v0__mux2_1
X_19408_ _19408_/D _20048_/RN clkload8/I _19408_/Q VSS VSS VSS VSS gf180mcu_fd_sc_mcu9t5v0__dffrnq_1
XTAP_TAPCELL_ROW_197_3_8213 VSS VSS gf180mcu_fd_sc_mcu9t5v0__filltie
XPHY_EDGE_ROW_298_Right_225 VSS VSS gf180mcu_fd_sc_mcu9t5v0__endcap
XTAP_TAPCELL_ROW_214_4955 VSS VSS gf180mcu_fd_sc_mcu9t5v0__filltie
XTAP_TAPCELL_ROW_214_4944 VSS VSS gf180mcu_fd_sc_mcu9t5v0__filltie
XPHY_EDGE_ROW_163_3_Right_278 VSS VSS gf180mcu_fd_sc_mcu9t5v0__endcap
XTAP_TAPCELL_ROW_132_4622 VSS VSS gf180mcu_fd_sc_mcu9t5v0__filltie
XTAP_TAPCELL_ROW_132_4611 VSS VSS gf180mcu_fd_sc_mcu9t5v0__filltie
XTAP_TAPCELL_ROW_132_4600 VSS VSS gf180mcu_fd_sc_mcu9t5v0__filltie
X_19339_ _19339_/D _20043_/RN clkload18/I _19339_/Q VSS VSS VSS VSS gf180mcu_fd_sc_mcu9t5v0__dffrnq_1
XTAP_TAPCELL_ROW_214_4966 VSS VSS gf180mcu_fd_sc_mcu9t5v0__filltie
XTAP_TAPCELL_ROW_117_4190 VSS VSS gf180mcu_fd_sc_mcu9t5v0__filltie
XTAP_TAPCELL_ROW_322_7919 VSS VSS gf180mcu_fd_sc_mcu9t5v0__filltie
XTAP_TAPCELL_ROW_177_3_8144 VSS VSS gf180mcu_fd_sc_mcu9t5v0__filltie
XTAP_TAPCELL_ROW_113_4098 VSS VSS gf180mcu_fd_sc_mcu9t5v0__filltie
XTAP_TAPCELL_ROW_113_4087 VSS VSS gf180mcu_fd_sc_mcu9t5v0__filltie
XTAP_TAPCELL_ROW_202_3_8231 VSS VSS gf180mcu_fd_sc_mcu9t5v0__filltie
XTAP_TAPCELL_ROW_299_7299 VSS VSS gf180mcu_fd_sc_mcu9t5v0__filltie
XTAP_TAPCELL_ROW_299_7288 VSS VSS gf180mcu_fd_sc_mcu9t5v0__filltie
X_20114_ _20114_/D _20129_/CLK _20114_/Q VSS VSS VSS VSS gf180mcu_fd_sc_mcu9t5v0__dffq_1
X_09925_ _15830_/A2 _09978_/B1 _10166_/A2 VSS _09928_/VNW VSS VSS gf180mcu_fd_sc_mcu9t5v0__nor2_1
XTAP_TAPCELL_ROW_126_4448 VSS VSS gf180mcu_fd_sc_mcu9t5v0__filltie
XTAP_TAPCELL_ROW_126_4437 VSS VSS gf180mcu_fd_sc_mcu9t5v0__filltie
XTAP_TAPCELL_ROW_126_4459 VSS VSS gf180mcu_fd_sc_mcu9t5v0__filltie
X_20045_ _20045_/D _20045_/RN clkload40/I _20045_/Q VSS VSS VSS VSS gf180mcu_fd_sc_mcu9t5v0__dffrnq_1
X_09856_ _09856_/I _20035_/D VSS VSS VSS VSS gf180mcu_fd_sc_mcu9t5v0__clkinv_1
X_09787_ _18850_/Q _11585_/A2 _11612_/A1 VSS _09789_/VNW VSS VSS gf180mcu_fd_sc_mcu9t5v0__nor2_1
XPHY_EDGE_ROW_219_Right_146 VSS VSS gf180mcu_fd_sc_mcu9t5v0__endcap
XPHY_EDGE_ROW_85_Left_409 VSS VSS gf180mcu_fd_sc_mcu9t5v0__endcap
X_10700_ _19820_/Q _10389_/C _10700_/B1 _17411_/C _17412_/B _10701_/B VSS VSS VSS
+ VSS gf180mcu_fd_sc_mcu9t5v0__aoi221_1
XTAP_TAPCELL_ROW_102_3791 VSS VSS gf180mcu_fd_sc_mcu9t5v0__filltie
XTAP_TAPCELL_ROW_102_3780 VSS VSS gf180mcu_fd_sc_mcu9t5v0__filltie
XPHY_EDGE_ROW_174_1_Right_758 VSS VSS gf180mcu_fd_sc_mcu9t5v0__endcap
X_11680_ _18891_/Q _12076_/B _11681_/A2 VSS _11680_/VNW VSS VSS gf180mcu_fd_sc_mcu9t5v0__nand2_1
XTAP_TAPCELL_ROW_288_6981 VSS VSS gf180mcu_fd_sc_mcu9t5v0__filltie
X_10631_ _17358_/A1 _18264_/Q _10634_/A2 VSS _12481_/VNW VSS VSS gf180mcu_fd_sc_mcu9t5v0__nor2_1
XTAP_TAPCELL_ROW_288_6992 VSS VSS gf180mcu_fd_sc_mcu9t5v0__filltie
X_10562_ _17404_/S _18213_/Q _10564_/A3 VSS VSS VSS VSS gf180mcu_fd_sc_mcu9t5v0__nor2_1
X_13350_ _13360_/A1 _13347_/Z _13351_/A2 VSS VSS VSS VSS gf180mcu_fd_sc_mcu9t5v0__nand2_1
XTAP_TAPCELL_ROW_40_2072 VSS VSS gf180mcu_fd_sc_mcu9t5v0__filltie
XTAP_TAPCELL_ROW_284_6889 VSS VSS gf180mcu_fd_sc_mcu9t5v0__filltie
XTAP_TAPCELL_ROW_284_6878 VSS VSS gf180mcu_fd_sc_mcu9t5v0__filltie
XTAP_TAPCELL_ROW_284_6867 VSS VSS gf180mcu_fd_sc_mcu9t5v0__filltie
X_12301_ _18438_/Q _18422_/Q _12340_/S _12301_/Z VSS VSS VSS VSS gf180mcu_fd_sc_mcu9t5v0__mux2_1
XTAP_TAPCELL_ROW_40_2083 VSS VSS gf180mcu_fd_sc_mcu9t5v0__filltie
XTAP_TAPCELL_ROW_40_2094 VSS VSS gf180mcu_fd_sc_mcu9t5v0__filltie
XPHY_EDGE_ROW_94_Left_418 VSS VSS gf180mcu_fd_sc_mcu9t5v0__endcap
X_13281_ _13281_/A1 _19769_/Q _13300_/B VSS VSS VSS VSS gf180mcu_fd_sc_mcu9t5v0__nand2_1
X_10493_ _18290_/Q _17380_/A2 _17380_/B1 _18306_/Q _10494_/A2 VSS VSS VSS VSS gf180mcu_fd_sc_mcu9t5v0__aoi22_1
X_12232_ wire213/I _12232_/A2 _12232_/B1 _12296_/B2 _12311_/B _12233_/B VSS VSS VSS
+ VSS gf180mcu_fd_sc_mcu9t5v0__aoi221_1
X_15020_ _19377_/Q _15020_/A2 _15022_/S _15021_/I1 VSS VSS VSS VSS gf180mcu_fd_sc_mcu9t5v0__xnor3_1
X_12163_ _12163_/I _12166_/A1 VSS _12163_/VNW VSS VSS gf180mcu_fd_sc_mcu9t5v0__clkinv_1
XTAP_TAPCELL_ROW_53_2433 VSS VSS gf180mcu_fd_sc_mcu9t5v0__filltie
XTAP_TAPCELL_ROW_53_2444 VSS VSS gf180mcu_fd_sc_mcu9t5v0__filltie
X_16971_ _19248_/Q _16599_/B _16971_/S _16971_/Z VSS VSS VSS VSS gf180mcu_fd_sc_mcu9t5v0__mux2_1
X_12094_ _11736_/C _12094_/A2 _12094_/A3 _12094_/B1 _12094_/B2 _12095_/B VSS VSS VSS
+ VSS gf180mcu_fd_sc_mcu9t5v0__oai32_2
XTAP_TAPCELL_ROW_224_5240 VSS VSS gf180mcu_fd_sc_mcu9t5v0__filltie
X_11114_ _18298_/Q _11385_/A2 _11429_/B _11115_/B2 VSS VSS VSS VSS gf180mcu_fd_sc_mcu9t5v0__aoi21_1
X_15922_ _20131_/Q _19252_/Q _15928_/S _20131_/D VSS VSS VSS VSS gf180mcu_fd_sc_mcu9t5v0__mux2_1
XTAP_TAPCELL_ROW_220_5126 VSS VSS gf180mcu_fd_sc_mcu9t5v0__filltie
XTAP_TAPCELL_ROW_220_5115 VSS VSS gf180mcu_fd_sc_mcu9t5v0__filltie
X_18710_ _18710_/D clkload65/I _18710_/Q VSS VSS VSS VSS gf180mcu_fd_sc_mcu9t5v0__dffq_1
X_11045_ _18031_/I0 _19046_/Q _11051_/S _19046_/D VSS VSS VSS VSS gf180mcu_fd_sc_mcu9t5v0__mux2_1
XTAP_TAPCELL_ROW_109_3989 VSS VSS gf180mcu_fd_sc_mcu9t5v0__filltie
XTAP_TAPCELL_ROW_109_3978 VSS VSS gf180mcu_fd_sc_mcu9t5v0__filltie
X_19690_ _19690_/D _20138_/RN clkload33/I _19690_/Q VSS VSS VSS VSS gf180mcu_fd_sc_mcu9t5v0__dffrnq_1
XTAP_TAPCELL_ROW_109_3967 VSS VSS gf180mcu_fd_sc_mcu9t5v0__filltie
XTAP_TAPCELL_ROW_237_5601 VSS VSS gf180mcu_fd_sc_mcu9t5v0__filltie
X_18641_ _18641_/D _20045_/RN clkload54/I _18641_/Q VSS VSS VSS VSS gf180mcu_fd_sc_mcu9t5v0__dffrnq_1
X_15853_ _15855_/A1 _09758_/B _17617_/S _20138_/D VSS VSS VSS VSS gf180mcu_fd_sc_mcu9t5v0__oai21_1
XTAP_TAPCELL_ROW_66_2805 VSS VSS gf180mcu_fd_sc_mcu9t5v0__filltie
X_15784_ _19978_/Q _19954_/Q _15786_/S _19954_/D VSS VSS VSS VSS gf180mcu_fd_sc_mcu9t5v0__mux2_1
X_14804_ _19571_/Q _09462_/I _14805_/B VSS VSS VSS VSS gf180mcu_fd_sc_mcu9t5v0__nand2_1
X_12996_ _12996_/A1 _12996_/A2 _12996_/B _13015_/A2 VSS VSS VSS VSS gf180mcu_fd_sc_mcu9t5v0__oai21_1
X_18572_ _18572_/D _20072_/RN clkload28/I _18572_/Q VSS VSS VSS VSS gf180mcu_fd_sc_mcu9t5v0__dffrnq_1
X_17523_ wire301/Z _18628_/Q _17529_/S _18628_/D VSS VSS VSS VSS gf180mcu_fd_sc_mcu9t5v0__mux2_1
XTAP_TAPCELL_ROW_218_5055 VSS VSS gf180mcu_fd_sc_mcu9t5v0__filltie
X_11947_ _12548_/A1 _11947_/A2 _11947_/B1 _12004_/B _11985_/B _11948_/B VSS VSS VSS
+ VSS gf180mcu_fd_sc_mcu9t5v0__oai221_4
X_14735_ _14735_/A1 _14735_/A2 _14735_/B _14738_/A2 VSS VSS VSS VSS gf180mcu_fd_sc_mcu9t5v0__oai21_1
XTAP_TAPCELL_ROW_218_5077 VSS VSS gf180mcu_fd_sc_mcu9t5v0__filltie
XTAP_TAPCELL_ROW_218_5066 VSS VSS gf180mcu_fd_sc_mcu9t5v0__filltie
XTAP_TAPCELL_ROW_183_3_8165 VSS VSS gf180mcu_fd_sc_mcu9t5v0__filltie
X_11878_ _11878_/A1 _11961_/B _12004_/B VSS VSS VSS VSS gf180mcu_fd_sc_mcu9t5v0__nand2_1
X_14666_ _14666_/A1 _14668_/A2 _14666_/Z VSS _14666_/VNW VSS VSS gf180mcu_fd_sc_mcu9t5v0__xor2_1
X_17454_ _17462_/A1 _17454_/A2 _18573_/D VSS VSS VSS VSS gf180mcu_fd_sc_mcu9t5v0__nor2_1
X_17385_ _09261_/I _17385_/A2 _17385_/A3 _17385_/B _17386_/C2 VSS VSS VSS VSS gf180mcu_fd_sc_mcu9t5v0__oai31_1
X_16405_ _19228_/Q _16932_/A2 _16406_/A2 VSS VSS VSS VSS gf180mcu_fd_sc_mcu9t5v0__nand2_1
X_10829_ _10829_/A1 _09749_/B _10829_/B _20066_/D VSS VSS VSS VSS gf180mcu_fd_sc_mcu9t5v0__oai21_1
X_13617_ _19286_/Q _13419_/B _13622_/B VSS _13617_/VNW VSS VSS gf180mcu_fd_sc_mcu9t5v0__nand2_1
X_14597_ _19176_/Q _19475_/Q _14715_/S _19475_/D VSS VSS VSS VSS gf180mcu_fd_sc_mcu9t5v0__mux2_1
X_16336_ _16478_/A1 _16336_/A2 _16865_/S wire37/I VSS VSS VSS VSS gf180mcu_fd_sc_mcu9t5v0__oai21_4
X_13548_ _13548_/A1 _13548_/A2 _13548_/B _19270_/D VSS _13548_/VNW VSS VSS gf180mcu_fd_sc_mcu9t5v0__oai21_1
X_19124_ _19124_/D _20020_/RN clkload28/I _19124_/Q VSS VSS VSS VSS gf180mcu_fd_sc_mcu9t5v0__dffrnq_1
X_16267_ _16267_/A1 _16424_/B _16268_/I1 VSS VSS VSS VSS gf180mcu_fd_sc_mcu9t5v0__nand2_1
X_19055_ _19055_/D _20143_/RN _19806_/CLK _19055_/Q VSS VSS VSS VSS gf180mcu_fd_sc_mcu9t5v0__dffrnq_1
X_13479_ _13461_/Z _13480_/A2 _13640_/B _13482_/A1 VSS VSS VSS VSS gf180mcu_fd_sc_mcu9t5v0__nand3_1
X_15218_ _15218_/I0 _19723_/Q _15417_/S _19723_/D VSS VSS VSS VSS gf180mcu_fd_sc_mcu9t5v0__mux2_1
X_18006_ _18022_/I0 _18891_/Q _18021_/S _18891_/D VSS VSS VSS VSS gf180mcu_fd_sc_mcu9t5v0__mux2_1
X_16198_ _10064_/S _16198_/A2 _16198_/B _16198_/C _16512_/A1 VSS VSS VSS VSS gf180mcu_fd_sc_mcu9t5v0__aoi211_4
XTAP_TAPCELL_ROW_302_7362 VSS VSS gf180mcu_fd_sc_mcu9t5v0__filltie
X_15149_ _19691_/Q _19531_/Q wire108/Z _19691_/D VSS _15149_/VNW VSS VSS gf180mcu_fd_sc_mcu9t5v0__mux2_1
XTAP_TAPCELL_ROW_302_7384 VSS VSS gf180mcu_fd_sc_mcu9t5v0__filltie
XTAP_TAPCELL_ROW_302_7373 VSS VSS gf180mcu_fd_sc_mcu9t5v0__filltie
X_19957_ _19957_/D _20021_/RN clkload46/I _19957_/Q VSS VSS VSS VSS gf180mcu_fd_sc_mcu9t5v0__dffrnq_1
XTAP_TAPCELL_ROW_294_7163 VSS VSS gf180mcu_fd_sc_mcu9t5v0__filltie
XTAP_TAPCELL_ROW_294_7152 VSS VSS gf180mcu_fd_sc_mcu9t5v0__filltie
X_09710_ _20143_/Q _09758_/B _10821_/B VSS _09710_/VNW VSS VSS gf180mcu_fd_sc_mcu9t5v0__and2_4
XTAP_TAPCELL_ROW_36_1963 VSS VSS gf180mcu_fd_sc_mcu9t5v0__filltie
X_18908_ _18908_/D _20060_/RN clkload10/I _18908_/Q VSS VSS VSS VSS gf180mcu_fd_sc_mcu9t5v0__dffrnq_1
XTAP_TAPCELL_ROW_36_1974 VSS VSS gf180mcu_fd_sc_mcu9t5v0__filltie
XTAP_TAPCELL_ROW_36_1985 VSS VSS gf180mcu_fd_sc_mcu9t5v0__filltie
X_19888_ _19888_/D _20144_/RN clkload38/I _19888_/Q VSS VSS VSS VSS gf180mcu_fd_sc_mcu9t5v0__dffrnq_1
XTAP_TAPCELL_ROW_121_4301 VSS VSS gf180mcu_fd_sc_mcu9t5v0__filltie
XTAP_TAPCELL_ROW_32_1849 VSS VSS gf180mcu_fd_sc_mcu9t5v0__filltie
XTAP_TAPCELL_ROW_315_7734 VSS VSS gf180mcu_fd_sc_mcu9t5v0__filltie
XTAP_TAPCELL_ROW_290_7049 VSS VSS gf180mcu_fd_sc_mcu9t5v0__filltie
XTAP_TAPCELL_ROW_315_7723 VSS VSS gf180mcu_fd_sc_mcu9t5v0__filltie
XTAP_TAPCELL_ROW_290_7038 VSS VSS gf180mcu_fd_sc_mcu9t5v0__filltie
XPHY_EDGE_ROW_246_Left_569 VSS VSS gf180mcu_fd_sc_mcu9t5v0__endcap
X_09641_ wire301/Z _17765_/A1 _09646_/A3 _09642_/A3 VSS VSS VSS VSS gf180mcu_fd_sc_mcu9t5v0__nand3_1
XTAP_TAPCELL_ROW_121_4323 VSS VSS gf180mcu_fd_sc_mcu9t5v0__filltie
XTAP_TAPCELL_ROW_121_4312 VSS VSS gf180mcu_fd_sc_mcu9t5v0__filltie
X_18839_ _18839_/D _20055_/RN clkload33/I _18839_/Q VSS VSS VSS VSS gf180mcu_fd_sc_mcu9t5v0__dffrnq_1
XTAP_TAPCELL_ROW_315_7745 VSS VSS gf180mcu_fd_sc_mcu9t5v0__filltie
X_09572_ _20026_/Q _09573_/A2 _10803_/C VSS _13613_/VNW VSS VSS gf180mcu_fd_sc_mcu9t5v0__and2_1
XTAP_TAPCELL_ROW_119_4263 VSS VSS gf180mcu_fd_sc_mcu9t5v0__filltie
XTAP_TAPCELL_ROW_119_4252 VSS VSS gf180mcu_fd_sc_mcu9t5v0__filltie
XPHY_EDGE_ROW_255_Left_578 VSS VSS gf180mcu_fd_sc_mcu9t5v0__endcap
XTAP_TAPCELL_ROW_115_4149 VSS VSS gf180mcu_fd_sc_mcu9t5v0__filltie
XTAP_TAPCELL_ROW_115_4138 VSS VSS gf180mcu_fd_sc_mcu9t5v0__filltie
XPHY_EDGE_ROW_164_3_Right_279 VSS VSS gf180mcu_fd_sc_mcu9t5v0__endcap
X_09908_ _19213_/Q wire172/Z _10172_/A2 _19197_/Q wire285/I _19253_/Q _09981_/A1 VSS
+ _10141_/VNW VSS VSS gf180mcu_fd_sc_mcu9t5v0__aoi222_1
XPHY_EDGE_ROW_264_Left_587 VSS VSS gf180mcu_fd_sc_mcu9t5v0__endcap
XTAP_TAPCELL_ROW_277_6693 VSS VSS gf180mcu_fd_sc_mcu9t5v0__filltie
XTAP_TAPCELL_ROW_277_6682 VSS VSS gf180mcu_fd_sc_mcu9t5v0__filltie
XPHY_EDGE_ROW_230_Right_157 VSS VSS gf180mcu_fd_sc_mcu9t5v0__endcap
X_09839_ _18835_/Q _09852_/A2 _17621_/A1 VSS VSS VSS VSS gf180mcu_fd_sc_mcu9t5v0__nor2_1
X_20028_ _20031_/Q _20028_/RN clkload45/I _20028_/Q VSS VSS VSS VSS gf180mcu_fd_sc_mcu9t5v0__dffrnq_1
XTAP_TAPCELL_ROW_273_6568 VSS VSS gf180mcu_fd_sc_mcu9t5v0__filltie
XTAP_TAPCELL_ROW_104_3842 VSS VSS gf180mcu_fd_sc_mcu9t5v0__filltie
X_12850_ _19767_/Q _12848_/Z _12853_/A2 VSS _12850_/VNW VSS VSS gf180mcu_fd_sc_mcu9t5v0__nor2_1
XTAP_TAPCELL_ROW_104_3831 VSS VSS gf180mcu_fd_sc_mcu9t5v0__filltie
XTAP_TAPCELL_ROW_273_6579 VSS VSS gf180mcu_fd_sc_mcu9t5v0__filltie
X_11801_ _18271_/Q _12340_/S _11804_/A1 VSS VSS VSS VSS gf180mcu_fd_sc_mcu9t5v0__nor2_1
XTAP_TAPCELL_ROW_104_3853 VSS VSS gf180mcu_fd_sc_mcu9t5v0__filltie
XTAP_TAPCELL_ROW_100_3739 VSS VSS gf180mcu_fd_sc_mcu9t5v0__filltie
X_14520_ _19464_/Q _14766_/A2 _14521_/B VSS VSS VSS VSS gf180mcu_fd_sc_mcu9t5v0__nand2_1
X_12781_ _12781_/A1 _12781_/A2 _12781_/B _12781_/C _12783_/A3 VSS VSS VSS VSS gf180mcu_fd_sc_mcu9t5v0__aoi211_1
XTAP_TAPCELL_ROW_100_3728 VSS VSS gf180mcu_fd_sc_mcu9t5v0__filltie
X_11732_ _18300_/Q _18284_/Q _18236_/Q _18220_/Q _12046_/S _12208_/C _11732_/Z VSS
+ VSS VSS VSS gf180mcu_fd_sc_mcu9t5v0__mux4_1
XPHY_EDGE_ROW_148_3_Left_806 VSS VSS gf180mcu_fd_sc_mcu9t5v0__endcap
XTAP_TAPCELL_ROW_286_6929 VSS VSS gf180mcu_fd_sc_mcu9t5v0__filltie
XPHY_EDGE_ROW_273_Left_596 VSS VSS gf180mcu_fd_sc_mcu9t5v0__endcap
XPHY_EDGE_ROW_175_1_Right_759 VSS VSS gf180mcu_fd_sc_mcu9t5v0__endcap
XTAP_TAPCELL_ROW_42_2134 VSS VSS gf180mcu_fd_sc_mcu9t5v0__filltie
X_11663_ _12649_/A2 _11663_/A2 _11663_/A3 _11675_/A2 VSS VSS VSS VSS gf180mcu_fd_sc_mcu9t5v0__nand3_1
XTAP_TAPCELL_ROW_42_2145 VSS VSS gf180mcu_fd_sc_mcu9t5v0__filltie
X_14451_ _14452_/A1 _14703_/A1 _14590_/B _14455_/B VSS VSS VSS VSS gf180mcu_fd_sc_mcu9t5v0__aoi21_1
X_17170_ _18461_/Q _18445_/Q _17260_/S _17170_/Z VSS _17170_/VNW VSS VSS gf180mcu_fd_sc_mcu9t5v0__mux2_1
X_10614_ _17404_/S _18343_/Q _10617_/A2 VSS _10614_/VNW VSS VSS gf180mcu_fd_sc_mcu9t5v0__nor2_1
X_13402_ _19776_/Q _13402_/A2 _13422_/A2 VSS _13422_/VNW VSS VSS gf180mcu_fd_sc_mcu9t5v0__nor2_1
X_14382_ _19446_/Q _14546_/S _14383_/A2 VSS VSS VSS VSS gf180mcu_fd_sc_mcu9t5v0__nor2_1
X_16121_ _18170_/Q _16747_/A2 _16747_/A3 _16125_/B VSS VSS VSS VSS gf180mcu_fd_sc_mcu9t5v0__nand3_1
X_13333_ _13333_/A1 _13333_/A2 _13599_/B _13333_/Z VSS _13598_/VNW VSS VSS gf180mcu_fd_sc_mcu9t5v0__and3_1
X_11594_ _18848_/Q _18847_/Q _18836_/Q _11594_/Z VSS VSS VSS VSS gf180mcu_fd_sc_mcu9t5v0__mux2_1
X_10545_ _20104_/Q _17407_/C _10546_/A3 VSS VSS VSS VSS gf180mcu_fd_sc_mcu9t5v0__nand2_1
Xclkbuf_leaf_21_clk_regs clkload4/I _20129_/CLK VSS VSS VSS VSS gf180mcu_fd_sc_mcu9t5v0__clkbuf_8
X_16052_ _19235_/Q _16744_/A2 wire71/Z _16054_/A2 VSS VSS VSS VSS gf180mcu_fd_sc_mcu9t5v0__nor3_1
X_10476_ _19949_/Q wire216/Z _10655_/B _10477_/B2 VSS VSS VSS VSS gf180mcu_fd_sc_mcu9t5v0__aoi21_1
XPHY_EDGE_ROW_144_1_Left_467 VSS VSS gf180mcu_fd_sc_mcu9t5v0__endcap
X_13264_ _13265_/A1 _13265_/A2 _13265_/B _13264_/Z VSS _13264_/VNW VSS VSS gf180mcu_fd_sc_mcu9t5v0__and3_1
XTAP_TAPCELL_ROW_55_2506 VSS VSS gf180mcu_fd_sc_mcu9t5v0__filltie
X_13195_ _13195_/A1 _13195_/A2 _13195_/B _13214_/A1 VSS VSS VSS VSS gf180mcu_fd_sc_mcu9t5v0__oai21_1
Xrst_tree_leaf_26 rst_tree_mid_3/Z _20057_/RN VSS VSS VSS VSS gf180mcu_fd_sc_mcu9t5v0__clkbuf_16
Xrst_tree_leaf_15 rst_tree_mid_1/Z _20068_/RN VSS VSS VSS VSS gf180mcu_fd_sc_mcu9t5v0__clkbuf_16
Xrst_tree_leaf_37 rst_tree_mid_4/Z _20046_/RN VSS VSS VSS VSS gf180mcu_fd_sc_mcu9t5v0__clkbuf_16
X_12215_ _19132_/Q _12311_/B _12216_/B VSS _14514_/VNW VSS VSS gf180mcu_fd_sc_mcu9t5v0__nand2_1
X_15003_ _15003_/A1 _15003_/A2 _15015_/A1 VSS _15003_/VNW VSS VSS gf180mcu_fd_sc_mcu9t5v0__nor2_1
X_12146_ _12071_/B _12146_/A2 _12146_/B _12147_/I1 VSS _12146_/VNW VSS VSS gf180mcu_fd_sc_mcu9t5v0__aoi21_1
X_19811_ _19811_/D _20067_/RN clkload37/I _19811_/Q VSS VSS VSS VSS gf180mcu_fd_sc_mcu9t5v0__dffrnq_1
Xrst_tree_leaf_59 rst_tree_mid_7/Z _19960_/RN VSS VSS VSS VSS gf180mcu_fd_sc_mcu9t5v0__clkbuf_16
Xrst_tree_leaf_48 rst_tree_mid_6/Z _20035_/RN VSS VSS VSS VSS gf180mcu_fd_sc_mcu9t5v0__clkbuf_16
XTAP_TAPCELL_ROW_200_2_8222 VSS VSS gf180mcu_fd_sc_mcu9t5v0__filltie
X_16954_ _16954_/I0 _18468_/Q _16960_/S _18468_/D VSS VSS VSS VSS gf180mcu_fd_sc_mcu9t5v0__mux2_1
X_19742_ _19742_/D _20062_/RN clkload44/I _19742_/Q VSS VSS VSS VSS gf180mcu_fd_sc_mcu9t5v0__dffrnq_1
X_12077_ _18910_/Q _12077_/A2 _12099_/A2 VSS VSS VSS VSS gf180mcu_fd_sc_mcu9t5v0__xnor2_1
X_15905_ _20114_/Q _19250_/Q _15905_/S _20114_/D VSS VSS VSS VSS gf180mcu_fd_sc_mcu9t5v0__mux2_1
X_16885_ _19254_/Q _16641_/B _16895_/S _16885_/Z VSS VSS VSS VSS gf180mcu_fd_sc_mcu9t5v0__mux2_1
X_19673_ _19673_/D _20057_/RN clkload45/I _19673_/Q VSS VSS VSS VSS gf180mcu_fd_sc_mcu9t5v0__dffrnq_1
X_11028_ _19061_/Q _19029_/Q _11051_/S _19029_/D VSS VSS VSS VSS gf180mcu_fd_sc_mcu9t5v0__mux2_1
X_18624_ _18624_/D _20028_/RN _20099_/CLK _18624_/Q VSS VSS VSS VSS gf180mcu_fd_sc_mcu9t5v0__dffrnq_1
X_15836_ _20144_/Q _09698_/B _15837_/A2 VSS _15836_/VNW VSS VSS gf180mcu_fd_sc_mcu9t5v0__nand2_1
X_15767_ input5/Z _19937_/Q _15770_/S _19937_/D VSS VSS VSS VSS gf180mcu_fd_sc_mcu9t5v0__mux2_1
X_18555_ _18555_/D _20055_/RN clkload38/I _18555_/Q VSS VSS VSS VSS gf180mcu_fd_sc_mcu9t5v0__dffrnq_1
X_12979_ _12734_/Z _12979_/A2 _12991_/A2 VSS _12979_/VNW VSS VSS gf180mcu_fd_sc_mcu9t5v0__nand2_1
X_17506_ _18611_/Q _19252_/Q _17513_/S _18611_/D VSS VSS VSS VSS gf180mcu_fd_sc_mcu9t5v0__mux2_1
X_18486_ _18486_/D clkload82/I _18486_/Q VSS VSS VSS VSS gf180mcu_fd_sc_mcu9t5v0__dffq_1
X_15698_ _19915_/Q _19916_/Q _19917_/Q _15701_/B1 VSS _15698_/VNW VSS VSS gf180mcu_fd_sc_mcu9t5v0__oai21_1
X_14718_ _19542_/Q _14715_/S _14719_/B VSS VSS VSS VSS gf180mcu_fd_sc_mcu9t5v0__nand2_1
X_17437_ _18566_/Q _17431_/S _17438_/B VSS _17551_/VNW VSS VSS gf180mcu_fd_sc_mcu9t5v0__nor2_1
X_14649_ _14648_/Z _19524_/Q _14715_/S _19524_/D VSS VSS VSS VSS gf180mcu_fd_sc_mcu9t5v0__mux2_1
XANTENNA_16 output13/I VSS VSS VSS VSS gf180mcu_fd_sc_mcu9t5v0__antenna
XPHY_EDGE_ROW_120_Right_120 VSS VSS gf180mcu_fd_sc_mcu9t5v0__endcap
XTAP_TAPCELL_ROW_25_1664 VSS VSS gf180mcu_fd_sc_mcu9t5v0__filltie
X_17368_ _20121_/Q wire168/Z _17409_/B _17370_/A2 VSS VSS VSS VSS gf180mcu_fd_sc_mcu9t5v0__oai21_1
X_19107_ _19107_/D _20067_/RN clkload10/I _19107_/Q VSS VSS VSS VSS gf180mcu_fd_sc_mcu9t5v0__dffrnq_1
XTAP_TAPCELL_ROW_25_1675 VSS VSS gf180mcu_fd_sc_mcu9t5v0__filltie
XTAP_TAPCELL_ROW_304_7424 VSS VSS gf180mcu_fd_sc_mcu9t5v0__filltie
X_17299_ _17299_/A1 _17299_/A2 _17299_/B1 _17299_/B2 _17304_/A2 VSS VSS VSS VSS gf180mcu_fd_sc_mcu9t5v0__aoi22_1
X_16319_ _19236_/Q _16058_/B _16833_/S _16319_/Z VSS VSS VSS VSS gf180mcu_fd_sc_mcu9t5v0__mux2_1
XTAP_TAPCELL_ROW_110_4013 VSS VSS gf180mcu_fd_sc_mcu9t5v0__filltie
XTAP_TAPCELL_ROW_110_4002 VSS VSS gf180mcu_fd_sc_mcu9t5v0__filltie
XTAP_TAPCELL_ROW_304_7435 VSS VSS gf180mcu_fd_sc_mcu9t5v0__filltie
XPHY_EDGE_ROW_194_3_Left_852 VSS VSS gf180mcu_fd_sc_mcu9t5v0__endcap
X_19038_ _19038_/D _20062_/RN _19806_/CLK _19038_/Q VSS VSS VSS VSS gf180mcu_fd_sc_mcu9t5v0__dffrnq_1
XTAP_TAPCELL_ROW_296_7214 VSS VSS gf180mcu_fd_sc_mcu9t5v0__filltie
XTAP_TAPCELL_ROW_296_7203 VSS VSS gf180mcu_fd_sc_mcu9t5v0__filltie
XTAP_TAPCELL_ROW_209_4821 VSS VSS gf180mcu_fd_sc_mcu9t5v0__filltie
XTAP_TAPCELL_ROW_209_4810 VSS VSS gf180mcu_fd_sc_mcu9t5v0__filltie
XPHY_EDGE_ROW_137_1_Right_721 VSS VSS gf180mcu_fd_sc_mcu9t5v0__endcap
X_09624_ _20001_/Q input9/Z _20008_/Q _09658_/A2 _09625_/I VSS VSS VSS VSS gf180mcu_fd_sc_mcu9t5v0__aoi22_1
Xmax_cap29 wire28/I _16994_/S VSS _16491_/VNW VSS VSS gf180mcu_fd_sc_mcu9t5v0__buf_4
XTAP_TAPCELL_ROW_188_2_8180 VSS VSS gf180mcu_fd_sc_mcu9t5v0__filltie
X_09555_ _18825_/Q _18826_/Q _17851_/A1 _09556_/A4 VSS VSS VSS VSS gf180mcu_fd_sc_mcu9t5v0__nand3_1
X_09486_ _09395_/I _11788_/B _12543_/B1 VSS VSS VSS VSS gf180mcu_fd_sc_mcu9t5v0__nor2_2
XTAP_TAPCELL_ROW_281_6804 VSS VSS gf180mcu_fd_sc_mcu9t5v0__filltie
XTAP_TAPCELL_ROW_266_6383 VSS VSS gf180mcu_fd_sc_mcu9t5v0__filltie
XTAP_TAPCELL_ROW_266_6372 VSS VSS gf180mcu_fd_sc_mcu9t5v0__filltie
XTAP_TAPCELL_ROW_95_3587 VSS VSS gf180mcu_fd_sc_mcu9t5v0__filltie
X_10330_ _10330_/A1 _10330_/A2 _10330_/B _17409_/B _10331_/C VSS VSS VSS VSS gf180mcu_fd_sc_mcu9t5v0__oai211_1
XTAP_TAPCELL_ROW_266_6394 VSS VSS gf180mcu_fd_sc_mcu9t5v0__filltie
XTAP_TAPCELL_ROW_95_3598 VSS VSS gf180mcu_fd_sc_mcu9t5v0__filltie
XTAP_TAPCELL_ROW_262_6269 VSS VSS gf180mcu_fd_sc_mcu9t5v0__filltie
X_10261_ _10261_/A1 _10261_/A2 _10261_/B1 _10261_/B2 _10261_/ZN VSS VSS VSS VSS gf180mcu_fd_sc_mcu9t5v0__aoi22_4
X_12000_ _18328_/Q _12345_/B _12347_/C _12000_/C _12001_/A3 VSS _12000_/VNW VSS VSS
+ gf180mcu_fd_sc_mcu9t5v0__oai211_1
XPHY_EDGE_ROW_139_2_Right_870 VSS VSS gf180mcu_fd_sc_mcu9t5v0__endcap
XTAP_TAPCELL_ROW_279_6755 VSS VSS gf180mcu_fd_sc_mcu9t5v0__filltie
XTAP_TAPCELL_ROW_279_6744 VSS VSS gf180mcu_fd_sc_mcu9t5v0__filltie
XTAP_TAPCELL_ROW_279_6733 VSS VSS gf180mcu_fd_sc_mcu9t5v0__filltie
X_10192_ _10192_/I _10201_/B VSS VSS VSS VSS gf180mcu_fd_sc_mcu9t5v0__clkinv_1
XTAP_TAPCELL_ROW_106_3904 VSS VSS gf180mcu_fd_sc_mcu9t5v0__filltie
X_13951_ _13951_/A1 _13951_/A2 _13951_/B _13988_/A1 VSS _13965_/VNW VSS VSS gf180mcu_fd_sc_mcu9t5v0__oai21_1
X_12902_ _19742_/Q _19807_/Q _12948_/S _12902_/Z VSS VSS VSS VSS gf180mcu_fd_sc_mcu9t5v0__mux2_1
XTAP_TAPCELL_ROW_48_2310 VSS VSS gf180mcu_fd_sc_mcu9t5v0__filltie
X_16670_ _18359_/Q _16670_/I1 _16670_/S _18359_/D VSS VSS VSS VSS gf180mcu_fd_sc_mcu9t5v0__mux2_1
XPHY_EDGE_ROW_158_2_Left_670 VSS VSS gf180mcu_fd_sc_mcu9t5v0__endcap
X_13882_ _19318_/Q _19297_/Q _13917_/B2 VSS VSS VSS VSS gf180mcu_fd_sc_mcu9t5v0__nand2_1
X_15621_ _15623_/A2 _15621_/A2 _15622_/A2 VSS VSS VSS VSS gf180mcu_fd_sc_mcu9t5v0__nand2_1
X_12833_ _19732_/Q _19797_/Q _12948_/S _12833_/Z VSS VSS VSS VSS gf180mcu_fd_sc_mcu9t5v0__mux2_1
X_18340_ _18340_/D clkload80/I _18340_/Q VSS VSS VSS VSS gf180mcu_fd_sc_mcu9t5v0__dffq_1
XPHY_EDGE_ROW_281_Left_604 VSS VSS gf180mcu_fd_sc_mcu9t5v0__endcap
X_15552_ _15552_/A1 _20052_/D _15552_/B _19870_/D VSS _15552_/VNW VSS VSS gf180mcu_fd_sc_mcu9t5v0__oai21_1
X_12764_ _19754_/Q _12763_/Z _12781_/C VSS VSS VSS VSS gf180mcu_fd_sc_mcu9t5v0__and2_1
X_11715_ _18299_/Q _18283_/Q _12046_/S _11715_/Z VSS _11716_/VNW VSS VSS gf180mcu_fd_sc_mcu9t5v0__mux2_1
X_18271_ _18271_/D _20099_/CLK _18271_/Q VSS VSS VSS VSS gf180mcu_fd_sc_mcu9t5v0__dffq_4
X_15483_ _15483_/A1 _17422_/S _19829_/D VSS VSS VSS VSS gf180mcu_fd_sc_mcu9t5v0__nand2_1
XTAP_TAPCELL_ROW_251_5962 VSS VSS gf180mcu_fd_sc_mcu9t5v0__filltie
X_14503_ _19164_/Q _19130_/Q _14505_/A1 VSS _14503_/VNW VSS VSS gf180mcu_fd_sc_mcu9t5v0__nor2_1
X_17222_ _20129_/Q _17326_/A1 wire168/I _17222_/C _17224_/A2 VSS VSS VSS VSS gf180mcu_fd_sc_mcu9t5v0__oai211_1
XTAP_TAPCELL_ROW_251_5984 VSS VSS gf180mcu_fd_sc_mcu9t5v0__filltie
XTAP_TAPCELL_ROW_251_5973 VSS VSS gf180mcu_fd_sc_mcu9t5v0__filltie
X_12695_ _12695_/A1 _12724_/C _12693_/Z _12714_/B1 _19184_/D VSS VSS VSS VSS gf180mcu_fd_sc_mcu9t5v0__aoi22_1
X_11646_ _11659_/A1 _11659_/A2 _11654_/C _12652_/A2 VSS VSS VSS VSS gf180mcu_fd_sc_mcu9t5v0__aoi21_1
X_14434_ _19120_/Q wire199/Z _14704_/S _14434_/C _14435_/A2 VSS VSS VSS VSS gf180mcu_fd_sc_mcu9t5v0__oai211_1
X_17153_ _18348_/Q _17322_/A2 _17255_/B1 _18364_/Q _17406_/C _17154_/B VSS _17153_/VNW
+ VSS VSS gf180mcu_fd_sc_mcu9t5v0__aoi221_1
X_11577_ _18891_/Q _12147_/S _11985_/B _11577_/C _11579_/A1 VSS VSS VSS VSS gf180mcu_fd_sc_mcu9t5v0__oai211_1
X_14365_ _14365_/I0 _19435_/Q _14367_/S _19435_/D VSS VSS VSS VSS gf180mcu_fd_sc_mcu9t5v0__mux2_1
X_10528_ _18966_/Q wire165/Z _10530_/A2 VSS VSS VSS VSS gf180mcu_fd_sc_mcu9t5v0__nand2_1
X_17084_ _17084_/A1 _17084_/A2 _17275_/C _17089_/C VSS VSS VSS VSS gf180mcu_fd_sc_mcu9t5v0__aoi21_1
X_16104_ _16198_/B _16197_/C _16105_/A1 _16478_/A1 VSS VSS VSS VSS gf180mcu_fd_sc_mcu9t5v0__nand3_4
X_13316_ _19738_/Q _13316_/A2 _13316_/B _13337_/A1 VSS _13316_/VNW VSS VSS gf180mcu_fd_sc_mcu9t5v0__oai21_1
X_14296_ _13986_/Z _19369_/Q _14304_/S _19369_/D VSS VSS VSS VSS gf180mcu_fd_sc_mcu9t5v0__mux2_1
X_16035_ _18678_/Q _18775_/Q _16619_/S _16035_/Z VSS VSS VSS VSS gf180mcu_fd_sc_mcu9t5v0__mux2_1
X_13247_ _12843_/B _19766_/Q _13248_/B _13250_/B1 VSS VSS VSS VSS gf180mcu_fd_sc_mcu9t5v0__nor3_1
XPHY_EDGE_ROW_290_Left_613 VSS VSS gf180mcu_fd_sc_mcu9t5v0__endcap
X_10459_ _17404_/S _11847_/A1 _10459_/B _10459_/C _10460_/C VSS VSS VSS VSS gf180mcu_fd_sc_mcu9t5v0__aoi211_1
XTAP_TAPCELL_ROW_245_5799 VSS VSS gf180mcu_fd_sc_mcu9t5v0__filltie
X_13178_ _13184_/A1 _13194_/A2 _13179_/A2 VSS VSS VSS VSS gf180mcu_fd_sc_mcu9t5v0__nor2_1
X_12129_ _18726_/Q _12527_/A2 _12146_/A2 VSS VSS VSS VSS gf180mcu_fd_sc_mcu9t5v0__nand2_1
X_17986_ _18873_/Q _18036_/I0 wire128/Z _18873_/D VSS VSS VSS VSS gf180mcu_fd_sc_mcu9t5v0__mux2_1
XTAP_TAPCELL_ROW_33_1900 VSS VSS gf180mcu_fd_sc_mcu9t5v0__filltie
X_16937_ _19247_/Q _16592_/B _16949_/S _16937_/Z VSS VSS VSS VSS gf180mcu_fd_sc_mcu9t5v0__mux2_1
X_19725_ _19725_/D _20045_/RN clkload36/I _19725_/Q VSS VSS VSS VSS gf180mcu_fd_sc_mcu9t5v0__dffrnq_1
XTAP_TAPCELL_ROW_18_1490 VSS VSS gf180mcu_fd_sc_mcu9t5v0__filltie
XTAP_TAPCELL_ROW_14_1354 VSS VSS gf180mcu_fd_sc_mcu9t5v0__filltie
XTAP_TAPCELL_ROW_14_1365 VSS VSS gf180mcu_fd_sc_mcu9t5v0__filltie
XTAP_TAPCELL_ROW_14_1376 VSS VSS gf180mcu_fd_sc_mcu9t5v0__filltie
X_16868_ _18426_/Q _16867_/Z wire38/I _18426_/D VSS _16868_/VNW VSS VSS gf180mcu_fd_sc_mcu9t5v0__mux2_1
X_19656_ _19656_/D _20040_/RN clkload35/I _19656_/Q VSS VSS VSS VSS gf180mcu_fd_sc_mcu9t5v0__dffrnq_1
X_18607_ _18607_/D clkload60/I _18607_/Q VSS VSS VSS VSS gf180mcu_fd_sc_mcu9t5v0__dffq_1
X_16799_ _19281_/Q _16606_/B _16949_/S _16799_/Z VSS VSS VSS VSS gf180mcu_fd_sc_mcu9t5v0__mux2_1
X_15819_ input8/Z _19988_/Q _15819_/S _19988_/D VSS VSS VSS VSS gf180mcu_fd_sc_mcu9t5v0__mux2_1
X_19587_ _19587_/D _20035_/RN clkload19/I _19587_/Q VSS VSS VSS VSS gf180mcu_fd_sc_mcu9t5v0__dffrnq_1
X_18538_ _18538_/D _20038_/RN clkload58/I _18538_/Q VSS VSS VSS VSS gf180mcu_fd_sc_mcu9t5v0__dffrnq_1
X_09340_ _19203_/Q _16051_/A1 VSS VSS VSS VSS gf180mcu_fd_sc_mcu9t5v0__clkinv_1
XTAP_TAPCELL_ROW_27_1715 VSS VSS gf180mcu_fd_sc_mcu9t5v0__filltie
X_09271_ _19931_/Q _15759_/A1 VSS _09271_/VNW VSS VSS gf180mcu_fd_sc_mcu9t5v0__clkinv_1
XTAP_TAPCELL_ROW_27_1726 VSS VSS gf180mcu_fd_sc_mcu9t5v0__filltie
XTAP_TAPCELL_ROW_27_1737 VSS VSS gf180mcu_fd_sc_mcu9t5v0__filltie
X_18469_ _18469_/D clkload78/I _18469_/Q VSS VSS VSS VSS gf180mcu_fd_sc_mcu9t5v0__dffq_1
XTAP_TAPCELL_ROW_90_3451 VSS VSS gf180mcu_fd_sc_mcu9t5v0__filltie
XTAP_TAPCELL_ROW_90_3462 VSS VSS gf180mcu_fd_sc_mcu9t5v0__filltie
XPHY_EDGE_ROW_138_1_Right_722 VSS VSS gf180mcu_fd_sc_mcu9t5v0__endcap
XTAP_TAPCELL_ROW_88_3391 VSS VSS gf180mcu_fd_sc_mcu9t5v0__filltie
XTAP_TAPCELL_ROW_270_6505 VSS VSS gf180mcu_fd_sc_mcu9t5v0__filltie
XTAP_TAPCELL_ROW_255_6095 VSS VSS gf180mcu_fd_sc_mcu9t5v0__filltie
XTAP_TAPCELL_ROW_255_6084 VSS VSS gf180mcu_fd_sc_mcu9t5v0__filltie
XTAP_TAPCELL_ROW_255_6073 VSS VSS gf180mcu_fd_sc_mcu9t5v0__filltie
X_09607_ _20055_/Q _20012_/Q _17425_/A2 _09613_/A2 VSS wire208/VNW VSS VSS gf180mcu_fd_sc_mcu9t5v0__nand3_1
XTAP_TAPCELL_ROW_84_3299 VSS VSS gf180mcu_fd_sc_mcu9t5v0__filltie
XTAP_TAPCELL_ROW_84_3288 VSS VSS gf180mcu_fd_sc_mcu9t5v0__filltie
Xwire71 wire71/I wire71/Z VSS VSS VSS VSS gf180mcu_fd_sc_mcu9t5v0__buf_4
X_09538_ _09538_/A1 _09538_/A2 _17763_/A2 _09538_/A4 _09539_/B VSS _09538_/VNW VSS
+ VSS gf180mcu_fd_sc_mcu9t5v0__nand4_1
X_11500_ _11526_/B _11500_/A2 _11500_/B1 _11500_/B2 _11788_/B _11501_/B2 VSS VSS VSS
+ VSS gf180mcu_fd_sc_mcu9t5v0__aoi221_2
XTAP_TAPCELL_ROW_208_3_8251 VSS VSS gf180mcu_fd_sc_mcu9t5v0__filltie
XTAP_TAPCELL_ROW_268_6434 VSS VSS gf180mcu_fd_sc_mcu9t5v0__filltie
XPHY_EDGE_ROW_200_3_Right_315 VSS VSS gf180mcu_fd_sc_mcu9t5v0__endcap
XTAP_TAPCELL_ROW_196_3_8209 VSS VSS gf180mcu_fd_sc_mcu9t5v0__filltie
XTAP_TAPCELL_ROW_97_3649 VSS VSS gf180mcu_fd_sc_mcu9t5v0__filltie
X_09469_ _09496_/B _09469_/A2 _09469_/B _09469_/C _09473_/B VSS VSS VSS VSS gf180mcu_fd_sc_mcu9t5v0__aoi211_4
XTAP_TAPCELL_ROW_97_3638 VSS VSS gf180mcu_fd_sc_mcu9t5v0__filltie
XTAP_TAPCELL_ROW_268_6445 VSS VSS gf180mcu_fd_sc_mcu9t5v0__filltie
X_12480_ _18264_/Q _12615_/A2 _12482_/B1 VSS VSS VSS VSS gf180mcu_fd_sc_mcu9t5v0__nor2_1
X_11431_ _11429_/B _11430_/Z _11431_/B _11434_/A2 VSS _16945_/VNW VSS VSS gf180mcu_fd_sc_mcu9t5v0__oai21_1
X_11362_ _18491_/Q _11524_/S _11363_/C VSS VSS VSS VSS gf180mcu_fd_sc_mcu9t5v0__nor2_1
X_14150_ _19177_/Q _14149_/Z _14715_/S _14150_/Z VSS VSS VSS VSS gf180mcu_fd_sc_mcu9t5v0__mux2_1
X_10313_ _19943_/Q wire216/Z _10655_/B _10314_/B2 VSS _10313_/VNW VSS VSS gf180mcu_fd_sc_mcu9t5v0__aoi21_1
X_13101_ _19726_/Q _13101_/A2 _13103_/B VSS _13101_/VNW VSS VSS gf180mcu_fd_sc_mcu9t5v0__xnor2_1
XTAP_TAPCELL_ROW_37_2000 VSS VSS gf180mcu_fd_sc_mcu9t5v0__filltie
XTAP_TAPCELL_ROW_37_2011 VSS VSS gf180mcu_fd_sc_mcu9t5v0__filltie
X_11293_ _11293_/A1 _11293_/A2 _11788_/B _11294_/B2 VSS VSS VSS VSS gf180mcu_fd_sc_mcu9t5v0__aoi21_2
XTAP_TAPCELL_ROW_201_3_8227 VSS VSS gf180mcu_fd_sc_mcu9t5v0__filltie
X_14081_ _19321_/Q _19299_/Q _14081_/Z VSS VSS VSS VSS gf180mcu_fd_sc_mcu9t5v0__and2_1
X_10244_ _17411_/C _15470_/A1 _17231_/B VSS VSS VSS VSS gf180mcu_fd_sc_mcu9t5v0__nand2_1
XTAP_TAPCELL_ROW_166_1_4753 VSS VSS gf180mcu_fd_sc_mcu9t5v0__filltie
X_13032_ _13053_/B1 _13053_/B2 _13034_/A3 VSS VSS VSS VSS gf180mcu_fd_sc_mcu9t5v0__nor2_1
XTAP_TAPCELL_ROW_73_2992 VSS VSS gf180mcu_fd_sc_mcu9t5v0__filltie
XTAP_TAPCELL_ROW_73_2981 VSS VSS gf180mcu_fd_sc_mcu9t5v0__filltie
X_10175_ _10659_/C _10175_/A2 _10175_/B _10176_/C VSS _10175_/VNW VSS VSS gf180mcu_fd_sc_mcu9t5v0__aoi21_1
X_17840_ _19047_/Q _18817_/Q _17844_/S _18817_/D VSS _17840_/VNW VSS VSS gf180mcu_fd_sc_mcu9t5v0__mux2_1
XTAP_TAPCELL_ROW_240_5674 VSS VSS gf180mcu_fd_sc_mcu9t5v0__filltie
XTAP_TAPCELL_ROW_240_5663 VSS VSS gf180mcu_fd_sc_mcu9t5v0__filltie
X_17771_ _17771_/A1 _17773_/A2 _17771_/B _17779_/C _18760_/D VSS _17771_/VNW VSS VSS
+ gf180mcu_fd_sc_mcu9t5v0__aoi211_1
X_19510_ _19510_/D _20022_/RN clkload27/I _19510_/Q VSS VSS VSS VSS gf180mcu_fd_sc_mcu9t5v0__dffrnq_1
X_14983_ _14984_/A1 _14984_/A2 _14986_/B VSS VSS VSS VSS gf180mcu_fd_sc_mcu9t5v0__nor2_1
X_16722_ _16722_/A1 _16722_/A2 _16722_/A3 _16722_/B _18370_/D VSS VSS VSS VSS gf180mcu_fd_sc_mcu9t5v0__oai31_4
X_13934_ _13967_/A1 _13934_/A2 _13934_/A3 _13936_/A2 VSS VSS VSS VSS gf180mcu_fd_sc_mcu9t5v0__xnor3_1
X_16653_ _19256_/Q _16744_/A2 wire71/Z _16655_/A2 VSS _16654_/VNW VSS VSS gf180mcu_fd_sc_mcu9t5v0__nor3_1
X_19441_ _19441_/D _20145_/RN clkload15/I _19441_/Q VSS VSS VSS VSS gf180mcu_fd_sc_mcu9t5v0__dffrnq_1
X_13865_ _13866_/A1 _13866_/A2 _13869_/B VSS VSS VSS VSS gf180mcu_fd_sc_mcu9t5v0__nor2_1
X_15604_ _19886_/Q _19887_/Q _15605_/A2 VSS _15604_/VNW VSS VSS gf180mcu_fd_sc_mcu9t5v0__xnor2_1
X_12816_ _19761_/Q _12815_/Z _12816_/Z VSS VSS VSS VSS gf180mcu_fd_sc_mcu9t5v0__or2_1
X_19372_ _19372_/D _20140_/RN clkload20/I _19372_/Q VSS VSS VSS VSS gf180mcu_fd_sc_mcu9t5v0__dffrnq_1
X_18323_ _18323_/D _18324_/CLK _18323_/Q VSS VSS VSS VSS gf180mcu_fd_sc_mcu9t5v0__dffq_4
X_16584_ _16750_/A1 _16628_/A2 _16584_/B _16586_/A2 VSS VSS VSS VSS gf180mcu_fd_sc_mcu9t5v0__aoi21_1
X_13796_ _19320_/Q _19293_/Q _13823_/A2 VSS _13796_/VNW VSS VSS gf180mcu_fd_sc_mcu9t5v0__nand2_1
X_15535_ _19853_/Q _19836_/Q _15551_/S _19853_/D VSS VSS VSS VSS gf180mcu_fd_sc_mcu9t5v0__mux2_1
X_12747_ _19752_/Q _12746_/Z _12753_/B VSS _12749_/VNW VSS VSS gf180mcu_fd_sc_mcu9t5v0__and2_1
X_18254_ _18254_/D clkload72/I _18254_/Q VSS VSS VSS VSS gf180mcu_fd_sc_mcu9t5v0__dffq_1
X_15466_ _17411_/C _09849_/B _15466_/A3 _15466_/A4 _15474_/A3 VSS _15466_/VNW VSS
+ VSS gf180mcu_fd_sc_mcu9t5v0__nand4_1
X_12678_ _19180_/Q _12655_/S _12679_/B VSS _12679_/VNW VSS VSS gf180mcu_fd_sc_mcu9t5v0__nand2_1
XTAP_TAPCELL_ROW_22_1601 VSS VSS gf180mcu_fd_sc_mcu9t5v0__filltie
X_17205_ _17775_/A1 _17411_/C _17231_/A3 _17205_/B _17206_/B VSS _17208_/VNW VSS VSS
+ gf180mcu_fd_sc_mcu9t5v0__oai31_1
X_18185_ _18185_/D clkload64/I _18185_/Q VSS VSS VSS VSS gf180mcu_fd_sc_mcu9t5v0__dffq_1
X_11629_ _11654_/C _12670_/A2 _12664_/A1 VSS _12671_/VNW VSS VSS gf180mcu_fd_sc_mcu9t5v0__nand2_1
X_14417_ _19153_/Q _14417_/A2 _14428_/B VSS VSS VSS VSS gf180mcu_fd_sc_mcu9t5v0__nor2_1
X_17136_ _20125_/Q _17177_/B _17408_/B _17136_/C _17138_/A2 VSS VSS VSS VSS gf180mcu_fd_sc_mcu9t5v0__aoi211_1
X_15397_ _19682_/Q _19782_/Q _15417_/S _19782_/D VSS VSS VSS VSS gf180mcu_fd_sc_mcu9t5v0__mux2_1
X_14348_ _13986_/Z _19419_/Q _14352_/S _19419_/D VSS VSS VSS VSS gf180mcu_fd_sc_mcu9t5v0__mux2_1
X_17067_ _18529_/Q _16628_/B _17067_/S _18529_/D VSS VSS VSS VSS gf180mcu_fd_sc_mcu9t5v0__mux2_4
X_14279_ _14365_/I0 _19353_/Q _14285_/S _19353_/D VSS VSS VSS VSS gf180mcu_fd_sc_mcu9t5v0__mux2_1
X_16018_ _15996_/B _16018_/A2 _16018_/A3 _16018_/B _16019_/I1 VSS _16934_/VNW VSS
+ VSS gf180mcu_fd_sc_mcu9t5v0__oai31_1
XTAP_TAPCELL_ROW_16_1416 VSS VSS gf180mcu_fd_sc_mcu9t5v0__filltie
XTAP_TAPCELL_ROW_16_1427 VSS VSS gf180mcu_fd_sc_mcu9t5v0__filltie
XTAP_TAPCELL_ROW_189_3_8185 VSS VSS gf180mcu_fd_sc_mcu9t5v0__filltie
X_17969_ _17888_/B _17969_/A2 _17971_/A3 VSS _17969_/VNW VSS VSS gf180mcu_fd_sc_mcu9t5v0__nand2_1
X_19708_ _19708_/D _20028_/RN clkload36/I _19708_/Q VSS VSS VSS VSS gf180mcu_fd_sc_mcu9t5v0__dffrnq_1
X_19639_ _19639_/D _20023_/RN clkload20/I _19639_/Q VSS VSS VSS VSS gf180mcu_fd_sc_mcu9t5v0__dffrnq_1
X_09323_ _19012_/Q _10715_/A1 VSS VSS VSS VSS gf180mcu_fd_sc_mcu9t5v0__clkinv_1
X_09254_ _18848_/Q _17933_/B2 VSS VSS VSS VSS gf180mcu_fd_sc_mcu9t5v0__clkinv_1
XTAP_TAPCELL_ROW_135_4697 VSS VSS gf180mcu_fd_sc_mcu9t5v0__filltie
XTAP_TAPCELL_ROW_135_4686 VSS VSS gf180mcu_fd_sc_mcu9t5v0__filltie
X_09185_ _19156_/Q _14455_/A1 VSS VSS VSS VSS gf180mcu_fd_sc_mcu9t5v0__clkinv_1
XTAP_TAPCELL_ROW_92_3502 VSS VSS gf180mcu_fd_sc_mcu9t5v0__filltie
XTAP_TAPCELL_ROW_92_3524 VSS VSS gf180mcu_fd_sc_mcu9t5v0__filltie
XTAP_TAPCELL_ROW_92_3513 VSS VSS gf180mcu_fd_sc_mcu9t5v0__filltie
XTAP_TAPCELL_ROW_77_3092 VSS VSS gf180mcu_fd_sc_mcu9t5v0__filltie
XPHY_EDGE_ROW_157_3_Left_815 VSS VSS gf180mcu_fd_sc_mcu9t5v0__endcap
XPHY_EDGE_ROW_139_1_Right_723 VSS VSS gf180mcu_fd_sc_mcu9t5v0__endcap
XTAP_TAPCELL_ROW_257_6146 VSS VSS gf180mcu_fd_sc_mcu9t5v0__filltie
XTAP_TAPCELL_ROW_257_6135 VSS VSS gf180mcu_fd_sc_mcu9t5v0__filltie
XTAP_TAPCELL_ROW_86_3339 VSS VSS gf180mcu_fd_sc_mcu9t5v0__filltie
X_11980_ _18327_/Q _12299_/S _11981_/A3 VSS _16542_/VNW VSS VSS gf180mcu_fd_sc_mcu9t5v0__nor2_1
X_10931_ _18927_/Q _18934_/Q _10936_/B VSS VSS VSS VSS gf180mcu_fd_sc_mcu9t5v0__nand2_1
XTAP_TAPCELL_ROW_6_1150 VSS VSS gf180mcu_fd_sc_mcu9t5v0__filltie
XTAP_TAPCELL_ROW_6_1161 VSS VSS gf180mcu_fd_sc_mcu9t5v0__filltie
XPHY_EDGE_ROW_153_1_Left_476 VSS VSS gf180mcu_fd_sc_mcu9t5v0__endcap
XTAP_TAPCELL_ROW_2_1025 VSS VSS gf180mcu_fd_sc_mcu9t5v0__filltie
XTAP_TAPCELL_ROW_2_1036 VSS VSS gf180mcu_fd_sc_mcu9t5v0__filltie
XTAP_TAPCELL_ROW_2_1047 VSS VSS gf180mcu_fd_sc_mcu9t5v0__filltie
X_10862_ _19227_/Q _18970_/Q _18148_/S _18970_/D VSS VSS VSS VSS gf180mcu_fd_sc_mcu9t5v0__mux2_1
X_13650_ _19107_/Q _14475_/B _14546_/S _13650_/C _14372_/A1 VSS VSS VSS VSS gf180mcu_fd_sc_mcu9t5v0__oai211_1
X_12601_ _12616_/B _12601_/A2 _12601_/A3 _12601_/B1 _12601_/B2 _12602_/A2 VSS VSS
+ VSS VSS gf180mcu_fd_sc_mcu9t5v0__oai32_4
X_10793_ _18829_/Q _20030_/Q _10795_/A1 VSS VSS VSS VSS gf180mcu_fd_sc_mcu9t5v0__nand2_1
X_13581_ _13239_/Z _13580_/B _13581_/A3 _13581_/Z VSS _13581_/VNW VSS VSS gf180mcu_fd_sc_mcu9t5v0__or3_1
X_12532_ _18446_/Q _12607_/A2 _12534_/B1 VSS VSS VSS VSS gf180mcu_fd_sc_mcu9t5v0__nor2_1
XTAP_TAPCELL_ROW_62_2682 VSS VSS gf180mcu_fd_sc_mcu9t5v0__filltie
XTAP_TAPCELL_ROW_62_2693 VSS VSS gf180mcu_fd_sc_mcu9t5v0__filltie
X_15320_ _19640_/Q _19617_/Q _15320_/B _15324_/A3 VSS VSS VSS VSS gf180mcu_fd_sc_mcu9t5v0__aoi21_1
X_12463_ _18214_/Q wire163/Z _12466_/A3 VSS _12463_/VNW VSS VSS gf180mcu_fd_sc_mcu9t5v0__nor2_1
XPHY_EDGE_ROW_201_3_Right_316 VSS VSS gf180mcu_fd_sc_mcu9t5v0__endcap
X_15251_ _15364_/S _15258_/C _15252_/A2 VSS VSS VSS VSS gf180mcu_fd_sc_mcu9t5v0__nand2_1
X_11414_ _11414_/A1 _11414_/A2 _11521_/B _11414_/C _11416_/B VSS VSS VSS VSS gf180mcu_fd_sc_mcu9t5v0__oai211_1
X_14202_ _14115_/Z _14201_/Z _14220_/A2 VSS VSS VSS VSS gf180mcu_fd_sc_mcu9t5v0__nand2_1
X_15182_ _19583_/Q _15182_/A2 _15183_/C VSS VSS VSS VSS gf180mcu_fd_sc_mcu9t5v0__nor2_1
X_12394_ _12628_/A1 _12355_/I _12394_/A3 _12394_/B _19145_/D VSS VSS VSS VSS gf180mcu_fd_sc_mcu9t5v0__oai31_1
X_11345_ _18522_/Q _18506_/Q _18490_/Q _18474_/Q _11403_/S _11098_/B _11345_/Z VSS
+ VSS VSS VSS gf180mcu_fd_sc_mcu9t5v0__mux4_1
X_19990_ _19990_/D _20054_/RN _20054_/CLK _19990_/Q VSS VSS VSS VSS gf180mcu_fd_sc_mcu9t5v0__dffrnq_1
X_14133_ _14034_/B _14133_/A2 _14134_/A2 _14184_/A2 VSS _14134_/VNW VSS VSS gf180mcu_fd_sc_mcu9t5v0__nand3_1
XTAP_TAPCELL_ROW_242_5736 VSS VSS gf180mcu_fd_sc_mcu9t5v0__filltie
XTAP_TAPCELL_ROW_242_5725 VSS VSS gf180mcu_fd_sc_mcu9t5v0__filltie
X_18941_ _18941_/D _20029_/RN clkload67/I _18941_/Q VSS VSS VSS VSS gf180mcu_fd_sc_mcu9t5v0__dffrnq_1
X_11276_ _11469_/B _11275_/Z _11276_/B _11280_/A2 VSS VSS VSS VSS gf180mcu_fd_sc_mcu9t5v0__oai21_1
XTAP_TAPCELL_ROW_242_5714 VSS VSS gf180mcu_fd_sc_mcu9t5v0__filltie
X_14064_ _14064_/A1 _14064_/A2 _14062_/B _14099_/B VSS VSS VSS VSS gf180mcu_fd_sc_mcu9t5v0__nand3_1
XTAP_TAPCELL_ROW_71_2929 VSS VSS gf180mcu_fd_sc_mcu9t5v0__filltie
X_10227_ _18281_/Q _17282_/A2 _17282_/B1 _18297_/Q _10228_/B VSS _16442_/VNW VSS VSS
+ gf180mcu_fd_sc_mcu9t5v0__aoi22_1
X_13015_ _13015_/A1 _13015_/A2 _13015_/B _13053_/B2 VSS _13015_/VNW VSS VSS gf180mcu_fd_sc_mcu9t5v0__aoi21_1
XPHY_EDGE_ROW_141_3_Left_799 VSS VSS gf180mcu_fd_sc_mcu9t5v0__endcap
X_18872_ _18872_/D _19960_/RN clkload40/I _18872_/Q VSS VSS VSS VSS gf180mcu_fd_sc_mcu9t5v0__dffrnq_1
XPHY_EDGE_ROW_105_Left_429 VSS VSS gf180mcu_fd_sc_mcu9t5v0__endcap
X_10158_ _10158_/A1 _10158_/A2 _10159_/B1 VSS VSS VSS VSS gf180mcu_fd_sc_mcu9t5v0__nand2_1
X_17823_ _19030_/Q _18800_/Q _17845_/S _18800_/D VSS _17823_/VNW VSS VSS gf180mcu_fd_sc_mcu9t5v0__mux2_1
X_10089_ _19264_/Q _10165_/A2 _10091_/A2 VSS _10091_/VNW VSS VSS gf180mcu_fd_sc_mcu9t5v0__nand2_1
X_17754_ _18765_/Q _18766_/Q _17780_/A1 VSS _17757_/VNW VSS VSS gf180mcu_fd_sc_mcu9t5v0__nand2_1
XTAP_TAPCELL_ROW_69_2869 VSS VSS gf180mcu_fd_sc_mcu9t5v0__filltie
X_14966_ _19427_/Q _19372_/Q _14966_/Z VSS _14966_/VNW VSS VSS gf180mcu_fd_sc_mcu9t5v0__xor2_1
XPHY_EDGE_ROW_279_Right_206 VSS VSS gf180mcu_fd_sc_mcu9t5v0__endcap
X_16705_ _19282_/Q _16695_/B _16706_/C VSS VSS VSS VSS gf180mcu_fd_sc_mcu9t5v0__nor2_1
X_13917_ _13917_/A1 _13956_/A1 _13917_/B1 _13917_/B2 _13919_/A2 VSS VSS VSS VSS gf180mcu_fd_sc_mcu9t5v0__oai22_1
X_17685_ _17684_/Z _18722_/Q _17685_/S _18722_/D VSS VSS VSS VSS gf180mcu_fd_sc_mcu9t5v0__mux2_1
X_14897_ _19415_/Q _19356_/Q _14897_/B _14899_/A2 VSS VSS VSS VSS gf180mcu_fd_sc_mcu9t5v0__oai21_1
X_19424_ _19424_/D _20064_/RN clkload21/I _19424_/Q VSS VSS VSS VSS gf180mcu_fd_sc_mcu9t5v0__dffrnq_1
X_16636_ _16675_/A1 _16636_/A2 _16636_/A3 _16636_/B _16637_/I1 VSS VSS VSS VSS gf180mcu_fd_sc_mcu9t5v0__oai31_4
X_13848_ _19320_/Q _19295_/Q _13885_/A1 VSS VSS VSS VSS gf180mcu_fd_sc_mcu9t5v0__nand2_1
X_16567_ _16750_/A1 _16628_/A2 _16678_/B _16569_/A3 VSS VSS VSS VSS gf180mcu_fd_sc_mcu9t5v0__aoi21_1
XPHY_EDGE_ROW_114_Left_438 VSS VSS gf180mcu_fd_sc_mcu9t5v0__endcap
X_13779_ _19316_/Q _19294_/Q _19295_/Q _19317_/Q _13781_/B VSS VSS VSS VSS gf180mcu_fd_sc_mcu9t5v0__and4_1
X_19355_ _19355_/D _20059_/RN clkload19/I _19355_/Q VSS VSS VSS VSS gf180mcu_fd_sc_mcu9t5v0__dffrnq_1
X_18306_ _18306_/D clkload80/I _18306_/Q VSS VSS VSS VSS gf180mcu_fd_sc_mcu9t5v0__dffq_1
X_15518_ _19843_/Q _15515_/Z _15518_/Z VSS _15518_/VNW VSS VSS gf180mcu_fd_sc_mcu9t5v0__and2_1
X_19286_ _19286_/D _20054_/RN clkload37/I _19286_/Q VSS VSS VSS VSS gf180mcu_fd_sc_mcu9t5v0__dffrnq_1
X_18237_ _18237_/D _18510_/CLK _18237_/Q VSS VSS VSS VSS gf180mcu_fd_sc_mcu9t5v0__dffq_1
X_16498_ _18306_/Q _16497_/Z _17026_/S _18306_/D VSS VSS VSS VSS gf180mcu_fd_sc_mcu9t5v0__mux2_4
X_15449_ _15472_/A2 _15447_/S _15459_/A2 VSS VSS VSS VSS gf180mcu_fd_sc_mcu9t5v0__nand2_1
X_18168_ _18168_/D clkload82/I _18168_/Q VSS VSS VSS VSS gf180mcu_fd_sc_mcu9t5v0__dffq_1
XTAP_TAPCELL_ROW_212_4894 VSS VSS gf180mcu_fd_sc_mcu9t5v0__filltie
XTAP_TAPCELL_ROW_130_4561 VSS VSS gf180mcu_fd_sc_mcu9t5v0__filltie
XTAP_TAPCELL_ROW_130_4550 VSS VSS gf180mcu_fd_sc_mcu9t5v0__filltie
Xmax_cap100 _14546_/S _14704_/S VSS VSS VSS VSS gf180mcu_fd_sc_mcu9t5v0__buf_4
X_17119_ _18538_/Q _17394_/A2 _17120_/B VSS VSS VSS VSS gf180mcu_fd_sc_mcu9t5v0__nand2_1
Xmax_cap133 _11359_/B _11538_/B VSS VSS VSS VSS gf180mcu_fd_sc_mcu9t5v0__buf_4
X_18099_ _18937_/Q _18099_/A2 _18099_/Z VSS VSS VSS VSS gf180mcu_fd_sc_mcu9t5v0__xor2_1
XTAP_TAPCELL_ROW_320_7869 VSS VSS gf180mcu_fd_sc_mcu9t5v0__filltie
X_20130_ _20130_/D clkload72/I _20130_/Q VSS VSS VSS VSS gf180mcu_fd_sc_mcu9t5v0__dffq_1
Xmax_cap155 _12382_/S _12613_/A2 VSS VSS VSS VSS gf180mcu_fd_sc_mcu9t5v0__clkbuf_8
XTAP_TAPCELL_ROW_320_7858 VSS VSS gf180mcu_fd_sc_mcu9t5v0__filltie
X_09941_ _20028_/Q _18821_/Q _09943_/A2 VSS VSS VSS VSS gf180mcu_fd_sc_mcu9t5v0__nand2_1
Xmax_cap188 _12181_/A2 _12203_/A2 VSS VSS VSS VSS gf180mcu_fd_sc_mcu9t5v0__buf_8
XPHY_EDGE_ROW_123_Left_447 VSS VSS gf180mcu_fd_sc_mcu9t5v0__endcap
X_20061_ _20061_/D _20061_/RN clkload58/I _20061_/Q VSS VSS VSS VSS gf180mcu_fd_sc_mcu9t5v0__dffrnq_1
X_09872_ _20047_/Q _20048_/Q _09870_/Z _09873_/B VSS _10201_/VNW VSS VSS gf180mcu_fd_sc_mcu9t5v0__nor3_1
XTAP_TAPCELL_ROW_128_4490 VSS VSS gf180mcu_fd_sc_mcu9t5v0__filltie
XTAP_TAPCELL_ROW_124_4387 VSS VSS gf180mcu_fd_sc_mcu9t5v0__filltie
XTAP_TAPCELL_ROW_252_6010 VSS VSS gf180mcu_fd_sc_mcu9t5v0__filltie
XTAP_TAPCELL_ROW_124_4398 VSS VSS gf180mcu_fd_sc_mcu9t5v0__filltie
XTAP_TAPCELL_ROW_81_3214 VSS VSS gf180mcu_fd_sc_mcu9t5v0__filltie
XTAP_TAPCELL_ROW_81_3203 VSS VSS gf180mcu_fd_sc_mcu9t5v0__filltie
XPHY_EDGE_ROW_132_Left_456 VSS VSS gf180mcu_fd_sc_mcu9t5v0__endcap
X_09306_ _19227_/Q _16672_/A1 VSS VSS VSS VSS gf180mcu_fd_sc_mcu9t5v0__clkinv_1
X_09237_ _20056_/Q _15929_/A2 VSS VSS VSS VSS gf180mcu_fd_sc_mcu9t5v0__clkinv_1
XTAP_TAPCELL_ROW_79_3165 VSS VSS gf180mcu_fd_sc_mcu9t5v0__filltie
XTAP_TAPCELL_ROW_79_3154 VSS VSS gf180mcu_fd_sc_mcu9t5v0__filltie
XTAP_TAPCELL_ROW_79_3143 VSS VSS gf180mcu_fd_sc_mcu9t5v0__filltie
X_09168_ _19142_/Q _13664_/A1 VSS VSS VSS VSS gf180mcu_fd_sc_mcu9t5v0__clkinv_1
X_09099_ _18568_/Q _15939_/B VSS VSS VSS VSS gf180mcu_fd_sc_mcu9t5v0__clkinv_8
X_11130_ _11429_/B _11128_/Z _11130_/B _11134_/A2 VSS VSS VSS VSS gf180mcu_fd_sc_mcu9t5v0__oai21_1
X_11061_ _18031_/I0 _19062_/Q _11067_/S _19062_/D VSS _17823_/VNW VSS VSS gf180mcu_fd_sc_mcu9t5v0__mux2_1
X_10012_ _10012_/A1 _10012_/A2 _10043_/A2 VSS _10012_/VNW VSS VSS gf180mcu_fd_sc_mcu9t5v0__nand2_1
Xclkbuf_leaf_46_clk_regs clkload5/I clkload68/I VSS VSS VSS VSS gf180mcu_fd_sc_mcu9t5v0__clkbuf_8
XTAP_TAPCELL_ROW_51_2372 VSS VSS gf180mcu_fd_sc_mcu9t5v0__filltie
XTAP_TAPCELL_ROW_8_1201 VSS VSS gf180mcu_fd_sc_mcu9t5v0__filltie
XTAP_TAPCELL_ROW_51_2383 VSS VSS gf180mcu_fd_sc_mcu9t5v0__filltie
XTAP_TAPCELL_ROW_8_1212 VSS VSS gf180mcu_fd_sc_mcu9t5v0__filltie
X_14820_ _19574_/Q _14820_/I1 _15148_/S _19574_/D VSS _14820_/VNW VSS VSS gf180mcu_fd_sc_mcu9t5v0__mux2_1
XTAP_TAPCELL_ROW_51_2394 VSS VSS gf180mcu_fd_sc_mcu9t5v0__filltie
X_11963_ _18903_/Q _11963_/A2 _12336_/B _11965_/A2 VSS VSS VSS VSS gf180mcu_fd_sc_mcu9t5v0__oai21_1
X_14751_ _19169_/Q _19135_/Q _14751_/B _14751_/C _14754_/A2 VSS VSS VSS VSS gf180mcu_fd_sc_mcu9t5v0__aoi211_1
Xeco15_sk2_5 eco15_sk2_5/I _18510_/CLK VSS VSS VSS VSS gf180mcu_fd_sc_mcu9t5v0__clkbuf_16
X_11894_ _18259_/Q _12345_/A2 _12345_/B _11896_/A2 VSS VSS VSS VSS gf180mcu_fd_sc_mcu9t5v0__oai21_1
XTAP_TAPCELL_ROW_235_5540 VSS VSS gf180mcu_fd_sc_mcu9t5v0__filltie
X_10914_ _16719_/A1 _18151_/S _10924_/B _10915_/I0 VSS _10914_/VNW VSS VSS gf180mcu_fd_sc_mcu9t5v0__oai21_1
X_13702_ _14501_/S _13702_/A2 _13703_/C VSS _14664_/VNW VSS VSS gf180mcu_fd_sc_mcu9t5v0__nand2_1
XTAP_TAPCELL_ROW_64_2733 VSS VSS gf180mcu_fd_sc_mcu9t5v0__filltie
X_14682_ _19532_/Q _14681_/Z _14704_/S _19532_/D VSS VSS VSS VSS gf180mcu_fd_sc_mcu9t5v0__mux2_1
XTAP_TAPCELL_ROW_64_2744 VSS VSS gf180mcu_fd_sc_mcu9t5v0__filltie
XTAP_TAPCELL_ROW_64_2755 VSS VSS gf180mcu_fd_sc_mcu9t5v0__filltie
X_17470_ _09517_/I _17470_/A2 _18581_/D VSS VSS VSS VSS gf180mcu_fd_sc_mcu9t5v0__nor2_1
X_16421_ _16421_/I0 _18271_/Q _16958_/S _18271_/D VSS VSS VSS VSS gf180mcu_fd_sc_mcu9t5v0__mux2_4
XTAP_TAPCELL_ROW_231_5415 VSS VSS gf180mcu_fd_sc_mcu9t5v0__filltie
X_10845_ _11004_/A2 _18923_/Q _18059_/A2 VSS _10980_/VNW VSS VSS gf180mcu_fd_sc_mcu9t5v0__nand2_1
X_13633_ _19289_/Q _13497_/B _13636_/B VSS VSS VSS VSS gf180mcu_fd_sc_mcu9t5v0__nand2_1
XTAP_TAPCELL_ROW_60_2619 VSS VSS gf180mcu_fd_sc_mcu9t5v0__filltie
X_16352_ _18240_/Q _16351_/Z _16882_/S _18240_/D VSS VSS VSS VSS gf180mcu_fd_sc_mcu9t5v0__mux2_4
XTAP_TAPCELL_ROW_231_5426 VSS VSS gf180mcu_fd_sc_mcu9t5v0__filltie
X_19140_ _19140_/D _20036_/RN clkload10/I _19140_/Q VSS VSS VSS VSS gf180mcu_fd_sc_mcu9t5v0__dffrnq_1
X_13564_ _19731_/Q _13564_/A2 _13566_/A2 VSS _13564_/VNW VSS VSS gf180mcu_fd_sc_mcu9t5v0__nor2_1
X_15303_ _15302_/Z _19737_/Q _15417_/S _19737_/D VSS VSS VSS VSS gf180mcu_fd_sc_mcu9t5v0__mux2_1
X_10776_ _10776_/A1 _10776_/A2 _10776_/B _10799_/A1 VSS VSS VSS VSS gf180mcu_fd_sc_mcu9t5v0__oai21_1
X_12515_ _18396_/Q _12582_/A2 _12518_/A3 VSS _16250_/VNW VSS VSS gf180mcu_fd_sc_mcu9t5v0__nor2_1
XTAP_TAPCELL_ROW_248_5901 VSS VSS gf180mcu_fd_sc_mcu9t5v0__filltie
X_16283_ _16283_/A1 _16432_/B _16284_/I1 VSS VSS VSS VSS gf180mcu_fd_sc_mcu9t5v0__nand2_1
XPHY_EDGE_ROW_202_3_Right_317 VSS VSS gf180mcu_fd_sc_mcu9t5v0__endcap
X_13495_ _13495_/A1 _13495_/A2 _13495_/B _13496_/A2 VSS VSS VSS VSS gf180mcu_fd_sc_mcu9t5v0__oai21_1
X_19071_ _19071_/D _20031_/RN clkload11/I _19071_/Q VSS VSS VSS VSS gf180mcu_fd_sc_mcu9t5v0__dffrnq_1
X_12446_ _18164_/Q _12613_/A2 _12450_/A2 VSS VSS VSS VSS gf180mcu_fd_sc_mcu9t5v0__nor2_1
X_15234_ _15242_/A1 _19574_/Q _15247_/C VSS _15242_/VNW VSS VSS gf180mcu_fd_sc_mcu9t5v0__nand2_1
X_18022_ _18022_/I0 _18907_/Q _18037_/S _18907_/D VSS VSS VSS VSS gf180mcu_fd_sc_mcu9t5v0__mux2_1
X_12377_ _18251_/Q _12607_/A2 _12541_/B _12377_/C _12378_/B VSS _16376_/VNW VSS VSS
+ gf180mcu_fd_sc_mcu9t5v0__oai211_1
XTAP_TAPCELL_ROW_229_5366 VSS VSS gf180mcu_fd_sc_mcu9t5v0__filltie
XTAP_TAPCELL_ROW_229_5355 VSS VSS gf180mcu_fd_sc_mcu9t5v0__filltie
X_15165_ _19707_/Q _19547_/Q wire108/Z _19707_/D VSS _15165_/VNW VSS VSS gf180mcu_fd_sc_mcu9t5v0__mux2_1
XTAP_TAPCELL_ROW_229_5377 VSS VSS gf180mcu_fd_sc_mcu9t5v0__filltie
X_11328_ _18425_/Q wire136/I _11331_/C VSS VSS VSS VSS gf180mcu_fd_sc_mcu9t5v0__nand2_1
X_14116_ _14081_/Z _14116_/A2 _14116_/B _14117_/I VSS VSS VSS VSS gf180mcu_fd_sc_mcu9t5v0__aoi21_1
X_19973_ _19973_/D _20037_/RN clkload66/I _19973_/Q VSS VSS VSS VSS gf180mcu_fd_sc_mcu9t5v0__dffrnq_1
X_15096_ _15096_/A1 _15095_/I _15097_/I1 VSS _15096_/VNW VSS VSS gf180mcu_fd_sc_mcu9t5v0__xnor2_1
X_11259_ _11915_/A1 _11509_/A2 _11537_/S _11259_/C _11260_/C VSS _11267_/VNW VSS VSS
+ gf180mcu_fd_sc_mcu9t5v0__oai211_1
X_18924_ _18924_/D _20140_/RN clkload39/I _18924_/Q VSS VSS VSS VSS gf180mcu_fd_sc_mcu9t5v0__dffrnq_1
X_14047_ _19297_/Q _19322_/Q _14080_/A1 VSS VSS VSS VSS gf180mcu_fd_sc_mcu9t5v0__nand2_1
X_18855_ _18855_/D _20071_/RN clkload35/I _18855_/Q VSS VSS VSS VSS gf180mcu_fd_sc_mcu9t5v0__dffrnq_1
X_17806_ input7/Z _18784_/Q _17807_/S _18784_/D VSS VSS VSS VSS gf180mcu_fd_sc_mcu9t5v0__mux2_1
XPHY_EDGE_ROW_290_Right_217 VSS VSS gf180mcu_fd_sc_mcu9t5v0__endcap
XTAP_TAPCELL_ROW_292_7091 VSS VSS gf180mcu_fd_sc_mcu9t5v0__filltie
X_15998_ _15976_/Z _16570_/A3 _16005_/A1 VSS VSS VSS VSS gf180mcu_fd_sc_mcu9t5v0__nor2_1
X_18786_ _18786_/D _20066_/RN clkload51/I _18786_/Q VSS VSS VSS VSS gf180mcu_fd_sc_mcu9t5v0__dffrnq_1
X_17737_ _17556_/B _17681_/S _17737_/B _18744_/D VSS VSS VSS VSS gf180mcu_fd_sc_mcu9t5v0__oai21_1
XTAP_TAPCELL_ROW_30_1799 VSS VSS gf180mcu_fd_sc_mcu9t5v0__filltie
X_14949_ _19424_/Q _19369_/Q _14957_/A1 VSS _14949_/VNW VSS VSS gf180mcu_fd_sc_mcu9t5v0__nand2_1
XTAP_TAPCELL_ROW_313_7684 VSS VSS gf180mcu_fd_sc_mcu9t5v0__filltie
XTAP_TAPCELL_ROW_313_7673 VSS VSS gf180mcu_fd_sc_mcu9t5v0__filltie
X_17668_ _18631_/Q _18707_/Q _17685_/S _18707_/D VSS VSS VSS VSS gf180mcu_fd_sc_mcu9t5v0__mux2_1
X_16619_ input8/Z _18785_/Q _16619_/S _16619_/Z VSS _16702_/VNW VSS VSS gf180mcu_fd_sc_mcu9t5v0__mux2_1
X_19407_ _19407_/D _20047_/RN clkload8/I _19407_/Q VSS VSS VSS VSS gf180mcu_fd_sc_mcu9t5v0__dffrnq_1
X_17599_ _17599_/A1 _17619_/A3 _17599_/B _18663_/D VSS _17599_/VNW VSS VSS gf180mcu_fd_sc_mcu9t5v0__oai21_1
XTAP_TAPCELL_ROW_197_3_8214 VSS VSS gf180mcu_fd_sc_mcu9t5v0__filltie
X_19338_ _19338_/D _20042_/RN clkload18/I _19338_/Q VSS VSS VSS VSS gf180mcu_fd_sc_mcu9t5v0__dffrnq_1
XTAP_TAPCELL_ROW_214_4956 VSS VSS gf180mcu_fd_sc_mcu9t5v0__filltie
XTAP_TAPCELL_ROW_214_4945 VSS VSS gf180mcu_fd_sc_mcu9t5v0__filltie
XTAP_TAPCELL_ROW_132_4623 VSS VSS gf180mcu_fd_sc_mcu9t5v0__filltie
XTAP_TAPCELL_ROW_132_4612 VSS VSS gf180mcu_fd_sc_mcu9t5v0__filltie
XTAP_TAPCELL_ROW_132_4601 VSS VSS gf180mcu_fd_sc_mcu9t5v0__filltie
XTAP_TAPCELL_ROW_214_4967 VSS VSS gf180mcu_fd_sc_mcu9t5v0__filltie
X_19269_ _19269_/D _20037_/RN clkload43/I _19269_/Q VSS VSS VSS VSS gf180mcu_fd_sc_mcu9t5v0__dffrnq_1
XTAP_TAPCELL_ROW_117_4191 VSS VSS gf180mcu_fd_sc_mcu9t5v0__filltie
XTAP_TAPCELL_ROW_113_4099 VSS VSS gf180mcu_fd_sc_mcu9t5v0__filltie
XTAP_TAPCELL_ROW_113_4088 VSS VSS gf180mcu_fd_sc_mcu9t5v0__filltie
XTAP_TAPCELL_ROW_113_4077 VSS VSS gf180mcu_fd_sc_mcu9t5v0__filltie
XTAP_TAPCELL_ROW_202_3_8232 VSS VSS gf180mcu_fd_sc_mcu9t5v0__filltie
XTAP_TAPCELL_ROW_299_7289 VSS VSS gf180mcu_fd_sc_mcu9t5v0__filltie
XPHY_EDGE_ROW_211_Right_138 VSS VSS gf180mcu_fd_sc_mcu9t5v0__endcap
X_20113_ _20113_/D clkload57/I _20113_/Q VSS VSS VSS VSS gf180mcu_fd_sc_mcu9t5v0__dffq_1
X_09924_ _09924_/A1 _09927_/A2 _10165_/A2 VSS VSS VSS VSS gf180mcu_fd_sc_mcu9t5v0__nor2_1
XTAP_TAPCELL_ROW_126_4438 VSS VSS gf180mcu_fd_sc_mcu9t5v0__filltie
XTAP_TAPCELL_ROW_126_4449 VSS VSS gf180mcu_fd_sc_mcu9t5v0__filltie
X_09855_ _20035_/Q _09863_/A2 _10416_/B _09856_/I VSS VSS VSS VSS gf180mcu_fd_sc_mcu9t5v0__aoi21_1
X_20044_ _20044_/D _20044_/RN clkload22/I _20044_/Q VSS VSS VSS VSS gf180mcu_fd_sc_mcu9t5v0__dffrnq_1
X_09786_ _18849_/Q _11610_/A1 _09792_/B VSS VSS VSS VSS gf180mcu_fd_sc_mcu9t5v0__xor2_1
XPHY_EDGE_ROW_134_Right_134 VSS VSS gf180mcu_fd_sc_mcu9t5v0__endcap
XTAP_TAPCELL_ROW_102_3792 VSS VSS gf180mcu_fd_sc_mcu9t5v0__filltie
XTAP_TAPCELL_ROW_102_3781 VSS VSS gf180mcu_fd_sc_mcu9t5v0__filltie
X_10630_ _10809_/B _10630_/A2 _10630_/B1 _10630_/B2 _10630_/ZN VSS VSS VSS VSS gf180mcu_fd_sc_mcu9t5v0__aoi22_4
XTAP_TAPCELL_ROW_288_6982 VSS VSS gf180mcu_fd_sc_mcu9t5v0__filltie
XTAP_TAPCELL_ROW_288_6993 VSS VSS gf180mcu_fd_sc_mcu9t5v0__filltie
X_10561_ _17358_/A1 _18197_/Q _10564_/A2 VSS _12456_/VNW VSS VSS gf180mcu_fd_sc_mcu9t5v0__nor2_1
X_10492_ _10514_/B _10491_/Z _10494_/A1 VSS VSS VSS VSS gf180mcu_fd_sc_mcu9t5v0__nand2_1
XTAP_TAPCELL_ROW_284_6879 VSS VSS gf180mcu_fd_sc_mcu9t5v0__filltie
XTAP_TAPCELL_ROW_284_6868 VSS VSS gf180mcu_fd_sc_mcu9t5v0__filltie
X_12300_ _18470_/Q _18454_/Q _12340_/S _12300_/Z VSS VSS VSS VSS gf180mcu_fd_sc_mcu9t5v0__mux2_1
X_13280_ _13280_/A1 _19768_/Q _13280_/B _13300_/A1 VSS VSS VSS VSS gf180mcu_fd_sc_mcu9t5v0__aoi21_1
XTAP_TAPCELL_ROW_40_2073 VSS VSS gf180mcu_fd_sc_mcu9t5v0__filltie
XTAP_TAPCELL_ROW_40_2084 VSS VSS gf180mcu_fd_sc_mcu9t5v0__filltie
XTAP_TAPCELL_ROW_40_2095 VSS VSS gf180mcu_fd_sc_mcu9t5v0__filltie
X_12231_ _12028_/C _12307_/B _12351_/B VSS _12231_/VNW VSS VSS gf180mcu_fd_sc_mcu9t5v0__nand2_1
X_12162_ _12162_/A1 _12162_/A2 _12162_/B1 _12153_/B _12163_/I VSS VSS VSS VSS gf180mcu_fd_sc_mcu9t5v0__aoi22_1
XTAP_TAPCELL_ROW_224_5230 VSS VSS gf180mcu_fd_sc_mcu9t5v0__filltie
XTAP_TAPCELL_ROW_53_2434 VSS VSS gf180mcu_fd_sc_mcu9t5v0__filltie
X_12093_ _12093_/A1 _12093_/A2 _12093_/B1 _12093_/B2 _12116_/C _12094_/A3 VSS _12093_/VNW
+ VSS VSS gf180mcu_fd_sc_mcu9t5v0__aoi221_1
X_16970_ _18476_/Q _16969_/Z _16972_/S _18476_/D VSS VSS VSS VSS gf180mcu_fd_sc_mcu9t5v0__mux2_1
XTAP_TAPCELL_ROW_224_5241 VSS VSS gf180mcu_fd_sc_mcu9t5v0__filltie
X_11113_ _11429_/B _11110_/Z _11113_/B1 _11113_/B2 _11116_/A2 VSS VSS VSS VSS gf180mcu_fd_sc_mcu9t5v0__aoi22_1
XTAP_TAPCELL_ROW_53_2445 VSS VSS gf180mcu_fd_sc_mcu9t5v0__filltie
X_15921_ _20130_/Q _19251_/Q _15928_/S _20130_/D VSS VSS VSS VSS gf180mcu_fd_sc_mcu9t5v0__mux2_1
XTAP_TAPCELL_ROW_220_5127 VSS VSS gf180mcu_fd_sc_mcu9t5v0__filltie
XTAP_TAPCELL_ROW_220_5116 VSS VSS gf180mcu_fd_sc_mcu9t5v0__filltie
X_11044_ _18030_/I0 _19045_/Q _11051_/S _19045_/D VSS VSS VSS VSS gf180mcu_fd_sc_mcu9t5v0__mux2_1
X_18640_ _18640_/D _20044_/RN clkload54/I _18640_/Q VSS VSS VSS VSS gf180mcu_fd_sc_mcu9t5v0__dffrnq_1
XTAP_TAPCELL_ROW_109_3979 VSS VSS gf180mcu_fd_sc_mcu9t5v0__filltie
XTAP_TAPCELL_ROW_109_3968 VSS VSS gf180mcu_fd_sc_mcu9t5v0__filltie
X_15852_ _20016_/Q _09758_/B _17617_/S VSS VSS VSS VSS gf180mcu_fd_sc_mcu9t5v0__nand2_1
XTAP_TAPCELL_ROW_66_2806 VSS VSS gf180mcu_fd_sc_mcu9t5v0__filltie
X_15783_ _19977_/Q _19953_/Q _15786_/S _19953_/D VSS VSS VSS VSS gf180mcu_fd_sc_mcu9t5v0__mux2_1
XPHY_EDGE_ROW_101_Right_101 VSS VSS gf180mcu_fd_sc_mcu9t5v0__endcap
X_14803_ _19400_/Q _19337_/Q _14806_/A1 _14805_/A2 VSS VSS VSS VSS gf180mcu_fd_sc_mcu9t5v0__xnor3_1
X_12995_ _19753_/Q _19787_/Q _12996_/B VSS VSS VSS VSS gf180mcu_fd_sc_mcu9t5v0__xnor2_1
X_18571_ _18571_/D _20071_/RN clkload27/I _18571_/Q VSS VSS VSS VSS gf180mcu_fd_sc_mcu9t5v0__dffrnq_1
X_11946_ _11946_/A1 _11946_/A2 _11947_/B1 VSS VSS VSS VSS gf180mcu_fd_sc_mcu9t5v0__nor2_4
X_17522_ _09065_/I _18627_/Q _17529_/S _18627_/D VSS VSS VSS VSS gf180mcu_fd_sc_mcu9t5v0__mux2_1
X_14734_ _19165_/Q _19131_/Q _14735_/B VSS VSS VSS VSS gf180mcu_fd_sc_mcu9t5v0__nand2_1
XTAP_TAPCELL_ROW_218_5078 VSS VSS gf180mcu_fd_sc_mcu9t5v0__filltie
XTAP_TAPCELL_ROW_218_5067 VSS VSS gf180mcu_fd_sc_mcu9t5v0__filltie
XTAP_TAPCELL_ROW_218_5056 VSS VSS gf180mcu_fd_sc_mcu9t5v0__filltie
X_17453_ _17461_/A1 _12333_/B _18573_/Q _17454_/A2 VSS VSS VSS VSS gf180mcu_fd_sc_mcu9t5v0__aoi21_1
X_16404_ _16408_/I1 _16932_/A2 wire33/I VSS VSS VSS VSS gf180mcu_fd_sc_mcu9t5v0__nor2_4
X_11877_ _18720_/Q wire198/Z _11961_/B VSS VSS VSS VSS gf180mcu_fd_sc_mcu9t5v0__nand2_1
X_14665_ _19145_/Q _19111_/Q _14665_/B _14668_/A2 VSS VSS VSS VSS gf180mcu_fd_sc_mcu9t5v0__aoi21_1
X_17384_ _18359_/Q _17406_/A2 _17405_/A2 _18375_/Q _17385_/B VSS VSS VSS VSS gf180mcu_fd_sc_mcu9t5v0__aoi22_1
XTAP_TAPCELL_ROW_207_3_8247 VSS VSS gf180mcu_fd_sc_mcu9t5v0__filltie
X_10828_ _20138_/Q _10829_/A1 _09758_/B _10829_/B VSS _10828_/VNW VSS VSS gf180mcu_fd_sc_mcu9t5v0__nand3_1
X_13616_ _13620_/A1 _13616_/A2 _13616_/B _19285_/D VSS VSS VSS VSS gf180mcu_fd_sc_mcu9t5v0__oai21_1
X_14596_ _19175_/Q _19474_/Q _14715_/S _19474_/D VSS VSS VSS VSS gf180mcu_fd_sc_mcu9t5v0__mux2_1
X_16335_ _16298_/Z _16750_/A2 _16865_/S VSS _16335_/VNW VSS VSS gf180mcu_fd_sc_mcu9t5v0__nand2_4
X_13547_ _13615_/B _13551_/A2 _13548_/A2 VSS _13547_/VNW VSS VSS gf180mcu_fd_sc_mcu9t5v0__nand2_1
X_10759_ _10759_/I _10760_/A2 VSS VSS VSS VSS gf180mcu_fd_sc_mcu9t5v0__clkinv_1
X_19123_ _19123_/D _20019_/RN clkload27/I _19123_/Q VSS VSS VSS VSS gf180mcu_fd_sc_mcu9t5v0__dffrnq_1
X_16266_ _16058_/B _16809_/S _16424_/B VSS VSS VSS VSS gf180mcu_fd_sc_mcu9t5v0__nand2_1
X_19054_ _19054_/D _20142_/RN _19806_/CLK _19054_/Q VSS VSS VSS VSS gf180mcu_fd_sc_mcu9t5v0__dffrnq_1
XPHY_EDGE_ROW_203_3_Right_318 VSS VSS gf180mcu_fd_sc_mcu9t5v0__endcap
X_13478_ _19748_/Q _13478_/A2 _13640_/B VSS VSS VSS VSS gf180mcu_fd_sc_mcu9t5v0__xnor2_1
X_18005_ _18855_/Q _18005_/A2 _18021_/S VSS _18005_/VNW VSS VSS gf180mcu_fd_sc_mcu9t5v0__nand2_1
X_15217_ _15217_/A1 _19570_/Q _15219_/A2 _15218_/I0 VSS VSS VSS VSS gf180mcu_fd_sc_mcu9t5v0__xnor3_1
X_16197_ _16197_/A1 _16197_/A2 _16197_/B _16197_/C _16198_/C VSS VSS VSS VSS gf180mcu_fd_sc_mcu9t5v0__oai211_4
X_12429_ _12355_/I _12485_/A2 _12429_/A3 _12429_/B _19149_/D VSS _12429_/VNW VSS VSS
+ gf180mcu_fd_sc_mcu9t5v0__oai31_1
XTAP_TAPCELL_ROW_302_7363 VSS VSS gf180mcu_fd_sc_mcu9t5v0__filltie
XPHY_EDGE_ROW_178_1_Left_501 VSS VSS gf180mcu_fd_sc_mcu9t5v0__endcap
X_15148_ _19690_/Q _19530_/Q _15148_/S _19690_/D VSS VSS VSS VSS gf180mcu_fd_sc_mcu9t5v0__mux2_1
XTAP_TAPCELL_ROW_302_7385 VSS VSS gf180mcu_fd_sc_mcu9t5v0__filltie
XTAP_TAPCELL_ROW_302_7374 VSS VSS gf180mcu_fd_sc_mcu9t5v0__filltie
X_19956_ _19956_/D _20020_/RN clkload66/I _19956_/Q VSS VSS VSS VSS gf180mcu_fd_sc_mcu9t5v0__dffrnq_1
X_15079_ _15099_/A1 _15086_/A1 _15082_/A1 VSS _15086_/VNW VSS VSS gf180mcu_fd_sc_mcu9t5v0__nand2_1
XTAP_TAPCELL_ROW_294_7153 VSS VSS gf180mcu_fd_sc_mcu9t5v0__filltie
XTAP_TAPCELL_ROW_294_7142 VSS VSS gf180mcu_fd_sc_mcu9t5v0__filltie
XTAP_TAPCELL_ROW_36_1964 VSS VSS gf180mcu_fd_sc_mcu9t5v0__filltie
X_18907_ _18907_/D _20059_/RN clkload10/I _18907_/Q VSS VSS VSS VSS gf180mcu_fd_sc_mcu9t5v0__dffrnq_1
XTAP_TAPCELL_ROW_36_1975 VSS VSS gf180mcu_fd_sc_mcu9t5v0__filltie
XTAP_TAPCELL_ROW_294_7164 VSS VSS gf180mcu_fd_sc_mcu9t5v0__filltie
X_19887_ _19887_/D _20143_/RN clkload71/I _19887_/Q VSS VSS VSS VSS gf180mcu_fd_sc_mcu9t5v0__dffrnq_1
XTAP_TAPCELL_ROW_121_4302 VSS VSS gf180mcu_fd_sc_mcu9t5v0__filltie
XTAP_TAPCELL_ROW_36_1986 VSS VSS gf180mcu_fd_sc_mcu9t5v0__filltie
XTAP_TAPCELL_ROW_315_7735 VSS VSS gf180mcu_fd_sc_mcu9t5v0__filltie
XTAP_TAPCELL_ROW_315_7724 VSS VSS gf180mcu_fd_sc_mcu9t5v0__filltie
XTAP_TAPCELL_ROW_290_7039 VSS VSS gf180mcu_fd_sc_mcu9t5v0__filltie
X_09640_ _20006_/Q _09698_/B _09642_/B VSS _09640_/VNW VSS VSS gf180mcu_fd_sc_mcu9t5v0__nand2_1
XTAP_TAPCELL_ROW_121_4313 VSS VSS gf180mcu_fd_sc_mcu9t5v0__filltie
X_18838_ _18838_/D _20054_/RN clkload33/I _18838_/Q VSS VSS VSS VSS gf180mcu_fd_sc_mcu9t5v0__dffrnq_1
XTAP_TAPCELL_ROW_315_7746 VSS VSS gf180mcu_fd_sc_mcu9t5v0__filltie
X_18769_ _18769_/D _20049_/RN clkload49/I _18769_/Q VSS VSS VSS VSS gf180mcu_fd_sc_mcu9t5v0__dffrnq_1
X_09571_ _18832_/Q _18853_/Q _09573_/A2 VSS _09571_/VNW VSS VSS gf180mcu_fd_sc_mcu9t5v0__nor2_1
XTAP_TAPCELL_ROW_119_4253 VSS VSS gf180mcu_fd_sc_mcu9t5v0__filltie
XTAP_TAPCELL_ROW_119_4242 VSS VSS gf180mcu_fd_sc_mcu9t5v0__filltie
XTAP_TAPCELL_ROW_119_4264 VSS VSS gf180mcu_fd_sc_mcu9t5v0__filltie
Xclkbuf_0_clk_regs clkbuf_0_clk_regs/I clkbuf_0_clk_regs/Z VSS VSS VSS VSS gf180mcu_fd_sc_mcu9t5v0__clkbuf_16
XPHY_EDGE_ROW_166_3_Left_824 VSS VSS gf180mcu_fd_sc_mcu9t5v0__endcap
XTAP_TAPCELL_ROW_115_4139 VSS VSS gf180mcu_fd_sc_mcu9t5v0__filltie
XPHY_EDGE_ROW_162_1_Left_485 VSS VSS gf180mcu_fd_sc_mcu9t5v0__endcap
X_09907_ _09978_/B1 _09924_/A1 wire285/I VSS _09918_/VNW VSS VSS gf180mcu_fd_sc_mcu9t5v0__nor2_1
XTAP_TAPCELL_ROW_277_6694 VSS VSS gf180mcu_fd_sc_mcu9t5v0__filltie
XTAP_TAPCELL_ROW_277_6683 VSS VSS gf180mcu_fd_sc_mcu9t5v0__filltie
X_20027_ _20027_/D _19963_/RN clkload50/I _20027_/Q VSS VSS VSS VSS gf180mcu_fd_sc_mcu9t5v0__dffsnq_1
X_09838_ _10179_/A1 _09838_/A2 _09840_/C VSS VSS VSS VSS gf180mcu_fd_sc_mcu9t5v0__nor2_1
X_09769_ _09833_/B2 _19019_/Q _09770_/B1 VSS _09770_/VNW VSS VSS gf180mcu_fd_sc_mcu9t5v0__nand2_1
XTAP_TAPCELL_ROW_104_3843 VSS VSS gf180mcu_fd_sc_mcu9t5v0__filltie
XTAP_TAPCELL_ROW_104_3832 VSS VSS gf180mcu_fd_sc_mcu9t5v0__filltie
XTAP_TAPCELL_ROW_273_6569 VSS VSS gf180mcu_fd_sc_mcu9t5v0__filltie
X_11800_ _18303_/Q _18287_/Q _18239_/Q _18223_/Q _12340_/S _12208_/C _11800_/Z VSS
+ VSS VSS VSS gf180mcu_fd_sc_mcu9t5v0__mux4_1
XTAP_TAPCELL_ROW_104_3854 VSS VSS gf180mcu_fd_sc_mcu9t5v0__filltie
X_12780_ _19756_/Q _12778_/Z _12782_/B VSS _13085_/VNW VSS VSS gf180mcu_fd_sc_mcu9t5v0__xnor2_1
XTAP_TAPCELL_ROW_100_3729 VSS VSS gf180mcu_fd_sc_mcu9t5v0__filltie
X_11731_ _18188_/Q _12090_/B _12153_/B _11737_/A2 VSS VSS VSS VSS gf180mcu_fd_sc_mcu9t5v0__aoi21_1
XTAP_TAPCELL_ROW_42_2124 VSS VSS gf180mcu_fd_sc_mcu9t5v0__filltie
XTAP_TAPCELL_ROW_46_2260 VSS VSS gf180mcu_fd_sc_mcu9t5v0__filltie
X_11662_ _12699_/A1 _12698_/A2 _12706_/A2 VSS VSS VSS VSS gf180mcu_fd_sc_mcu9t5v0__nand2_1
XTAP_TAPCELL_ROW_42_2135 VSS VSS gf180mcu_fd_sc_mcu9t5v0__filltie
X_14450_ _19156_/Q _19122_/Q _14703_/A1 VSS VSS VSS VSS gf180mcu_fd_sc_mcu9t5v0__xnor2_1
XTAP_TAPCELL_ROW_42_2146 VSS VSS gf180mcu_fd_sc_mcu9t5v0__filltie
X_10613_ _10459_/C _10613_/A2 _10613_/A3 _10613_/B _10618_/C1 VSS _12471_/VNW VSS
+ VSS gf180mcu_fd_sc_mcu9t5v0__oai31_1
X_13401_ _19776_/Q _13402_/A2 _13422_/B VSS _13401_/VNW VSS VSS gf180mcu_fd_sc_mcu9t5v0__nand2_1
X_14381_ _13712_/Z _19445_/Q _14670_/S _19445_/D VSS VSS VSS VSS gf180mcu_fd_sc_mcu9t5v0__mux2_1
X_11593_ _11610_/B _11592_/Z _11593_/Z VSS _11593_/VNW VSS VSS gf180mcu_fd_sc_mcu9t5v0__or2_1
X_10544_ _10543_/C _10544_/A2 _10544_/B _17304_/C _10546_/A2 VSS VSS VSS VSS gf180mcu_fd_sc_mcu9t5v0__oai211_1
X_16120_ _18169_/Q _16120_/I1 _16707_/S _18169_/D VSS VSS VSS VSS gf180mcu_fd_sc_mcu9t5v0__mux2_4
XTAP_TAPCELL_ROW_59_2610 VSS VSS gf180mcu_fd_sc_mcu9t5v0__filltie
X_13332_ _13333_/A1 _13333_/A2 _13599_/B _13354_/A2 VSS _13598_/VNW VSS VSS gf180mcu_fd_sc_mcu9t5v0__aoi21_1
X_16051_ _16051_/A1 _16042_/S _16098_/B _16151_/B VSS _16051_/VNW VSS VSS gf180mcu_fd_sc_mcu9t5v0__oai21_2
X_10475_ _18995_/Q _10654_/A2 _10475_/B wire160/Z _10477_/B1 VSS VSS VSS VSS gf180mcu_fd_sc_mcu9t5v0__oai211_1
X_13263_ _19736_/Q _19768_/Q _13265_/B VSS _13263_/VNW VSS VSS gf180mcu_fd_sc_mcu9t5v0__xor2_1
XTAP_TAPCELL_ROW_55_2507 VSS VSS gf180mcu_fd_sc_mcu9t5v0__filltie
X_12214_ _18729_/Q wire198/Z wire213/Z _12214_/C _12216_/A3 VSS VSS VSS VSS gf180mcu_fd_sc_mcu9t5v0__aoi211_2
X_13194_ _13194_/A1 _13194_/A2 _13561_/B _13194_/B _13200_/B1 VSS VSS VSS VSS gf180mcu_fd_sc_mcu9t5v0__oai31_1
Xrst_tree_leaf_38 rst_tree_mid_4/Z _20045_/RN VSS VSS VSS VSS gf180mcu_fd_sc_mcu9t5v0__clkbuf_16
Xrst_tree_leaf_16 rst_tree_mid_2/Z _20067_/RN VSS VSS VSS VSS gf180mcu_fd_sc_mcu9t5v0__clkbuf_16
Xrst_tree_leaf_27 rst_tree_mid_3/Z _19992_/RN VSS VSS VSS VSS gf180mcu_fd_sc_mcu9t5v0__clkbuf_16
Xclkbuf_leaf_61_clk_regs clkload1/I clkload32/I VSS VSS VSS VSS gf180mcu_fd_sc_mcu9t5v0__clkbuf_8
X_15002_ _19622_/Q _15002_/I1 _15163_/S _19622_/D VSS _15011_/VNW VSS VSS gf180mcu_fd_sc_mcu9t5v0__mux2_1
X_12145_ _12071_/B _12145_/A2 _12146_/B VSS VSS VSS VSS gf180mcu_fd_sc_mcu9t5v0__nor2_1
X_19810_ _19810_/D _20066_/RN clkload37/I _19810_/Q VSS VSS VSS VSS gf180mcu_fd_sc_mcu9t5v0__dffrnq_1
Xrst_tree_leaf_49 rst_tree_mid_6/Z _20034_/RN VSS VSS VSS VSS gf180mcu_fd_sc_mcu9t5v0__clkbuf_16
X_16953_ _16953_/A1 _16955_/S _16953_/B _16954_/I0 VSS VSS VSS VSS gf180mcu_fd_sc_mcu9t5v0__oai21_1
X_19741_ _19741_/D _20061_/RN clkload26/I _19741_/Q VSS VSS VSS VSS gf180mcu_fd_sc_mcu9t5v0__dffrnq_1
X_12076_ _18907_/Q _18908_/Q _18909_/Q _12076_/B _12077_/A2 VSS VSS VSS VSS gf180mcu_fd_sc_mcu9t5v0__oai31_1
X_16884_ _18434_/Q _16883_/Z _16892_/S _18434_/D VSS VSS VSS VSS gf180mcu_fd_sc_mcu9t5v0__mux2_4
X_15904_ _20113_/Q _19249_/Q _15905_/S _20113_/D VSS VSS VSS VSS gf180mcu_fd_sc_mcu9t5v0__mux2_1
X_11027_ _19060_/Q _19028_/Q _11051_/S _19028_/D VSS VSS VSS VSS gf180mcu_fd_sc_mcu9t5v0__mux2_1
X_19672_ _19672_/D _19992_/RN clkload26/I _19672_/Q VSS VSS VSS VSS gf180mcu_fd_sc_mcu9t5v0__dffrnq_1
X_18623_ _18623_/D _19963_/RN _20099_/CLK _18623_/Q VSS VSS VSS VSS gf180mcu_fd_sc_mcu9t5v0__dffrnq_1
X_15835_ _20145_/Q _20007_/Q input9/Z _20145_/D VSS _15837_/VNW VSS VSS gf180mcu_fd_sc_mcu9t5v0__mux2_1
X_18554_ _18554_/D _20054_/RN clkload22/I _18554_/Q VSS VSS VSS VSS gf180mcu_fd_sc_mcu9t5v0__dffrnq_1
X_17505_ _18610_/Q _19251_/Q _17513_/S _18610_/D VSS VSS VSS VSS gf180mcu_fd_sc_mcu9t5v0__mux2_1
X_15766_ input4/Z _19936_/Q _15770_/S _19936_/D VSS VSS VSS VSS gf180mcu_fd_sc_mcu9t5v0__mux2_1
X_12978_ _12978_/A1 _12978_/A2 _12977_/B _12979_/A2 VSS VSS VSS VSS gf180mcu_fd_sc_mcu9t5v0__nand3_1
X_18485_ _18485_/D clkload79/I _18485_/Q VSS VSS VSS VSS gf180mcu_fd_sc_mcu9t5v0__dffq_1
X_15697_ _15697_/I0 _19916_/Q _15726_/S _19916_/D VSS VSS VSS VSS gf180mcu_fd_sc_mcu9t5v0__mux2_1
X_14717_ _14717_/A1 _14716_/B _14717_/A3 _14717_/Z VSS VSS VSS VSS gf180mcu_fd_sc_mcu9t5v0__and3_1
X_11929_ _18903_/Q _11929_/A2 _11947_/A2 VSS VSS VSS VSS gf180mcu_fd_sc_mcu9t5v0__xnor2_1
X_17436_ _17431_/S _17436_/A2 _17436_/B _18565_/D VSS _17439_/VNW VSS VSS gf180mcu_fd_sc_mcu9t5v0__oai21_1
X_14648_ _13666_/B _14651_/A2 _14648_/Z VSS _14648_/VNW VSS VSS gf180mcu_fd_sc_mcu9t5v0__xor2_1
XTAP_TAPCELL_ROW_29_1790 VSS VSS gf180mcu_fd_sc_mcu9t5v0__filltie
XANTENNA_17 output14/I VSS ANTENNA_17/VNW VSS VSS gf180mcu_fd_sc_mcu9t5v0__antenna
X_17367_ _20136_/Q _17407_/C _17408_/B _17367_/C _17370_/A1 VSS _17367_/VNW VSS VSS
+ gf180mcu_fd_sc_mcu9t5v0__aoi211_1
XTAP_TAPCELL_ROW_308_7550 VSS VSS gf180mcu_fd_sc_mcu9t5v0__filltie
X_16318_ _18224_/Q _16317_/Z _16850_/S _18224_/D VSS VSS VSS VSS gf180mcu_fd_sc_mcu9t5v0__mux2_4
XTAP_TAPCELL_ROW_25_1665 VSS VSS gf180mcu_fd_sc_mcu9t5v0__filltie
XTAP_TAPCELL_ROW_25_1676 VSS VSS gf180mcu_fd_sc_mcu9t5v0__filltie
X_14579_ _14580_/A1 _19137_/Q _14581_/A2 VSS _14758_/VNW VSS VSS gf180mcu_fd_sc_mcu9t5v0__nor2_1
X_19106_ _19106_/D _20066_/RN clkload26/I _19106_/Q VSS VSS VSS VSS gf180mcu_fd_sc_mcu9t5v0__dffrnq_1
X_17298_ _18419_/Q _17406_/A2 _17296_/Z _10514_/B _17401_/C _17299_/B2 VSS VSS VSS
+ VSS gf180mcu_fd_sc_mcu9t5v0__aoi221_1
XTAP_TAPCELL_ROW_110_4014 VSS VSS gf180mcu_fd_sc_mcu9t5v0__filltie
XTAP_TAPCELL_ROW_110_4003 VSS VSS gf180mcu_fd_sc_mcu9t5v0__filltie
XTAP_TAPCELL_ROW_304_7436 VSS VSS gf180mcu_fd_sc_mcu9t5v0__filltie
XTAP_TAPCELL_ROW_304_7425 VSS VSS gf180mcu_fd_sc_mcu9t5v0__filltie
X_16249_ _19263_/Q _16932_/A2 _16251_/A1 VSS VSS VSS VSS gf180mcu_fd_sc_mcu9t5v0__nand2_1
XPHY_EDGE_ROW_204_3_Right_319 VSS VSS gf180mcu_fd_sc_mcu9t5v0__endcap
X_19037_ _19037_/D _20061_/RN _19806_/CLK _19037_/Q VSS VSS VSS VSS gf180mcu_fd_sc_mcu9t5v0__dffrnq_1
XTAP_TAPCELL_ROW_296_7204 VSS VSS gf180mcu_fd_sc_mcu9t5v0__filltie
XTAP_TAPCELL_ROW_209_4822 VSS VSS gf180mcu_fd_sc_mcu9t5v0__filltie
XTAP_TAPCELL_ROW_209_4811 VSS VSS gf180mcu_fd_sc_mcu9t5v0__filltie
XTAP_TAPCELL_ROW_209_4800 VSS VSS gf180mcu_fd_sc_mcu9t5v0__filltie
XTAP_TAPCELL_ROW_296_7215 VSS VSS gf180mcu_fd_sc_mcu9t5v0__filltie
X_19939_ _19939_/D _20067_/RN clkload71/I _19939_/Q VSS VSS VSS VSS gf180mcu_fd_sc_mcu9t5v0__dffrnq_1
X_09623_ _11547_/A2 _11547_/B _20057_/D VSS VSS VSS VSS gf180mcu_fd_sc_mcu9t5v0__nor2_1
X_09554_ _18824_/Q _18823_/Q _17851_/A1 VSS _10306_/VNW VSS VSS gf180mcu_fd_sc_mcu9t5v0__nor2_1
X_09485_ _18748_/Q wire198/I _12723_/B VSS VSS VSS VSS gf180mcu_fd_sc_mcu9t5v0__nand2_1
XTAP_TAPCELL_ROW_281_6805 VSS VSS gf180mcu_fd_sc_mcu9t5v0__filltie
XTAP_TAPCELL_ROW_266_6373 VSS VSS gf180mcu_fd_sc_mcu9t5v0__filltie
XTAP_TAPCELL_ROW_95_3588 VSS VSS gf180mcu_fd_sc_mcu9t5v0__filltie
XTAP_TAPCELL_ROW_266_6395 VSS VSS gf180mcu_fd_sc_mcu9t5v0__filltie
XTAP_TAPCELL_ROW_266_6384 VSS VSS gf180mcu_fd_sc_mcu9t5v0__filltie
XTAP_TAPCELL_ROW_95_3599 VSS VSS gf180mcu_fd_sc_mcu9t5v0__filltie
X_10260_ _19941_/Q wire216/Z _10655_/B _10261_/B2 VSS _10285_/VNW VSS VSS gf180mcu_fd_sc_mcu9t5v0__aoi21_1
XPHY_EDGE_ROW_195_2_Left_707 VSS VSS gf180mcu_fd_sc_mcu9t5v0__endcap
XTAP_TAPCELL_ROW_279_6745 VSS VSS gf180mcu_fd_sc_mcu9t5v0__filltie
XTAP_TAPCELL_ROW_279_6734 VSS VSS gf180mcu_fd_sc_mcu9t5v0__filltie
X_10191_ _09863_/B _10191_/A2 _10192_/I VSS VSS VSS VSS gf180mcu_fd_sc_mcu9t5v0__nor2_1
XTAP_TAPCELL_ROW_279_6756 VSS VSS gf180mcu_fd_sc_mcu9t5v0__filltie
XTAP_TAPCELL_ROW_106_3905 VSS VSS gf180mcu_fd_sc_mcu9t5v0__filltie
X_13950_ _13950_/A1 _13950_/A2 _14027_/A1 VSS _13950_/VNW VSS VSS gf180mcu_fd_sc_mcu9t5v0__nand2_1
X_12901_ _12896_/Z _12901_/A2 _12901_/Z VSS VSS VSS VSS gf180mcu_fd_sc_mcu9t5v0__or2_1
XTAP_TAPCELL_ROW_48_2300 VSS VSS gf180mcu_fd_sc_mcu9t5v0__filltie
X_15620_ _15611_/I _15620_/A2 _15620_/B _15621_/A2 VSS VSS VSS VSS gf180mcu_fd_sc_mcu9t5v0__oai21_1
X_13881_ _13841_/Z _13879_/Z _13881_/Z VSS _13950_/VNW VSS VSS gf180mcu_fd_sc_mcu9t5v0__xor2_1
XTAP_TAPCELL_ROW_48_2311 VSS VSS gf180mcu_fd_sc_mcu9t5v0__filltie
X_12832_ _12832_/I0 _19209_/Q _13497_/B _19209_/D VSS VSS VSS VSS gf180mcu_fd_sc_mcu9t5v0__mux2_1
X_15551_ _19869_/Q _19876_/Q _15551_/S _19869_/D VSS VSS VSS VSS gf180mcu_fd_sc_mcu9t5v0__mux2_1
X_12763_ _19722_/Q _19787_/Q _12948_/S _12763_/Z VSS _13015_/VNW VSS VSS gf180mcu_fd_sc_mcu9t5v0__mux2_1
X_18270_ _18270_/D clkload73/I _18270_/Q VSS VSS VSS VSS gf180mcu_fd_sc_mcu9t5v0__dffq_1
X_11714_ _11714_/A1 _11714_/A2 _11714_/B1 _11714_/B2 _12116_/C _11717_/B VSS _11714_/VNW
+ VSS VSS gf180mcu_fd_sc_mcu9t5v0__aoi221_1
X_15482_ _19829_/Q _19870_/Q _09726_/B _15566_/A1 VSS _15482_/VNW VSS VSS gf180mcu_fd_sc_mcu9t5v0__nor3_2
XTAP_TAPCELL_ROW_251_5963 VSS VSS gf180mcu_fd_sc_mcu9t5v0__filltie
X_14502_ _14501_/Z _19462_/Q _14670_/S _19462_/D VSS VSS VSS VSS gf180mcu_fd_sc_mcu9t5v0__mux2_1
X_17221_ _17407_/C _17221_/A2 _17222_/C VSS _17221_/VNW VSS VSS gf180mcu_fd_sc_mcu9t5v0__or2_1
XTAP_TAPCELL_ROW_251_5985 VSS VSS gf180mcu_fd_sc_mcu9t5v0__filltie
XTAP_TAPCELL_ROW_251_5974 VSS VSS gf180mcu_fd_sc_mcu9t5v0__filltie
X_14433_ _14442_/A1 _14697_/A1 _14433_/B _14434_/C VSS _14433_/VNW VSS VSS gf180mcu_fd_sc_mcu9t5v0__oai21_1
X_12694_ _12694_/A1 _12724_/C _12714_/B1 VSS VSS VSS VSS gf180mcu_fd_sc_mcu9t5v0__nor2_1
X_11645_ _12720_/S _11645_/A2 _11645_/A3 _11645_/B _12699_/A1 VSS _12637_/VNW VSS
+ VSS gf180mcu_fd_sc_mcu9t5v0__oai31_1
X_17152_ _17260_/S _18396_/Q _17154_/A3 VSS _17153_/VNW VSS VSS gf180mcu_fd_sc_mcu9t5v0__nor2_1
X_11576_ _12028_/A1 _11706_/A1 _11576_/B _12028_/C _11577_/C VSS VSS VSS VSS gf180mcu_fd_sc_mcu9t5v0__oai211_4
X_14364_ _14364_/I0 _19434_/Q _14367_/S _19434_/D VSS VSS VSS VSS gf180mcu_fd_sc_mcu9t5v0__mux2_1
X_16103_ _18168_/Q _16103_/I1 _16643_/S _18168_/D VSS _16829_/VNW VSS VSS gf180mcu_fd_sc_mcu9t5v0__mux2_4
X_10527_ _10527_/A1 _10527_/A2 _10527_/B1 _10655_/B _10527_/ZN VSS VSS VSS VSS gf180mcu_fd_sc_mcu9t5v0__aoi22_4
X_17083_ _18473_/Q _17282_/A2 _17282_/B1 _18489_/Q _17084_/A2 VSS VSS VSS VSS gf180mcu_fd_sc_mcu9t5v0__aoi22_1
X_14295_ _13948_/Z _19368_/Q _14304_/S _19368_/D VSS VSS VSS VSS gf180mcu_fd_sc_mcu9t5v0__mux2_1
X_13315_ _13333_/A1 _13315_/A2 _13321_/B1 VSS VSS VSS VSS gf180mcu_fd_sc_mcu9t5v0__nand2_1
XTAP_TAPCELL_ROW_20_1540 VSS VSS gf180mcu_fd_sc_mcu9t5v0__filltie
X_16034_ _19265_/Q _15996_/B _16039_/B VSS VSS VSS VSS gf180mcu_fd_sc_mcu9t5v0__nand2_1
X_10458_ _17404_/S _18337_/Q _10459_/B VSS _16320_/VNW VSS VSS gf180mcu_fd_sc_mcu9t5v0__nor2_1
X_13246_ _19735_/Q _19767_/Q _13248_/B VSS VSS VSS VSS gf180mcu_fd_sc_mcu9t5v0__xnor2_1
X_10389_ _10648_/C _10389_/A2 _10389_/B1 _10389_/B2 _10389_/C _10390_/I1 VSS VSS VSS
+ VSS gf180mcu_fd_sc_mcu9t5v0__aoi221_1
X_13177_ _13177_/A1 _13177_/A2 _13556_/B _13194_/A2 VSS _13177_/VNW VSS VSS gf180mcu_fd_sc_mcu9t5v0__aoi21_1
X_17985_ _18872_/Q _18035_/I0 wire128/Z _18872_/D VSS VSS VSS VSS gf180mcu_fd_sc_mcu9t5v0__mux2_1
X_12128_ _18912_/Q _12128_/A2 _12147_/I0 VSS VSS VSS VSS gf180mcu_fd_sc_mcu9t5v0__xnor2_1
XTAP_TAPCELL_ROW_33_1901 VSS VSS gf180mcu_fd_sc_mcu9t5v0__filltie
X_16936_ _16935_/Z _18459_/Q _16940_/S _18459_/D VSS _17170_/VNW VSS VSS gf180mcu_fd_sc_mcu9t5v0__mux2_1
X_12059_ _18363_/Q _18347_/Q _12315_/S _12059_/Z VSS _17129_/VNW VSS VSS gf180mcu_fd_sc_mcu9t5v0__mux2_1
X_19724_ _19724_/D _20044_/RN clkload13/I _19724_/Q VSS VSS VSS VSS gf180mcu_fd_sc_mcu9t5v0__dffrnq_1
XTAP_TAPCELL_ROW_18_1480 VSS VSS gf180mcu_fd_sc_mcu9t5v0__filltie
XTAP_TAPCELL_ROW_18_1491 VSS VSS gf180mcu_fd_sc_mcu9t5v0__filltie
XTAP_TAPCELL_ROW_14_1355 VSS VSS gf180mcu_fd_sc_mcu9t5v0__filltie
XTAP_TAPCELL_ROW_14_1366 VSS VSS gf180mcu_fd_sc_mcu9t5v0__filltie
XTAP_TAPCELL_ROW_14_1377 VSS VSS gf180mcu_fd_sc_mcu9t5v0__filltie
X_16867_ _19245_/Q _16576_/B _16871_/S _16867_/Z VSS VSS VSS VSS gf180mcu_fd_sc_mcu9t5v0__mux2_1
X_19655_ _19655_/D _20039_/RN clkload35/I _19655_/Q VSS VSS VSS VSS gf180mcu_fd_sc_mcu9t5v0__dffrnq_1
X_18606_ _18606_/D clkload57/I _18606_/Q VSS VSS VSS VSS gf180mcu_fd_sc_mcu9t5v0__dffq_1
X_16798_ _18397_/Q _16797_/Z _16798_/S _18397_/D VSS VSS VSS VSS gf180mcu_fd_sc_mcu9t5v0__mux2_1
X_15818_ input7/Z _19987_/Q _15819_/S _19987_/D VSS _15818_/VNW VSS VSS gf180mcu_fd_sc_mcu9t5v0__mux2_1
X_19586_ _19586_/D _20034_/RN clkload19/I _19586_/Q VSS VSS VSS VSS gf180mcu_fd_sc_mcu9t5v0__dffrnq_1
XTAP_TAPCELL_ROW_289_7030 VSS VSS gf180mcu_fd_sc_mcu9t5v0__filltie
X_18537_ _18537_/D _20037_/RN clkload50/I _18537_/Q VSS VSS VSS VSS gf180mcu_fd_sc_mcu9t5v0__dffrnq_1
X_15749_ _19928_/Q _15757_/B _15740_/Z _15751_/A2 VSS _15751_/VNW VSS VSS gf180mcu_fd_sc_mcu9t5v0__nor3_1
XTAP_TAPCELL_ROW_27_1716 VSS VSS gf180mcu_fd_sc_mcu9t5v0__filltie
X_18468_ _18468_/D clkload75/I _18468_/Q VSS VSS VSS VSS gf180mcu_fd_sc_mcu9t5v0__dffq_1
X_09270_ _19927_/Q _15744_/A1 VSS VSS VSS VSS gf180mcu_fd_sc_mcu9t5v0__clkinv_1
XTAP_TAPCELL_ROW_27_1727 VSS VSS gf180mcu_fd_sc_mcu9t5v0__filltie
XTAP_TAPCELL_ROW_27_1738 VSS VSS gf180mcu_fd_sc_mcu9t5v0__filltie
X_17419_ _10774_/Z _18558_/Q _17420_/S _18558_/D VSS VSS VSS VSS gf180mcu_fd_sc_mcu9t5v0__mux2_1
X_18399_ _18399_/D _20099_/CLK _18399_/Q VSS VSS VSS VSS gf180mcu_fd_sc_mcu9t5v0__dffq_4
XTAP_TAPCELL_ROW_90_3463 VSS VSS gf180mcu_fd_sc_mcu9t5v0__filltie
XTAP_TAPCELL_ROW_90_3452 VSS VSS gf180mcu_fd_sc_mcu9t5v0__filltie
XTAP_TAPCELL_ROW_88_3392 VSS VSS gf180mcu_fd_sc_mcu9t5v0__filltie
XTAP_TAPCELL_ROW_270_6506 VSS VSS gf180mcu_fd_sc_mcu9t5v0__filltie
XTAP_TAPCELL_ROW_255_6085 VSS VSS gf180mcu_fd_sc_mcu9t5v0__filltie
XTAP_TAPCELL_ROW_255_6074 VSS VSS gf180mcu_fd_sc_mcu9t5v0__filltie
X_09606_ _17631_/A3 _10841_/A1 _17425_/A2 VSS _09689_/VNW VSS VSS gf180mcu_fd_sc_mcu9t5v0__nand2_1
XTAP_TAPCELL_ROW_84_3289 VSS VSS gf180mcu_fd_sc_mcu9t5v0__filltie
XTAP_TAPCELL_ROW_255_6096 VSS VSS gf180mcu_fd_sc_mcu9t5v0__filltie
X_09537_ _20141_/Q _20013_/Q _20018_/Q _20016_/Q _09538_/A4 VSS _09538_/VNW VSS VSS
+ gf180mcu_fd_sc_mcu9t5v0__nor4_1
XTAP_TAPCELL_ROW_200_1_4770 VSS VSS gf180mcu_fd_sc_mcu9t5v0__filltie
XTAP_TAPCELL_ROW_208_3_8252 VSS VSS gf180mcu_fd_sc_mcu9t5v0__filltie
X_09468_ _19106_/Q _19123_/Q _19174_/Q _19183_/Q _09469_/C VSS VSS VSS VSS gf180mcu_fd_sc_mcu9t5v0__nand4_1
XTAP_TAPCELL_ROW_97_3639 VSS VSS gf180mcu_fd_sc_mcu9t5v0__filltie
XTAP_TAPCELL_ROW_268_6446 VSS VSS gf180mcu_fd_sc_mcu9t5v0__filltie
XTAP_TAPCELL_ROW_268_6435 VSS VSS gf180mcu_fd_sc_mcu9t5v0__filltie
X_09399_ _09400_/A1 wire216/I _09875_/A2 _09399_/Z VSS VSS VSS VSS gf180mcu_fd_sc_mcu9t5v0__and3_4
X_11430_ _18528_/Q _18512_/Q _18496_/Q _18480_/Q _11524_/S _11485_/C _11430_/Z VSS
+ VSS VSS VSS gf180mcu_fd_sc_mcu9t5v0__mux4_1
X_11361_ _11176_/C _11360_/Z _11365_/A2 VSS _11361_/VNW VSS VSS gf180mcu_fd_sc_mcu9t5v0__nor2_1
X_10312_ _18989_/Q _10654_/A2 _10312_/B wire160/Z _10314_/B1 VSS _18108_/VNW VSS VSS
+ gf180mcu_fd_sc_mcu9t5v0__oai211_1
X_13100_ _13100_/I _13124_/A1 VSS VSS VSS VSS gf180mcu_fd_sc_mcu9t5v0__clkinv_1
XTAP_TAPCELL_ROW_37_2001 VSS VSS gf180mcu_fd_sc_mcu9t5v0__filltie
XTAP_TAPCELL_ROW_37_2012 VSS VSS gf180mcu_fd_sc_mcu9t5v0__filltie
X_11292_ wire136/Z _11287_/Z _11292_/B wire283/Z _11293_/A2 VSS VSS VSS VSS gf180mcu_fd_sc_mcu9t5v0__oai211_1
XTAP_TAPCELL_ROW_201_3_8228 VSS VSS gf180mcu_fd_sc_mcu9t5v0__filltie
X_14080_ _14080_/A1 _14080_/A2 _14080_/B _14088_/A1 VSS _14080_/VNW VSS VSS gf180mcu_fd_sc_mcu9t5v0__oai21_1
XPHY_EDGE_ROW_18_Left_342 VSS VSS gf180mcu_fd_sc_mcu9t5v0__endcap
X_10243_ _10648_/C _19817_/Q _17225_/B VSS VSS VSS VSS gf180mcu_fd_sc_mcu9t5v0__nor2_2
XTAP_TAPCELL_ROW_73_2982 VSS VSS gf180mcu_fd_sc_mcu9t5v0__filltie
X_13031_ _13031_/A1 _13304_/B _13031_/B1 _13031_/B2 _19232_/D VSS _13031_/VNW VSS
+ VSS gf180mcu_fd_sc_mcu9t5v0__aoi22_1
X_10174_ _18978_/Q _09998_/C _10174_/B _10174_/C _10175_/B VSS _10174_/VNW VSS VSS
+ gf180mcu_fd_sc_mcu9t5v0__aoi211_1
XTAP_TAPCELL_ROW_73_2993 VSS VSS gf180mcu_fd_sc_mcu9t5v0__filltie
XTAP_TAPCELL_ROW_240_5675 VSS VSS gf180mcu_fd_sc_mcu9t5v0__filltie
XTAP_TAPCELL_ROW_240_5664 VSS VSS gf180mcu_fd_sc_mcu9t5v0__filltie
X_17770_ _18760_/Q _17773_/A2 _17771_/B VSS _17770_/VNW VSS VSS gf180mcu_fd_sc_mcu9t5v0__nor2_1
X_16721_ _19285_/Q _16695_/B _16722_/A3 VSS VSS VSS VSS gf180mcu_fd_sc_mcu9t5v0__nor2_1
X_14982_ _19429_/Q _19374_/Q _14982_/B _14984_/A2 VSS VSS VSS VSS gf180mcu_fd_sc_mcu9t5v0__oai21_1
X_13933_ _13934_/A2 _13934_/A3 _13933_/Z VSS _13933_/VNW VSS VSS gf180mcu_fd_sc_mcu9t5v0__and2_1
X_16652_ _16652_/A1 _16672_/A2 _16672_/B _16654_/B VSS VSS VSS VSS gf180mcu_fd_sc_mcu9t5v0__oai21_2
X_19440_ _19440_/D _20144_/RN clkload12/I _19440_/Q VSS VSS VSS VSS gf180mcu_fd_sc_mcu9t5v0__dffrnq_1
X_13864_ _13870_/A1 _13870_/A2 _13866_/A2 VSS VSS VSS VSS gf180mcu_fd_sc_mcu9t5v0__xnor2_1
X_16583_ _16584_/B _16688_/A2 VSS VSS VSS VSS gf180mcu_fd_sc_mcu9t5v0__clkinv_1
X_15603_ _19886_/Q _19887_/Q _15618_/A3 VSS VSS VSS VSS gf180mcu_fd_sc_mcu9t5v0__nand2_1
X_12815_ _19729_/Q _19794_/Q _12948_/S _12815_/Z VSS VSS VSS VSS gf180mcu_fd_sc_mcu9t5v0__mux2_1
XPHY_EDGE_ROW_27_Left_351 VSS VSS gf180mcu_fd_sc_mcu9t5v0__endcap
X_19371_ _19371_/D _20139_/RN clkload20/I _19371_/Q VSS VSS VSS VSS gf180mcu_fd_sc_mcu9t5v0__dffrnq_1
X_18322_ _18322_/D _18324_/CLK _18322_/Q VSS VSS VSS VSS gf180mcu_fd_sc_mcu9t5v0__dffq_4
X_15534_ _19852_/Q _19835_/Q _15551_/S _19852_/D VSS VSS VSS VSS gf180mcu_fd_sc_mcu9t5v0__mux2_1
X_13795_ _13803_/B2 _13781_/B _13795_/A3 _13795_/Z VSS VSS VSS VSS gf180mcu_fd_sc_mcu9t5v0__xor3_1
XPHY_EDGE_ROW_187_1_Left_510 VSS VSS gf180mcu_fd_sc_mcu9t5v0__endcap
X_12746_ _19720_/Q _19785_/Q _13244_/B _12746_/Z VSS _12749_/VNW VSS VSS gf180mcu_fd_sc_mcu9t5v0__mux2_1
X_18253_ _18253_/D clkload62/I _18253_/Q VSS VSS VSS VSS gf180mcu_fd_sc_mcu9t5v0__dffq_1
X_15465_ _19824_/Q _15465_/A2 _19817_/Q _15466_/A4 VSS VSS VSS VSS gf180mcu_fd_sc_mcu9t5v0__oai21_1
X_12677_ _12716_/S _12716_/I1 _12677_/B _12682_/C _12679_/A2 VSS _12677_/VNW VSS VSS
+ gf180mcu_fd_sc_mcu9t5v0__oai211_1
X_17204_ _17225_/B _17204_/A2 _17412_/B _17205_/B VSS VSS VSS VSS gf180mcu_fd_sc_mcu9t5v0__aoi21_1
X_18184_ _18184_/D clkload82/I _18184_/Q VSS VSS VSS VSS gf180mcu_fd_sc_mcu9t5v0__dffq_4
X_15396_ _19681_/Q _19781_/Q _15420_/S _19781_/D VSS VSS VSS VSS gf180mcu_fd_sc_mcu9t5v0__mux2_1
X_11628_ _11659_/A1 _11604_/Z _12670_/A2 VSS _12649_/VNW VSS VSS gf180mcu_fd_sc_mcu9t5v0__nand2_1
X_14416_ _19452_/Q _14766_/A2 _14426_/A1 VSS VSS VSS VSS gf180mcu_fd_sc_mcu9t5v0__nand2_1
X_17135_ _17177_/B _17135_/A2 _17136_/C VSS _17135_/VNW VSS VSS gf180mcu_fd_sc_mcu9t5v0__nor2_1
X_14347_ _13948_/Z _19418_/Q _14352_/S _19418_/D VSS VSS VSS VSS gf180mcu_fd_sc_mcu9t5v0__mux2_1
X_11559_ _18567_/Q wire175/I _15939_/B _11736_/C VSS _11559_/VNW VSS VSS gf180mcu_fd_sc_mcu9t5v0__aoi21_4
XPHY_EDGE_ROW_36_Left_360 VSS VSS gf180mcu_fd_sc_mcu9t5v0__endcap
X_17066_ _18528_/Q _16622_/B _17067_/S _18528_/D VSS VSS VSS VSS gf180mcu_fd_sc_mcu9t5v0__mux2_4
X_14278_ _14364_/I0 _19352_/Q _14285_/S _19352_/D VSS VSS VSS VSS gf180mcu_fd_sc_mcu9t5v0__mux2_1
X_16017_ _19230_/Q _16700_/A2 wire71/I _16018_/A3 VSS VSS VSS VSS gf180mcu_fd_sc_mcu9t5v0__nor3_1
X_13229_ _19800_/Q _13229_/A2 _13238_/A1 VSS _13229_/VNW VSS VSS gf180mcu_fd_sc_mcu9t5v0__nand2_1
XTAP_TAPCELL_ROW_16_1417 VSS VSS gf180mcu_fd_sc_mcu9t5v0__filltie
XTAP_TAPCELL_ROW_16_1428 VSS VSS gf180mcu_fd_sc_mcu9t5v0__filltie
XTAP_TAPCELL_ROW_189_3_8186 VSS VSS gf180mcu_fd_sc_mcu9t5v0__filltie
XPHY_EDGE_ROW_175_3_Left_833 VSS VSS gf180mcu_fd_sc_mcu9t5v0__endcap
X_17968_ _17968_/A1 _17968_/A2 _18858_/D VSS _17968_/VNW VSS VSS gf180mcu_fd_sc_mcu9t5v0__nor2_1
X_16919_ _16647_/B _19255_/Q _16925_/S _16919_/Z VSS _16919_/VNW VSS VSS gf180mcu_fd_sc_mcu9t5v0__mux2_1
X_17899_ _18836_/Q _17902_/A3 _17899_/B _18836_/D VSS VSS VSS VSS gf180mcu_fd_sc_mcu9t5v0__oai21_1
X_19707_ _19707_/D _19963_/RN clkload35/I _19707_/Q VSS VSS VSS VSS gf180mcu_fd_sc_mcu9t5v0__dffrnq_1
Xeco10_buf_15936 _15936_/ZN _15988_/C VSS VSS VSS VSS gf180mcu_fd_sc_mcu9t5v0__clkbuf_16
X_19638_ _19638_/D _20022_/RN clkload20/I _19638_/Q VSS VSS VSS VSS gf180mcu_fd_sc_mcu9t5v0__dffrnq_1
X_09322_ _19239_/Q _16430_/A1 VSS VSS VSS VSS gf180mcu_fd_sc_mcu9t5v0__inv_2
X_19569_ _19569_/D _20145_/RN clkload17/I _19569_/Q VSS VSS VSS VSS gf180mcu_fd_sc_mcu9t5v0__dffrnq_1
XPHY_EDGE_ROW_171_1_Left_494 VSS VSS gf180mcu_fd_sc_mcu9t5v0__endcap
X_09253_ _18843_/Q _17919_/A1 VSS VSS VSS VSS gf180mcu_fd_sc_mcu9t5v0__clkinv_1
XTAP_TAPCELL_ROW_135_4698 VSS VSS gf180mcu_fd_sc_mcu9t5v0__filltie
XTAP_TAPCELL_ROW_135_4687 VSS VSS gf180mcu_fd_sc_mcu9t5v0__filltie
X_09184_ _19121_/Q _14448_/A2 VSS VSS VSS VSS gf180mcu_fd_sc_mcu9t5v0__clkinv_1
XTAP_TAPCELL_ROW_263_6310 VSS VSS gf180mcu_fd_sc_mcu9t5v0__filltie
XTAP_TAPCELL_ROW_92_3525 VSS VSS gf180mcu_fd_sc_mcu9t5v0__filltie
XTAP_TAPCELL_ROW_92_3514 VSS VSS gf180mcu_fd_sc_mcu9t5v0__filltie
XTAP_TAPCELL_ROW_92_3503 VSS VSS gf180mcu_fd_sc_mcu9t5v0__filltie
XTAP_TAPCELL_ROW_77_3093 VSS VSS gf180mcu_fd_sc_mcu9t5v0__filltie
XTAP_TAPCELL_ROW_257_6147 VSS VSS gf180mcu_fd_sc_mcu9t5v0__filltie
XTAP_TAPCELL_ROW_257_6136 VSS VSS gf180mcu_fd_sc_mcu9t5v0__filltie
XTAP_TAPCELL_ROW_257_6125 VSS VSS gf180mcu_fd_sc_mcu9t5v0__filltie
X_10930_ _10962_/B _19004_/Q _18102_/B _19004_/D VSS _10930_/VNW VSS VSS gf180mcu_fd_sc_mcu9t5v0__mux2_1
XTAP_TAPCELL_ROW_6_1140 VSS VSS gf180mcu_fd_sc_mcu9t5v0__filltie
XTAP_TAPCELL_ROW_6_1151 VSS VSS gf180mcu_fd_sc_mcu9t5v0__filltie
XTAP_TAPCELL_ROW_2_1026 VSS VSS gf180mcu_fd_sc_mcu9t5v0__filltie
XTAP_TAPCELL_ROW_2_1037 VSS VSS gf180mcu_fd_sc_mcu9t5v0__filltie
X_12600_ _18502_/Q _12616_/A2 _12616_/B _12601_/B2 VSS VSS VSS VSS gf180mcu_fd_sc_mcu9t5v0__oai21_1
X_10861_ _10861_/I0 _18969_/Q _18148_/S _18969_/D VSS _10861_/VNW VSS VSS gf180mcu_fd_sc_mcu9t5v0__mux2_1
XTAP_TAPCELL_ROW_2_1048 VSS VSS gf180mcu_fd_sc_mcu9t5v0__filltie
X_10792_ _10792_/A1 _10792_/A2 _10792_/B _10792_/ZN VSS VSS VSS VSS gf180mcu_fd_sc_mcu9t5v0__aoi21_4
X_13580_ _13239_/Z _13581_/A3 _13580_/B _13586_/A3 VSS _13580_/VNW VSS VSS gf180mcu_fd_sc_mcu9t5v0__oai21_1
X_12531_ _18398_/Q _12582_/A2 _12534_/A3 VSS VSS VSS VSS gf180mcu_fd_sc_mcu9t5v0__nor2_1
XTAP_TAPCELL_ROW_233_5490 VSS VSS gf180mcu_fd_sc_mcu9t5v0__filltie
XTAP_TAPCELL_ROW_62_2683 VSS VSS gf180mcu_fd_sc_mcu9t5v0__filltie
XTAP_TAPCELL_ROW_62_2694 VSS VSS gf180mcu_fd_sc_mcu9t5v0__filltie
X_12462_ _18166_/Q _12613_/A2 _12466_/A2 VSS _12463_/VNW VSS VSS gf180mcu_fd_sc_mcu9t5v0__nor2_1
XPHY_EDGE_ROW_139_2_Left_651 VSS VSS gf180mcu_fd_sc_mcu9t5v0__endcap
X_15250_ _19729_/Q _15417_/S _15252_/B VSS VSS VSS VSS gf180mcu_fd_sc_mcu9t5v0__nand2_1
X_11413_ _18463_/Q _11403_/S _11428_/B _11414_/A2 VSS VSS VSS VSS gf180mcu_fd_sc_mcu9t5v0__oai21_1
X_14201_ _14201_/A1 _14201_/A2 _14201_/Z VSS VSS VSS VSS gf180mcu_fd_sc_mcu9t5v0__xor2_1
X_12393_ _18735_/Q wire198/Z _12543_/B1 _12393_/B2 _12394_/A3 VSS VSS VSS VSS gf180mcu_fd_sc_mcu9t5v0__aoi22_1
X_15181_ _19583_/Q _15182_/A2 _19582_/Q _15181_/B2 _15183_/B2 VSS VSS VSS VSS gf180mcu_fd_sc_mcu9t5v0__aoi22_1
X_11344_ _18458_/Q _11403_/S _11428_/B _11346_/A2 VSS _11346_/VNW VSS VSS gf180mcu_fd_sc_mcu9t5v0__oai21_1
XTAP_TAPCELL_ROW_246_5840 VSS VSS gf180mcu_fd_sc_mcu9t5v0__filltie
X_14132_ _14105_/I _14132_/A2 _14134_/A2 VSS VSS VSS VSS gf180mcu_fd_sc_mcu9t5v0__xnor2_1
XTAP_TAPCELL_ROW_242_5726 VSS VSS gf180mcu_fd_sc_mcu9t5v0__filltie
X_11275_ _18341_/Q _18325_/Q _18309_/Q _18293_/Q _11534_/S wire136/Z _11275_/Z VSS
+ VSS VSS VSS gf180mcu_fd_sc_mcu9t5v0__mux4_1
X_18940_ _18940_/D _20028_/RN clkload66/I _18940_/Q VSS VSS VSS VSS gf180mcu_fd_sc_mcu9t5v0__dffrnq_1
XTAP_TAPCELL_ROW_242_5715 VSS VSS gf180mcu_fd_sc_mcu9t5v0__filltie
X_14063_ _14063_/I _14065_/A1 VSS VSS VSS VSS gf180mcu_fd_sc_mcu9t5v0__clkinv_1
X_10226_ _17404_/S _18329_/Q _10228_/A3 VSS _10231_/VNW VSS VSS gf180mcu_fd_sc_mcu9t5v0__nor2_1
XTAP_TAPCELL_ROW_242_5737 VSS VSS gf180mcu_fd_sc_mcu9t5v0__filltie
X_13014_ _19754_/Q _19788_/Q _13015_/B VSS _13044_/VNW VSS VSS gf180mcu_fd_sc_mcu9t5v0__xor2_1
X_18871_ _18871_/D _20023_/RN clkload40/I _18871_/Q VSS VSS VSS VSS gf180mcu_fd_sc_mcu9t5v0__dffrnq_1
X_10157_ _20042_/Q _15597_/A1 _10157_/B1 _10157_/B2 _10158_/A2 VSS VSS VSS VSS gf180mcu_fd_sc_mcu9t5v0__aoi22_1
X_17822_ _19029_/Q _18799_/Q _17845_/S _18799_/D VSS _17822_/VNW VSS VSS gf180mcu_fd_sc_mcu9t5v0__mux2_1
X_10088_ _10088_/A1 _10088_/A2 _10108_/A2 VSS _10088_/VNW VSS VSS gf180mcu_fd_sc_mcu9t5v0__nand2_1
X_17753_ _18748_/Q _18754_/Q _17753_/S _18754_/D VSS VSS VSS VSS gf180mcu_fd_sc_mcu9t5v0__mux2_1
X_14965_ _19427_/Q _19372_/Q _14971_/A1 VSS _14971_/VNW VSS VSS gf180mcu_fd_sc_mcu9t5v0__nand2_1
X_16704_ _19250_/Q _16730_/C _16706_/B1 VSS VSS VSS VSS gf180mcu_fd_sc_mcu9t5v0__nor2_1
X_17684_ _09705_/Z _18646_/Q _18664_/Q _17684_/Z VSS VSS VSS VSS gf180mcu_fd_sc_mcu9t5v0__mux2_1
X_13916_ _13916_/A1 _13916_/A2 _13919_/A1 VSS VSS VSS VSS gf180mcu_fd_sc_mcu9t5v0__nor2_1
X_16635_ _19253_/Q _16751_/A2 wire71/Z _16636_/A3 VSS VSS VSS VSS gf180mcu_fd_sc_mcu9t5v0__nor3_1
X_14896_ _14896_/A1 _14896_/A2 _14897_/B VSS VSS VSS VSS gf180mcu_fd_sc_mcu9t5v0__nand2_1
X_19423_ _19423_/D _20063_/RN clkload8/I _19423_/Q VSS VSS VSS VSS gf180mcu_fd_sc_mcu9t5v0__dffrnq_1
X_13847_ _19318_/Q _19296_/Q _13873_/B2 VSS VSS VSS VSS gf180mcu_fd_sc_mcu9t5v0__nand2_1
X_16566_ _16665_/A2 _16563_/Z _16566_/B _17059_/I1 VSS _16566_/VNW VSS VSS gf180mcu_fd_sc_mcu9t5v0__oai21_1
X_13778_ _13803_/B2 _13803_/B3 _13783_/A1 VSS VSS VSS VSS gf180mcu_fd_sc_mcu9t5v0__nor2_1
X_19354_ _19354_/D _20058_/RN clkload18/I _19354_/Q VSS VSS VSS VSS gf180mcu_fd_sc_mcu9t5v0__dffrnq_1
X_16497_ _19237_/Q _16162_/B _17025_/S _16497_/Z VSS _16497_/VNW VSS VSS gf180mcu_fd_sc_mcu9t5v0__mux2_4
X_18305_ _18305_/D clkload68/I _18305_/Q VSS VSS VSS VSS gf180mcu_fd_sc_mcu9t5v0__dffq_1
X_15517_ _19843_/Q _15515_/Z _15519_/A2 VSS _15517_/VNW VSS VSS gf180mcu_fd_sc_mcu9t5v0__nor2_1
X_19285_ _19285_/D _20053_/RN clkload37/I _19285_/Q VSS VSS VSS VSS gf180mcu_fd_sc_mcu9t5v0__dffrnq_1
X_12729_ _15090_/A2 _12729_/A2 _19193_/D VSS VSS VSS VSS gf180mcu_fd_sc_mcu9t5v0__nand2_1
X_15448_ _15445_/B _15448_/A2 _19819_/Q _15450_/B VSS VSS VSS VSS gf180mcu_fd_sc_mcu9t5v0__oai21_1
X_18236_ _18236_/D _20129_/CLK _18236_/Q VSS VSS VSS VSS gf180mcu_fd_sc_mcu9t5v0__dffq_1
XTAP_TAPCELL_ROW_206_2_8243 VSS VSS gf180mcu_fd_sc_mcu9t5v0__filltie
X_18167_ _18167_/D clkload68/I _18167_/Q VSS VSS VSS VSS gf180mcu_fd_sc_mcu9t5v0__dffq_1
XTAP_TAPCELL_ROW_212_4895 VSS VSS gf180mcu_fd_sc_mcu9t5v0__filltie
XTAP_TAPCELL_ROW_130_4562 VSS VSS gf180mcu_fd_sc_mcu9t5v0__filltie
X_15379_ _19664_/Q _19764_/Q _15420_/S _19764_/D VSS VSS VSS VSS gf180mcu_fd_sc_mcu9t5v0__mux2_1
XTAP_TAPCELL_ROW_130_4551 VSS VSS gf180mcu_fd_sc_mcu9t5v0__filltie
Xmax_cap101 _14546_/S _14764_/B VSS VSS VSS VSS gf180mcu_fd_sc_mcu9t5v0__buf_4
X_17118_ _19857_/Q _17161_/C _17118_/B _17120_/A3 VSS _17118_/VNW VSS VSS gf180mcu_fd_sc_mcu9t5v0__oai21_1
X_18098_ _18060_/B _10996_/S _18098_/B _18936_/Q _18099_/A2 VSS VSS VSS VSS gf180mcu_fd_sc_mcu9t5v0__oai211_1
X_17049_ _16647_/B _19255_/Q _17055_/S _17049_/Z VSS _17049_/VNW VSS VSS gf180mcu_fd_sc_mcu9t5v0__mux2_1
XTAP_TAPCELL_ROW_320_7859 VSS VSS gf180mcu_fd_sc_mcu9t5v0__filltie
Xmax_cap156 _11519_/A2 _11509_/A2 VSS VSS VSS VSS gf180mcu_fd_sc_mcu9t5v0__clkbuf_8
X_09940_ _18815_/Q _18816_/Q _18814_/Q _09943_/A1 VSS VSS VSS VSS gf180mcu_fd_sc_mcu9t5v0__nand3_1
Xmax_cap189 _17380_/B1 _17405_/A2 VSS _16497_/VNW VSS VSS gf180mcu_fd_sc_mcu9t5v0__buf_8
X_20060_ _20060_/D _20060_/RN clkload58/I _20060_/Q VSS VSS VSS VSS gf180mcu_fd_sc_mcu9t5v0__dffrnq_1
XPHY_EDGE_ROW_115_Right_115 VSS VSS gf180mcu_fd_sc_mcu9t5v0__endcap
Xmax_cap178 _13244_/B _12948_/S VSS _12497_/VNW VSS VSS gf180mcu_fd_sc_mcu9t5v0__buf_8
X_09871_ _20047_/Q _09870_/Z _10201_/A2 VSS VSS VSS VSS gf180mcu_fd_sc_mcu9t5v0__nor2_1
XTAP_TAPCELL_ROW_128_4491 VSS VSS gf180mcu_fd_sc_mcu9t5v0__filltie
XTAP_TAPCELL_ROW_124_4388 VSS VSS gf180mcu_fd_sc_mcu9t5v0__filltie
XTAP_TAPCELL_ROW_252_6000 VSS VSS gf180mcu_fd_sc_mcu9t5v0__filltie
XTAP_TAPCELL_ROW_124_4399 VSS VSS gf180mcu_fd_sc_mcu9t5v0__filltie
XTAP_TAPCELL_ROW_81_3215 VSS VSS gf180mcu_fd_sc_mcu9t5v0__filltie
XTAP_TAPCELL_ROW_81_3204 VSS VSS gf180mcu_fd_sc_mcu9t5v0__filltie
XTAP_TAPCELL_ROW_252_6011 VSS VSS gf180mcu_fd_sc_mcu9t5v0__filltie
X_09305_ _19258_/Q _16959_/A1 VSS VSS VSS VSS gf180mcu_fd_sc_mcu9t5v0__inv_1
X_09236_ _18769_/Q _15936_/B VSS _10205_/VNW VSS VSS gf180mcu_fd_sc_mcu9t5v0__clkinv_1
XTAP_TAPCELL_ROW_79_3166 VSS VSS gf180mcu_fd_sc_mcu9t5v0__filltie
XTAP_TAPCELL_ROW_79_3155 VSS VSS gf180mcu_fd_sc_mcu9t5v0__filltie
XTAP_TAPCELL_ROW_79_3144 VSS VSS gf180mcu_fd_sc_mcu9t5v0__filltie
XPHY_EDGE_ROW_17_Right_17 VSS VSS gf180mcu_fd_sc_mcu9t5v0__endcap
X_09167_ _19814_/Q _13475_/A2 VSS _09167_/VNW VSS VSS gf180mcu_fd_sc_mcu9t5v0__clkinv_1
X_09098_ _18566_/Q _11558_/C VSS wire28/VNW VSS VSS gf180mcu_fd_sc_mcu9t5v0__inv_8
X_11060_ _18030_/I0 _19061_/Q _11067_/S _19061_/D VSS _17822_/VNW VSS VSS gf180mcu_fd_sc_mcu9t5v0__mux2_1
X_10011_ _18973_/Q _09998_/C _10169_/B1 _18981_/Q _10011_/C _10012_/A2 VSS _10011_/VNW
+ VSS VSS gf180mcu_fd_sc_mcu9t5v0__aoi221_1
XTAP_TAPCELL_ROW_51_2373 VSS VSS gf180mcu_fd_sc_mcu9t5v0__filltie
XTAP_TAPCELL_ROW_8_1202 VSS VSS gf180mcu_fd_sc_mcu9t5v0__filltie
XTAP_TAPCELL_ROW_51_2384 VSS VSS gf180mcu_fd_sc_mcu9t5v0__filltie
XTAP_TAPCELL_ROW_8_1213 VSS VSS gf180mcu_fd_sc_mcu9t5v0__filltie
XPHY_EDGE_ROW_26_Right_26 VSS VSS gf180mcu_fd_sc_mcu9t5v0__endcap
XTAP_TAPCELL_ROW_222_5180 VSS VSS gf180mcu_fd_sc_mcu9t5v0__filltie
XTAP_TAPCELL_ROW_51_2395 VSS VSS gf180mcu_fd_sc_mcu9t5v0__filltie
X_14750_ _14752_/C _14752_/A2 _14751_/C VSS VSS VSS VSS gf180mcu_fd_sc_mcu9t5v0__nor2_1
X_13701_ _13724_/B1 _14662_/A1 _13702_/A2 VSS VSS VSS VSS gf180mcu_fd_sc_mcu9t5v0__xnor2_1
X_11962_ _12548_/A1 _11962_/A2 _11967_/B1 VSS _11962_/VNW VSS VSS gf180mcu_fd_sc_mcu9t5v0__nand2_4
X_11893_ _18275_/Q _12315_/S _11896_/A1 VSS _11897_/VNW VSS VSS gf180mcu_fd_sc_mcu9t5v0__nor2_1
XTAP_TAPCELL_ROW_235_5541 VSS VSS gf180mcu_fd_sc_mcu9t5v0__filltie
XTAP_TAPCELL_ROW_235_5530 VSS VSS gf180mcu_fd_sc_mcu9t5v0__filltie
X_10913_ _19259_/Q _18147_/S _10924_/B VSS VSS VSS VSS gf180mcu_fd_sc_mcu9t5v0__nand2_1
Xclkbuf_leaf_15_clk_regs clkload4/I clkload55/I VSS VSS VSS VSS gf180mcu_fd_sc_mcu9t5v0__clkbuf_8
XTAP_TAPCELL_ROW_64_2734 VSS VSS gf180mcu_fd_sc_mcu9t5v0__filltie
X_14681_ _14681_/A1 _14681_/A2 _14681_/Z VSS VSS VSS VSS gf180mcu_fd_sc_mcu9t5v0__xor2_1
XTAP_TAPCELL_ROW_64_2745 VSS VSS gf180mcu_fd_sc_mcu9t5v0__filltie
XTAP_TAPCELL_ROW_64_2756 VSS VSS gf180mcu_fd_sc_mcu9t5v0__filltie
Xeco15_sk2_6 eco15_sk2_6/I _18291_/CLK VSS VSS VSS VSS gf180mcu_fd_sc_mcu9t5v0__clkbuf_16
X_16420_ _16420_/A1 _16809_/S _16420_/B _16421_/I0 VSS VSS VSS VSS gf180mcu_fd_sc_mcu9t5v0__oai21_1
X_10844_ _19195_/Q _09417_/I _18102_/B VSS _11424_/VNW VSS VSS gf180mcu_fd_sc_mcu9t5v0__nand2_2
X_13632_ _13632_/A1 _13632_/A2 _13632_/B _19288_/D VSS VSS VSS VSS gf180mcu_fd_sc_mcu9t5v0__oai21_1
X_16351_ _19235_/Q _16151_/B _16881_/S _16351_/Z VSS VSS VSS VSS gf180mcu_fd_sc_mcu9t5v0__mux2_4
XTAP_TAPCELL_ROW_231_5427 VSS VSS gf180mcu_fd_sc_mcu9t5v0__filltie
XTAP_TAPCELL_ROW_231_5416 VSS VSS gf180mcu_fd_sc_mcu9t5v0__filltie
X_13563_ _19274_/Q _13497_/B _13568_/B VSS _13567_/VNW VSS VSS gf180mcu_fd_sc_mcu9t5v0__nand2_1
X_12514_ _18348_/Q _12382_/S _12518_/A2 VSS VSS VSS VSS gf180mcu_fd_sc_mcu9t5v0__nor2_1
XPHY_EDGE_ROW_266_Right_193 VSS VSS gf180mcu_fd_sc_mcu9t5v0__endcap
X_10775_ _18558_/Q _10796_/A2 _10774_/Z _17075_/A1 wire282/I _10792_/B VSS VSS VSS
+ VSS gf180mcu_fd_sc_mcu9t5v0__aoi221_4
X_15302_ _19637_/Q _19614_/Q _15302_/A3 _15302_/Z VSS VSS VSS VSS gf180mcu_fd_sc_mcu9t5v0__xor3_1
XPHY_EDGE_ROW_35_Right_35 VSS VSS gf180mcu_fd_sc_mcu9t5v0__endcap
X_19070_ _19070_/D _20030_/RN clkload11/I _19070_/Q VSS VSS VSS VSS gf180mcu_fd_sc_mcu9t5v0__dffrnq_1
XTAP_TAPCELL_ROW_248_5902 VSS VSS gf180mcu_fd_sc_mcu9t5v0__filltie
X_16282_ _16177_/C _16809_/S _16432_/B VSS _16433_/VNW VSS VSS gf180mcu_fd_sc_mcu9t5v0__nand2_4
XTAP_TAPCELL_ROW_154_1_4747 VSS VSS gf180mcu_fd_sc_mcu9t5v0__filltie
X_13494_ _12948_/S _13492_/Z _13494_/A3 _13498_/B1 VSS VSS VSS VSS gf180mcu_fd_sc_mcu9t5v0__nand3_1
X_18021_ _15581_/B _18906_/Q _18021_/S _18906_/D VSS _18021_/VNW VSS VSS gf180mcu_fd_sc_mcu9t5v0__mux2_1
X_12445_ _12355_/I _12485_/A2 _12445_/A3 _12445_/B _19151_/D VSS _12445_/VNW VSS VSS
+ gf180mcu_fd_sc_mcu9t5v0__oai31_1
X_15233_ _19726_/Q _15233_/I1 _15364_/S _19726_/D VSS VSS VSS VSS gf180mcu_fd_sc_mcu9t5v0__mux2_1
X_12376_ _12376_/A1 _12607_/A2 _12377_/C VSS VSS VSS VSS gf180mcu_fd_sc_mcu9t5v0__nand2_1
XTAP_TAPCELL_ROW_229_5367 VSS VSS gf180mcu_fd_sc_mcu9t5v0__filltie
XTAP_TAPCELL_ROW_229_5356 VSS VSS gf180mcu_fd_sc_mcu9t5v0__filltie
X_15164_ _19706_/Q _19546_/Q wire108/Z _19706_/D VSS VSS VSS VSS gf180mcu_fd_sc_mcu9t5v0__mux2_1
XTAP_TAPCELL_ROW_229_5378 VSS VSS gf180mcu_fd_sc_mcu9t5v0__filltie
X_11327_ _19090_/Q _11423_/A1 _11340_/B VSS VSS VSS VSS gf180mcu_fd_sc_mcu9t5v0__nand2_1
X_14115_ _14115_/A1 _14115_/A2 _14115_/Z VSS VSS VSS VSS gf180mcu_fd_sc_mcu9t5v0__xor2_1
X_19972_ _19972_/D _20036_/RN clkload46/I _19972_/Q VSS VSS VSS VSS gf180mcu_fd_sc_mcu9t5v0__dffrnq_1
X_15095_ _15095_/I _15098_/A3 VSS _15099_/VNW VSS VSS gf180mcu_fd_sc_mcu9t5v0__clkinv_1
X_11258_ _18212_/Q _11509_/A2 _11259_/C VSS VSS VSS VSS gf180mcu_fd_sc_mcu9t5v0__nand2_1
X_18923_ _18923_/D _20139_/RN clkload44/I _18923_/Q VSS VSS VSS VSS gf180mcu_fd_sc_mcu9t5v0__dffrnq_1
X_14046_ _19321_/Q _19298_/Q _14051_/A1 VSS VSS VSS VSS gf180mcu_fd_sc_mcu9t5v0__nand2_1
XPHY_EDGE_ROW_44_Right_44 VSS VSS gf180mcu_fd_sc_mcu9t5v0__endcap
X_11189_ _18271_/Q _11534_/S _11428_/B _11191_/A2 VSS VSS VSS VSS gf180mcu_fd_sc_mcu9t5v0__oai21_1
X_10209_ _15442_/A1 _15466_/A3 _20050_/D VSS VSS VSS VSS gf180mcu_fd_sc_mcu9t5v0__nor2_1
X_18854_ _18854_/D _20070_/RN clkload35/I _18854_/Q VSS VSS VSS VSS gf180mcu_fd_sc_mcu9t5v0__dffrnq_1
X_17805_ input6/Z _18783_/Q _17807_/S _18783_/D VSS VSS VSS VSS gf180mcu_fd_sc_mcu9t5v0__mux2_1
XTAP_TAPCELL_ROW_292_7092 VSS VSS gf180mcu_fd_sc_mcu9t5v0__filltie
X_18785_ _18785_/D _20065_/RN clkload63/I _18785_/Q VSS VSS VSS VSS gf180mcu_fd_sc_mcu9t5v0__dffrnq_1
X_15997_ _16700_/A2 wire71/I _16024_/B _16570_/A3 VSS VSS VSS VSS gf180mcu_fd_sc_mcu9t5v0__oai21_1
X_17736_ _18744_/Q _17681_/S _17737_/B VSS _17736_/VNW VSS VSS gf180mcu_fd_sc_mcu9t5v0__nand2_1
X_14948_ _19612_/Q _19368_/Q _20039_/D _19612_/D VSS _14948_/VNW VSS VSS gf180mcu_fd_sc_mcu9t5v0__mux2_1
XTAP_TAPCELL_ROW_313_7674 VSS VSS gf180mcu_fd_sc_mcu9t5v0__filltie
X_17667_ _18630_/Q _18706_/Q _17685_/S _18706_/D VSS VSS VSS VSS gf180mcu_fd_sc_mcu9t5v0__mux2_1
X_14879_ _14879_/A1 _14879_/A2 _14883_/A1 VSS VSS VSS VSS gf180mcu_fd_sc_mcu9t5v0__nand2_1
XTAP_TAPCELL_ROW_313_7685 VSS VSS gf180mcu_fd_sc_mcu9t5v0__filltie
X_16618_ _19283_/Q _16675_/A1 _16624_/B VSS VSS VSS VSS gf180mcu_fd_sc_mcu9t5v0__nand2_1
X_17598_ _18663_/Q _09737_/Z _17599_/B VSS VSS VSS VSS gf180mcu_fd_sc_mcu9t5v0__nand2_1
X_19406_ _19406_/D _20046_/RN clkload8/I _19406_/Q VSS VSS VSS VSS gf180mcu_fd_sc_mcu9t5v0__dffrnq_1
X_16549_ _18332_/Q _16131_/B _17062_/S _18332_/D VSS VSS VSS VSS gf180mcu_fd_sc_mcu9t5v0__mux2_1
X_19337_ _19337_/D _20041_/RN clkload18/I _19337_/Q VSS VSS VSS VSS gf180mcu_fd_sc_mcu9t5v0__dffrnq_1
XPHY_EDGE_ROW_53_Right_53 VSS VSS gf180mcu_fd_sc_mcu9t5v0__endcap
XTAP_TAPCELL_ROW_214_4946 VSS VSS gf180mcu_fd_sc_mcu9t5v0__filltie
XTAP_TAPCELL_ROW_132_4613 VSS VSS gf180mcu_fd_sc_mcu9t5v0__filltie
XTAP_TAPCELL_ROW_132_4602 VSS VSS gf180mcu_fd_sc_mcu9t5v0__filltie
XPHY_EDGE_ROW_233_Right_160 VSS VSS gf180mcu_fd_sc_mcu9t5v0__endcap
XTAP_TAPCELL_ROW_214_4968 VSS VSS gf180mcu_fd_sc_mcu9t5v0__filltie
XTAP_TAPCELL_ROW_214_4957 VSS VSS gf180mcu_fd_sc_mcu9t5v0__filltie
XTAP_TAPCELL_ROW_132_4624 VSS VSS gf180mcu_fd_sc_mcu9t5v0__filltie
X_19268_ _19268_/D _20036_/RN clkload39/I _19268_/Q VSS VSS VSS VSS gf180mcu_fd_sc_mcu9t5v0__dffrnq_1
XTAP_TAPCELL_ROW_117_4192 VSS VSS gf180mcu_fd_sc_mcu9t5v0__filltie
X_18219_ _18219_/D clkload60/I _18219_/Q VSS VSS VSS VSS gf180mcu_fd_sc_mcu9t5v0__dffq_4
XTAP_TAPCELL_ROW_74_3030 VSS VSS gf180mcu_fd_sc_mcu9t5v0__filltie
X_19199_ _19199_/D _20031_/RN clkload28/I _19199_/Q VSS VSS VSS VSS gf180mcu_fd_sc_mcu9t5v0__dffrnq_1
XPHY_EDGE_ROW_190_2_Right_921 VSS VSS gf180mcu_fd_sc_mcu9t5v0__endcap
XTAP_TAPCELL_ROW_113_4089 VSS VSS gf180mcu_fd_sc_mcu9t5v0__filltie
XTAP_TAPCELL_ROW_113_4078 VSS VSS gf180mcu_fd_sc_mcu9t5v0__filltie
X_20112_ _20112_/D clkload60/I _20112_/Q VSS VSS VSS VSS gf180mcu_fd_sc_mcu9t5v0__dffq_1
XPHY_EDGE_ROW_62_Right_62 VSS VSS gf180mcu_fd_sc_mcu9t5v0__endcap
X_09923_ _19995_/Q _19994_/Q _09927_/A2 VSS VSS VSS VSS gf180mcu_fd_sc_mcu9t5v0__nand2_1
XTAP_TAPCELL_ROW_126_4439 VSS VSS gf180mcu_fd_sc_mcu9t5v0__filltie
X_20043_ _20043_/D _20043_/RN _20054_/CLK _20043_/Q VSS VSS VSS VSS gf180mcu_fd_sc_mcu9t5v0__dffrnq_4
X_09854_ _20030_/Q _10445_/A2 _10416_/B VSS VSS VSS VSS gf180mcu_fd_sc_mcu9t5v0__nor2_4
X_09785_ _18838_/Q _09782_/Z _11610_/A1 VSS VSS VSS VSS gf180mcu_fd_sc_mcu9t5v0__nand2_1
Xclkbuf_3_0_0_clk_regs clkbuf_0_clk_regs/Z clkbuf_3_0_0_clk_regs/Z VSS _17479_/VNW
+ VSS VSS gf180mcu_fd_sc_mcu9t5v0__clkbuf_8
XPHY_EDGE_ROW_201_1_Left_524 VSS VSS gf180mcu_fd_sc_mcu9t5v0__endcap
XPHY_EDGE_ROW_71_Right_71 VSS VSS gf180mcu_fd_sc_mcu9t5v0__endcap
XTAP_TAPCELL_ROW_102_3782 VSS VSS gf180mcu_fd_sc_mcu9t5v0__filltie
XTAP_TAPCELL_ROW_102_3793 VSS VSS gf180mcu_fd_sc_mcu9t5v0__filltie
XTAP_TAPCELL_ROW_288_6994 VSS VSS gf180mcu_fd_sc_mcu9t5v0__filltie
XTAP_TAPCELL_ROW_288_6983 VSS VSS gf180mcu_fd_sc_mcu9t5v0__filltie
X_10560_ _10459_/C _10560_/A2 _10560_/A3 _10560_/B _10565_/B1 VSS VSS VSS VSS gf180mcu_fd_sc_mcu9t5v0__oai31_1
X_10491_ _18338_/Q _18322_/Q _17260_/S _10491_/Z VSS VSS VSS VSS gf180mcu_fd_sc_mcu9t5v0__mux2_1
XTAP_TAPCELL_ROW_284_6869 VSS VSS gf180mcu_fd_sc_mcu9t5v0__filltie
XTAP_TAPCELL_ROW_40_2074 VSS VSS gf180mcu_fd_sc_mcu9t5v0__filltie
X_09219_ _19573_/Q _15231_/A2 VSS VSS VSS VSS gf180mcu_fd_sc_mcu9t5v0__clkinv_1
XTAP_TAPCELL_ROW_40_2085 VSS VSS gf180mcu_fd_sc_mcu9t5v0__filltie
XTAP_TAPCELL_ROW_40_2096 VSS VSS gf180mcu_fd_sc_mcu9t5v0__filltie
X_12230_ _18730_/Q wire198/I wire213/I _12296_/B2 VSS _12230_/VNW VSS VSS gf180mcu_fd_sc_mcu9t5v0__aoi21_1
XPHY_EDGE_ROW_80_Right_80 VSS VSS gf180mcu_fd_sc_mcu9t5v0__endcap
XTAP_TAPCELL_ROW_57_2560 VSS VSS gf180mcu_fd_sc_mcu9t5v0__filltie
X_12161_ _12320_/C _12155_/Z _12161_/B _12162_/B1 VSS VSS VSS VSS gf180mcu_fd_sc_mcu9t5v0__aoi21_1
XTAP_TAPCELL_ROW_224_5220 VSS VSS gf180mcu_fd_sc_mcu9t5v0__filltie
XTAP_TAPCELL_ROW_53_2435 VSS VSS gf180mcu_fd_sc_mcu9t5v0__filltie
X_12092_ _18460_/Q _12203_/A2 _12092_/B _12093_/B2 VSS _12093_/VNW VSS VSS gf180mcu_fd_sc_mcu9t5v0__aoi21_1
XTAP_TAPCELL_ROW_224_5242 VSS VSS gf180mcu_fd_sc_mcu9t5v0__filltie
XTAP_TAPCELL_ROW_224_5231 VSS VSS gf180mcu_fd_sc_mcu9t5v0__filltie
X_11112_ _18314_/Q _11403_/S _11429_/B _11113_/B2 VSS VSS VSS VSS gf180mcu_fd_sc_mcu9t5v0__aoi21_1
XTAP_TAPCELL_ROW_53_2446 VSS VSS gf180mcu_fd_sc_mcu9t5v0__filltie
X_15920_ _20129_/Q _19250_/Q _15920_/S _20129_/D VSS VSS VSS VSS gf180mcu_fd_sc_mcu9t5v0__mux2_1
XTAP_TAPCELL_ROW_220_5128 VSS VSS gf180mcu_fd_sc_mcu9t5v0__filltie
XTAP_TAPCELL_ROW_220_5117 VSS VSS gf180mcu_fd_sc_mcu9t5v0__filltie
X_11043_ _18029_/I0 _19044_/Q _11051_/S _19044_/D VSS VSS VSS VSS gf180mcu_fd_sc_mcu9t5v0__mux2_1
X_15851_ _17529_/S _15851_/A2 _20139_/D VSS _15851_/VNW VSS VSS gf180mcu_fd_sc_mcu9t5v0__nand2_1
XTAP_TAPCELL_ROW_109_3969 VSS VSS gf180mcu_fd_sc_mcu9t5v0__filltie
X_14802_ _19400_/Q _19337_/Q _14802_/Z VSS _14806_/VNW VSS VSS gf180mcu_fd_sc_mcu9t5v0__or2_1
XTAP_TAPCELL_ROW_66_2807 VSS VSS gf180mcu_fd_sc_mcu9t5v0__filltie
X_15782_ _19976_/Q _19952_/Q _15786_/S _19952_/D VSS VSS VSS VSS gf180mcu_fd_sc_mcu9t5v0__mux2_1
X_12994_ _19753_/Q _12994_/A2 _13015_/A1 VSS VSS VSS VSS gf180mcu_fd_sc_mcu9t5v0__nand2_1
X_18570_ _18570_/D _20070_/RN clkload27/I _18570_/Q VSS VSS VSS VSS gf180mcu_fd_sc_mcu9t5v0__dffrnq_1
X_17521_ input8/Z _18626_/Q _17521_/S _18626_/D VSS VSS VSS VSS gf180mcu_fd_sc_mcu9t5v0__mux2_1
X_11945_ wire208/Z _11960_/A2 _11946_/A2 VSS VSS VSS VSS gf180mcu_fd_sc_mcu9t5v0__nand2_1
X_14733_ _19546_/Q _14732_/Z _14764_/B _19546_/D VSS VSS VSS VSS gf180mcu_fd_sc_mcu9t5v0__mux2_1
XTAP_TAPCELL_ROW_218_5079 VSS VSS gf180mcu_fd_sc_mcu9t5v0__filltie
XTAP_TAPCELL_ROW_218_5068 VSS VSS gf180mcu_fd_sc_mcu9t5v0__filltie
XTAP_TAPCELL_ROW_218_5057 VSS VSS gf180mcu_fd_sc_mcu9t5v0__filltie
X_14664_ _14766_/A2 _14661_/Z _14665_/B _14664_/B _19527_/D VSS _14664_/VNW VSS VSS
+ gf180mcu_fd_sc_mcu9t5v0__oai31_1
X_17452_ _17462_/A1 _17452_/A2 _18572_/D VSS _17469_/VNW VSS VSS gf180mcu_fd_sc_mcu9t5v0__nor2_1
X_11876_ _11876_/A1 _11884_/A2 _11879_/A2 VSS VSS VSS VSS gf180mcu_fd_sc_mcu9t5v0__xnor2_2
X_16403_ _16442_/A1 _16443_/A3 _16545_/A3 _16198_/C _16408_/I1 VSS VSS VSS VSS gf180mcu_fd_sc_mcu9t5v0__nor4_4
X_13615_ _13369_/I _13615_/A2 _13615_/A3 _13615_/B _13616_/A2 VSS VSS VSS VSS gf180mcu_fd_sc_mcu9t5v0__oai31_1
X_17383_ _17399_/A1 _18391_/Q _17385_/A3 VSS _17383_/VNW VSS VSS gf180mcu_fd_sc_mcu9t5v0__nor2_1
XTAP_TAPCELL_ROW_207_3_8248 VSS VSS gf180mcu_fd_sc_mcu9t5v0__filltie
X_10827_ _10827_/I _20065_/D VSS VSS VSS VSS gf180mcu_fd_sc_mcu9t5v0__clkinv_1
XPHY_EDGE_ROW_196_1_Right_780 VSS VSS gf180mcu_fd_sc_mcu9t5v0__endcap
X_14595_ _14595_/A1 _14766_/A2 _14595_/B1 _14595_/B2 _19473_/D VSS VSS VSS VSS gf180mcu_fd_sc_mcu9t5v0__aoi22_1
X_16334_ _18232_/Q _16333_/Z _16864_/S _18232_/D VSS _16334_/VNW VSS VSS gf180mcu_fd_sc_mcu9t5v0__mux2_1
X_13546_ _13546_/A1 _13546_/A2 _13546_/B _13551_/A2 VSS VSS VSS VSS gf180mcu_fd_sc_mcu9t5v0__oai21_1
X_10758_ _10776_/A1 _10776_/A2 _10759_/I VSS _10762_/VNW VSS VSS gf180mcu_fd_sc_mcu9t5v0__xnor2_1
X_19122_ _19122_/D _20018_/RN _19798_/CLK _19122_/Q VSS VSS VSS VSS gf180mcu_fd_sc_mcu9t5v0__dffrnq_4
X_16265_ _19268_/Q _16829_/A2 _16267_/A1 VSS VSS VSS VSS gf180mcu_fd_sc_mcu9t5v0__nand2_1
X_13477_ _19748_/Q _13478_/A2 _13477_/Z VSS _13492_/VNW VSS VSS gf180mcu_fd_sc_mcu9t5v0__and2_1
X_19053_ _19053_/D _20141_/RN _19806_/CLK _19053_/Q VSS VSS VSS VSS gf180mcu_fd_sc_mcu9t5v0__dffrnq_1
XTAP_TAPCELL_ROW_321_7910 VSS VSS gf180mcu_fd_sc_mcu9t5v0__filltie
XPHY_EDGE_ROW_184_3_Left_842 VSS VSS gf180mcu_fd_sc_mcu9t5v0__endcap
X_18004_ _18890_/Q _15581_/B _18004_/S _18890_/D VSS _18004_/VNW VSS VSS gf180mcu_fd_sc_mcu9t5v0__mux2_1
X_12428_ _19149_/Q _12355_/I _12429_/B VSS VSS VSS VSS gf180mcu_fd_sc_mcu9t5v0__nand2_1
X_15216_ _15216_/A1 _15216_/A2 _15216_/B _15219_/A2 VSS _15216_/VNW VSS VSS gf180mcu_fd_sc_mcu9t5v0__oai21_1
X_10689_ _10689_/I _10690_/B1 VSS _10689_/VNW VSS VSS gf180mcu_fd_sc_mcu9t5v0__clkinv_1
X_16196_ _16196_/A1 _15988_/B _16763_/S VSS VSS VSS VSS gf180mcu_fd_sc_mcu9t5v0__nor2_2
X_12359_ _18201_/Q _12582_/A2 _12362_/A3 VSS VSS VSS VSS gf180mcu_fd_sc_mcu9t5v0__nor2_1
X_15147_ _19689_/Q _19529_/Q wire108/Z _19689_/D VSS _15147_/VNW VSS VSS gf180mcu_fd_sc_mcu9t5v0__mux2_1
XTAP_TAPCELL_ROW_302_7386 VSS VSS gf180mcu_fd_sc_mcu9t5v0__filltie
XTAP_TAPCELL_ROW_302_7375 VSS VSS gf180mcu_fd_sc_mcu9t5v0__filltie
XTAP_TAPCELL_ROW_302_7364 VSS VSS gf180mcu_fd_sc_mcu9t5v0__filltie
X_19955_ _19955_/D _20019_/RN clkload65/I _19955_/Q VSS VSS VSS VSS gf180mcu_fd_sc_mcu9t5v0__dffrnq_1
X_15078_ _19644_/Q _15077_/Z _20039_/Q _19644_/D VSS _15083_/VNW VSS VSS gf180mcu_fd_sc_mcu9t5v0__mux2_1
XTAP_TAPCELL_ROW_294_7154 VSS VSS gf180mcu_fd_sc_mcu9t5v0__filltie
XTAP_TAPCELL_ROW_294_7143 VSS VSS gf180mcu_fd_sc_mcu9t5v0__filltie
XTAP_TAPCELL_ROW_36_1965 VSS VSS gf180mcu_fd_sc_mcu9t5v0__filltie
X_14029_ _14031_/A2 _14029_/A2 _14364_/I0 VSS VSS VSS VSS gf180mcu_fd_sc_mcu9t5v0__xnor2_2
XTAP_TAPCELL_ROW_36_1976 VSS VSS gf180mcu_fd_sc_mcu9t5v0__filltie
X_18906_ _18906_/D _20058_/RN clkload43/I _18906_/Q VSS VSS VSS VSS gf180mcu_fd_sc_mcu9t5v0__dffrnq_1
XTAP_TAPCELL_ROW_294_7165 VSS VSS gf180mcu_fd_sc_mcu9t5v0__filltie
XTAP_TAPCELL_ROW_319_7850 VSS VSS gf180mcu_fd_sc_mcu9t5v0__filltie
X_19886_ _19886_/D _20142_/RN clkload71/I _19886_/Q VSS VSS VSS VSS gf180mcu_fd_sc_mcu9t5v0__dffrnq_1
XTAP_TAPCELL_ROW_315_7725 VSS VSS gf180mcu_fd_sc_mcu9t5v0__filltie
XTAP_TAPCELL_ROW_121_4314 VSS VSS gf180mcu_fd_sc_mcu9t5v0__filltie
XTAP_TAPCELL_ROW_121_4303 VSS VSS gf180mcu_fd_sc_mcu9t5v0__filltie
X_18837_ _18837_/D _20053_/RN clkload33/I _18837_/Q VSS VSS VSS VSS gf180mcu_fd_sc_mcu9t5v0__dffrnq_1
XTAP_TAPCELL_ROW_315_7736 VSS VSS gf180mcu_fd_sc_mcu9t5v0__filltie
X_18768_ _18768_/D _20048_/RN clkload51/I _18768_/Q VSS VSS VSS VSS gf180mcu_fd_sc_mcu9t5v0__dffrnq_1
X_09570_ _09575_/B _10715_/C wire160/I VSS VSS VSS VSS gf180mcu_fd_sc_mcu9t5v0__nor2_1
X_17719_ _17719_/I _18735_/D VSS VSS VSS VSS gf180mcu_fd_sc_mcu9t5v0__clkinv_1
X_18699_ _18699_/D clkload63/I _18699_/Q VSS VSS VSS VSS gf180mcu_fd_sc_mcu9t5v0__dffq_1
XTAP_TAPCELL_ROW_119_4254 VSS VSS gf180mcu_fd_sc_mcu9t5v0__filltie
XTAP_TAPCELL_ROW_119_4243 VSS VSS gf180mcu_fd_sc_mcu9t5v0__filltie
XTAP_TAPCELL_ROW_119_4265 VSS VSS gf180mcu_fd_sc_mcu9t5v0__filltie
XPHY_EDGE_ROW_191_2_Right_922 VSS VSS gf180mcu_fd_sc_mcu9t5v0__endcap
X_09906_ _09926_/A1 _10057_/A2 _10133_/A2 VSS _09978_/VNW VSS VSS gf180mcu_fd_sc_mcu9t5v0__nor2_1
X_20026_ _20026_/D _20026_/RN clkload37/I _20026_/Q VSS VSS VSS VSS gf180mcu_fd_sc_mcu9t5v0__dffrnq_1
XTAP_TAPCELL_ROW_277_6684 VSS VSS gf180mcu_fd_sc_mcu9t5v0__filltie
X_09837_ _09837_/A1 _09837_/A2 _09837_/B1 _10190_/B _20024_/D VSS VSS VSS VSS gf180mcu_fd_sc_mcu9t5v0__oai22_1
Xeco7_buf_09435 _09435_/ZN _09438_/B VSS VSS VSS VSS gf180mcu_fd_sc_mcu9t5v0__clkbuf_16
XTAP_TAPCELL_ROW_277_6695 VSS VSS gf180mcu_fd_sc_mcu9t5v0__filltie
XPHY_EDGE_ROW_148_2_Left_660 VSS VSS gf180mcu_fd_sc_mcu9t5v0__endcap
X_09768_ _09768_/A1 _09768_/A2 _17885_/S _17879_/A1 VSS VSS VSS VSS gf180mcu_fd_sc_mcu9t5v0__nand3_1
XTAP_TAPCELL_ROW_104_3833 VSS VSS gf180mcu_fd_sc_mcu9t5v0__filltie
XTAP_TAPCELL_ROW_104_3855 VSS VSS gf180mcu_fd_sc_mcu9t5v0__filltie
XTAP_TAPCELL_ROW_104_3844 VSS VSS gf180mcu_fd_sc_mcu9t5v0__filltie
XPHY_EDGE_ROW_319_Left_642 VSS VSS gf180mcu_fd_sc_mcu9t5v0__endcap
X_11730_ _12092_/B _11729_/Z _11737_/A1 VSS VSS VSS VSS gf180mcu_fd_sc_mcu9t5v0__nand2_1
X_09699_ input9/Z _09699_/A2 _17763_/A3 VSS _09703_/VNW VSS VSS gf180mcu_fd_sc_mcu9t5v0__nand2_1
XTAP_TAPCELL_ROW_46_2250 VSS VSS gf180mcu_fd_sc_mcu9t5v0__filltie
XTAP_TAPCELL_ROW_100_3719 VSS VSS gf180mcu_fd_sc_mcu9t5v0__filltie
XTAP_TAPCELL_ROW_46_2261 VSS VSS gf180mcu_fd_sc_mcu9t5v0__filltie
XTAP_TAPCELL_ROW_42_2125 VSS VSS gf180mcu_fd_sc_mcu9t5v0__filltie
X_11661_ _12626_/B _11661_/A2 _12629_/A2 _12720_/S _12698_/A2 VSS _12629_/VNW VSS
+ VSS gf180mcu_fd_sc_mcu9t5v0__aoi22_1
XTAP_TAPCELL_ROW_42_2136 VSS VSS gf180mcu_fd_sc_mcu9t5v0__filltie
XTAP_TAPCELL_ROW_42_2147 VSS VSS gf180mcu_fd_sc_mcu9t5v0__filltie
X_10612_ _18167_/Q _17406_/A2 _17405_/A2 _18183_/Q _10613_/B VSS _12473_/VNW VSS VSS
+ gf180mcu_fd_sc_mcu9t5v0__aoi22_1
X_13400_ _16719_/A1 _13419_/B _13400_/B1 _13400_/B2 _19253_/D VSS VSS VSS VSS gf180mcu_fd_sc_mcu9t5v0__aoi22_1
X_14380_ _14380_/A1 _14380_/A2 _19444_/D VSS VSS VSS VSS gf180mcu_fd_sc_mcu9t5v0__nand2_1
X_11592_ _18846_/Q _18845_/Q _18836_/Q _11592_/Z VSS _11592_/VNW VSS VSS gf180mcu_fd_sc_mcu9t5v0__mux2_1
X_10543_ _09261_/I _10543_/A2 _10543_/B _10543_/C _10544_/B VSS _11084_/VNW VSS VSS
+ gf180mcu_fd_sc_mcu9t5v0__oai211_1
XTAP_TAPCELL_ROW_59_2600 VSS VSS gf180mcu_fd_sc_mcu9t5v0__filltie
XTAP_TAPCELL_ROW_59_2611 VSS VSS gf180mcu_fd_sc_mcu9t5v0__filltie
X_13331_ _19740_/Q _13331_/A2 _13599_/B VSS VSS VSS VSS gf180mcu_fd_sc_mcu9t5v0__xnor2_1
X_16050_ _15973_/B _15988_/C _15988_/B _16049_/Z _16098_/B VSS VSS VSS VSS gf180mcu_fd_sc_mcu9t5v0__nand4_4
X_10474_ _10654_/A2 _10474_/A2 _10474_/A3 _10475_/B VSS _10869_/VNW VSS VSS gf180mcu_fd_sc_mcu9t5v0__nand3_1
X_13262_ _13244_/B _13262_/A2 _13266_/B2 VSS _13264_/VNW VSS VSS gf180mcu_fd_sc_mcu9t5v0__nand2_1
XTAP_TAPCELL_ROW_55_2508 VSS VSS gf180mcu_fd_sc_mcu9t5v0__filltie
X_15001_ _15001_/A1 _15003_/A2 _15002_/I1 VSS VSS VSS VSS gf180mcu_fd_sc_mcu9t5v0__xnor2_1
X_12213_ _12071_/B _12213_/A2 _12214_/C VSS _12213_/VNW VSS VSS gf180mcu_fd_sc_mcu9t5v0__nor2_1
X_13193_ _12948_/S _13209_/A2 _13194_/B VSS _13564_/VNW VSS VSS gf180mcu_fd_sc_mcu9t5v0__and2_1
Xrst_tree_leaf_17 rst_tree_mid_2/Z _20066_/RN VSS VSS VSS VSS gf180mcu_fd_sc_mcu9t5v0__clkbuf_16
Xrst_tree_leaf_28 rst_tree_mid_3/Z _20055_/RN VSS VSS VSS VSS gf180mcu_fd_sc_mcu9t5v0__clkbuf_16
X_12144_ _12164_/A3 _12144_/A2 _12145_/A2 VSS _12146_/VNW VSS VSS gf180mcu_fd_sc_mcu9t5v0__xnor2_1
Xrst_tree_leaf_39 rst_tree_mid_4/Z _20044_/RN VSS VSS VSS VSS gf180mcu_fd_sc_mcu9t5v0__clkbuf_16
X_19740_ _19740_/D _20060_/RN clkload20/I _19740_/Q VSS VSS VSS VSS gf180mcu_fd_sc_mcu9t5v0__dffrnq_1
X_16952_ _16952_/I0 _18467_/Q _16958_/S _18467_/D VSS VSS VSS VSS gf180mcu_fd_sc_mcu9t5v0__mux2_4
X_12075_ _14480_/A2 _12311_/B _12075_/B _19126_/D VSS VSS VSS VSS gf180mcu_fd_sc_mcu9t5v0__aoi21_1
X_16883_ _19253_/Q _16634_/B _16895_/S _16883_/Z VSS VSS VSS VSS gf180mcu_fd_sc_mcu9t5v0__mux2_1
X_15903_ _20112_/Q _19248_/Q _15905_/S _20112_/D VSS VSS VSS VSS gf180mcu_fd_sc_mcu9t5v0__mux2_1
Xclkbuf_leaf_30_clk_regs clkload5/I clkload65/I VSS VSS VSS VSS gf180mcu_fd_sc_mcu9t5v0__clkbuf_8
X_19671_ _19671_/D _20055_/RN _20054_/CLK _19671_/Q VSS VSS VSS VSS gf180mcu_fd_sc_mcu9t5v0__dffrnq_1
X_11026_ _19059_/Q _19027_/Q wire174/Z _19027_/D VSS VSS VSS VSS gf180mcu_fd_sc_mcu9t5v0__mux2_1
X_15834_ _15834_/A1 _15834_/A2 _15834_/B1 _15834_/B2 _19995_/D VSS VSS VSS VSS gf180mcu_fd_sc_mcu9t5v0__oai22_1
X_18622_ _18622_/D _20026_/RN clkload59/I _18622_/Q VSS VSS VSS VSS gf180mcu_fd_sc_mcu9t5v0__dffrnq_1
XTAP_TAPCELL_ROW_31_1840 VSS VSS gf180mcu_fd_sc_mcu9t5v0__filltie
X_18553_ _18553_/D _20053_/RN clkload22/I _18553_/Q VSS VSS VSS VSS gf180mcu_fd_sc_mcu9t5v0__dffrnq_1
XTAP_TAPCELL_ROW_310_7600 VSS VSS gf180mcu_fd_sc_mcu9t5v0__filltie
X_17504_ _18609_/Q _19250_/Q _17504_/S _18609_/D VSS VSS VSS VSS gf180mcu_fd_sc_mcu9t5v0__mux2_1
X_15765_ wire300/Z _19935_/Q _15770_/S _19935_/D VSS VSS VSS VSS gf180mcu_fd_sc_mcu9t5v0__mux2_1
X_12977_ _12978_/A1 _12978_/A2 _12977_/B _13008_/A2 VSS _12979_/VNW VSS VSS gf180mcu_fd_sc_mcu9t5v0__aoi21_1
X_18484_ _18484_/D clkload79/I _18484_/Q VSS VSS VSS VSS gf180mcu_fd_sc_mcu9t5v0__dffq_1
X_15696_ _20003_/Q _09705_/Z _17601_/A3 _15696_/B _15697_/I0 VSS VSS VSS VSS gf180mcu_fd_sc_mcu9t5v0__oai31_1
X_14716_ _14717_/A1 _14717_/A3 _14716_/B _14720_/B VSS _14716_/VNW VSS VSS gf180mcu_fd_sc_mcu9t5v0__aoi21_1
X_11928_ _12336_/B _11963_/A2 _11929_/A2 VSS VSS VSS VSS gf180mcu_fd_sc_mcu9t5v0__nand2_1
X_17435_ _17435_/A1 _17431_/S _17439_/A2 _17436_/B VSS VSS VSS VSS gf180mcu_fd_sc_mcu9t5v0__nand3_1
X_14647_ _19141_/Q _19107_/Q _14651_/A2 VSS VSS VSS VSS gf180mcu_fd_sc_mcu9t5v0__nand2_1
XTAP_TAPCELL_ROW_29_1780 VSS VSS gf180mcu_fd_sc_mcu9t5v0__filltie
X_11859_ _18900_/Q _11859_/A2 _11860_/A2 VSS _18015_/VNW VSS VSS gf180mcu_fd_sc_mcu9t5v0__xnor2_1
XTAP_TAPCELL_ROW_29_1791 VSS VSS gf180mcu_fd_sc_mcu9t5v0__filltie
XANTENNA_18 output15/I VSS VSS VSS VSS gf180mcu_fd_sc_mcu9t5v0__antenna
X_17366_ _17406_/C _17366_/A2 _17366_/B1 _17366_/B2 _17407_/C _17367_/C VSS VSS VSS
+ VSS gf180mcu_fd_sc_mcu9t5v0__aoi221_1
XPHY_EDGE_ROW_197_1_Right_781 VSS VSS gf180mcu_fd_sc_mcu9t5v0__endcap
X_14578_ _14762_/B _14578_/A2 _14578_/Z VSS VSS VSS VSS gf180mcu_fd_sc_mcu9t5v0__or2_1
XTAP_TAPCELL_ROW_308_7540 VSS VSS gf180mcu_fd_sc_mcu9t5v0__filltie
X_16317_ _19235_/Q _16151_/B _16861_/S _16317_/Z VSS VSS VSS VSS gf180mcu_fd_sc_mcu9t5v0__mux2_1
X_19105_ _19105_/D _20065_/RN _19680_/CLK _19105_/Q VSS VSS VSS VSS gf180mcu_fd_sc_mcu9t5v0__dffrnq_1
X_13529_ _19724_/Q _13529_/A2 _13055_/Z _13529_/B _13534_/A2 VSS _13529_/VNW VSS VSS
+ gf180mcu_fd_sc_mcu9t5v0__oai31_1
XTAP_TAPCELL_ROW_25_1666 VSS VSS gf180mcu_fd_sc_mcu9t5v0__filltie
XTAP_TAPCELL_ROW_25_1677 VSS VSS gf180mcu_fd_sc_mcu9t5v0__filltie
XTAP_TAPCELL_ROW_308_7551 VSS VSS gf180mcu_fd_sc_mcu9t5v0__filltie
X_17297_ _18435_/Q _17405_/A2 _17299_/B1 VSS VSS VSS VSS gf180mcu_fd_sc_mcu9t5v0__nand2_1
XTAP_TAPCELL_ROW_110_4015 VSS VSS gf180mcu_fd_sc_mcu9t5v0__filltie
XTAP_TAPCELL_ROW_110_4004 VSS VSS gf180mcu_fd_sc_mcu9t5v0__filltie
XTAP_TAPCELL_ROW_304_7437 VSS VSS gf180mcu_fd_sc_mcu9t5v0__filltie
XTAP_TAPCELL_ROW_304_7426 VSS VSS gf180mcu_fd_sc_mcu9t5v0__filltie
X_16248_ _18203_/Q _16248_/I1 _16798_/S _18203_/D VSS VSS VSS VSS gf180mcu_fd_sc_mcu9t5v0__mux2_1
X_19036_ _19036_/D _20060_/RN clkload35/I _19036_/Q VSS VSS VSS VSS gf180mcu_fd_sc_mcu9t5v0__dffrnq_1
XTAP_TAPCELL_ROW_296_7205 VSS VSS gf180mcu_fd_sc_mcu9t5v0__filltie
X_16179_ _16730_/A1 _16179_/A2 _16179_/B _16179_/C _16180_/I1 VSS VSS VSS VSS gf180mcu_fd_sc_mcu9t5v0__oai211_4
XTAP_TAPCELL_ROW_209_4812 VSS VSS gf180mcu_fd_sc_mcu9t5v0__filltie
XTAP_TAPCELL_ROW_209_4801 VSS VSS gf180mcu_fd_sc_mcu9t5v0__filltie
XTAP_TAPCELL_ROW_296_7216 VSS VSS gf180mcu_fd_sc_mcu9t5v0__filltie
XTAP_TAPCELL_ROW_209_4823 VSS VSS gf180mcu_fd_sc_mcu9t5v0__filltie
X_19938_ _19938_/D _20066_/RN clkload71/I _19938_/Q VSS VSS VSS VSS gf180mcu_fd_sc_mcu9t5v0__dffrnq_1
X_19869_ _19869_/D _20061_/RN clkload55/I _19869_/Q VSS VSS VSS VSS gf180mcu_fd_sc_mcu9t5v0__dffrnq_1
X_09622_ _18564_/Q _17434_/A2 _20058_/D VSS VSS VSS VSS gf180mcu_fd_sc_mcu9t5v0__nor2_1
X_09553_ _09553_/I _20031_/D VSS _15573_/VNW VSS VSS gf180mcu_fd_sc_mcu9t5v0__clkinv_1
X_09484_ _19069_/Q _11069_/B _09489_/B1 VSS VSS VSS VSS gf180mcu_fd_sc_mcu9t5v0__nor2_1
XTAP_TAPCELL_ROW_285_6920 VSS VSS gf180mcu_fd_sc_mcu9t5v0__filltie
Xwire208 wire208/I wire208/Z VSS wire208/VNW VSS VSS gf180mcu_fd_sc_mcu9t5v0__buf_8
XTAP_TAPCELL_ROW_99_3692 VSS VSS gf180mcu_fd_sc_mcu9t5v0__filltie
XTAP_TAPCELL_ROW_281_6806 VSS VSS gf180mcu_fd_sc_mcu9t5v0__filltie
XTAP_TAPCELL_ROW_266_6374 VSS VSS gf180mcu_fd_sc_mcu9t5v0__filltie
XTAP_TAPCELL_ROW_266_6396 VSS VSS gf180mcu_fd_sc_mcu9t5v0__filltie
XTAP_TAPCELL_ROW_266_6385 VSS VSS gf180mcu_fd_sc_mcu9t5v0__filltie
XTAP_TAPCELL_ROW_95_3589 VSS VSS gf180mcu_fd_sc_mcu9t5v0__filltie
XPHY_EDGE_ROW_192_2_Right_923 VSS VSS gf180mcu_fd_sc_mcu9t5v0__endcap
X_10190_ _11018_/A1 _09578_/Z _10190_/B _20040_/D VSS _10190_/VNW VSS VSS gf180mcu_fd_sc_mcu9t5v0__aoi21_1
XTAP_TAPCELL_ROW_279_6746 VSS VSS gf180mcu_fd_sc_mcu9t5v0__filltie
XTAP_TAPCELL_ROW_279_6735 VSS VSS gf180mcu_fd_sc_mcu9t5v0__filltie
XTAP_TAPCELL_ROW_106_3906 VSS VSS gf180mcu_fd_sc_mcu9t5v0__filltie
X_20009_ _20009_/D _20073_/RN clkload46/I _20009_/Q VSS VSS VSS VSS gf180mcu_fd_sc_mcu9t5v0__dffrnq_1
X_12900_ _12900_/I0 _19219_/Q _13320_/B _19219_/D VSS VSS VSS VSS gf180mcu_fd_sc_mcu9t5v0__mux2_1
X_13880_ _13841_/Z _13879_/Z _13909_/A2 VSS VSS VSS VSS gf180mcu_fd_sc_mcu9t5v0__nand2_1
XTAP_TAPCELL_ROW_48_2301 VSS VSS gf180mcu_fd_sc_mcu9t5v0__filltie
X_12831_ _19763_/Q _12836_/A1 _12828_/Z _12832_/I0 VSS _12831_/VNW VSS VSS gf180mcu_fd_sc_mcu9t5v0__xnor3_1
XTAP_TAPCELL_ROW_48_2312 VSS VSS gf180mcu_fd_sc_mcu9t5v0__filltie
X_15550_ _19868_/Q _19875_/Q _15551_/S _19868_/D VSS VSS VSS VSS gf180mcu_fd_sc_mcu9t5v0__mux2_1
X_12762_ _12762_/A1 _12762_/A2 _12762_/B _12781_/A1 VSS VSS VSS VSS gf180mcu_fd_sc_mcu9t5v0__oai21_1
X_11713_ _18267_/Q _12203_/A2 _12159_/B _11714_/B2 VSS _11714_/VNW VSS VSS gf180mcu_fd_sc_mcu9t5v0__aoi21_1
X_15481_ _19829_/Q _19870_/Q _17601_/A2 _15747_/A2 _17422_/S VSS _15482_/VNW VSS VSS
+ gf180mcu_fd_sc_mcu9t5v0__or4_1
X_12693_ _12147_/S _12698_/A2 _12693_/Z VSS _12693_/VNW VSS VSS gf180mcu_fd_sc_mcu9t5v0__or2_1
X_14501_ _19129_/Q _14501_/I1 _14501_/S _14501_/Z VSS _14501_/VNW VSS VSS gf180mcu_fd_sc_mcu9t5v0__mux2_1
X_17220_ _17220_/A1 _17220_/A2 _17220_/B1 _17220_/B2 _17220_/C _17221_/A2 VSS VSS
+ VSS VSS gf180mcu_fd_sc_mcu9t5v0__aoi221_1
XTAP_TAPCELL_ROW_251_5986 VSS VSS gf180mcu_fd_sc_mcu9t5v0__filltie
XTAP_TAPCELL_ROW_251_5975 VSS VSS gf180mcu_fd_sc_mcu9t5v0__filltie
XTAP_TAPCELL_ROW_251_5964 VSS VSS gf180mcu_fd_sc_mcu9t5v0__filltie
X_11644_ _12720_/S _12637_/A2 _11645_/B VSS VSS VSS VSS gf180mcu_fd_sc_mcu9t5v0__nand2_1
X_14432_ _14442_/A1 _14697_/A1 _14590_/B _14433_/B VSS _14695_/VNW VSS VSS gf180mcu_fd_sc_mcu9t5v0__aoi21_1
X_17151_ _17195_/A1 _18380_/Q _17154_/A2 VSS VSS VSS VSS gf180mcu_fd_sc_mcu9t5v0__nor2_1
X_16102_ _16675_/A1 _16102_/A2 _16102_/A3 _16102_/B _16103_/I1 VSS VSS VSS VSS gf180mcu_fd_sc_mcu9t5v0__oai31_1
X_11575_ _18711_/Q _12527_/A2 _11576_/B VSS _11575_/VNW VSS VSS gf180mcu_fd_sc_mcu9t5v0__nand2_1
X_14363_ _13986_/Z _19433_/Q _14367_/S _19433_/D VSS _14993_/VNW VSS VSS gf180mcu_fd_sc_mcu9t5v0__mux2_1
X_10526_ _18547_/Q wire80/Z _10650_/B1 _10526_/B2 _10527_/B1 VSS VSS VSS VSS gf180mcu_fd_sc_mcu9t5v0__aoi22_4
X_17082_ _10514_/B _17081_/Z _17084_/A1 VSS VSS VSS VSS gf180mcu_fd_sc_mcu9t5v0__nand2_1
X_13314_ _12734_/Z _13314_/A2 _13315_/A2 VSS VSS VSS VSS gf180mcu_fd_sc_mcu9t5v0__nor2_1
XTAP_TAPCELL_ROW_20_1530 VSS VSS gf180mcu_fd_sc_mcu9t5v0__filltie
XTAP_TAPCELL_ROW_20_1541 VSS VSS gf180mcu_fd_sc_mcu9t5v0__filltie
X_14294_ _13904_/Z _19367_/Q _14304_/S _19367_/D VSS VSS VSS VSS gf180mcu_fd_sc_mcu9t5v0__mux2_1
X_16033_ _18157_/Q _16033_/I1 _16602_/S _18157_/D VSS VSS VSS VSS gf180mcu_fd_sc_mcu9t5v0__mux2_4
X_10457_ _10459_/C _10457_/A2 _10457_/A3 _10457_/B _10465_/A2 VSS _10457_/VNW VSS
+ VSS gf180mcu_fd_sc_mcu9t5v0__oai31_1
X_13245_ _13245_/A1 _19767_/Q _13265_/A1 VSS VSS VSS VSS gf180mcu_fd_sc_mcu9t5v0__nand2_1
X_10388_ _10648_/C _15470_/A1 _10389_/C VSS VSS VSS VSS gf180mcu_fd_sc_mcu9t5v0__nor2_4
X_13176_ _13177_/A1 _13177_/A2 _13556_/B _13179_/A1 VSS _13177_/VNW VSS VSS gf180mcu_fd_sc_mcu9t5v0__nand3_1
X_17984_ _18871_/Q _18034_/I0 wire128/Z _18871_/D VSS _17984_/VNW VSS VSS gf180mcu_fd_sc_mcu9t5v0__mux2_1
XTAP_TAPCELL_ROW_18_1470 VSS VSS gf180mcu_fd_sc_mcu9t5v0__filltie
X_12127_ _12217_/B _12172_/A3 _12128_/A2 VSS VSS VSS VSS gf180mcu_fd_sc_mcu9t5v0__nand2_1
XTAP_TAPCELL_ROW_33_1902 VSS VSS gf180mcu_fd_sc_mcu9t5v0__filltie
X_16935_ _19246_/Q _16584_/B _16949_/S _16935_/Z VSS VSS VSS VSS gf180mcu_fd_sc_mcu9t5v0__mux2_1
X_12058_ _11706_/B _12057_/Z _12058_/Z VSS VSS VSS VSS gf180mcu_fd_sc_mcu9t5v0__or2_1
X_19723_ _19723_/D _20043_/RN clkload15/I _19723_/Q VSS VSS VSS VSS gf180mcu_fd_sc_mcu9t5v0__dffrnq_1
XTAP_TAPCELL_ROW_18_1481 VSS VSS gf180mcu_fd_sc_mcu9t5v0__filltie
X_11009_ _10996_/S _18053_/A2 _18097_/A1 VSS _11009_/VNW VSS VSS gf180mcu_fd_sc_mcu9t5v0__nand2_1
XTAP_TAPCELL_ROW_14_1356 VSS VSS gf180mcu_fd_sc_mcu9t5v0__filltie
XTAP_TAPCELL_ROW_14_1367 VSS VSS gf180mcu_fd_sc_mcu9t5v0__filltie
X_19654_ _19654_/D _20038_/RN clkload26/I _19654_/Q VSS VSS VSS VSS gf180mcu_fd_sc_mcu9t5v0__dffrnq_1
X_18605_ _18605_/D clkload57/I _18605_/Q VSS VSS VSS VSS gf180mcu_fd_sc_mcu9t5v0__dffq_1
X_16866_ _18425_/Q _16865_/Z wire38/I _18425_/D VSS _16866_/VNW VSS VSS gf180mcu_fd_sc_mcu9t5v0__mux2_1
XTAP_TAPCELL_ROW_14_1378 VSS VSS gf180mcu_fd_sc_mcu9t5v0__filltie
X_16797_ _19280_/Q _16599_/B _16949_/S _16797_/Z VSS VSS VSS VSS gf180mcu_fd_sc_mcu9t5v0__mux2_1
X_15817_ input6/Z _19986_/Q _15819_/S _19986_/D VSS VSS VSS VSS gf180mcu_fd_sc_mcu9t5v0__mux2_1
X_19585_ _19585_/D _20033_/RN clkload19/I _19585_/Q VSS VSS VSS VSS gf180mcu_fd_sc_mcu9t5v0__dffrnq_1
XTAP_TAPCELL_ROW_289_7031 VSS VSS gf180mcu_fd_sc_mcu9t5v0__filltie
XTAP_TAPCELL_ROW_289_7020 VSS VSS gf180mcu_fd_sc_mcu9t5v0__filltie
X_18536_ _18536_/D clkload77/I _18536_/Q VSS VSS VSS VSS gf180mcu_fd_sc_mcu9t5v0__dffq_1
X_15748_ _15748_/I0 _19928_/Q _15757_/B _19928_/D VSS _15748_/VNW VSS VSS gf180mcu_fd_sc_mcu9t5v0__mux2_1
X_18467_ _18467_/D clkload67/I _18467_/Q VSS VSS VSS VSS gf180mcu_fd_sc_mcu9t5v0__dffq_4
XTAP_TAPCELL_ROW_27_1717 VSS VSS gf180mcu_fd_sc_mcu9t5v0__filltie
XTAP_TAPCELL_ROW_27_1728 VSS VSS gf180mcu_fd_sc_mcu9t5v0__filltie
X_15679_ _19996_/Q _15686_/A1 _09675_/B _15820_/B1 _15686_/B VSS VSS VSS VSS gf180mcu_fd_sc_mcu9t5v0__oai22_1
X_17418_ _17418_/I0 _18557_/Q _17420_/S _18557_/D VSS VSS VSS VSS gf180mcu_fd_sc_mcu9t5v0__mux2_1
X_18398_ _18398_/D clkload62/I _18398_/Q VSS VSS VSS VSS gf180mcu_fd_sc_mcu9t5v0__dffq_4
X_17349_ _18615_/Q _17306_/C _17350_/B VSS VSS VSS VSS gf180mcu_fd_sc_mcu9t5v0__nand2_1
XPHY_EDGE_ROW_198_1_Right_782 VSS VSS gf180mcu_fd_sc_mcu9t5v0__endcap
X_19019_ _19019_/D _20043_/RN clkload44/I _19019_/Q VSS VSS VSS VSS gf180mcu_fd_sc_mcu9t5v0__dffrnq_1
XTAP_TAPCELL_ROW_261_6260 VSS VSS gf180mcu_fd_sc_mcu9t5v0__filltie
XTAP_TAPCELL_ROW_90_3464 VSS VSS gf180mcu_fd_sc_mcu9t5v0__filltie
XTAP_TAPCELL_ROW_90_3453 VSS VSS gf180mcu_fd_sc_mcu9t5v0__filltie
XPHY_EDGE_ROW_147_3_Left_805 VSS VSS gf180mcu_fd_sc_mcu9t5v0__endcap
XTAP_TAPCELL_ROW_274_6610 VSS VSS gf180mcu_fd_sc_mcu9t5v0__filltie
XTAP_TAPCELL_ROW_88_3393 VSS VSS gf180mcu_fd_sc_mcu9t5v0__filltie
XTAP_TAPCELL_ROW_270_6507 VSS VSS gf180mcu_fd_sc_mcu9t5v0__filltie
X_09605_ _15939_/B _18567_/Q _09605_/A3 _10841_/A1 VSS VSS VSS VSS gf180mcu_fd_sc_mcu9t5v0__nor3_1
XTAP_TAPCELL_ROW_255_6086 VSS VSS gf180mcu_fd_sc_mcu9t5v0__filltie
XTAP_TAPCELL_ROW_255_6075 VSS VSS gf180mcu_fd_sc_mcu9t5v0__filltie
XPHY_EDGE_ROW_143_1_Left_466 VSS VSS gf180mcu_fd_sc_mcu9t5v0__endcap
XTAP_TAPCELL_ROW_84_3279 VSS VSS gf180mcu_fd_sc_mcu9t5v0__filltie
X_09536_ _18755_/Q _20023_/Q _17763_/A2 VSS _09536_/VNW VSS VSS gf180mcu_fd_sc_mcu9t5v0__nand2_1
XTAP_TAPCELL_ROW_4_1090 VSS VSS gf180mcu_fd_sc_mcu9t5v0__filltie
X_09467_ _19072_/Q _19089_/Q _09469_/B VSS VSS VSS VSS gf180mcu_fd_sc_mcu9t5v0__nand2_1
XTAP_TAPCELL_ROW_208_3_8253 VSS VSS gf180mcu_fd_sc_mcu9t5v0__filltie
XTAP_TAPCELL_ROW_268_6447 VSS VSS gf180mcu_fd_sc_mcu9t5v0__filltie
XTAP_TAPCELL_ROW_268_6436 VSS VSS gf180mcu_fd_sc_mcu9t5v0__filltie
X_09398_ _20002_/Q _20008_/Q _09875_/A2 VSS _09671_/VNW VSS VSS gf180mcu_fd_sc_mcu9t5v0__nor2_1
X_11360_ _18523_/Q _18507_/Q _18459_/Q _18443_/Q _11524_/S _11521_/B _11360_/Z VSS
+ VSS VSS VSS gf180mcu_fd_sc_mcu9t5v0__mux4_1
XPHY_EDGE_ROW_129_Right_129 VSS VSS gf180mcu_fd_sc_mcu9t5v0__endcap
X_10311_ _10654_/A2 _10311_/A2 _10311_/A3 _10312_/B VSS _18108_/VNW VSS VSS gf180mcu_fd_sc_mcu9t5v0__nand3_1
XTAP_TAPCELL_ROW_37_2002 VSS VSS gf180mcu_fd_sc_mcu9t5v0__filltie
XTAP_TAPCELL_ROW_37_2013 VSS VSS gf180mcu_fd_sc_mcu9t5v0__filltie
X_11291_ _11291_/A1 _11291_/A2 _11291_/B wire136/Z _11292_/B VSS VSS VSS VSS gf180mcu_fd_sc_mcu9t5v0__oai211_1
X_13030_ _13030_/A1 _13030_/A2 _13304_/B _13031_/B2 VSS _13030_/VNW VSS VSS gf180mcu_fd_sc_mcu9t5v0__aoi21_1
X_10242_ _10242_/A1 _17409_/B _10242_/A3 _10245_/B VSS VSS VSS VSS gf180mcu_fd_sc_mcu9t5v0__nand3_1
XTAP_TAPCELL_ROW_73_2983 VSS VSS gf180mcu_fd_sc_mcu9t5v0__filltie
XTAP_TAPCELL_ROW_244_5790 VSS VSS gf180mcu_fd_sc_mcu9t5v0__filltie
X_10173_ _09916_/B _10173_/A2 _10173_/A3 _10174_/C VSS VSS VSS VSS gf180mcu_fd_sc_mcu9t5v0__nand3_1
XPHY_EDGE_ROW_193_2_Right_924 VSS VSS gf180mcu_fd_sc_mcu9t5v0__endcap
XTAP_TAPCELL_ROW_73_2994 VSS VSS gf180mcu_fd_sc_mcu9t5v0__filltie
XTAP_TAPCELL_ROW_240_5676 VSS VSS gf180mcu_fd_sc_mcu9t5v0__filltie
XTAP_TAPCELL_ROW_240_5665 VSS VSS gf180mcu_fd_sc_mcu9t5v0__filltie
X_16720_ _16730_/A1 _16634_/B _16720_/B _16725_/C _16722_/A2 VSS VSS VSS VSS gf180mcu_fd_sc_mcu9t5v0__aoi211_1
X_14981_ _14981_/A1 _14981_/A2 _14982_/B VSS _14981_/VNW VSS VSS gf180mcu_fd_sc_mcu9t5v0__nand2_1
X_13932_ _13934_/A2 _13934_/A3 _13967_/B VSS _13933_/VNW VSS VSS gf180mcu_fd_sc_mcu9t5v0__or2_1
X_16651_ _19224_/Q _16665_/A2 _16735_/B2 VSS VSS VSS VSS gf180mcu_fd_sc_mcu9t5v0__nand2_1
XPHY_EDGE_ROW_193_3_Left_851 VSS VSS gf180mcu_fd_sc_mcu9t5v0__endcap
X_13863_ _13863_/A1 _13863_/A2 _13870_/A2 VSS VSS VSS VSS gf180mcu_fd_sc_mcu9t5v0__xnor2_1
X_16582_ _19214_/Q _16581_/Z _16612_/S _16584_/B VSS _16582_/VNW VSS VSS gf180mcu_fd_sc_mcu9t5v0__mux2_1
X_15602_ _15629_/B _15602_/A2 _19886_/D VSS VSS VSS VSS gf180mcu_fd_sc_mcu9t5v0__xnor2_1
X_12814_ _12822_/A1 _12822_/A2 _12818_/A2 VSS _12818_/VNW VSS VSS gf180mcu_fd_sc_mcu9t5v0__nand2_1
X_13794_ _13781_/B _13793_/Z _13810_/A2 VSS VSS VSS VSS gf180mcu_fd_sc_mcu9t5v0__nand2_1
X_19370_ _19370_/D _20138_/RN clkload21/I _19370_/Q VSS VSS VSS VSS gf180mcu_fd_sc_mcu9t5v0__dffrnq_1
X_18321_ _18321_/D _18518_/CLK _18321_/Q VSS VSS VSS VSS gf180mcu_fd_sc_mcu9t5v0__dffq_4
X_15533_ _19851_/Q _19834_/Q _15544_/S _19851_/D VSS _15533_/VNW VSS VSS gf180mcu_fd_sc_mcu9t5v0__mux2_1
X_12745_ _12737_/Z _12745_/A2 _12745_/B _12753_/A1 VSS VSS VSS VSS gf180mcu_fd_sc_mcu9t5v0__oai21_1
X_18252_ _18252_/D _20129_/CLK _18252_/Q VSS VSS VSS VSS gf180mcu_fd_sc_mcu9t5v0__dffq_1
X_15464_ _19824_/Q _15464_/A2 _19824_/D VSS VSS VSS VSS gf180mcu_fd_sc_mcu9t5v0__and2_1
X_12676_ _12665_/B _12676_/A2 _12676_/B _12716_/I1 VSS _12710_/VNW VSS VSS gf180mcu_fd_sc_mcu9t5v0__oai21_1
X_17203_ _17159_/B _17203_/A2 _17203_/A3 _17203_/B _17204_/A2 VSS VSS VSS VSS gf180mcu_fd_sc_mcu9t5v0__oai31_1
X_18183_ _18183_/D clkload82/I _18183_/Q VSS VSS VSS VSS gf180mcu_fd_sc_mcu9t5v0__dffq_4
X_15395_ _19680_/Q _19780_/Q _15420_/S _19780_/D VSS _15395_/VNW VSS VSS gf180mcu_fd_sc_mcu9t5v0__mux2_1
X_11627_ _12664_/C _11627_/A2 _11645_/A2 VSS VSS VSS VSS gf180mcu_fd_sc_mcu9t5v0__nor2_1
X_14415_ _14415_/A1 _14415_/A2 _19451_/D VSS VSS VSS VSS gf180mcu_fd_sc_mcu9t5v0__nand2_1
X_17134_ _10543_/C _17134_/A2 _17134_/B1 _10516_/C _10353_/C _17134_/C2 _17135_/A2
+ VSS _17134_/VNW VSS VSS gf180mcu_fd_sc_mcu9t5v0__aoi222_1
X_11558_ _15939_/B _12164_/B _11558_/B _11558_/C _12092_/B VSS VSS VSS VSS gf180mcu_fd_sc_mcu9t5v0__oai211_4
X_14346_ _13904_/Z _19417_/Q _14352_/S _19417_/D VSS VSS VSS VSS gf180mcu_fd_sc_mcu9t5v0__mux2_1
X_10509_ _17378_/A1 _18323_/Q _10512_/A2 VSS VSS VSS VSS gf180mcu_fd_sc_mcu9t5v0__nor2_1
X_17065_ _18527_/Q _16614_/B _17067_/S _18527_/D VSS VSS VSS VSS gf180mcu_fd_sc_mcu9t5v0__mux2_4
X_16016_ _16750_/A1 _16628_/A2 _16016_/B _16018_/A2 VSS VSS VSS VSS gf180mcu_fd_sc_mcu9t5v0__aoi21_1
X_11489_ _19101_/Q _11541_/A2 _11490_/B VSS _11489_/VNW VSS VSS gf180mcu_fd_sc_mcu9t5v0__nand2_1
X_14277_ _13986_/Z _19351_/Q _14285_/S _19351_/D VSS _14277_/VNW VSS VSS gf180mcu_fd_sc_mcu9t5v0__mux2_1
X_13228_ _19800_/Q _12734_/Z _13233_/A2 VSS VSS VSS VSS gf180mcu_fd_sc_mcu9t5v0__nand2_1
X_13159_ _13159_/A1 _13159_/A2 _13551_/B _13177_/A2 VSS VSS VSS VSS gf180mcu_fd_sc_mcu9t5v0__oai21_1
XTAP_TAPCELL_ROW_16_1418 VSS VSS gf180mcu_fd_sc_mcu9t5v0__filltie
XTAP_TAPCELL_ROW_16_1429 VSS VSS gf180mcu_fd_sc_mcu9t5v0__filltie
X_17967_ _17888_/B _17966_/B _18858_/Q _17968_/A2 VSS VSS VSS VSS gf180mcu_fd_sc_mcu9t5v0__aoi21_1
X_19706_ _19706_/D _20026_/RN _19806_/CLK _19706_/Q VSS VSS VSS VSS gf180mcu_fd_sc_mcu9t5v0__dffrnq_1
X_16918_ _16917_/Z _18451_/Q _16924_/S _18451_/D VSS VSS VSS VSS gf180mcu_fd_sc_mcu9t5v0__mux2_1
X_17898_ _17885_/S _17939_/A1 _17902_/A3 VSS VSS VSS VSS gf180mcu_fd_sc_mcu9t5v0__nand2_1
X_16849_ _19252_/Q _16628_/B _16861_/S _16849_/Z VSS VSS VSS VSS gf180mcu_fd_sc_mcu9t5v0__mux2_1
X_19637_ _19637_/D _20021_/RN clkload22/I _19637_/Q VSS VSS VSS VSS gf180mcu_fd_sc_mcu9t5v0__dffrnq_1
X_19568_ _19568_/D _20144_/RN clkload8/I _19568_/Q VSS VSS VSS VSS gf180mcu_fd_sc_mcu9t5v0__dffrnq_1
X_18519_ _18519_/D clkload79/I _18519_/Q VSS VSS VSS VSS gf180mcu_fd_sc_mcu9t5v0__dffq_1
X_09321_ _19206_/Q _18124_/A1 VSS VSS VSS VSS gf180mcu_fd_sc_mcu9t5v0__clkinv_1
X_19499_ _19499_/D _20139_/RN clkload42/I _19499_/Q VSS VSS VSS VSS gf180mcu_fd_sc_mcu9t5v0__dffrnq_1
X_09252_ _18840_/Q _17907_/C VSS VSS VSS VSS gf180mcu_fd_sc_mcu9t5v0__clkinv_1
XTAP_TAPCELL_ROW_135_4699 VSS VSS gf180mcu_fd_sc_mcu9t5v0__filltie
XTAP_TAPCELL_ROW_135_4688 VSS VSS gf180mcu_fd_sc_mcu9t5v0__filltie
X_09183_ _19120_/Q _11967_/A1 VSS _11962_/VNW VSS VSS gf180mcu_fd_sc_mcu9t5v0__clkinv_1
XTAP_TAPCELL_ROW_263_6311 VSS VSS gf180mcu_fd_sc_mcu9t5v0__filltie
XTAP_TAPCELL_ROW_263_6300 VSS VSS gf180mcu_fd_sc_mcu9t5v0__filltie
XPHY_EDGE_ROW_199_1_Right_783 VSS VSS gf180mcu_fd_sc_mcu9t5v0__endcap
XTAP_TAPCELL_ROW_92_3526 VSS VSS gf180mcu_fd_sc_mcu9t5v0__filltie
XTAP_TAPCELL_ROW_92_3515 VSS VSS gf180mcu_fd_sc_mcu9t5v0__filltie
XTAP_TAPCELL_ROW_92_3504 VSS VSS gf180mcu_fd_sc_mcu9t5v0__filltie
XTAP_TAPCELL_ROW_77_3094 VSS VSS gf180mcu_fd_sc_mcu9t5v0__filltie
XTAP_TAPCELL_ROW_257_6137 VSS VSS gf180mcu_fd_sc_mcu9t5v0__filltie
XTAP_TAPCELL_ROW_257_6126 VSS VSS gf180mcu_fd_sc_mcu9t5v0__filltie
XTAP_TAPCELL_ROW_257_6148 VSS VSS gf180mcu_fd_sc_mcu9t5v0__filltie
XTAP_TAPCELL_ROW_6_1141 VSS VSS gf180mcu_fd_sc_mcu9t5v0__filltie
XTAP_TAPCELL_ROW_6_1152 VSS VSS gf180mcu_fd_sc_mcu9t5v0__filltie
XPHY_EDGE_ROW_247_Right_174 VSS VSS gf180mcu_fd_sc_mcu9t5v0__endcap
X_10860_ _16666_/A1 _18147_/S _10860_/B _10861_/I0 VSS VSS VSS VSS gf180mcu_fd_sc_mcu9t5v0__oai21_1
XTAP_TAPCELL_ROW_2_1027 VSS VSS gf180mcu_fd_sc_mcu9t5v0__filltie
XTAP_TAPCELL_ROW_2_1038 VSS VSS gf180mcu_fd_sc_mcu9t5v0__filltie
XTAP_TAPCELL_ROW_2_1049 VSS VSS gf180mcu_fd_sc_mcu9t5v0__filltie
X_09519_ _09514_/Z _09519_/A2 _09494_/Z _18685_/Q _09519_/ZN VSS VSS VSS VSS gf180mcu_fd_sc_mcu9t5v0__oai31_4
X_10791_ _10659_/C _10790_/Z _10809_/B _10792_/A2 VSS VSS VSS VSS gf180mcu_fd_sc_mcu9t5v0__aoi21_1
X_12530_ _18350_/Q _12382_/S _12534_/A2 VSS VSS VSS VSS gf180mcu_fd_sc_mcu9t5v0__nor2_1
XTAP_TAPCELL_ROW_233_5480 VSS VSS gf180mcu_fd_sc_mcu9t5v0__filltie
XTAP_TAPCELL_ROW_62_2684 VSS VSS gf180mcu_fd_sc_mcu9t5v0__filltie
XTAP_TAPCELL_ROW_62_2695 VSS VSS gf180mcu_fd_sc_mcu9t5v0__filltie
XPHY_EDGE_ROW_293_Right_220 VSS VSS gf180mcu_fd_sc_mcu9t5v0__endcap
XTAP_TAPCELL_ROW_233_5491 VSS VSS gf180mcu_fd_sc_mcu9t5v0__filltie
X_12461_ _12355_/I _12485_/A2 _12461_/A3 _12461_/B _19153_/D VSS VSS VSS VSS gf180mcu_fd_sc_mcu9t5v0__oai31_1
X_11412_ _18447_/Q _11519_/A2 _11414_/A1 VSS VSS VSS VSS gf180mcu_fd_sc_mcu9t5v0__nor2_1
X_15180_ _19582_/Q _15181_/B2 _19581_/Q _15180_/C _15183_/B1 VSS VSS VSS VSS gf180mcu_fd_sc_mcu9t5v0__oai211_1
X_14200_ _14201_/A1 _14201_/A2 _14220_/A1 VSS VSS VSS VSS gf180mcu_fd_sc_mcu9t5v0__nand2_1
X_12392_ wire146/Z _12392_/A2 _12392_/A3 _12392_/B1 _12392_/B2 _12393_/B2 VSS VSS
+ VSS VSS gf180mcu_fd_sc_mcu9t5v0__oai32_2
X_14131_ _14131_/A1 _14132_/A2 _14184_/A1 VSS VSS VSS VSS gf180mcu_fd_sc_mcu9t5v0__nand2_1
X_11343_ _18442_/Q _11385_/A2 _11346_/A1 VSS VSS VSS VSS gf180mcu_fd_sc_mcu9t5v0__nor2_1
XTAP_TAPCELL_ROW_246_5841 VSS VSS gf180mcu_fd_sc_mcu9t5v0__filltie
XTAP_TAPCELL_ROW_246_5830 VSS VSS gf180mcu_fd_sc_mcu9t5v0__filltie
XTAP_TAPCELL_ROW_242_5727 VSS VSS gf180mcu_fd_sc_mcu9t5v0__filltie
X_11274_ _11274_/A1 _11274_/A2 _11469_/B _11274_/C _11276_/B VSS VSS VSS VSS gf180mcu_fd_sc_mcu9t5v0__oai211_1
XTAP_TAPCELL_ROW_242_5716 VSS VSS gf180mcu_fd_sc_mcu9t5v0__filltie
X_14062_ _14064_/A1 _14064_/A2 _14062_/B _14063_/I VSS _14062_/VNW VSS VSS gf180mcu_fd_sc_mcu9t5v0__aoi21_1
X_10225_ _17195_/A1 _18313_/Q _10228_/A2 VSS _16684_/VNW VSS VSS gf180mcu_fd_sc_mcu9t5v0__nor2_1
XTAP_TAPCELL_ROW_242_5738 VSS VSS gf180mcu_fd_sc_mcu9t5v0__filltie
X_18870_ _18870_/D _20022_/RN clkload40/I _18870_/Q VSS VSS VSS VSS gf180mcu_fd_sc_mcu9t5v0__dffrnq_1
X_13013_ _13025_/A2 _19788_/Q _13053_/B1 VSS VSS VSS VSS gf180mcu_fd_sc_mcu9t5v0__nor2_1
XPHY_EDGE_ROW_194_2_Right_925 VSS VSS gf180mcu_fd_sc_mcu9t5v0__endcap
X_17821_ _19028_/Q _18798_/Q _17845_/S _18798_/D VSS VSS VSS VSS gf180mcu_fd_sc_mcu9t5v0__mux2_1
X_10156_ _20000_/Q _19963_/Q _19971_/Q _20004_/Q _19987_/Q _19998_/Q _10157_/B2 VSS
+ VSS VSS VSS gf180mcu_fd_sc_mcu9t5v0__aoi222_1
XPHY_EDGE_ROW_278_Left_601 VSS VSS gf180mcu_fd_sc_mcu9t5v0__endcap
X_10087_ _20042_/Q _15593_/A1 _09974_/C _10087_/B2 _10088_/A2 VSS _17996_/VNW VSS
+ VSS gf180mcu_fd_sc_mcu9t5v0__aoi22_1
X_17752_ _18753_/Q _18748_/Q _17752_/S _18753_/D VSS VSS VSS VSS gf180mcu_fd_sc_mcu9t5v0__mux2_1
X_14964_ _14964_/A1 _14964_/A2 _14968_/A1 VSS _14967_/VNW VSS VSS gf180mcu_fd_sc_mcu9t5v0__nand2_1
X_16703_ _16722_/A1 _16703_/A2 _16703_/A3 _16703_/B _18366_/D VSS VSS VSS VSS gf180mcu_fd_sc_mcu9t5v0__oai31_4
X_17683_ _17682_/Z _18721_/Q _17742_/S _18721_/D VSS VSS VSS VSS gf180mcu_fd_sc_mcu9t5v0__mux2_1
X_13915_ _13915_/I _13916_/A2 VSS VSS VSS VSS gf180mcu_fd_sc_mcu9t5v0__clkinv_1
XPHY_EDGE_ROW_214_Right_141 VSS VSS gf180mcu_fd_sc_mcu9t5v0__endcap
X_16634_ _16750_/A1 _16674_/A2 _16634_/B _16636_/A2 VSS VSS VSS VSS gf180mcu_fd_sc_mcu9t5v0__aoi21_1
X_14895_ _19416_/Q _19357_/Q _14899_/A1 VSS VSS VSS VSS gf180mcu_fd_sc_mcu9t5v0__xnor2_1
X_19422_ _19422_/D _20062_/RN _19633_/CLK _19422_/Q VSS VSS VSS VSS gf180mcu_fd_sc_mcu9t5v0__dffrnq_1
X_13846_ _13820_/I _13846_/A2 _13846_/A3 _13872_/A1 VSS _15226_/VNW VSS VSS gf180mcu_fd_sc_mcu9t5v0__xnor3_1
X_16565_ _16565_/I0 _16563_/Z _16598_/S _16678_/B VSS VSS VSS VSS gf180mcu_fd_sc_mcu9t5v0__mux2_1
X_10989_ _18053_/A1 _10950_/Z _10992_/A2 VSS _10989_/VNW VSS VSS gf180mcu_fd_sc_mcu9t5v0__nor2_1
X_13777_ _19292_/Q _19319_/Q _19318_/Q _19293_/Q _13803_/B3 VSS VSS VSS VSS gf180mcu_fd_sc_mcu9t5v0__aoi22_1
X_19353_ _19353_/D _20057_/RN clkload7/I _19353_/Q VSS VSS VSS VSS gf180mcu_fd_sc_mcu9t5v0__dffrnq_1
X_18304_ _18304_/D _18320_/CLK _18304_/Q VSS VSS VSS VSS gf180mcu_fd_sc_mcu9t5v0__dffq_4
X_16496_ _18305_/Q _16495_/Z _16496_/S _18305_/D VSS _16496_/VNW VSS VSS gf180mcu_fd_sc_mcu9t5v0__mux2_1
X_15516_ _15566_/A1 _15516_/A2 _15515_/Z _19842_/D VSS VSS VSS VSS gf180mcu_fd_sc_mcu9t5v0__nor3_1
X_19284_ _19284_/D _20052_/RN clkload44/I _19284_/Q VSS VSS VSS VSS gf180mcu_fd_sc_mcu9t5v0__dffrnq_1
X_12728_ _14166_/B _19192_/D VSS VSS VSS VSS gf180mcu_fd_sc_mcu9t5v0__clkinv_1
X_18235_ _18235_/D clkload60/I _18235_/Q VSS VSS VSS VSS gf180mcu_fd_sc_mcu9t5v0__dffq_1
XPHY_EDGE_ROW_287_Left_610 VSS VSS gf180mcu_fd_sc_mcu9t5v0__endcap
X_15447_ _19818_/Q _15448_/A2 _15447_/S _19818_/D VSS VSS VSS VSS gf180mcu_fd_sc_mcu9t5v0__mux2_1
X_12659_ _12661_/A2 _12661_/A3 _12660_/B VSS VSS VSS VSS gf180mcu_fd_sc_mcu9t5v0__nand2_1
X_18166_ _18166_/D clkload82/I _18166_/Q VSS VSS VSS VSS gf180mcu_fd_sc_mcu9t5v0__dffq_1
XTAP_TAPCELL_ROW_212_4896 VSS VSS gf180mcu_fd_sc_mcu9t5v0__filltie
XTAP_TAPCELL_ROW_130_4563 VSS VSS gf180mcu_fd_sc_mcu9t5v0__filltie
X_15378_ _19663_/Q _19763_/Q _15420_/S _19763_/D VSS VSS VSS VSS gf180mcu_fd_sc_mcu9t5v0__mux2_1
XTAP_TAPCELL_ROW_130_4552 VSS VSS gf180mcu_fd_sc_mcu9t5v0__filltie
Xmax_cap135 _11176_/C _11485_/C VSS VSS VSS VSS gf180mcu_fd_sc_mcu9t5v0__clkbuf_8
X_17117_ _17231_/A3 _17117_/A2 _17117_/B1 _17117_/B2 _17161_/C _17118_/B VSS _17117_/VNW
+ VSS VSS gf180mcu_fd_sc_mcu9t5v0__oai221_1
X_18097_ _18097_/A1 _18097_/A2 _18097_/B _18936_/D VSS _18097_/VNW VSS VSS gf180mcu_fd_sc_mcu9t5v0__oai21_1
X_14329_ _14359_/I0 _19401_/Q _14337_/S _19401_/D VSS VSS VSS VSS gf180mcu_fd_sc_mcu9t5v0__mux2_1
Xmax_cap102 _15420_/S _15430_/S VSS VSS VSS VSS gf180mcu_fd_sc_mcu9t5v0__clkbuf_16
Xmax_cap113 _13320_/B _13419_/B VSS VSS VSS VSS gf180mcu_fd_sc_mcu9t5v0__clkbuf_16
X_17048_ _17047_/Z _18515_/Q _17054_/S _18515_/D VSS VSS VSS VSS gf180mcu_fd_sc_mcu9t5v0__mux2_4
Xmax_cap157 _11385_/A2 _11519_/A2 VSS _16444_/VNW VSS VSS gf180mcu_fd_sc_mcu9t5v0__buf_8
Xmax_cap179 _12159_/B _12324_/B VSS VSS VSS VSS gf180mcu_fd_sc_mcu9t5v0__clkbuf_8
X_09870_ _20045_/Q _20046_/Q _09870_/Z VSS _17987_/VNW VSS VSS gf180mcu_fd_sc_mcu9t5v0__or2_1
X_18999_ _18999_/D _20023_/RN clkload70/I _18999_/Q VSS VSS VSS VSS gf180mcu_fd_sc_mcu9t5v0__dffrnq_1
XTAP_TAPCELL_ROW_128_4492 VSS VSS gf180mcu_fd_sc_mcu9t5v0__filltie
XPHY_EDGE_ROW_0_Left_324 VSS VSS gf180mcu_fd_sc_mcu9t5v0__endcap
XTAP_TAPCELL_ROW_85_3330 VSS VSS gf180mcu_fd_sc_mcu9t5v0__filltie
XTAP_TAPCELL_ROW_252_6001 VSS VSS gf180mcu_fd_sc_mcu9t5v0__filltie
XTAP_TAPCELL_ROW_124_4389 VSS VSS gf180mcu_fd_sc_mcu9t5v0__filltie
XTAP_TAPCELL_ROW_81_3205 VSS VSS gf180mcu_fd_sc_mcu9t5v0__filltie
XTAP_TAPCELL_ROW_252_6012 VSS VSS gf180mcu_fd_sc_mcu9t5v0__filltie
XTAP_TAPCELL_ROW_81_3216 VSS VSS gf180mcu_fd_sc_mcu9t5v0__filltie
X_09304_ _19226_/Q _16666_/A1 VSS VSS VSS VSS gf180mcu_fd_sc_mcu9t5v0__clkinv_1
XTAP_TAPCELL_ROW_79_3167 VSS VSS gf180mcu_fd_sc_mcu9t5v0__filltie
XTAP_TAPCELL_ROW_79_3156 VSS VSS gf180mcu_fd_sc_mcu9t5v0__filltie
X_09235_ _19300_/Q _14223_/A2 VSS _12726_/VNW VSS VSS gf180mcu_fd_sc_mcu9t5v0__clkinv_1
XTAP_TAPCELL_ROW_79_3145 VSS VSS gf180mcu_fd_sc_mcu9t5v0__filltie
X_09166_ _19748_/Q _13486_/A1 VSS VSS VSS VSS gf180mcu_fd_sc_mcu9t5v0__clkinv_1
X_09097_ _19910_/Q _15671_/A1 VSS _09596_/VNW VSS VSS gf180mcu_fd_sc_mcu9t5v0__clkinv_1
XTAP_TAPCELL_ROW_70_2920 VSS VSS gf180mcu_fd_sc_mcu9t5v0__filltie
XPHY_EDGE_ROW_316_Right_243 VSS VSS gf180mcu_fd_sc_mcu9t5v0__endcap
X_10010_ _18989_/Q wire297/Z wire172/Z _18957_/Q _10012_/A1 VSS _10309_/VNW VSS VSS
+ gf180mcu_fd_sc_mcu9t5v0__aoi22_1
XPHY_EDGE_ROW_55_Left_379 VSS VSS gf180mcu_fd_sc_mcu9t5v0__endcap
X_09999_ _18988_/Q wire297/Z wire285/I _18996_/Q _10001_/A1 VSS VSS VSS VSS gf180mcu_fd_sc_mcu9t5v0__aoi22_1
XTAP_TAPCELL_ROW_51_2374 VSS VSS gf180mcu_fd_sc_mcu9t5v0__filltie
XTAP_TAPCELL_ROW_8_1203 VSS VSS gf180mcu_fd_sc_mcu9t5v0__filltie
XTAP_TAPCELL_ROW_8_1214 VSS VSS gf180mcu_fd_sc_mcu9t5v0__filltie
XTAP_TAPCELL_ROW_222_5181 VSS VSS gf180mcu_fd_sc_mcu9t5v0__filltie
XTAP_TAPCELL_ROW_222_5170 VSS VSS gf180mcu_fd_sc_mcu9t5v0__filltie
XTAP_TAPCELL_ROW_51_2385 VSS VSS gf180mcu_fd_sc_mcu9t5v0__filltie
XTAP_TAPCELL_ROW_51_2396 VSS VSS gf180mcu_fd_sc_mcu9t5v0__filltie
X_11961_ _12071_/B _11959_/Z _11988_/A1 _11961_/B _11962_/A2 VSS VSS VSS VSS gf180mcu_fd_sc_mcu9t5v0__oai31_4
XPHY_EDGE_ROW_300_Left_623 VSS VSS gf180mcu_fd_sc_mcu9t5v0__endcap
X_10912_ _10911_/Z _18995_/Q _18152_/S _18995_/D VSS _12220_/VNW VSS VSS gf180mcu_fd_sc_mcu9t5v0__mux2_1
XTAP_TAPCELL_ROW_68_2860 VSS VSS gf180mcu_fd_sc_mcu9t5v0__filltie
Xrst_tree_mid_0 rst_tree_root/Z rst_tree_mid_0/Z VSS VSS VSS VSS gf180mcu_fd_sc_mcu9t5v0__clkbuf_16
X_13700_ _13700_/I _14662_/A1 VSS VSS VSS VSS gf180mcu_fd_sc_mcu9t5v0__clkinv_1
X_11892_ _11892_/A1 _11892_/A2 _11892_/B1 _11892_/B2 _12324_/B _11897_/A2 VSS VSS
+ VSS VSS gf180mcu_fd_sc_mcu9t5v0__oai221_1
XTAP_TAPCELL_ROW_235_5531 VSS VSS gf180mcu_fd_sc_mcu9t5v0__filltie
XTAP_TAPCELL_ROW_235_5520 VSS VSS gf180mcu_fd_sc_mcu9t5v0__filltie
XTAP_TAPCELL_ROW_64_2735 VSS VSS gf180mcu_fd_sc_mcu9t5v0__filltie
X_14680_ _19149_/Q _19115_/Q _14683_/C _14681_/A2 VSS _14680_/VNW VSS VSS gf180mcu_fd_sc_mcu9t5v0__aoi21_1
XTAP_TAPCELL_ROW_64_2746 VSS VSS gf180mcu_fd_sc_mcu9t5v0__filltie
Xeco15_sk2_7 eco15_sk2_7/I _18366_/CLK VSS VSS VSS VSS gf180mcu_fd_sc_mcu9t5v0__clkbuf_16
XTAP_TAPCELL_ROW_235_5542 VSS VSS gf180mcu_fd_sc_mcu9t5v0__filltie
X_13631_ _13615_/B _13635_/A3 _13632_/A2 VSS _13631_/VNW VSS VSS gf180mcu_fd_sc_mcu9t5v0__nand2_1
X_10843_ _10843_/A1 _10843_/A2 _10996_/S VSS _12885_/VNW VSS VSS gf180mcu_fd_sc_mcu9t5v0__nor2_2
X_16350_ _18239_/Q _16349_/Z wire37/I _18239_/D VSS VSS VSS VSS gf180mcu_fd_sc_mcu9t5v0__mux2_1
XTAP_TAPCELL_ROW_231_5428 VSS VSS gf180mcu_fd_sc_mcu9t5v0__filltie
X_10774_ _10774_/I0 _18828_/Q _20030_/Q _10774_/Z VSS VSS VSS VSS gf180mcu_fd_sc_mcu9t5v0__mux2_1
XTAP_TAPCELL_ROW_231_5417 VSS VSS gf180mcu_fd_sc_mcu9t5v0__filltie
X_13562_ _13043_/I _13560_/Z _13566_/A1 _13562_/B _19273_/D VSS _13562_/VNW VSS VSS
+ gf180mcu_fd_sc_mcu9t5v0__oai31_1
XPHY_EDGE_ROW_64_Left_388 VSS VSS gf180mcu_fd_sc_mcu9t5v0__endcap
X_16281_ _19272_/Q _16829_/A2 _16283_/A1 VSS _16281_/VNW VSS VSS gf180mcu_fd_sc_mcu9t5v0__nand2_1
Xclkbuf_leaf_55_clk_regs clkload2/I clkload42/I VSS VSS VSS VSS gf180mcu_fd_sc_mcu9t5v0__clkbuf_8
X_15301_ _15304_/A1 _15300_/Z _15302_/A3 VSS VSS VSS VSS gf180mcu_fd_sc_mcu9t5v0__nor2_1
X_12513_ _12686_/C _12488_/I _12513_/A3 _12513_/B _19160_/D VSS VSS VSS VSS gf180mcu_fd_sc_mcu9t5v0__oai31_1
XTAP_TAPCELL_ROW_248_5903 VSS VSS gf180mcu_fd_sc_mcu9t5v0__filltie
X_13493_ _13477_/Z _13493_/A2 _13645_/B _13494_/A3 VSS VSS VSS VSS gf180mcu_fd_sc_mcu9t5v0__oai21_1
X_18020_ _18036_/I0 _18905_/Q _18021_/S _18905_/D VSS _18020_/VNW VSS VSS gf180mcu_fd_sc_mcu9t5v0__mux2_1
X_12444_ _19151_/Q _12355_/I _12445_/B VSS VSS VSS VSS gf180mcu_fd_sc_mcu9t5v0__nand2_1
X_15232_ _19596_/Q _19573_/Q _15237_/A1 _15233_/I1 VSS VSS VSS VSS gf180mcu_fd_sc_mcu9t5v0__xnor3_1
X_12375_ _18203_/Q _12582_/A2 _12378_/A3 VSS VSS VSS VSS gf180mcu_fd_sc_mcu9t5v0__nor2_1
XTAP_TAPCELL_ROW_229_5357 VSS VSS gf180mcu_fd_sc_mcu9t5v0__filltie
X_15163_ _19705_/Q _19545_/Q _15163_/S _19705_/D VSS VSS VSS VSS gf180mcu_fd_sc_mcu9t5v0__mux2_1
XTAP_TAPCELL_ROW_229_5379 VSS VSS gf180mcu_fd_sc_mcu9t5v0__filltie
XTAP_TAPCELL_ROW_229_5368 VSS VSS gf180mcu_fd_sc_mcu9t5v0__filltie
X_19971_ _19971_/D _20035_/RN clkload44/I _19971_/Q VSS VSS VSS VSS gf180mcu_fd_sc_mcu9t5v0__dffrnq_1
X_14114_ _14115_/A1 _14115_/A2 _14114_/Z VSS VSS VSS VSS gf180mcu_fd_sc_mcu9t5v0__or2_1
X_11326_ _17961_/A3 _11541_/A2 _19089_/D VSS VSS VSS VSS gf180mcu_fd_sc_mcu9t5v0__nand2_1
X_15094_ _19395_/Q _19313_/Q _15095_/I VSS VSS VSS VSS gf180mcu_fd_sc_mcu9t5v0__xnor2_1
X_14045_ _14045_/A1 _14045_/A2 _14045_/B _14053_/A1 VSS _14045_/VNW VSS VSS gf180mcu_fd_sc_mcu9t5v0__oai21_1
X_18922_ _18922_/D _20138_/RN clkload31/I _18922_/Q VSS VSS VSS VSS gf180mcu_fd_sc_mcu9t5v0__dffrnq_1
XPHY_EDGE_ROW_73_Left_397 VSS VSS gf180mcu_fd_sc_mcu9t5v0__endcap
X_11257_ _11257_/A1 _11257_/A2 _19083_/D VSS VSS VSS VSS gf180mcu_fd_sc_mcu9t5v0__nand2_1
X_10208_ _15470_/A1 _17322_/A2 _10237_/A1 _15466_/A3 VSS _15466_/VNW VSS VSS gf180mcu_fd_sc_mcu9t5v0__nand3_1
X_11188_ _18255_/Q _11509_/A2 _11191_/A1 VSS VSS VSS VSS gf180mcu_fd_sc_mcu9t5v0__nor2_1
X_18853_ _18853_/D _20069_/RN clkload35/I _18853_/Q VSS VSS VSS VSS gf180mcu_fd_sc_mcu9t5v0__dffrnq_1
X_18784_ _18784_/D _20064_/RN clkload63/I _18784_/Q VSS VSS VSS VSS gf180mcu_fd_sc_mcu9t5v0__dffrnq_1
X_10139_ _10139_/A1 _10139_/A2 _10139_/A3 _10140_/A2 VSS _12273_/VNW VSS VSS gf180mcu_fd_sc_mcu9t5v0__nand3_1
X_17804_ input5/Z _18782_/Q _17807_/S _18782_/D VSS VSS VSS VSS gf180mcu_fd_sc_mcu9t5v0__mux2_1
XPHY_EDGE_ROW_195_2_Right_926 VSS VSS gf180mcu_fd_sc_mcu9t5v0__endcap
XTAP_TAPCELL_ROW_292_7093 VSS VSS gf180mcu_fd_sc_mcu9t5v0__filltie
X_15996_ _16750_/A1 _16628_/A2 _15996_/B _16004_/B1 VSS VSS VSS VSS gf180mcu_fd_sc_mcu9t5v0__aoi21_4
X_17735_ _17735_/A1 _17742_/S _17735_/B _18743_/D VSS _17735_/VNW VSS VSS gf180mcu_fd_sc_mcu9t5v0__oai21_1
X_14947_ _19611_/Q _19367_/Q _20039_/D _19611_/D VSS VSS VSS VSS gf180mcu_fd_sc_mcu9t5v0__mux2_1
XTAP_TAPCELL_ROW_313_7675 VSS VSS gf180mcu_fd_sc_mcu9t5v0__filltie
X_17666_ _18629_/Q _18705_/Q _17685_/S _18705_/D VSS VSS VSS VSS gf180mcu_fd_sc_mcu9t5v0__mux2_1
X_14878_ _19593_/Q wire108/I _14884_/B VSS VSS VSS VSS gf180mcu_fd_sc_mcu9t5v0__nor2_1
XTAP_TAPCELL_ROW_313_7686 VSS VSS gf180mcu_fd_sc_mcu9t5v0__filltie
X_16617_ _18351_/Q _16617_/I1 _16643_/S _18351_/D VSS VSS VSS VSS gf180mcu_fd_sc_mcu9t5v0__mux2_4
X_17597_ input8/Z _18662_/Q _17597_/S _18662_/D VSS VSS VSS VSS gf180mcu_fd_sc_mcu9t5v0__mux2_1
X_13829_ _13795_/Z _13829_/A2 _13828_/Z _13837_/B VSS _13830_/VNW VSS VSS gf180mcu_fd_sc_mcu9t5v0__and3_1
X_19405_ _19405_/D _20045_/RN clkload17/I _19405_/Q VSS VSS VSS VSS gf180mcu_fd_sc_mcu9t5v0__dffrnq_1
X_16548_ _18331_/Q _16016_/B _17062_/S _18331_/D VSS VSS VSS VSS gf180mcu_fd_sc_mcu9t5v0__mux2_1
XPHY_EDGE_ROW_156_3_Left_814 VSS VSS gf180mcu_fd_sc_mcu9t5v0__endcap
X_19336_ _19336_/D _20040_/RN clkload18/I _19336_/Q VSS VSS VSS VSS gf180mcu_fd_sc_mcu9t5v0__dffrnq_1
XTAP_TAPCELL_ROW_214_4947 VSS VSS gf180mcu_fd_sc_mcu9t5v0__filltie
XTAP_TAPCELL_ROW_132_4614 VSS VSS gf180mcu_fd_sc_mcu9t5v0__filltie
XTAP_TAPCELL_ROW_132_4603 VSS VSS gf180mcu_fd_sc_mcu9t5v0__filltie
X_16479_ _19228_/Q _16117_/C _17023_/S _16479_/Z VSS VSS VSS VSS gf180mcu_fd_sc_mcu9t5v0__mux2_1
XTAP_TAPCELL_ROW_214_4969 VSS VSS gf180mcu_fd_sc_mcu9t5v0__filltie
XTAP_TAPCELL_ROW_214_4958 VSS VSS gf180mcu_fd_sc_mcu9t5v0__filltie
XTAP_TAPCELL_ROW_132_4625 VSS VSS gf180mcu_fd_sc_mcu9t5v0__filltie
X_19267_ _19267_/D _20035_/RN clkload39/I _19267_/Q VSS VSS VSS VSS gf180mcu_fd_sc_mcu9t5v0__dffrnq_1
XTAP_TAPCELL_ROW_117_4193 VSS VSS gf180mcu_fd_sc_mcu9t5v0__filltie
X_18218_ _18218_/D clkload64/I _18218_/Q VSS VSS VSS VSS gf180mcu_fd_sc_mcu9t5v0__dffq_1
XTAP_TAPCELL_ROW_74_3020 VSS VSS gf180mcu_fd_sc_mcu9t5v0__filltie
X_19198_ _19198_/D _20030_/RN clkload24/I _19198_/Q VSS VSS VSS VSS gf180mcu_fd_sc_mcu9t5v0__dffrnq_1
X_18149_ _19219_/Q _19225_/Q _18151_/S _18149_/Z VSS _18149_/VNW VSS VSS gf180mcu_fd_sc_mcu9t5v0__mux2_1
XTAP_TAPCELL_ROW_74_3031 VSS VSS gf180mcu_fd_sc_mcu9t5v0__filltie
XTAP_TAPCELL_ROW_113_4079 VSS VSS gf180mcu_fd_sc_mcu9t5v0__filltie
XPHY_EDGE_ROW_152_1_Left_475 VSS VSS gf180mcu_fd_sc_mcu9t5v0__endcap
X_20111_ _20111_/D clkload57/I _20111_/Q VSS VSS VSS VSS gf180mcu_fd_sc_mcu9t5v0__dffq_1
X_09922_ _10064_/S _10841_/A2 _09922_/B _09930_/A2 VSS VSS VSS VSS gf180mcu_fd_sc_mcu9t5v0__oai21_1
X_09853_ _09558_/I _17863_/A2 _20027_/D VSS _09853_/VNW VSS VSS gf180mcu_fd_sc_mcu9t5v0__nand2_1
X_20042_ _20042_/D _20042_/RN clkload45/I _20042_/Q VSS VSS VSS VSS gf180mcu_fd_sc_mcu9t5v0__dffrnq_1
X_09784_ _18845_/Q _17903_/A1 _09784_/Z VSS VSS VSS VSS gf180mcu_fd_sc_mcu9t5v0__xor2_1
Xu_transform_scheduler_core.u_fft_scratch_sram.u_lo.g_pin_drive\[3\].u_addr_driver
+ _10719_/ZN u_transform_scheduler_core.u_fft_scratch_sram.u_lo.u_sram/A[3] VSS VSS
+ VSS VSS gf180mcu_fd_sc_mcu9t5v0__buf_8
XTAP_TAPCELL_ROW_102_3783 VSS VSS gf180mcu_fd_sc_mcu9t5v0__filltie
XTAP_TAPCELL_ROW_102_3794 VSS VSS gf180mcu_fd_sc_mcu9t5v0__filltie
XPHY_EDGE_ROW_140_3_Left_798 VSS VSS gf180mcu_fd_sc_mcu9t5v0__endcap
XTAP_TAPCELL_ROW_288_6995 VSS VSS gf180mcu_fd_sc_mcu9t5v0__filltie
XTAP_TAPCELL_ROW_288_6984 VSS VSS gf180mcu_fd_sc_mcu9t5v0__filltie
X_10490_ _09261_/I _10490_/A2 _10490_/A3 _10490_/B _10495_/B1 VSS VSS VSS VSS gf180mcu_fd_sc_mcu9t5v0__oai31_1
XTAP_TAPCELL_ROW_40_2075 VSS VSS gf180mcu_fd_sc_mcu9t5v0__filltie
X_09218_ _19595_/Q _15224_/A1 VSS VSS VSS VSS gf180mcu_fd_sc_mcu9t5v0__clkinv_1
XTAP_TAPCELL_ROW_40_2086 VSS VSS gf180mcu_fd_sc_mcu9t5v0__filltie
X_09149_ _19770_/Q _13316_/A2 VSS _13292_/VNW VSS VSS gf180mcu_fd_sc_mcu9t5v0__clkinv_1
X_12160_ _12160_/A1 _12160_/A2 _12160_/B1 _12160_/B2 _12320_/C _12161_/B VSS VSS VSS
+ VSS gf180mcu_fd_sc_mcu9t5v0__aoi221_1
XTAP_TAPCELL_ROW_57_2550 VSS VSS gf180mcu_fd_sc_mcu9t5v0__filltie
XTAP_TAPCELL_ROW_57_2561 VSS VSS gf180mcu_fd_sc_mcu9t5v0__filltie
X_11111_ _18330_/Q _11385_/A2 _11113_/B1 VSS VSS VSS VSS gf180mcu_fd_sc_mcu9t5v0__nand2_1
XTAP_TAPCELL_ROW_224_5221 VSS VSS gf180mcu_fd_sc_mcu9t5v0__filltie
X_12091_ _18444_/Q _12046_/S _12093_/B1 VSS _17147_/VNW VSS VSS gf180mcu_fd_sc_mcu9t5v0__nand2_1
XTAP_TAPCELL_ROW_224_5243 VSS VSS gf180mcu_fd_sc_mcu9t5v0__filltie
XTAP_TAPCELL_ROW_224_5232 VSS VSS gf180mcu_fd_sc_mcu9t5v0__filltie
XTAP_TAPCELL_ROW_53_2436 VSS VSS gf180mcu_fd_sc_mcu9t5v0__filltie
XTAP_TAPCELL_ROW_53_2447 VSS VSS gf180mcu_fd_sc_mcu9t5v0__filltie
XTAP_TAPCELL_ROW_220_5118 VSS VSS gf180mcu_fd_sc_mcu9t5v0__filltie
XTAP_TAPCELL_ROW_220_5107 VSS VSS gf180mcu_fd_sc_mcu9t5v0__filltie
X_11042_ _18028_/I0 _19043_/Q wire174/Z _19043_/D VSS VSS VSS VSS gf180mcu_fd_sc_mcu9t5v0__mux2_1
XTAP_TAPCELL_ROW_220_5129 VSS VSS gf180mcu_fd_sc_mcu9t5v0__filltie
X_15850_ _20139_/Q _15850_/A2 _15851_/A2 VSS _15850_/VNW VSS VSS gf180mcu_fd_sc_mcu9t5v0__nand2_1
X_14801_ _19400_/Q _19337_/Q _14806_/B VSS _14805_/VNW VSS VSS gf180mcu_fd_sc_mcu9t5v0__and2_1
X_15781_ _19975_/Q _19951_/Q _15786_/S _19951_/D VSS VSS VSS VSS gf180mcu_fd_sc_mcu9t5v0__mux2_1
XTAP_TAPCELL_ROW_66_2808 VSS VSS gf180mcu_fd_sc_mcu9t5v0__filltie
X_12993_ _12996_/A1 _12996_/A2 _12997_/A1 VSS _12993_/VNW VSS VSS gf180mcu_fd_sc_mcu9t5v0__nor2_1
X_17520_ input7/Z _18625_/Q _17521_/S _18625_/D VSS VSS VSS VSS gf180mcu_fd_sc_mcu9t5v0__mux2_1
X_11944_ _11988_/B _11924_/Z _11944_/B _11960_/A2 VSS VSS VSS VSS gf180mcu_fd_sc_mcu9t5v0__oai21_4
X_14732_ _14735_/A1 _14735_/A2 _14732_/Z VSS _14732_/VNW VSS VSS gf180mcu_fd_sc_mcu9t5v0__xor2_1
X_11875_ _12261_/B _11863_/Z _11875_/B _11884_/A2 VSS _16073_/VNW VSS VSS gf180mcu_fd_sc_mcu9t5v0__oai21_1
XTAP_TAPCELL_ROW_218_5069 VSS VSS gf180mcu_fd_sc_mcu9t5v0__filltie
XTAP_TAPCELL_ROW_218_5058 VSS VSS gf180mcu_fd_sc_mcu9t5v0__filltie
X_14663_ _19527_/Q _14670_/S _14664_/B VSS VSS VSS VSS gf180mcu_fd_sc_mcu9t5v0__nand2_1
X_17451_ _17461_/A1 _11985_/B _18572_/Q _17452_/A2 VSS VSS VSS VSS gf180mcu_fd_sc_mcu9t5v0__aoi21_1
X_16402_ _16401_/Z _18264_/Q _16924_/S _18264_/D VSS VSS VSS VSS gf180mcu_fd_sc_mcu9t5v0__mux2_1
X_10826_ _20143_/Q _09709_/Z _10826_/B _20065_/Q _10827_/I VSS VSS VSS VSS gf180mcu_fd_sc_mcu9t5v0__oai211_1
X_13614_ _13614_/A1 _13610_/Z _13614_/B _13620_/A1 VSS _13614_/VNW VSS VSS gf180mcu_fd_sc_mcu9t5v0__aoi21_1
X_17382_ _17260_/S _18407_/Q _17385_/A2 VSS _17383_/VNW VSS VSS gf180mcu_fd_sc_mcu9t5v0__nor2_1
XTAP_TAPCELL_ROW_207_3_8249 VSS VSS gf180mcu_fd_sc_mcu9t5v0__filltie
X_14594_ _14594_/A1 _19139_/Q _14594_/B _14595_/B2 VSS _15175_/VNW VSS VSS gf180mcu_fd_sc_mcu9t5v0__oai21_1
X_19121_ _19121_/D _20145_/RN _19798_/CLK _19121_/Q VSS VSS VSS VSS gf180mcu_fd_sc_mcu9t5v0__dffrnq_4
X_16333_ _19243_/Q _16099_/B _16833_/S _16333_/Z VSS _16333_/VNW VSS VSS gf180mcu_fd_sc_mcu9t5v0__mux2_1
X_13545_ _13546_/B _13546_/A1 _13546_/A2 _13548_/A1 VSS VSS VSS VSS gf180mcu_fd_sc_mcu9t5v0__nor3_1
X_10757_ _10757_/A1 _10757_/A2 _10776_/A2 VSS _10777_/VNW VSS VSS gf180mcu_fd_sc_mcu9t5v0__xnor2_1
X_16264_ _18208_/Q _16264_/I1 _16818_/S _18208_/D VSS VSS VSS VSS gf180mcu_fd_sc_mcu9t5v0__mux2_4
X_13476_ _13486_/A1 _13478_/A2 _13645_/A1 VSS VSS VSS VSS gf180mcu_fd_sc_mcu9t5v0__nand2_1
X_10688_ _18836_/Q _18845_/Q _10688_/B _10688_/C _10689_/I VSS _10688_/VNW VSS VSS
+ gf180mcu_fd_sc_mcu9t5v0__oai211_1
X_19052_ _19052_/D _20140_/RN clkload35/I _19052_/Q VSS VSS VSS VSS gf180mcu_fd_sc_mcu9t5v0__dffrnq_1
XTAP_TAPCELL_ROW_321_7900 VSS VSS gf180mcu_fd_sc_mcu9t5v0__filltie
X_18003_ _18889_/Q _18036_/I0 _18004_/S _18889_/D VSS _18003_/VNW VSS VSS gf180mcu_fd_sc_mcu9t5v0__mux2_1
X_12427_ wire175/Z _12427_/A2 _12618_/B _12429_/A3 VSS _12427_/VNW VSS VSS gf180mcu_fd_sc_mcu9t5v0__aoi21_1
X_15215_ _15217_/A1 _19570_/Q _15219_/A1 VSS VSS VSS VSS gf180mcu_fd_sc_mcu9t5v0__nor2_1
XTAP_TAPCELL_ROW_321_7911 VSS VSS gf180mcu_fd_sc_mcu9t5v0__filltie
X_16195_ _16722_/A1 _16195_/A2 _16195_/A3 _16195_/B _18184_/D VSS VSS VSS VSS gf180mcu_fd_sc_mcu9t5v0__oai31_4
XPHY_EDGE_ROW_81_Left_405 VSS VSS gf180mcu_fd_sc_mcu9t5v0__endcap
XTAP_TAPCELL_ROW_306_7490 VSS VSS gf180mcu_fd_sc_mcu9t5v0__filltie
X_12358_ _18153_/Q _12382_/S _12362_/A2 VSS VSS VSS VSS gf180mcu_fd_sc_mcu9t5v0__nor2_1
X_15146_ _19688_/Q _19528_/Q wire108/I _19688_/D VSS VSS VSS VSS gf180mcu_fd_sc_mcu9t5v0__mux2_1
XTAP_TAPCELL_ROW_302_7387 VSS VSS gf180mcu_fd_sc_mcu9t5v0__filltie
X_12289_ _12324_/B _12289_/A2 _12289_/A3 _12290_/B VSS _16960_/VNW VSS VSS gf180mcu_fd_sc_mcu9t5v0__nand3_1
XTAP_TAPCELL_ROW_302_7376 VSS VSS gf180mcu_fd_sc_mcu9t5v0__filltie
XTAP_TAPCELL_ROW_302_7365 VSS VSS gf180mcu_fd_sc_mcu9t5v0__filltie
X_11309_ _18200_/Q _11534_/S _11311_/A2 VSS _11310_/VNW VSS VSS gf180mcu_fd_sc_mcu9t5v0__nand2_1
X_19954_ _19954_/D _20018_/RN clkload66/I _19954_/Q VSS VSS VSS VSS gf180mcu_fd_sc_mcu9t5v0__dffrnq_1
X_15077_ _19310_/Q _19395_/Q _15077_/A3 _15077_/Z VSS _15077_/VNW VSS VSS gf180mcu_fd_sc_mcu9t5v0__xor3_1
XTAP_TAPCELL_ROW_294_7144 VSS VSS gf180mcu_fd_sc_mcu9t5v0__filltie
Xu_transform_scheduler_core.u_fft_scratch_sram.u_hi.g_pin_drive\[5\].u_addr_driver
+ _10770_/ZN u_transform_scheduler_core.u_fft_scratch_sram.u_hi.u_sram/A[5] VSS VSS
+ VSS VSS gf180mcu_fd_sc_mcu9t5v0__buf_8
X_19885_ _19885_/D _20141_/RN clkload46/I _19885_/Q VSS VSS VSS VSS gf180mcu_fd_sc_mcu9t5v0__dffrnq_1
XTAP_TAPCELL_ROW_36_1966 VSS VSS gf180mcu_fd_sc_mcu9t5v0__filltie
X_14028_ _13984_/Z _14031_/A3 _14029_/A2 VSS VSS VSS VSS gf180mcu_fd_sc_mcu9t5v0__nor2_1
X_18905_ _18905_/D _20057_/RN clkload30/I _18905_/Q VSS VSS VSS VSS gf180mcu_fd_sc_mcu9t5v0__dffrnq_1
XTAP_TAPCELL_ROW_319_7851 VSS VSS gf180mcu_fd_sc_mcu9t5v0__filltie
XTAP_TAPCELL_ROW_294_7166 VSS VSS gf180mcu_fd_sc_mcu9t5v0__filltie
XTAP_TAPCELL_ROW_319_7840 VSS VSS gf180mcu_fd_sc_mcu9t5v0__filltie
XTAP_TAPCELL_ROW_294_7155 VSS VSS gf180mcu_fd_sc_mcu9t5v0__filltie
X_18836_ _18836_/D _20052_/RN clkload33/I _18836_/Q VSS VSS VSS VSS gf180mcu_fd_sc_mcu9t5v0__dffrnq_1
XTAP_TAPCELL_ROW_36_1977 VSS VSS gf180mcu_fd_sc_mcu9t5v0__filltie
XTAP_TAPCELL_ROW_315_7726 VSS VSS gf180mcu_fd_sc_mcu9t5v0__filltie
XPHY_EDGE_ROW_196_2_Right_927 VSS VSS gf180mcu_fd_sc_mcu9t5v0__endcap
XTAP_TAPCELL_ROW_121_4315 VSS VSS gf180mcu_fd_sc_mcu9t5v0__filltie
XTAP_TAPCELL_ROW_121_4304 VSS VSS gf180mcu_fd_sc_mcu9t5v0__filltie
XTAP_TAPCELL_ROW_315_7737 VSS VSS gf180mcu_fd_sc_mcu9t5v0__filltie
X_18767_ _18767_/D _20047_/RN clkload51/I _18767_/Q VSS VSS VSS VSS gf180mcu_fd_sc_mcu9t5v0__dffrnq_1
X_15979_ _18567_/Q _16298_/A1 _15979_/ZN VSS _15979_/VNW VSS VSS gf180mcu_fd_sc_mcu9t5v0__nor2_4
X_17718_ _18735_/Q _17681_/S _17743_/B _18659_/Q _17719_/I VSS VSS VSS VSS gf180mcu_fd_sc_mcu9t5v0__aoi22_1
X_18698_ _18698_/D clkload59/I _18698_/Q VSS VSS VSS VSS gf180mcu_fd_sc_mcu9t5v0__dffq_1
XPHY_EDGE_ROW_90_Left_414 VSS VSS gf180mcu_fd_sc_mcu9t5v0__endcap
XPHY_EDGE_ROW_215_Left_538 VSS VSS gf180mcu_fd_sc_mcu9t5v0__endcap
X_17649_ _17649_/I0 _18692_/Q _17649_/S _18692_/D VSS VSS VSS VSS gf180mcu_fd_sc_mcu9t5v0__mux2_1
XTAP_TAPCELL_ROW_119_4244 VSS VSS gf180mcu_fd_sc_mcu9t5v0__filltie
XTAP_TAPCELL_ROW_119_4266 VSS VSS gf180mcu_fd_sc_mcu9t5v0__filltie
XTAP_TAPCELL_ROW_119_4255 VSS VSS gf180mcu_fd_sc_mcu9t5v0__filltie
X_19319_ _19319_/D _20023_/RN clkload14/I _19319_/Q VSS VSS VSS VSS gf180mcu_fd_sc_mcu9t5v0__dffrnq_1
Xclkbuf_leaf_0_clk_regs clkbuf_3_0_0_clk_regs/Z clkload7/I VSS clkbuf_leaf_0_clk_regs/VNW
+ VSS VSS gf180mcu_fd_sc_mcu9t5v0__clkbuf_8
XPHY_EDGE_ROW_224_Left_547 VSS VSS gf180mcu_fd_sc_mcu9t5v0__endcap
X_09905_ _09924_/A1 _10054_/A2 wire172/I VSS VSS VSS VSS gf180mcu_fd_sc_mcu9t5v0__nor2_1
X_20025_ _20025_/D _20025_/RN clkload44/I _20025_/Q VSS VSS VSS VSS gf180mcu_fd_sc_mcu9t5v0__dffrnq_1
XTAP_TAPCELL_ROW_277_6685 VSS VSS gf180mcu_fd_sc_mcu9t5v0__filltie
X_09836_ _17888_/B _19017_/Q _10190_/B VSS VSS VSS VSS gf180mcu_fd_sc_mcu9t5v0__nand2_1
XPHY_EDGE_ROW_129_Left_453 VSS VSS gf180mcu_fd_sc_mcu9t5v0__endcap
XTAP_TAPCELL_ROW_277_6696 VSS VSS gf180mcu_fd_sc_mcu9t5v0__filltie
X_09767_ _09832_/A3 _09767_/A2 _09814_/A3 _09772_/A1 VSS VSS VSS VSS gf180mcu_fd_sc_mcu9t5v0__nand3_1
XTAP_TAPCELL_ROW_104_3834 VSS VSS gf180mcu_fd_sc_mcu9t5v0__filltie
XPHY_EDGE_ROW_233_Left_556 VSS VSS gf180mcu_fd_sc_mcu9t5v0__endcap
X_09698_ _15705_/B _09698_/A2 _09698_/B _15946_/A4 VSS _09698_/VNW VSS VSS gf180mcu_fd_sc_mcu9t5v0__aoi21_1
XTAP_TAPCELL_ROW_104_3856 VSS VSS gf180mcu_fd_sc_mcu9t5v0__filltie
XTAP_TAPCELL_ROW_104_3845 VSS VSS gf180mcu_fd_sc_mcu9t5v0__filltie
XTAP_TAPCELL_ROW_46_2240 VSS VSS gf180mcu_fd_sc_mcu9t5v0__filltie
XTAP_TAPCELL_ROW_46_2251 VSS VSS gf180mcu_fd_sc_mcu9t5v0__filltie
XTAP_TAPCELL_ROW_42_2126 VSS VSS gf180mcu_fd_sc_mcu9t5v0__filltie
X_11660_ _11660_/A1 _11660_/A2 _11660_/B1 _12664_/C _12629_/A2 VSS VSS VSS VSS gf180mcu_fd_sc_mcu9t5v0__oai22_1
XTAP_TAPCELL_ROW_42_2137 VSS VSS gf180mcu_fd_sc_mcu9t5v0__filltie
XTAP_TAPCELL_ROW_42_2148 VSS VSS gf180mcu_fd_sc_mcu9t5v0__filltie
X_10611_ _17404_/S _18215_/Q _10613_/A3 VSS VSS VSS VSS gf180mcu_fd_sc_mcu9t5v0__nor2_1
X_11591_ _18837_/Q _11591_/A2 _18838_/Q _18845_/Q _11656_/A1 VSS _11605_/VNW VSS VSS
+ gf180mcu_fd_sc_mcu9t5v0__nand4_1
X_10542_ _18164_/Q _17406_/A2 _17405_/A2 _18180_/Q _10543_/B VSS VSS VSS VSS gf180mcu_fd_sc_mcu9t5v0__aoi22_1
X_13330_ _13330_/I _13354_/A1 VSS _15323_/VNW VSS VSS gf180mcu_fd_sc_mcu9t5v0__clkinv_1
XTAP_TAPCELL_ROW_59_2601 VSS VSS gf180mcu_fd_sc_mcu9t5v0__filltie
XTAP_TAPCELL_ROW_59_2612 VSS VSS gf180mcu_fd_sc_mcu9t5v0__filltie
X_13261_ _13261_/A1 _13261_/A2 _13580_/B _13262_/A2 VSS _13261_/VNW VSS VSS gf180mcu_fd_sc_mcu9t5v0__nand3_1
X_10473_ _18963_/Q wire165/Z _10652_/B1 _18979_/Q _10474_/A3 VSS VSS VSS VSS gf180mcu_fd_sc_mcu9t5v0__aoi22_1
X_12212_ _12212_/A1 _12212_/A2 _12213_/A2 VSS VSS VSS VSS gf180mcu_fd_sc_mcu9t5v0__xnor2_1
XPHY_EDGE_ROW_242_Left_565 VSS VSS gf180mcu_fd_sc_mcu9t5v0__endcap
X_15000_ _19377_/Q _19433_/Q _15003_/A2 VSS VSS VSS VSS gf180mcu_fd_sc_mcu9t5v0__xnor2_1
X_13192_ _13194_/A1 _13194_/A2 _13561_/B _13209_/A2 VSS _15395_/VNW VSS VSS gf180mcu_fd_sc_mcu9t5v0__oai21_1
Xrst_tree_leaf_18 rst_tree_mid_2/Z _20065_/RN VSS VSS VSS VSS gf180mcu_fd_sc_mcu9t5v0__clkbuf_16
Xrst_tree_leaf_29 rst_tree_mid_3/Z _20054_/RN VSS VSS VSS VSS gf180mcu_fd_sc_mcu9t5v0__clkbuf_16
X_12143_ _12164_/A1 _12121_/B _12164_/B _12144_/A2 VSS VSS VSS VSS gf180mcu_fd_sc_mcu9t5v0__oai21_1
X_16951_ _16951_/A1 _16809_/S _16951_/B _16952_/I0 VSS VSS VSS VSS gf180mcu_fd_sc_mcu9t5v0__oai21_1
X_12074_ _12686_/C _12074_/A2 _12074_/B _12311_/B _12075_/B VSS _12074_/VNW VSS VSS
+ gf180mcu_fd_sc_mcu9t5v0__aoi211_1
X_15902_ _20111_/Q _19247_/Q _15905_/S _20111_/D VSS VSS VSS VSS gf180mcu_fd_sc_mcu9t5v0__mux2_1
X_11025_ _19058_/Q _19026_/Q wire174/Z _19026_/D VSS VSS VSS VSS gf180mcu_fd_sc_mcu9t5v0__mux2_1
X_16882_ _18433_/Q _16881_/Z _16882_/S _18433_/D VSS VSS VSS VSS gf180mcu_fd_sc_mcu9t5v0__mux2_4
XTAP_TAPCELL_ROW_31_1830 VSS VSS gf180mcu_fd_sc_mcu9t5v0__filltie
X_19670_ _19670_/D _20054_/RN clkload27/I _19670_/Q VSS VSS VSS VSS gf180mcu_fd_sc_mcu9t5v0__dffrnq_1
X_15833_ _15834_/A1 _15833_/A2 _15834_/B1 VSS VSS VSS VSS gf180mcu_fd_sc_mcu9t5v0__xnor2_1
X_18621_ _18621_/D _20025_/RN clkload59/I _18621_/Q VSS VSS VSS VSS gf180mcu_fd_sc_mcu9t5v0__dffrnq_1
XPHY_EDGE_ROW_251_Left_574 VSS VSS gf180mcu_fd_sc_mcu9t5v0__endcap
XTAP_TAPCELL_ROW_31_1841 VSS VSS gf180mcu_fd_sc_mcu9t5v0__filltie
X_18552_ _18552_/D _20052_/RN clkload76/I _18552_/Q VSS VSS VSS VSS gf180mcu_fd_sc_mcu9t5v0__dffrnq_4
X_15764_ wire301/Z _19934_/Q _15770_/S _19934_/D VSS _15764_/VNW VSS VSS gf180mcu_fd_sc_mcu9t5v0__mux2_1
XTAP_TAPCELL_ROW_310_7601 VSS VSS gf180mcu_fd_sc_mcu9t5v0__filltie
X_17503_ _18608_/Q _19249_/Q _17504_/S _18608_/D VSS VSS VSS VSS gf180mcu_fd_sc_mcu9t5v0__mux2_1
Xclkbuf_leaf_70_clk_regs clkload2/I clkload46/I VSS VSS VSS VSS gf180mcu_fd_sc_mcu9t5v0__clkbuf_8
X_14715_ _14715_/I0 _19541_/Q _14715_/S _19541_/D VSS VSS VSS VSS gf180mcu_fd_sc_mcu9t5v0__mux2_1
X_12976_ _19720_/Q _19752_/Q _12977_/B VSS VSS VSS VSS gf180mcu_fd_sc_mcu9t5v0__xor2_1
X_18483_ _18483_/D clkload76/I _18483_/Q VSS VSS VSS VSS gf180mcu_fd_sc_mcu9t5v0__dffq_1
X_15695_ _20003_/Q _15695_/A2 _15696_/B VSS VSS VSS VSS gf180mcu_fd_sc_mcu9t5v0__nand2_1
X_11927_ _14422_/A2 _11985_/B _11927_/B _19118_/D VSS VSS VSS VSS gf180mcu_fd_sc_mcu9t5v0__oai21_4
X_17434_ _17434_/A1 _17434_/A2 _17438_/C _17439_/A2 VSS VSS VSS VSS gf180mcu_fd_sc_mcu9t5v0__aoi21_1
XTAP_TAPCELL_ROW_29_1770 VSS VSS gf180mcu_fd_sc_mcu9t5v0__filltie
XTAP_TAPCELL_ROW_29_1781 VSS VSS gf180mcu_fd_sc_mcu9t5v0__filltie
X_11858_ _18899_/Q _11882_/A3 _12336_/B _11859_/A2 VSS _18015_/VNW VSS VSS gf180mcu_fd_sc_mcu9t5v0__oai21_1
X_14646_ _14458_/Z _19523_/Q _14715_/S _19523_/D VSS VSS VSS VSS gf180mcu_fd_sc_mcu9t5v0__mux2_1
XANTENNA_19 output15/I VSS VSS VSS VSS gf180mcu_fd_sc_mcu9t5v0__antenna
X_17365_ _18358_/Q _17406_/A2 _17363_/Z _10514_/B _17406_/C _17366_/B2 VSS _17365_/VNW
+ VSS VSS gf180mcu_fd_sc_mcu9t5v0__aoi221_1
X_11789_ _11807_/A3 _11789_/A2 _11789_/B _11790_/A2 VSS VSS VSS VSS gf180mcu_fd_sc_mcu9t5v0__oai21_1
X_10809_ _10659_/C _10808_/Z _10809_/B _10810_/B2 VSS _10809_/VNW VSS VSS gf180mcu_fd_sc_mcu9t5v0__aoi21_1
X_14577_ _14762_/B _14578_/A2 _14762_/A1 VSS _14577_/VNW VSS VSS gf180mcu_fd_sc_mcu9t5v0__nor2_1
XTAP_TAPCELL_ROW_29_1792 VSS VSS gf180mcu_fd_sc_mcu9t5v0__filltie
XTAP_TAPCELL_ROW_308_7541 VSS VSS gf180mcu_fd_sc_mcu9t5v0__filltie
XTAP_TAPCELL_ROW_308_7530 VSS VSS gf180mcu_fd_sc_mcu9t5v0__filltie
X_16316_ _18223_/Q _16315_/Z _16854_/S _18223_/D VSS VSS VSS VSS gf180mcu_fd_sc_mcu9t5v0__mux2_4
XPHY_EDGE_ROW_260_Left_583 VSS VSS gf180mcu_fd_sc_mcu9t5v0__endcap
XTAP_TAPCELL_ROW_114_4130 VSS VSS gf180mcu_fd_sc_mcu9t5v0__filltie
X_19104_ _19104_/D _20064_/RN _19680_/CLK _19104_/Q VSS VSS VSS VSS gf180mcu_fd_sc_mcu9t5v0__dffrnq_1
X_13528_ _19267_/Q _13419_/B _13532_/B VSS _13528_/VNW VSS VSS gf180mcu_fd_sc_mcu9t5v0__nand2_1
XTAP_TAPCELL_ROW_25_1667 VSS VSS gf180mcu_fd_sc_mcu9t5v0__filltie
XTAP_TAPCELL_ROW_25_1678 VSS VSS gf180mcu_fd_sc_mcu9t5v0__filltie
XTAP_TAPCELL_ROW_308_7552 VSS VSS gf180mcu_fd_sc_mcu9t5v0__filltie
X_17296_ _18467_/Q _18451_/Q _17404_/S _17296_/Z VSS VSS VSS VSS gf180mcu_fd_sc_mcu9t5v0__mux2_1
XTAP_TAPCELL_ROW_110_4005 VSS VSS gf180mcu_fd_sc_mcu9t5v0__filltie
X_19035_ _19035_/D _20059_/RN clkload32/I _19035_/Q VSS VSS VSS VSS gf180mcu_fd_sc_mcu9t5v0__dffrnq_1
XTAP_TAPCELL_ROW_304_7438 VSS VSS gf180mcu_fd_sc_mcu9t5v0__filltie
XTAP_TAPCELL_ROW_304_7427 VSS VSS gf180mcu_fd_sc_mcu9t5v0__filltie
X_16247_ _16247_/A1 _16411_/A1 _16248_/I1 VSS VSS VSS VSS gf180mcu_fd_sc_mcu9t5v0__nand2_1
XTAP_TAPCELL_ROW_110_4016 VSS VSS gf180mcu_fd_sc_mcu9t5v0__filltie
X_13459_ _13469_/A2 _19813_/Q _13474_/B VSS VSS VSS VSS gf180mcu_fd_sc_mcu9t5v0__nor2_1
X_16178_ _19272_/Q _16725_/C _16179_/C VSS VSS VSS VSS gf180mcu_fd_sc_mcu9t5v0__nand2_1
XTAP_TAPCELL_ROW_209_4813 VSS VSS gf180mcu_fd_sc_mcu9t5v0__filltie
XTAP_TAPCELL_ROW_209_4802 VSS VSS gf180mcu_fd_sc_mcu9t5v0__filltie
XTAP_TAPCELL_ROW_184_1_4762 VSS VSS gf180mcu_fd_sc_mcu9t5v0__filltie
XTAP_TAPCELL_ROW_296_7217 VSS VSS gf180mcu_fd_sc_mcu9t5v0__filltie
XTAP_TAPCELL_ROW_296_7206 VSS VSS gf180mcu_fd_sc_mcu9t5v0__filltie
XTAP_TAPCELL_ROW_209_4824 VSS VSS gf180mcu_fd_sc_mcu9t5v0__filltie
X_15129_ _19671_/Q _19511_/Q _15163_/S _19671_/D VSS VSS VSS VSS gf180mcu_fd_sc_mcu9t5v0__mux2_1
X_19937_ _19937_/D _20065_/RN clkload71/I _19937_/Q VSS VSS VSS VSS gf180mcu_fd_sc_mcu9t5v0__dffrnq_1
X_19868_ _19868_/D _20060_/RN clkload56/I _19868_/Q VSS VSS VSS VSS gf180mcu_fd_sc_mcu9t5v0__dffrnq_1
X_09621_ _11558_/C _18565_/Q _17434_/A2 VSS VSS VSS VSS gf180mcu_fd_sc_mcu9t5v0__nand2_1
X_19799_ _19799_/D _20055_/RN clkload29/I _19799_/Q VSS VSS VSS VSS gf180mcu_fd_sc_mcu9t5v0__dffrnq_1
X_18819_ _18819_/D _20035_/RN clkload34/I _18819_/Q VSS VSS VSS VSS gf180mcu_fd_sc_mcu9t5v0__dffrnq_1
XPHY_EDGE_ROW_197_2_Right_928 VSS VSS gf180mcu_fd_sc_mcu9t5v0__endcap
X_09552_ _20029_/Q _20053_/Q _09553_/I VSS _15573_/VNW VSS VSS gf180mcu_fd_sc_mcu9t5v0__nand2_1
XTAP_TAPCELL_ROW_272_6560 VSS VSS gf180mcu_fd_sc_mcu9t5v0__filltie
X_09483_ _12686_/C _09483_/A2 _11069_/B VSS _12690_/VNW VSS VSS gf180mcu_fd_sc_mcu9t5v0__nor2_4
XTAP_TAPCELL_ROW_285_6910 VSS VSS gf180mcu_fd_sc_mcu9t5v0__filltie
XTAP_TAPCELL_ROW_285_6921 VSS VSS gf180mcu_fd_sc_mcu9t5v0__filltie
XTAP_TAPCELL_ROW_99_3693 VSS VSS gf180mcu_fd_sc_mcu9t5v0__filltie
XTAP_TAPCELL_ROW_281_6807 VSS VSS gf180mcu_fd_sc_mcu9t5v0__filltie
XTAP_TAPCELL_ROW_266_6397 VSS VSS gf180mcu_fd_sc_mcu9t5v0__filltie
XTAP_TAPCELL_ROW_266_6386 VSS VSS gf180mcu_fd_sc_mcu9t5v0__filltie
XTAP_TAPCELL_ROW_266_6375 VSS VSS gf180mcu_fd_sc_mcu9t5v0__filltie
XTAP_TAPCELL_ROW_279_6736 VSS VSS gf180mcu_fd_sc_mcu9t5v0__filltie
XTAP_TAPCELL_ROW_279_6747 VSS VSS gf180mcu_fd_sc_mcu9t5v0__filltie
XTAP_TAPCELL_ROW_106_3907 VSS VSS gf180mcu_fd_sc_mcu9t5v0__filltie
X_20008_ _20008_/D _20072_/RN clkload22/I _20008_/Q VSS VSS VSS VSS gf180mcu_fd_sc_mcu9t5v0__dffrnq_1
X_09819_ _17909_/A1 _17886_/A2 _10783_/A1 _17909_/A3 VSS _17909_/VNW VSS VSS gf180mcu_fd_sc_mcu9t5v0__nand3_1
X_12830_ _19763_/Q _12828_/Z _12836_/B VSS VSS VSS VSS gf180mcu_fd_sc_mcu9t5v0__nand2_1
XTAP_TAPCELL_ROW_48_2302 VSS VSS gf180mcu_fd_sc_mcu9t5v0__filltie
XTAP_TAPCELL_ROW_48_2313 VSS VSS gf180mcu_fd_sc_mcu9t5v0__filltie
XPHY_EDGE_ROW_177_1_Left_500 VSS VSS gf180mcu_fd_sc_mcu9t5v0__endcap
X_12761_ _19753_/Q _12754_/Z _12761_/B _12771_/A1 VSS _12761_/VNW VSS VSS gf180mcu_fd_sc_mcu9t5v0__aoi21_1
X_11712_ _18251_/Q _12315_/S _11714_/B1 VSS _11712_/VNW VSS VSS gf180mcu_fd_sc_mcu9t5v0__nand2_1
X_15480_ _19829_/Q _15552_/B _15483_/A1 VSS VSS VSS VSS gf180mcu_fd_sc_mcu9t5v0__nand2_1
X_14500_ _14500_/A1 _14726_/A1 _14501_/I1 VSS _14500_/VNW VSS VSS gf180mcu_fd_sc_mcu9t5v0__xnor2_1
X_12692_ _12692_/A1 _12724_/C _19183_/D VSS VSS VSS VSS gf180mcu_fd_sc_mcu9t5v0__nand2_1
XTAP_TAPCELL_ROW_251_5976 VSS VSS gf180mcu_fd_sc_mcu9t5v0__filltie
XTAP_TAPCELL_ROW_251_5965 VSS VSS gf180mcu_fd_sc_mcu9t5v0__filltie
X_11643_ _11643_/A1 _11635_/Z _11643_/B1 _11643_/B2 _12637_/A2 VSS _11643_/VNW VSS
+ VSS gf180mcu_fd_sc_mcu9t5v0__aoi22_1
X_14431_ _19154_/Q _19120_/Q _14697_/A1 VSS _14431_/VNW VSS VSS gf180mcu_fd_sc_mcu9t5v0__xnor2_1
X_17150_ _18476_/Q _17380_/A2 _17148_/Z _10514_/B _17275_/C _17155_/B2 VSS VSS VSS
+ VSS gf180mcu_fd_sc_mcu9t5v0__aoi221_1
X_11574_ _11736_/C _11574_/A2 _11574_/A3 _11574_/B _11706_/A1 VSS VSS VSS VSS gf180mcu_fd_sc_mcu9t5v0__oai31_4
X_16101_ _19275_/Q _16675_/A1 _16102_/B VSS VSS VSS VSS gf180mcu_fd_sc_mcu9t5v0__nand2_1
X_14362_ _13948_/Z _19432_/Q _14367_/S _19432_/D VSS _14362_/VNW VSS VSS gf180mcu_fd_sc_mcu9t5v0__mux2_1
X_10525_ _10389_/C _10649_/A2 _10525_/A3 _17161_/C _10526_/B2 VSS VSS VSS VSS gf180mcu_fd_sc_mcu9t5v0__oai31_1
X_17081_ _18521_/Q _18505_/Q _19825_/Q _17081_/Z VSS VSS VSS VSS gf180mcu_fd_sc_mcu9t5v0__mux2_1
X_13313_ _13313_/A1 _13313_/A2 _13594_/B _13314_/A2 VSS VSS VSS VSS gf180mcu_fd_sc_mcu9t5v0__nor3_1
XTAP_TAPCELL_ROW_20_1520 VSS VSS gf180mcu_fd_sc_mcu9t5v0__filltie
X_14293_ _13867_/Z _19366_/Q _14304_/S _19366_/D VSS VSS VSS VSS gf180mcu_fd_sc_mcu9t5v0__mux2_1
XTAP_TAPCELL_ROW_20_1531 VSS VSS gf180mcu_fd_sc_mcu9t5v0__filltie
XTAP_TAPCELL_ROW_20_1542 VSS VSS gf180mcu_fd_sc_mcu9t5v0__filltie
X_16032_ _15996_/B _16032_/A2 _16032_/A3 _16032_/B _16033_/I1 VSS VSS VSS VSS gf180mcu_fd_sc_mcu9t5v0__oai31_1
X_10456_ _18225_/Q _17406_/A2 _17405_/A2 _18241_/Q _10457_/B VSS VSS VSS VSS gf180mcu_fd_sc_mcu9t5v0__aoi22_1
X_13244_ _13574_/A2 _13576_/B _13244_/B _13250_/A2 VSS _13244_/VNW VSS VSS gf180mcu_fd_sc_mcu9t5v0__oai21_1
X_13175_ _19730_/Q _13171_/Z _13556_/B VSS _13175_/VNW VSS VSS gf180mcu_fd_sc_mcu9t5v0__xnor2_1
X_10387_ _18592_/Q _17159_/B _10648_/C _10389_/B2 VSS _17100_/VNW VSS VSS gf180mcu_fd_sc_mcu9t5v0__aoi21_1
X_12126_ _12126_/A1 _12126_/A2 _12172_/A3 VSS _12126_/VNW VSS VSS gf180mcu_fd_sc_mcu9t5v0__nand2_1
X_17983_ _18870_/Q _18033_/I0 wire128/Z _18870_/D VSS VSS VSS VSS gf180mcu_fd_sc_mcu9t5v0__mux2_1
XTAP_TAPCELL_ROW_33_1903 VSS VSS gf180mcu_fd_sc_mcu9t5v0__filltie
X_16934_ _16934_/I0 _18458_/Q _16940_/S _18458_/D VSS _16934_/VNW VSS VSS gf180mcu_fd_sc_mcu9t5v0__mux2_1
X_12057_ _12057_/A1 _12057_/A2 _12057_/Z VSS _12096_/VNW VSS VSS gf180mcu_fd_sc_mcu9t5v0__and2_4
XPHY_EDGE_ROW_165_3_Left_823 VSS VSS gf180mcu_fd_sc_mcu9t5v0__endcap
XTAP_TAPCELL_ROW_18_1471 VSS VSS gf180mcu_fd_sc_mcu9t5v0__filltie
XTAP_TAPCELL_ROW_18_1482 VSS VSS gf180mcu_fd_sc_mcu9t5v0__filltie
X_19722_ _19722_/D _20042_/RN clkload9/I _19722_/Q VSS VSS VSS VSS gf180mcu_fd_sc_mcu9t5v0__dffrnq_1
X_16865_ _19244_/Q _17059_/I1 _16865_/S _16865_/Z VSS _16866_/VNW VSS VSS gf180mcu_fd_sc_mcu9t5v0__mux2_1
X_11008_ _10996_/S _18053_/A1 _11012_/A2 VSS VSS VSS VSS gf180mcu_fd_sc_mcu9t5v0__nand2_1
XTAP_TAPCELL_ROW_14_1357 VSS VSS gf180mcu_fd_sc_mcu9t5v0__filltie
XTAP_TAPCELL_ROW_14_1368 VSS VSS gf180mcu_fd_sc_mcu9t5v0__filltie
X_19653_ _19653_/D _20037_/RN clkload28/I _19653_/Q VSS VSS VSS VSS gf180mcu_fd_sc_mcu9t5v0__dffrnq_1
X_18604_ _18604_/D clkload57/I _18604_/Q VSS VSS VSS VSS gf180mcu_fd_sc_mcu9t5v0__dffq_1
X_15816_ input5/Z _19985_/Q _15819_/S _19985_/D VSS VSS VSS VSS gf180mcu_fd_sc_mcu9t5v0__mux2_1
XTAP_TAPCELL_ROW_14_1379 VSS VSS gf180mcu_fd_sc_mcu9t5v0__filltie
X_16796_ _18396_/Q _16795_/Z _16798_/S _18396_/D VSS VSS VSS VSS gf180mcu_fd_sc_mcu9t5v0__mux2_1
XTAP_TAPCELL_ROW_289_7010 VSS VSS gf180mcu_fd_sc_mcu9t5v0__filltie
X_19584_ _19584_/D _09246_/I clkload7/I _19584_/Q VSS VSS VSS VSS gf180mcu_fd_sc_mcu9t5v0__dffrnq_1
X_18535_ _18535_/D clkload79/I _18535_/Q VSS VSS VSS VSS gf180mcu_fd_sc_mcu9t5v0__dffq_1
XTAP_TAPCELL_ROW_289_7021 VSS VSS gf180mcu_fd_sc_mcu9t5v0__filltie
X_15747_ _19999_/Q _15747_/A2 _15747_/B _15748_/I0 VSS _15755_/VNW VSS VSS gf180mcu_fd_sc_mcu9t5v0__oai21_1
X_12959_ _19751_/Q _19785_/Q _12960_/B VSS _12961_/VNW VSS VSS gf180mcu_fd_sc_mcu9t5v0__xnor2_1
X_18466_ _18466_/D _20132_/CLK _18466_/Q VSS VSS VSS VSS gf180mcu_fd_sc_mcu9t5v0__dffq_1
XPHY_EDGE_ROW_161_1_Left_484 VSS VSS gf180mcu_fd_sc_mcu9t5v0__endcap
X_15678_ _19912_/Q _15678_/A2 _15678_/B _19912_/D VSS _15678_/VNW VSS VSS gf180mcu_fd_sc_mcu9t5v0__aoi21_1
XTAP_TAPCELL_ROW_27_1718 VSS VSS gf180mcu_fd_sc_mcu9t5v0__filltie
XTAP_TAPCELL_ROW_27_1729 VSS VSS gf180mcu_fd_sc_mcu9t5v0__filltie
X_17417_ _17417_/I0 _18556_/Q _17420_/S _18556_/D VSS VSS VSS VSS gf180mcu_fd_sc_mcu9t5v0__mux2_1
X_14629_ _19091_/Q _19507_/Q _14730_/S _19507_/D VSS VSS VSS VSS gf180mcu_fd_sc_mcu9t5v0__mux2_1
X_18397_ _18397_/D clkload61/I _18397_/Q VSS VSS VSS VSS gf180mcu_fd_sc_mcu9t5v0__dffq_1
X_17348_ _20120_/Q wire168/Z _17409_/B _17350_/A2 VSS VSS VSS VSS gf180mcu_fd_sc_mcu9t5v0__oai21_1
X_17279_ _17279_/A1 _17279_/A2 _17279_/B1 _17279_/B2 _17284_/A2 VSS VSS VSS VSS gf180mcu_fd_sc_mcu9t5v0__aoi22_1
X_19018_ _19018_/D _20042_/RN clkload46/I _19018_/Q VSS VSS VSS VSS gf180mcu_fd_sc_mcu9t5v0__dffrnq_1
XTAP_TAPCELL_ROW_261_6261 VSS VSS gf180mcu_fd_sc_mcu9t5v0__filltie
XTAP_TAPCELL_ROW_261_6250 VSS VSS gf180mcu_fd_sc_mcu9t5v0__filltie
XTAP_TAPCELL_ROW_90_3465 VSS VSS gf180mcu_fd_sc_mcu9t5v0__filltie
XTAP_TAPCELL_ROW_90_3454 VSS VSS gf180mcu_fd_sc_mcu9t5v0__filltie
XPHY_EDGE_ROW_228_Right_155 VSS VSS gf180mcu_fd_sc_mcu9t5v0__endcap
XTAP_TAPCELL_ROW_274_6611 VSS VSS gf180mcu_fd_sc_mcu9t5v0__filltie
XTAP_TAPCELL_ROW_274_6600 VSS VSS gf180mcu_fd_sc_mcu9t5v0__filltie
XTAP_TAPCELL_ROW_88_3394 VSS VSS gf180mcu_fd_sc_mcu9t5v0__filltie
XTAP_TAPCELL_ROW_259_6190 VSS VSS gf180mcu_fd_sc_mcu9t5v0__filltie
X_09604_ _09604_/I _17631_/A3 VSS VSS VSS VSS gf180mcu_fd_sc_mcu9t5v0__clkinv_1
XTAP_TAPCELL_ROW_270_6508 VSS VSS gf180mcu_fd_sc_mcu9t5v0__filltie
XTAP_TAPCELL_ROW_255_6076 VSS VSS gf180mcu_fd_sc_mcu9t5v0__filltie
XPHY_EDGE_ROW_198_2_Right_929 VSS VSS gf180mcu_fd_sc_mcu9t5v0__endcap
XPHY_EDGE_ROW_274_Right_201 VSS VSS gf180mcu_fd_sc_mcu9t5v0__endcap
XTAP_TAPCELL_ROW_255_6087 VSS VSS gf180mcu_fd_sc_mcu9t5v0__filltie
X_09535_ _18664_/Q _20142_/Q _09538_/A2 VSS VSS VSS VSS gf180mcu_fd_sc_mcu9t5v0__nand2_1
XTAP_TAPCELL_ROW_4_1080 VSS VSS gf180mcu_fd_sc_mcu9t5v0__filltie
XTAP_TAPCELL_ROW_4_1091 VSS VSS gf180mcu_fd_sc_mcu9t5v0__filltie
X_09466_ _19140_/Q _19157_/Q _19069_/Q _14475_/B _09469_/A2 VSS VSS VSS VSS gf180mcu_fd_sc_mcu9t5v0__nand4_1
XTAP_TAPCELL_ROW_268_6448 VSS VSS gf180mcu_fd_sc_mcu9t5v0__filltie
XTAP_TAPCELL_ROW_268_6437 VSS VSS gf180mcu_fd_sc_mcu9t5v0__filltie
X_09397_ _10659_/C _10194_/A1 _09875_/A1 VSS _10194_/VNW VSS VSS gf180mcu_fd_sc_mcu9t5v0__nand2_1
X_11290_ _18246_/Q _11469_/B _11291_/B VSS _11290_/VNW VSS VSS gf180mcu_fd_sc_mcu9t5v0__nand2_1
X_10310_ _18957_/Q wire165/Z _10652_/B1 _18973_/Q _10311_/A3 VSS _18108_/VNW VSS VSS
+ gf180mcu_fd_sc_mcu9t5v0__aoi22_1
XTAP_TAPCELL_ROW_37_2003 VSS VSS gf180mcu_fd_sc_mcu9t5v0__filltie
X_10241_ _20078_/Q _17408_/B _10242_/A3 VSS _10241_/VNW VSS VSS gf180mcu_fd_sc_mcu9t5v0__nand2_1
XTAP_TAPCELL_ROW_244_5791 VSS VSS gf180mcu_fd_sc_mcu9t5v0__filltie
XTAP_TAPCELL_ROW_244_5780 VSS VSS gf180mcu_fd_sc_mcu9t5v0__filltie
X_10172_ _18946_/Q _10172_/A2 _10173_/A3 VSS _10174_/VNW VSS VSS gf180mcu_fd_sc_mcu9t5v0__nand2_1
XTAP_TAPCELL_ROW_73_2995 VSS VSS gf180mcu_fd_sc_mcu9t5v0__filltie
XTAP_TAPCELL_ROW_73_2984 VSS VSS gf180mcu_fd_sc_mcu9t5v0__filltie
XTAP_TAPCELL_ROW_240_5666 VSS VSS gf180mcu_fd_sc_mcu9t5v0__filltie
X_14980_ _19430_/Q _19375_/Q _14984_/A1 VSS VSS VSS VSS gf180mcu_fd_sc_mcu9t5v0__xnor2_1
XTAP_TAPCELL_ROW_240_5677 VSS VSS gf180mcu_fd_sc_mcu9t5v0__filltie
X_13931_ _13931_/A1 _19323_/Q _13934_/A3 VSS VSS VSS VSS gf180mcu_fd_sc_mcu9t5v0__nand2_1
X_16650_ _19288_/Q _15996_/B _16655_/B VSS VSS VSS VSS gf180mcu_fd_sc_mcu9t5v0__nand2_1
X_13862_ _13863_/A1 _13863_/A2 _13870_/B VSS VSS VSS VSS gf180mcu_fd_sc_mcu9t5v0__nand2_1
X_16581_ wire300/Z _18780_/Q _16619_/S _16581_/Z VSS _16581_/VNW VSS VSS gf180mcu_fd_sc_mcu9t5v0__mux2_1
X_15601_ _19886_/Q _15608_/A1 _15657_/B _15602_/A2 VSS _15604_/VNW VSS VSS gf180mcu_fd_sc_mcu9t5v0__oai21_1
X_12813_ _12813_/I0 _19206_/Q _13419_/B _19206_/D VSS VSS VSS VSS gf180mcu_fd_sc_mcu9t5v0__mux2_1
X_13793_ _13803_/B2 _13795_/A3 _13793_/Z VSS VSS VSS VSS gf180mcu_fd_sc_mcu9t5v0__xor2_1
X_18320_ _18320_/D _18320_/CLK _18320_/Q VSS VSS VSS VSS gf180mcu_fd_sc_mcu9t5v0__dffq_4
X_15532_ _19850_/Q _19833_/Q _15544_/S _19850_/D VSS _15532_/VNW VSS VSS gf180mcu_fd_sc_mcu9t5v0__mux2_1
X_12744_ _12744_/I0 _19197_/Q _13304_/B _19197_/D VSS _12957_/VNW VSS VSS gf180mcu_fd_sc_mcu9t5v0__mux2_1
X_18251_ _18251_/D clkload60/I _18251_/Q VSS VSS VSS VSS gf180mcu_fd_sc_mcu9t5v0__dffq_1
X_17202_ _20113_/Q wire168/I _17203_/A3 VSS _17202_/VNW VSS VSS gf180mcu_fd_sc_mcu9t5v0__nor2_1
X_15463_ _15447_/S _15463_/A2 _15463_/B _19823_/D VSS VSS VSS VSS gf180mcu_fd_sc_mcu9t5v0__aoi21_1
X_12675_ _12632_/C _11672_/Z _12675_/B _12676_/B VSS _12675_/VNW VSS VSS gf180mcu_fd_sc_mcu9t5v0__oai21_1
X_18182_ _18182_/D clkload82/I _18182_/Q VSS VSS VSS VSS gf180mcu_fd_sc_mcu9t5v0__dffq_4
X_15394_ _19679_/Q _19779_/Q _15420_/S _19779_/D VSS VSS VSS VSS gf180mcu_fd_sc_mcu9t5v0__mux2_1
X_11626_ _12632_/C _11621_/Z _11626_/B _11627_/A2 VSS VSS VSS VSS gf180mcu_fd_sc_mcu9t5v0__oai21_1
X_14414_ _19118_/Q wire199/Z _14704_/S _14414_/C _14415_/A2 VSS VSS VSS VSS gf180mcu_fd_sc_mcu9t5v0__oai211_1
X_17133_ _17198_/A1 _17133_/A2 _17133_/A3 _17133_/B _17134_/B1 VSS _17133_/VNW VSS
+ VSS gf180mcu_fd_sc_mcu9t5v0__oai31_1
X_11557_ _18568_/Q _11988_/B _11557_/B _18566_/Q _12183_/C VSS VSS VSS VSS gf180mcu_fd_sc_mcu9t5v0__aoi211_4
X_14345_ _13867_/Z _19416_/Q _14352_/S _19416_/D VSS VSS VSS VSS gf180mcu_fd_sc_mcu9t5v0__mux2_1
X_17064_ _18526_/Q _16606_/B _17067_/S _18526_/D VSS VSS VSS VSS gf180mcu_fd_sc_mcu9t5v0__mux2_4
X_10508_ _19951_/Q wire216/Z _10655_/B _10527_/A2 VSS VSS VSS VSS gf180mcu_fd_sc_mcu9t5v0__aoi21_1
X_16015_ _19198_/Q _16014_/Z _16598_/S _16016_/B VSS VSS VSS VSS gf180mcu_fd_sc_mcu9t5v0__mux2_1
X_11488_ wire208/I _11488_/A2 _11488_/B _11490_/A3 VSS VSS VSS VSS gf180mcu_fd_sc_mcu9t5v0__aoi21_1
X_14276_ _13948_/Z _19350_/Q _14285_/S _19350_/D VSS VSS VSS VSS gf180mcu_fd_sc_mcu9t5v0__mux2_1
XPHY_EDGE_ROW_272_Right_199 VSS VSS gf180mcu_fd_sc_mcu9t5v0__endcap
X_10439_ _17407_/C _10439_/A2 _10439_/B wire168/Z _10442_/B1 VSS VSS VSS VSS gf180mcu_fd_sc_mcu9t5v0__oai211_1
X_13227_ _16438_/A1 _13497_/B _13227_/B1 _13227_/B2 _19243_/D VSS _13227_/VNW VSS
+ VSS gf180mcu_fd_sc_mcu9t5v0__aoi22_1
X_13158_ _13158_/I _13551_/B VSS _13158_/VNW VSS VSS gf180mcu_fd_sc_mcu9t5v0__clkinv_1
XTAP_TAPCELL_ROW_16_1419 VSS VSS gf180mcu_fd_sc_mcu9t5v0__filltie
X_12109_ _18413_/Q _12315_/S _12322_/B _12112_/A2 VSS _12109_/VNW VSS VSS gf180mcu_fd_sc_mcu9t5v0__aoi21_1
X_13089_ _13184_/A1 _13089_/A2 _13320_/B _13090_/B2 VSS VSS VSS VSS gf180mcu_fd_sc_mcu9t5v0__aoi21_1
X_17966_ _18037_/S _17966_/A2 _17966_/B _18857_/D VSS VSS VSS VSS gf180mcu_fd_sc_mcu9t5v0__aoi21_1
X_16917_ _16641_/B _19254_/Q _16927_/S _16917_/Z VSS VSS VSS VSS gf180mcu_fd_sc_mcu9t5v0__mux2_1
X_19705_ _19705_/D _20025_/RN clkload27/I _19705_/Q VSS VSS VSS VSS gf180mcu_fd_sc_mcu9t5v0__dffrnq_1
X_17897_ _18836_/Q _17901_/A2 _17899_/B VSS VSS VSS VSS gf180mcu_fd_sc_mcu9t5v0__nand2_1
X_16848_ _18416_/Q _16847_/Z _16850_/S _18416_/D VSS VSS VSS VSS gf180mcu_fd_sc_mcu9t5v0__mux2_4
X_19636_ _19636_/D _20020_/RN clkload22/I _19636_/Q VSS VSS VSS VSS gf180mcu_fd_sc_mcu9t5v0__dffrnq_1
X_16779_ _16654_/B _19288_/Q _16783_/S _16779_/Z VSS _16780_/VNW VSS VSS gf180mcu_fd_sc_mcu9t5v0__mux2_1
XPHY_EDGE_ROW_194_2_Left_706 VSS VSS gf180mcu_fd_sc_mcu9t5v0__endcap
X_19567_ _19567_/D _20143_/RN clkload8/I _19567_/Q VSS VSS VSS VSS gf180mcu_fd_sc_mcu9t5v0__dffrnq_1
X_18518_ _18518_/D _18518_/CLK _18518_/Q VSS VSS VSS VSS gf180mcu_fd_sc_mcu9t5v0__dffq_4
X_09320_ _19011_/Q _10692_/A1 VSS VSS VSS VSS gf180mcu_fd_sc_mcu9t5v0__clkinv_1
X_19498_ _19498_/D _20138_/RN clkload29/I _19498_/Q VSS VSS VSS VSS gf180mcu_fd_sc_mcu9t5v0__dffrnq_1
X_09251_ _18836_/Q _11591_/A2 VSS VSS VSS VSS gf180mcu_fd_sc_mcu9t5v0__clkinv_1
X_18449_ _18449_/D clkload73/I _18449_/Q VSS VSS VSS VSS gf180mcu_fd_sc_mcu9t5v0__dffq_1
XTAP_TAPCELL_ROW_96_3630 VSS VSS gf180mcu_fd_sc_mcu9t5v0__filltie
XTAP_TAPCELL_ROW_135_4689 VSS VSS gf180mcu_fd_sc_mcu9t5v0__filltie
X_09182_ _19154_/Q _14441_/A1 VSS VSS VSS VSS gf180mcu_fd_sc_mcu9t5v0__clkinv_1
XTAP_TAPCELL_ROW_263_6312 VSS VSS gf180mcu_fd_sc_mcu9t5v0__filltie
XTAP_TAPCELL_ROW_263_6301 VSS VSS gf180mcu_fd_sc_mcu9t5v0__filltie
XTAP_TAPCELL_ROW_92_3516 VSS VSS gf180mcu_fd_sc_mcu9t5v0__filltie
XTAP_TAPCELL_ROW_92_3505 VSS VSS gf180mcu_fd_sc_mcu9t5v0__filltie
XTAP_TAPCELL_ROW_77_3095 VSS VSS gf180mcu_fd_sc_mcu9t5v0__filltie
XTAP_TAPCELL_ROW_257_6138 VSS VSS gf180mcu_fd_sc_mcu9t5v0__filltie
XTAP_TAPCELL_ROW_257_6127 VSS VSS gf180mcu_fd_sc_mcu9t5v0__filltie
XPHY_EDGE_ROW_200_1_Right_784 VSS VSS gf180mcu_fd_sc_mcu9t5v0__endcap
XTAP_TAPCELL_ROW_257_6149 VSS VSS gf180mcu_fd_sc_mcu9t5v0__filltie
XTAP_TAPCELL_ROW_6_1142 VSS VSS gf180mcu_fd_sc_mcu9t5v0__filltie
XTAP_TAPCELL_ROW_6_1153 VSS VSS gf180mcu_fd_sc_mcu9t5v0__filltie
XTAP_TAPCELL_ROW_2_1028 VSS VSS gf180mcu_fd_sc_mcu9t5v0__filltie
XTAP_TAPCELL_ROW_2_1039 VSS VSS gf180mcu_fd_sc_mcu9t5v0__filltie
X_09518_ _09518_/A1 _09518_/A2 _09518_/B _09542_/A2 VSS VSS VSS VSS gf180mcu_fd_sc_mcu9t5v0__aoi21_4
X_10790_ _19939_/Q _19891_/Q _20043_/Q _10790_/Z VSS VSS VSS VSS gf180mcu_fd_sc_mcu9t5v0__mux2_1
XTAP_TAPCELL_ROW_233_5481 VSS VSS gf180mcu_fd_sc_mcu9t5v0__filltie
XTAP_TAPCELL_ROW_233_5470 VSS VSS gf180mcu_fd_sc_mcu9t5v0__filltie
X_09449_ _10659_/C _09617_/A1 _09450_/B VSS _09449_/VNW VSS VSS gf180mcu_fd_sc_mcu9t5v0__and2_1
XTAP_TAPCELL_ROW_62_2674 VSS VSS gf180mcu_fd_sc_mcu9t5v0__filltie
XTAP_TAPCELL_ROW_62_2685 VSS VSS gf180mcu_fd_sc_mcu9t5v0__filltie
XTAP_TAPCELL_ROW_62_2696 VSS VSS gf180mcu_fd_sc_mcu9t5v0__filltie
X_12460_ _19153_/Q _12355_/I _12461_/B VSS VSS VSS VSS gf180mcu_fd_sc_mcu9t5v0__nand2_1
X_12391_ _18301_/Q _12608_/A2 wire146/Z _12392_/B2 VSS VSS VSS VSS gf180mcu_fd_sc_mcu9t5v0__oai21_1
X_11411_ _18431_/Q _11176_/C _11414_/C VSS VSS VSS VSS gf180mcu_fd_sc_mcu9t5v0__nand2_1
X_11342_ _18426_/Q _11098_/B _11346_/C VSS VSS VSS VSS gf180mcu_fd_sc_mcu9t5v0__nand2_1
X_14130_ _14109_/I _14185_/A2 _14132_/A2 VSS _14130_/VNW VSS VSS gf180mcu_fd_sc_mcu9t5v0__xnor2_1
XTAP_TAPCELL_ROW_246_5842 VSS VSS gf180mcu_fd_sc_mcu9t5v0__filltie
XTAP_TAPCELL_ROW_246_5831 VSS VSS gf180mcu_fd_sc_mcu9t5v0__filltie
X_11273_ _18277_/Q _11534_/S _11537_/S _11274_/A2 VSS VSS VSS VSS gf180mcu_fd_sc_mcu9t5v0__oai21_1
XTAP_TAPCELL_ROW_242_5717 VSS VSS gf180mcu_fd_sc_mcu9t5v0__filltie
X_14061_ _14068_/A1 _14061_/A2 _14061_/A3 _14062_/B VSS VSS VSS VSS gf180mcu_fd_sc_mcu9t5v0__xnor3_1
XTAP_TAPCELL_ROW_242_5739 VSS VSS gf180mcu_fd_sc_mcu9t5v0__filltie
X_10224_ _17406_/C _17401_/C _17275_/C VSS VSS VSS VSS gf180mcu_fd_sc_mcu9t5v0__nand2_2
XTAP_TAPCELL_ROW_242_5728 VSS VSS gf180mcu_fd_sc_mcu9t5v0__filltie
X_13012_ _13015_/A1 _13015_/A2 _13016_/A1 VSS VSS VSS VSS gf180mcu_fd_sc_mcu9t5v0__nand2_1
X_17820_ _19027_/Q _18797_/Q _17844_/S _18797_/D VSS VSS VSS VSS gf180mcu_fd_sc_mcu9t5v0__mux2_1
X_10155_ _10180_/B1 _10155_/A2 _10155_/A3 _10158_/A1 VSS VSS VSS VSS gf180mcu_fd_sc_mcu9t5v0__nand3_1
X_10086_ _20000_/Q _19961_/Q _19969_/Q _20004_/Q _19985_/Q _19998_/Q _10087_/B2 VSS
+ _15801_/VNW VSS VSS gf180mcu_fd_sc_mcu9t5v0__aoi222_1
X_17751_ _18752_/Q _18748_/Q _17751_/S _18752_/D VSS VSS VSS VSS gf180mcu_fd_sc_mcu9t5v0__mux2_1
X_14963_ _19616_/Q _20039_/D _14969_/B VSS VSS VSS VSS gf180mcu_fd_sc_mcu9t5v0__nor2_1
X_16702_ _18366_/Q _16747_/A2 _16747_/A3 _16703_/B VSS _16702_/VNW VSS VSS gf180mcu_fd_sc_mcu9t5v0__nand3_1
X_17682_ _09065_/I _18645_/Q _18664_/Q _17682_/Z VSS _17682_/VNW VSS VSS gf180mcu_fd_sc_mcu9t5v0__mux2_1
X_14894_ _19595_/Q _14894_/I1 _14900_/S _19595_/D VSS VSS VSS VSS gf180mcu_fd_sc_mcu9t5v0__mux2_1
X_13914_ _19316_/Q _19317_/Q _19299_/Q _19300_/Q _13915_/I VSS VSS VSS VSS gf180mcu_fd_sc_mcu9t5v0__nand4_1
X_16633_ _16633_/A1 _16042_/S _16672_/B _16634_/B VSS VSS VSS VSS gf180mcu_fd_sc_mcu9t5v0__oai21_4
X_13845_ _13846_/A2 _13846_/A3 _13871_/A2 VSS _13845_/VNW VSS VSS gf180mcu_fd_sc_mcu9t5v0__nor2_1
X_19421_ _19421_/D _20061_/RN clkload8/I _19421_/Q VSS VSS VSS VSS gf180mcu_fd_sc_mcu9t5v0__dffrnq_1
X_19352_ _19352_/D _19992_/RN clkload7/I _19352_/Q VSS VSS VSS VSS gf180mcu_fd_sc_mcu9t5v0__dffrnq_1
X_18303_ _18303_/D _20132_/CLK _18303_/Q VSS VSS VSS VSS gf180mcu_fd_sc_mcu9t5v0__dffq_1
X_16564_ _19212_/Q _16665_/A2 _16566_/B VSS _16564_/VNW VSS VSS gf180mcu_fd_sc_mcu9t5v0__nand2_1
X_10988_ _18053_/A1 _10950_/Z _10992_/B VSS VSS VSS VSS gf180mcu_fd_sc_mcu9t5v0__nand2_1
X_13776_ _13776_/A1 _13843_/A1 _13803_/B2 VSS _13776_/VNW VSS VSS gf180mcu_fd_sc_mcu9t5v0__nor2_1
X_16495_ _19236_/Q _16058_/B _17025_/S _16495_/Z VSS _16496_/VNW VSS VSS gf180mcu_fd_sc_mcu9t5v0__mux2_1
X_15515_ _19842_/Q _15515_/A2 _15515_/Z VSS _15515_/VNW VSS VSS gf180mcu_fd_sc_mcu9t5v0__and2_1
X_19283_ _19283_/D _20051_/RN clkload44/I _19283_/Q VSS VSS VSS VSS gf180mcu_fd_sc_mcu9t5v0__dffrnq_1
X_12727_ _14143_/B2 _09473_/B _14166_/B VSS _14372_/VNW VSS VSS gf180mcu_fd_sc_mcu9t5v0__nor2_2
X_15446_ _19818_/Q _15468_/A3 _15448_/A2 VSS _15446_/VNW VSS VSS gf180mcu_fd_sc_mcu9t5v0__nor2_1
X_18234_ _18234_/D clkload64/I _18234_/Q VSS VSS VSS VSS gf180mcu_fd_sc_mcu9t5v0__dffq_1
X_12658_ _11632_/B _12658_/A2 _12658_/B _12664_/C _12663_/A1 VSS VSS VSS VSS gf180mcu_fd_sc_mcu9t5v0__oai211_1
X_18165_ _18165_/D clkload68/I _18165_/Q VSS VSS VSS VSS gf180mcu_fd_sc_mcu9t5v0__dffq_1
X_11609_ _12664_/C _12680_/A2 _12685_/A1 VSS _11615_/VNW VSS VSS gf180mcu_fd_sc_mcu9t5v0__nand2_1
X_12589_ _18357_/Q _12613_/A2 _12593_/A2 VSS _17339_/VNW VSS VSS gf180mcu_fd_sc_mcu9t5v0__nor2_1
X_17116_ _18604_/Q _17409_/B _17225_/B _17117_/B2 VSS _17117_/VNW VSS VSS gf180mcu_fd_sc_mcu9t5v0__oai21_1
X_15377_ _19662_/Q _19762_/Q _15420_/S _19762_/D VSS VSS VSS VSS gf180mcu_fd_sc_mcu9t5v0__mux2_1
XTAP_TAPCELL_ROW_130_4553 VSS VSS gf180mcu_fd_sc_mcu9t5v0__filltie
XTAP_TAPCELL_ROW_212_4897 VSS VSS gf180mcu_fd_sc_mcu9t5v0__filltie
XTAP_TAPCELL_ROW_130_4564 VSS VSS gf180mcu_fd_sc_mcu9t5v0__filltie
X_18096_ _18936_/Q _18098_/B _18097_/A2 VSS _18096_/VNW VSS VSS gf180mcu_fd_sc_mcu9t5v0__xnor2_1
Xmax_cap103 _15420_/S _15417_/S VSS VSS VSS VSS gf180mcu_fd_sc_mcu9t5v0__clkbuf_16
Xmax_cap114 _13320_/B _13304_/B VSS VSS VSS VSS gf180mcu_fd_sc_mcu9t5v0__clkbuf_16
X_14328_ _13807_/Z _19400_/Q _14337_/S _19400_/D VSS _15223_/VNW VSS VSS gf180mcu_fd_sc_mcu9t5v0__mux2_1
X_17047_ _16641_/B _19254_/Q _17055_/S _17047_/Z VSS VSS VSS VSS gf180mcu_fd_sc_mcu9t5v0__mux2_1
X_14259_ _14259_/A1 _14259_/A2 _14259_/Z VSS VSS VSS VSS gf180mcu_fd_sc_mcu9t5v0__xor2_1
Xmax_cap169 _17326_/A1 _17304_/C VSS VSS VSS VSS gf180mcu_fd_sc_mcu9t5v0__clkbuf_8
X_18998_ _18998_/D _20022_/RN clkload70/I _18998_/Q VSS VSS VSS VSS gf180mcu_fd_sc_mcu9t5v0__dffrnq_1
XTAP_TAPCELL_ROW_128_4493 VSS VSS gf180mcu_fd_sc_mcu9t5v0__filltie
XTAP_TAPCELL_ROW_85_3331 VSS VSS gf180mcu_fd_sc_mcu9t5v0__filltie
XTAP_TAPCELL_ROW_85_3320 VSS VSS gf180mcu_fd_sc_mcu9t5v0__filltie
X_17949_ _18854_/Q _11013_/B _17953_/B VSS _17963_/VNW VSS VSS gf180mcu_fd_sc_mcu9t5v0__nand2_1
XTAP_TAPCELL_ROW_124_4379 VSS VSS gf180mcu_fd_sc_mcu9t5v0__filltie
XTAP_TAPCELL_ROW_81_3206 VSS VSS gf180mcu_fd_sc_mcu9t5v0__filltie
XTAP_TAPCELL_ROW_252_6013 VSS VSS gf180mcu_fd_sc_mcu9t5v0__filltie
XTAP_TAPCELL_ROW_252_6002 VSS VSS gf180mcu_fd_sc_mcu9t5v0__filltie
XTAP_TAPCELL_ROW_81_3217 VSS VSS gf180mcu_fd_sc_mcu9t5v0__filltie
X_19619_ _19619_/D _20067_/RN clkload21/I _19619_/Q VSS VSS VSS VSS gf180mcu_fd_sc_mcu9t5v0__dffrnq_1
X_09303_ _19257_/Q _16957_/A1 VSS VSS VSS VSS gf180mcu_fd_sc_mcu9t5v0__clkinv_1
XTAP_TAPCELL_ROW_79_3157 VSS VSS gf180mcu_fd_sc_mcu9t5v0__filltie
X_09234_ _19299_/Q _14196_/A2 VSS VSS VSS VSS gf180mcu_fd_sc_mcu9t5v0__clkinv_1
XPHY_EDGE_ROW_3_Right_3 VSS VSS gf180mcu_fd_sc_mcu9t5v0__endcap
XTAP_TAPCELL_ROW_79_3146 VSS VSS gf180mcu_fd_sc_mcu9t5v0__filltie
XTAP_TAPCELL_ROW_79_3168 VSS VSS gf180mcu_fd_sc_mcu9t5v0__filltie
X_09165_ _19779_/Q _13469_/A2 VSS VSS VSS VSS gf180mcu_fd_sc_mcu9t5v0__clkinv_1
XPHY_EDGE_ROW_101_Left_425 VSS VSS gf180mcu_fd_sc_mcu9t5v0__endcap
X_09096_ _19020_/Q _09569_/A3 VSS _11018_/VNW VSS VSS gf180mcu_fd_sc_mcu9t5v0__clkinv_1
XTAP_TAPCELL_ROW_70_2921 VSS VSS gf180mcu_fd_sc_mcu9t5v0__filltie
XTAP_TAPCELL_ROW_70_2910 VSS VSS gf180mcu_fd_sc_mcu9t5v0__filltie
Xclkbuf_1_1__f_clk clkbuf_0_clk/Z clkbuf_1_1__f_clk/Z VSS VSS VSS VSS gf180mcu_fd_sc_mcu9t5v0__clkbuf_16
X_09998_ _10659_/C _18972_/Q _09981_/B _19229_/Q _09998_/C _10004_/A2 VSS _09998_/VNW
+ VSS VSS gf180mcu_fd_sc_mcu9t5v0__oai221_1
XTAP_TAPCELL_ROW_51_2375 VSS VSS gf180mcu_fd_sc_mcu9t5v0__filltie
XTAP_TAPCELL_ROW_8_1204 VSS VSS gf180mcu_fd_sc_mcu9t5v0__filltie
XTAP_TAPCELL_ROW_8_1215 VSS VSS gf180mcu_fd_sc_mcu9t5v0__filltie
XPHY_EDGE_ROW_110_Left_434 VSS VSS gf180mcu_fd_sc_mcu9t5v0__endcap
XTAP_TAPCELL_ROW_222_5182 VSS VSS gf180mcu_fd_sc_mcu9t5v0__filltie
XTAP_TAPCELL_ROW_222_5171 VSS VSS gf180mcu_fd_sc_mcu9t5v0__filltie
XTAP_TAPCELL_ROW_51_2386 VSS VSS gf180mcu_fd_sc_mcu9t5v0__filltie
XTAP_TAPCELL_ROW_51_2397 VSS VSS gf180mcu_fd_sc_mcu9t5v0__filltie
X_11960_ _12237_/B _11960_/A2 _11960_/B _11988_/A1 VSS _11960_/VNW VSS VSS gf180mcu_fd_sc_mcu9t5v0__aoi21_4
XPHY_EDGE_ROW_201_1_Right_785 VSS VSS gf180mcu_fd_sc_mcu9t5v0__endcap
X_10911_ _19252_/Q _19258_/Q _18151_/S _10911_/Z VSS _10911_/VNW VSS VSS gf180mcu_fd_sc_mcu9t5v0__mux2_1
XTAP_TAPCELL_ROW_68_2861 VSS VSS gf180mcu_fd_sc_mcu9t5v0__filltie
XTAP_TAPCELL_ROW_68_2850 VSS VSS gf180mcu_fd_sc_mcu9t5v0__filltie
Xrst_tree_mid_1 rst_tree_root/Z rst_tree_mid_1/Z VSS VSS VSS VSS gf180mcu_fd_sc_mcu9t5v0__clkbuf_16
X_11891_ _18243_/Q _12315_/S _12345_/B _11892_/B2 VSS VSS VSS VSS gf180mcu_fd_sc_mcu9t5v0__oai21_1
XTAP_TAPCELL_ROW_235_5532 VSS VSS gf180mcu_fd_sc_mcu9t5v0__filltie
XTAP_TAPCELL_ROW_235_5521 VSS VSS gf180mcu_fd_sc_mcu9t5v0__filltie
XTAP_TAPCELL_ROW_64_2736 VSS VSS gf180mcu_fd_sc_mcu9t5v0__filltie
XTAP_TAPCELL_ROW_64_2747 VSS VSS gf180mcu_fd_sc_mcu9t5v0__filltie
XTAP_TAPCELL_ROW_235_5543 VSS VSS gf180mcu_fd_sc_mcu9t5v0__filltie
X_10842_ _09446_/Z _17869_/A2 _10842_/A3 _20073_/D VSS VSS VSS VSS gf180mcu_fd_sc_mcu9t5v0__nor3_1
X_13630_ _13630_/A1 _13630_/A2 _13630_/B _13635_/A3 VSS VSS VSS VSS gf180mcu_fd_sc_mcu9t5v0__oai21_1
X_10773_ _10773_/A1 _17412_/B _10773_/B1 _10773_/B2 _10774_/I0 VSS _10773_/VNW VSS
+ VSS gf180mcu_fd_sc_mcu9t5v0__aoi22_1
XTAP_TAPCELL_ROW_231_5429 VSS VSS gf180mcu_fd_sc_mcu9t5v0__filltie
XTAP_TAPCELL_ROW_231_5418 VSS VSS gf180mcu_fd_sc_mcu9t5v0__filltie
X_13561_ _13561_/A1 _13561_/A2 _13561_/B _13566_/A1 VSS _13561_/VNW VSS VSS gf180mcu_fd_sc_mcu9t5v0__aoi21_1
X_16280_ _18212_/Q _16280_/I1 _16824_/S _18212_/D VSS VSS VSS VSS gf180mcu_fd_sc_mcu9t5v0__mux2_1
X_15300_ _15300_/A1 _15300_/A2 _15300_/A3 _15300_/Z VSS VSS VSS VSS gf180mcu_fd_sc_mcu9t5v0__and3_1
X_12512_ _19160_/Q _12488_/I _12513_/B VSS _12512_/VNW VSS VSS gf180mcu_fd_sc_mcu9t5v0__nand2_1
XTAP_TAPCELL_ROW_248_5904 VSS VSS gf180mcu_fd_sc_mcu9t5v0__filltie
XPHY_EDGE_ROW_174_3_Left_832 VSS VSS gf180mcu_fd_sc_mcu9t5v0__endcap
X_13492_ _13477_/Z _13493_/A2 _13645_/B _13492_/Z VSS _13492_/VNW VSS VSS gf180mcu_fd_sc_mcu9t5v0__or3_1
X_15231_ _19596_/Q _15231_/A2 _15237_/A2 VSS VSS VSS VSS gf180mcu_fd_sc_mcu9t5v0__nand2_1
X_12443_ wire175/Z wire123/Z _12618_/B _12445_/A3 VSS VSS VSS VSS gf180mcu_fd_sc_mcu9t5v0__aoi21_1
Xclkbuf_leaf_24_clk_regs clkload4/I clkload62/I VSS _17190_/VNW VSS VSS gf180mcu_fd_sc_mcu9t5v0__clkbuf_8
X_12374_ _18155_/Q _12382_/S _12378_/A2 VSS VSS VSS VSS gf180mcu_fd_sc_mcu9t5v0__nor2_1
XTAP_TAPCELL_ROW_229_5358 VSS VSS gf180mcu_fd_sc_mcu9t5v0__filltie
X_15162_ _19704_/Q _19544_/Q _15163_/S _19704_/D VSS _15162_/VNW VSS VSS gf180mcu_fd_sc_mcu9t5v0__mux2_1
XTAP_TAPCELL_ROW_229_5369 VSS VSS gf180mcu_fd_sc_mcu9t5v0__filltie
X_19970_ _19970_/D _20034_/RN clkload46/I _19970_/Q VSS VSS VSS VSS gf180mcu_fd_sc_mcu9t5v0__dffrnq_1
X_15093_ _15099_/A3 _15093_/A2 _15096_/A1 VSS _15096_/VNW VSS VSS gf180mcu_fd_sc_mcu9t5v0__nand2_1
X_14113_ _14113_/A1 _14188_/A2 _14115_/A2 VSS _14113_/VNW VSS VSS gf180mcu_fd_sc_mcu9t5v0__nand2_1
X_11325_ _11325_/A1 _11325_/A2 _11541_/A2 VSS VSS VSS VSS gf180mcu_fd_sc_mcu9t5v0__nand2_2
X_11256_ _19083_/Q _11321_/A2 _11257_/A2 VSS VSS VSS VSS gf180mcu_fd_sc_mcu9t5v0__nand2_1
X_14044_ _14044_/A1 _14115_/A1 _14106_/B2 _14055_/A1 VSS _14044_/VNW VSS VSS gf180mcu_fd_sc_mcu9t5v0__xnor3_1
X_18921_ _18921_/D _20073_/RN clkload31/I _18921_/Q VSS VSS VSS VSS gf180mcu_fd_sc_mcu9t5v0__dffrnq_1
XPHY_EDGE_ROW_170_1_Left_493 VSS VSS gf180mcu_fd_sc_mcu9t5v0__endcap
X_10207_ _17406_/C _19827_/Q _10237_/A1 VSS _16801_/VNW VSS VSS gf180mcu_fd_sc_mcu9t5v0__nor2_1
X_11187_ _18239_/Q wire136/I _11191_/C VSS VSS VSS VSS gf180mcu_fd_sc_mcu9t5v0__nand2_1
X_18852_ _18852_/D _20068_/RN clkload36/I _18852_/Q VSS VSS VSS VSS gf180mcu_fd_sc_mcu9t5v0__dffrnq_1
X_10138_ _18977_/Q _10138_/A2 _10138_/B1 _19009_/Q _10138_/C _10139_/A3 VSS VSS VSS
+ VSS gf180mcu_fd_sc_mcu9t5v0__aoi221_1
X_17803_ input4/Z _18781_/Q _17807_/S _18781_/D VSS VSS VSS VSS gf180mcu_fd_sc_mcu9t5v0__mux2_1
X_18783_ _18783_/D _20063_/RN clkload63/I _18783_/Q VSS VSS VSS VSS gf180mcu_fd_sc_mcu9t5v0__dffrnq_1
X_15995_ _18568_/Q _18567_/Q _16234_/A2 _16024_/B VSS VSS VSS VSS gf180mcu_fd_sc_mcu9t5v0__nand3_1
X_10069_ _18982_/Q _10169_/B1 _10133_/B1 _19013_/Q _10069_/C _10071_/A2 VSS VSS VSS
+ VSS gf180mcu_fd_sc_mcu9t5v0__aoi221_1
X_17734_ _18743_/Q _17742_/S _17735_/B VSS _17735_/VNW VSS VSS gf180mcu_fd_sc_mcu9t5v0__nand2_1
X_14946_ _19610_/Q _19366_/Q _20039_/D _19610_/D VSS VSS VSS VSS gf180mcu_fd_sc_mcu9t5v0__mux2_1
XTAP_TAPCELL_ROW_317_7790 VSS VSS gf180mcu_fd_sc_mcu9t5v0__filltie
XTAP_TAPCELL_ROW_292_7094 VSS VSS gf180mcu_fd_sc_mcu9t5v0__filltie
XTAP_TAPCELL_ROW_313_7665 VSS VSS gf180mcu_fd_sc_mcu9t5v0__filltie
X_17665_ _18628_/Q _18704_/Q _17685_/S _18704_/D VSS VSS VSS VSS gf180mcu_fd_sc_mcu9t5v0__mux2_1
X_14877_ _15148_/S _14877_/A2 _14877_/B _19592_/D VSS _14877_/VNW VSS VSS gf180mcu_fd_sc_mcu9t5v0__aoi21_1
XTAP_TAPCELL_ROW_313_7687 VSS VSS gf180mcu_fd_sc_mcu9t5v0__filltie
XTAP_TAPCELL_ROW_313_7676 VSS VSS gf180mcu_fd_sc_mcu9t5v0__filltie
X_16616_ _16675_/A1 _16616_/A2 _16616_/A3 _16616_/B _16617_/I1 VSS VSS VSS VSS gf180mcu_fd_sc_mcu9t5v0__oai31_1
X_17596_ input7/Z _18661_/Q _17597_/S _18661_/D VSS VSS VSS VSS gf180mcu_fd_sc_mcu9t5v0__mux2_1
X_19404_ _19404_/D _20044_/RN clkload17/I _19404_/Q VSS VSS VSS VSS gf180mcu_fd_sc_mcu9t5v0__dffrnq_1
X_13828_ _13818_/Z _13828_/A2 _13828_/Z VSS VSS VSS VSS gf180mcu_fd_sc_mcu9t5v0__xor2_1
X_16547_ _18330_/Q _16009_/B _17062_/S _18330_/D VSS VSS VSS VSS gf180mcu_fd_sc_mcu9t5v0__mux2_1
X_13759_ _19293_/Q _19317_/Q _13767_/B VSS _13759_/VNW VSS VSS gf180mcu_fd_sc_mcu9t5v0__and2_1
X_19335_ _19335_/D _20039_/RN clkload18/I _19335_/Q VSS VSS VSS VSS gf180mcu_fd_sc_mcu9t5v0__dffrnq_1
X_19266_ _19266_/D _20034_/RN clkload45/I _19266_/Q VSS VSS VSS VSS gf180mcu_fd_sc_mcu9t5v0__dffrnq_1
XTAP_TAPCELL_ROW_132_4604 VSS VSS gf180mcu_fd_sc_mcu9t5v0__filltie
X_18217_ _18217_/D clkload64/I _18217_/Q VSS VSS VSS VSS gf180mcu_fd_sc_mcu9t5v0__dffq_1
XTAP_TAPCELL_ROW_214_4959 VSS VSS gf180mcu_fd_sc_mcu9t5v0__filltie
X_16478_ _16478_/A1 _16545_/A2 _17023_/S _16496_/S VSS VSS VSS VSS gf180mcu_fd_sc_mcu9t5v0__oai21_4
XTAP_TAPCELL_ROW_214_4948 VSS VSS gf180mcu_fd_sc_mcu9t5v0__filltie
XTAP_TAPCELL_ROW_132_4626 VSS VSS gf180mcu_fd_sc_mcu9t5v0__filltie
XTAP_TAPCELL_ROW_132_4615 VSS VSS gf180mcu_fd_sc_mcu9t5v0__filltie
XTAP_TAPCELL_ROW_74_3021 VSS VSS gf180mcu_fd_sc_mcu9t5v0__filltie
XTAP_TAPCELL_ROW_117_4194 VSS VSS gf180mcu_fd_sc_mcu9t5v0__filltie
X_15429_ _19714_/Q _19814_/Q _15430_/S _19814_/D VSS VSS VSS VSS gf180mcu_fd_sc_mcu9t5v0__mux2_1
XTAP_TAPCELL_ROW_74_3010 VSS VSS gf180mcu_fd_sc_mcu9t5v0__filltie
X_19197_ _19197_/D _20029_/RN clkload24/I _19197_/Q VSS VSS VSS VSS gf180mcu_fd_sc_mcu9t5v0__dffrnq_1
X_18148_ _18147_/Z _18961_/Q _18148_/S _18961_/D VSS VSS VSS VSS gf180mcu_fd_sc_mcu9t5v0__mux2_1
X_18079_ _18079_/A1 _18079_/A2 _18079_/A3 _18080_/A2 VSS _18079_/VNW VSS VSS gf180mcu_fd_sc_mcu9t5v0__nand3_1
X_20110_ _20110_/D clkload57/I _20110_/Q VSS VSS VSS VSS gf180mcu_fd_sc_mcu9t5v0__dffq_1
X_09921_ _11013_/A1 _19003_/Q _09922_/B VSS VSS VSS VSS gf180mcu_fd_sc_mcu9t5v0__nand2_1
X_09852_ _18835_/Q _09852_/A2 _20027_/Q _17863_/A2 VSS _15840_/VNW VSS VSS gf180mcu_fd_sc_mcu9t5v0__oai21_1
X_20041_ _20041_/D _20041_/RN clkload44/I _20041_/Q VSS VSS VSS VSS gf180mcu_fd_sc_mcu9t5v0__dffrnq_4
XPHY_EDGE_ROW_138_2_Left_650 VSS VSS gf180mcu_fd_sc_mcu9t5v0__endcap
X_09783_ _18838_/Q _09782_/Z _17903_/A1 VSS _09783_/VNW VSS VSS gf180mcu_fd_sc_mcu9t5v0__nor2_1
XTAP_TAPCELL_ROW_102_3795 VSS VSS gf180mcu_fd_sc_mcu9t5v0__filltie
XTAP_TAPCELL_ROW_102_3784 VSS VSS gf180mcu_fd_sc_mcu9t5v0__filltie
XTAP_TAPCELL_ROW_288_6996 VSS VSS gf180mcu_fd_sc_mcu9t5v0__filltie
XTAP_TAPCELL_ROW_288_6985 VSS VSS gf180mcu_fd_sc_mcu9t5v0__filltie
XTAP_TAPCELL_ROW_44_2190 VSS VSS gf180mcu_fd_sc_mcu9t5v0__filltie
XTAP_TAPCELL_ROW_40_2076 VSS VSS gf180mcu_fd_sc_mcu9t5v0__filltie
X_09217_ _19594_/Q _15225_/A1 VSS _15223_/VNW VSS VSS gf180mcu_fd_sc_mcu9t5v0__clkinv_1
XTAP_TAPCELL_ROW_40_2087 VSS VSS gf180mcu_fd_sc_mcu9t5v0__filltie
X_09148_ _19803_/Q _13269_/A2 VSS _13269_/VNW VSS VSS gf180mcu_fd_sc_mcu9t5v0__clkinv_1
X_09079_ _19997_/Q _09400_/A1 VSS _10194_/VNW VSS VSS gf180mcu_fd_sc_mcu9t5v0__clkinv_1
XTAP_TAPCELL_ROW_57_2540 VSS VSS gf180mcu_fd_sc_mcu9t5v0__filltie
XTAP_TAPCELL_ROW_57_2551 VSS VSS gf180mcu_fd_sc_mcu9t5v0__filltie
X_11110_ _16409_/A1 _11688_/I1 _11403_/S _11110_/Z VSS _11688_/VNW VSS VSS gf180mcu_fd_sc_mcu9t5v0__mux2_1
XTAP_TAPCELL_ROW_57_2562 VSS VSS gf180mcu_fd_sc_mcu9t5v0__filltie
X_12090_ _18412_/Q _12046_/S _12090_/B _12093_/A2 VSS _12090_/VNW VSS VSS gf180mcu_fd_sc_mcu9t5v0__aoi21_1
XTAP_TAPCELL_ROW_224_5244 VSS VSS gf180mcu_fd_sc_mcu9t5v0__filltie
XTAP_TAPCELL_ROW_224_5233 VSS VSS gf180mcu_fd_sc_mcu9t5v0__filltie
XTAP_TAPCELL_ROW_224_5222 VSS VSS gf180mcu_fd_sc_mcu9t5v0__filltie
XTAP_TAPCELL_ROW_53_2437 VSS VSS gf180mcu_fd_sc_mcu9t5v0__filltie
XTAP_TAPCELL_ROW_53_2448 VSS VSS gf180mcu_fd_sc_mcu9t5v0__filltie
XTAP_TAPCELL_ROW_220_5119 VSS VSS gf180mcu_fd_sc_mcu9t5v0__filltie
XTAP_TAPCELL_ROW_220_5108 VSS VSS gf180mcu_fd_sc_mcu9t5v0__filltie
X_11041_ _18027_/I0 _19042_/Q wire174/Z _19042_/D VSS VSS VSS VSS gf180mcu_fd_sc_mcu9t5v0__mux2_1
X_14800_ _14800_/A1 _14800_/A2 _14806_/A1 VSS VSS VSS VSS gf180mcu_fd_sc_mcu9t5v0__nand2_1
X_15780_ _19974_/Q _19950_/Q _15786_/S _19950_/D VSS VSS VSS VSS gf180mcu_fd_sc_mcu9t5v0__mux2_1
XPHY_EDGE_ROW_202_1_Right_786 VSS VSS gf180mcu_fd_sc_mcu9t5v0__endcap
X_12992_ _12992_/I0 _19230_/Q _13304_/B _19230_/D VSS VSS VSS VSS gf180mcu_fd_sc_mcu9t5v0__mux2_1
XTAP_TAPCELL_ROW_66_2809 VSS VSS gf180mcu_fd_sc_mcu9t5v0__filltie
X_11943_ _11988_/B _11924_/Z _11944_/B _11946_/A1 VSS VSS VSS VSS gf180mcu_fd_sc_mcu9t5v0__nor3_4
X_14731_ _14731_/A1 _14731_/A2 _14731_/B _14735_/A2 VSS VSS VSS VSS gf180mcu_fd_sc_mcu9t5v0__aoi21_1
X_11874_ _12261_/B _11874_/A2 _11874_/A3 _11875_/B VSS VSS VSS VSS gf180mcu_fd_sc_mcu9t5v0__nand3_1
XTAP_TAPCELL_ROW_218_5059 VSS VSS gf180mcu_fd_sc_mcu9t5v0__filltie
X_14662_ _14662_/A1 _14662_/A2 _14665_/B VSS _14664_/VNW VSS VSS gf180mcu_fd_sc_mcu9t5v0__nor2_1
X_17450_ _17462_/A1 _17450_/A2 _18571_/D VSS VSS VSS VSS gf180mcu_fd_sc_mcu9t5v0__nor2_1
X_17381_ _09261_/I _17381_/A2 _17381_/A3 _17381_/B _17386_/B1 VSS VSS VSS VSS gf180mcu_fd_sc_mcu9t5v0__oai31_1
X_10825_ _10825_/A1 _09721_/B _10825_/B1 _10825_/B2 _20064_/D VSS VSS VSS VSS gf180mcu_fd_sc_mcu9t5v0__oai22_1
X_16401_ _16099_/B _19243_/Q _16927_/S _16401_/Z VSS VSS VSS VSS gf180mcu_fd_sc_mcu9t5v0__mux2_1
X_13613_ _19285_/Q _13419_/B _13616_/B VSS _13613_/VNW VSS VSS gf180mcu_fd_sc_mcu9t5v0__nand2_1
X_16332_ _18231_/Q _16331_/Z _16854_/S _18231_/D VSS VSS VSS VSS gf180mcu_fd_sc_mcu9t5v0__mux2_4
X_14593_ _14593_/A1 _14766_/A2 _14593_/B1 _14595_/B1 _19472_/D VSS _14593_/VNW VSS
+ VSS gf180mcu_fd_sc_mcu9t5v0__aoi22_1
X_19120_ _19120_/D _20144_/RN _19798_/CLK _19120_/Q VSS VSS VSS VSS gf180mcu_fd_sc_mcu9t5v0__dffrnq_4
X_13544_ _19727_/Q _13544_/A2 _13546_/A2 VSS VSS VSS VSS gf180mcu_fd_sc_mcu9t5v0__nor2_1
X_10756_ _10757_/A1 _10757_/A2 _10777_/B VSS _10756_/VNW VSS VSS gf180mcu_fd_sc_mcu9t5v0__nor2_1
X_16263_ _16263_/A1 _16422_/B _16264_/I1 VSS _16422_/VNW VSS VSS gf180mcu_fd_sc_mcu9t5v0__nand2_1
X_13475_ _19780_/Q _13475_/A2 _13489_/A2 _13478_/A2 VSS _13475_/VNW VSS VSS gf180mcu_fd_sc_mcu9t5v0__xnor3_1
X_10687_ _18836_/Q _18845_/Q _18852_/Q _10688_/B _10690_/A2 VSS _10688_/VNW VSS VSS
+ gf180mcu_fd_sc_mcu9t5v0__oai211_1
X_19051_ _19051_/D _20139_/RN clkload34/I _19051_/Q VSS VSS VSS VSS gf180mcu_fd_sc_mcu9t5v0__dffrnq_1
XTAP_TAPCELL_ROW_321_7901 VSS VSS gf180mcu_fd_sc_mcu9t5v0__filltie
X_16194_ _16099_/B _16730_/A1 _16194_/B _16195_/A3 VSS VSS VSS VSS gf180mcu_fd_sc_mcu9t5v0__aoi21_1
X_12426_ _12616_/B _12426_/A2 _12426_/A3 _12426_/B1 _12426_/B2 _12427_/A2 VSS VSS
+ VSS VSS gf180mcu_fd_sc_mcu9t5v0__oai32_4
X_18002_ _18888_/Q _18035_/I0 _18004_/S _18888_/D VSS _18002_/VNW VSS VSS gf180mcu_fd_sc_mcu9t5v0__mux2_1
X_15214_ _15217_/A1 _19570_/Q _15219_/B VSS VSS VSS VSS gf180mcu_fd_sc_mcu9t5v0__nand2_1
XTAP_TAPCELL_ROW_306_7480 VSS VSS gf180mcu_fd_sc_mcu9t5v0__filltie
X_15145_ _19687_/Q _19527_/Q _15148_/S _19687_/D VSS _15145_/VNW VSS VSS gf180mcu_fd_sc_mcu9t5v0__mux2_1
XTAP_TAPCELL_ROW_306_7491 VSS VSS gf180mcu_fd_sc_mcu9t5v0__filltie
X_12357_ _19141_/Q _12355_/I _12364_/B VSS VSS VSS VSS gf180mcu_fd_sc_mcu9t5v0__nand2_1
XTAP_TAPCELL_ROW_302_7388 VSS VSS gf180mcu_fd_sc_mcu9t5v0__filltie
X_12288_ _18501_/Q _12345_/A2 _12289_/A3 VSS VSS VSS VSS gf180mcu_fd_sc_mcu9t5v0__nand2_1
XTAP_TAPCELL_ROW_302_7377 VSS VSS gf180mcu_fd_sc_mcu9t5v0__filltie
XTAP_TAPCELL_ROW_298_7270 VSS VSS gf180mcu_fd_sc_mcu9t5v0__filltie
XTAP_TAPCELL_ROW_302_7366 VSS VSS gf180mcu_fd_sc_mcu9t5v0__filltie
X_19953_ _19953_/D _20145_/RN clkload66/I _19953_/Q VSS VSS VSS VSS gf180mcu_fd_sc_mcu9t5v0__dffrnq_1
X_11308_ _11308_/A1 _11308_/A2 _19087_/D VSS VSS VSS VSS gf180mcu_fd_sc_mcu9t5v0__nand2_1
X_15076_ _15077_/A3 _15074_/Z _15099_/A1 _15086_/A1 VSS _15087_/VNW VSS VSS gf180mcu_fd_sc_mcu9t5v0__nand3_1
X_11239_ _18242_/Q _11233_/Z _11520_/B _11239_/Z VSS _11239_/VNW VSS VSS gf180mcu_fd_sc_mcu9t5v0__mux2_1
XTAP_TAPCELL_ROW_294_7145 VSS VSS gf180mcu_fd_sc_mcu9t5v0__filltie
X_19884_ _19884_/D _20140_/RN clkload45/I _19884_/Q VSS VSS VSS VSS gf180mcu_fd_sc_mcu9t5v0__dffrnq_1
XTAP_TAPCELL_ROW_36_1967 VSS VSS gf180mcu_fd_sc_mcu9t5v0__filltie
X_14027_ _14027_/A1 _14027_/A2 _14031_/A3 VSS VSS VSS VSS gf180mcu_fd_sc_mcu9t5v0__nor2_1
X_18904_ _18904_/D _19992_/RN clkload30/I _18904_/Q VSS VSS VSS VSS gf180mcu_fd_sc_mcu9t5v0__dffrnq_1
XTAP_TAPCELL_ROW_319_7852 VSS VSS gf180mcu_fd_sc_mcu9t5v0__filltie
XTAP_TAPCELL_ROW_294_7167 VSS VSS gf180mcu_fd_sc_mcu9t5v0__filltie
XTAP_TAPCELL_ROW_319_7841 VSS VSS gf180mcu_fd_sc_mcu9t5v0__filltie
XTAP_TAPCELL_ROW_294_7156 VSS VSS gf180mcu_fd_sc_mcu9t5v0__filltie
XTAP_TAPCELL_ROW_319_7830 VSS VSS gf180mcu_fd_sc_mcu9t5v0__filltie
XTAP_TAPCELL_ROW_125_4430 VSS VSS gf180mcu_fd_sc_mcu9t5v0__filltie
X_18835_ _18835_/D _20051_/RN clkload22/I _18835_/Q VSS VSS VSS VSS gf180mcu_fd_sc_mcu9t5v0__dffrnq_1
XTAP_TAPCELL_ROW_36_1978 VSS VSS gf180mcu_fd_sc_mcu9t5v0__filltie
XTAP_TAPCELL_ROW_121_4316 VSS VSS gf180mcu_fd_sc_mcu9t5v0__filltie
XTAP_TAPCELL_ROW_121_4305 VSS VSS gf180mcu_fd_sc_mcu9t5v0__filltie
XTAP_TAPCELL_ROW_315_7738 VSS VSS gf180mcu_fd_sc_mcu9t5v0__filltie
XTAP_TAPCELL_ROW_315_7727 VSS VSS gf180mcu_fd_sc_mcu9t5v0__filltie
X_15978_ _18568_/Q _15954_/B _16298_/A1 VSS VSS VSS VSS gf180mcu_fd_sc_mcu9t5v0__nand2_4
X_18766_ _18766_/D _20046_/RN clkload51/I _18766_/Q VSS VSS VSS VSS gf180mcu_fd_sc_mcu9t5v0__dffrnq_1
X_18697_ _18697_/D clkload59/I _18697_/Q VSS VSS VSS VSS gf180mcu_fd_sc_mcu9t5v0__dffq_1
X_17717_ _17717_/I _18734_/D VSS VSS VSS VSS gf180mcu_fd_sc_mcu9t5v0__clkinv_1
X_14929_ _19601_/Q _14928_/Z _15163_/S _19601_/D VSS VSS VSS VSS gf180mcu_fd_sc_mcu9t5v0__mux2_1
X_17648_ _17648_/I0 _18691_/Q _17649_/S _18691_/D VSS VSS VSS VSS gf180mcu_fd_sc_mcu9t5v0__mux2_1
XTAP_TAPCELL_ROW_119_4245 VSS VSS gf180mcu_fd_sc_mcu9t5v0__filltie
X_17579_ _18647_/Q _17579_/I1 _17584_/S _18647_/D VSS _17579_/VNW VSS VSS gf180mcu_fd_sc_mcu9t5v0__mux2_1
XTAP_TAPCELL_ROW_119_4267 VSS VSS gf180mcu_fd_sc_mcu9t5v0__filltie
XTAP_TAPCELL_ROW_119_4256 VSS VSS gf180mcu_fd_sc_mcu9t5v0__filltie
X_19318_ _19318_/D _20022_/RN clkload14/I _19318_/Q VSS VSS VSS VSS gf180mcu_fd_sc_mcu9t5v0__dffrnq_1
X_19249_ _19249_/D _20145_/RN _20054_/CLK _19249_/Q VSS VSS VSS VSS gf180mcu_fd_sc_mcu9t5v0__dffrnq_2
XTAP_TAPCELL_ROW_283_6860 VSS VSS gf180mcu_fd_sc_mcu9t5v0__filltie
X_09904_ _15834_/A1 _19994_/Q _10054_/A2 VSS VSS VSS VSS gf180mcu_fd_sc_mcu9t5v0__nand2_1
X_09835_ _09835_/A1 _09820_/Z _09835_/B _09835_/C _09837_/B1 VSS VSS VSS VSS gf180mcu_fd_sc_mcu9t5v0__aoi211_1
X_20024_ _20024_/D _19960_/RN clkload44/I _20024_/Q VSS VSS VSS VSS gf180mcu_fd_sc_mcu9t5v0__dffsnq_1
XTAP_TAPCELL_ROW_277_6675 VSS VSS gf180mcu_fd_sc_mcu9t5v0__filltie
XTAP_TAPCELL_ROW_108_3960 VSS VSS gf180mcu_fd_sc_mcu9t5v0__filltie
XTAP_TAPCELL_ROW_277_6697 VSS VSS gf180mcu_fd_sc_mcu9t5v0__filltie
XTAP_TAPCELL_ROW_277_6686 VSS VSS gf180mcu_fd_sc_mcu9t5v0__filltie
X_09766_ _09768_/A2 _09416_/C _09814_/A3 VSS VSS VSS VSS gf180mcu_fd_sc_mcu9t5v0__nor2_1
X_09697_ _15705_/B _09698_/A2 _09699_/A2 VSS _09703_/VNW VSS VSS gf180mcu_fd_sc_mcu9t5v0__nand2_1
XTAP_TAPCELL_ROW_104_3846 VSS VSS gf180mcu_fd_sc_mcu9t5v0__filltie
XTAP_TAPCELL_ROW_104_3835 VSS VSS gf180mcu_fd_sc_mcu9t5v0__filltie
XTAP_TAPCELL_ROW_46_2241 VSS VSS gf180mcu_fd_sc_mcu9t5v0__filltie
XTAP_TAPCELL_ROW_46_2252 VSS VSS gf180mcu_fd_sc_mcu9t5v0__filltie
XTAP_TAPCELL_ROW_42_2127 VSS VSS gf180mcu_fd_sc_mcu9t5v0__filltie
XTAP_TAPCELL_ROW_42_2138 VSS VSS gf180mcu_fd_sc_mcu9t5v0__filltie
X_10610_ _17358_/A1 _18199_/Q _10613_/A2 VSS VSS VSS VSS gf180mcu_fd_sc_mcu9t5v0__nor2_1
X_11590_ _18837_/Q _11591_/A2 _18838_/Q _18845_/Q _11590_/Z VSS _11590_/VNW VSS VSS
+ gf180mcu_fd_sc_mcu9t5v0__and4_1
XTAP_TAPCELL_ROW_42_2149 VSS VSS gf180mcu_fd_sc_mcu9t5v0__filltie
X_10541_ _17404_/S _18212_/Q _10541_/B _10543_/A2 VSS VSS VSS VSS gf180mcu_fd_sc_mcu9t5v0__oai21_1
XTAP_TAPCELL_ROW_59_2602 VSS VSS gf180mcu_fd_sc_mcu9t5v0__filltie
XTAP_TAPCELL_ROW_59_2613 VSS VSS gf180mcu_fd_sc_mcu9t5v0__filltie
X_13260_ _13261_/A1 _13261_/A2 _13580_/B _13278_/A2 VSS _13261_/VNW VSS VSS gf180mcu_fd_sc_mcu9t5v0__aoi21_1
X_10472_ _18947_/Q wire166/Z _10474_/A2 VSS _10472_/VNW VSS VSS gf180mcu_fd_sc_mcu9t5v0__nand2_1
X_12211_ _12212_/A1 _12212_/A2 _12237_/A1 VSS _12211_/VNW VSS VSS gf180mcu_fd_sc_mcu9t5v0__nand2_4
X_13191_ _19731_/Q _13564_/A2 _13561_/B VSS _13561_/VNW VSS VSS gf180mcu_fd_sc_mcu9t5v0__xnor2_1
Xrst_tree_leaf_19 rst_tree_mid_2/Z _20064_/RN VSS VSS VSS VSS gf180mcu_fd_sc_mcu9t5v0__clkbuf_16
X_12142_ _12142_/A1 _12142_/A2 _12142_/B1 _12153_/B _12164_/A3 VSS VSS VSS VSS gf180mcu_fd_sc_mcu9t5v0__aoi22_1
X_16950_ _16949_/Z _18466_/Q _16960_/S _18466_/D VSS VSS VSS VSS gf180mcu_fd_sc_mcu9t5v0__mux2_1
X_12073_ _12073_/A1 _12073_/A2 wire213/Z _12074_/B VSS VSS VSS VSS gf180mcu_fd_sc_mcu9t5v0__aoi21_2
XPHY_EDGE_ROW_288_Right_215 VSS VSS gf180mcu_fd_sc_mcu9t5v0__endcap
X_15901_ _20110_/Q _19246_/Q _15905_/S _20110_/D VSS VSS VSS VSS gf180mcu_fd_sc_mcu9t5v0__mux2_1
XTAP_TAPCELL_ROW_140_3_8013 VSS VSS gf180mcu_fd_sc_mcu9t5v0__filltie
X_11024_ _19057_/Q _19025_/Q wire174/Z _19025_/D VSS _11056_/VNW VSS VSS gf180mcu_fd_sc_mcu9t5v0__mux2_1
X_16881_ _19252_/Q _16628_/B _16881_/S _16881_/Z VSS VSS VSS VSS gf180mcu_fd_sc_mcu9t5v0__mux2_4
X_15832_ _15832_/A1 _15834_/A2 _15832_/B1 _15834_/B2 _19994_/D VSS VSS VSS VSS gf180mcu_fd_sc_mcu9t5v0__oai22_1
X_18620_ _18620_/D _19960_/RN clkload59/I _18620_/Q VSS VSS VSS VSS gf180mcu_fd_sc_mcu9t5v0__dffrnq_1
XTAP_TAPCELL_ROW_31_1831 VSS VSS gf180mcu_fd_sc_mcu9t5v0__filltie
XTAP_TAPCELL_ROW_31_1842 VSS VSS gf180mcu_fd_sc_mcu9t5v0__filltie
X_18551_ _18551_/D _20051_/RN clkload76/I _18551_/Q VSS VSS VSS VSS gf180mcu_fd_sc_mcu9t5v0__dffrnq_4
X_15763_ _09065_/I _19933_/Q _15770_/S _19933_/D VSS VSS VSS VSS gf180mcu_fd_sc_mcu9t5v0__mux2_1
X_12975_ _19720_/Q _12981_/A1 _13008_/A1 VSS _13007_/VNW VSS VSS gf180mcu_fd_sc_mcu9t5v0__nor2_1
XTAP_TAPCELL_ROW_310_7602 VSS VSS gf180mcu_fd_sc_mcu9t5v0__filltie
X_17502_ _18607_/Q _19248_/Q _17504_/S _18607_/D VSS VSS VSS VSS gf180mcu_fd_sc_mcu9t5v0__mux2_1
X_18482_ _18482_/D _20132_/CLK _18482_/Q VSS VSS VSS VSS gf180mcu_fd_sc_mcu9t5v0__dffq_1
XPHY_EDGE_ROW_203_1_Right_787 VSS VSS gf180mcu_fd_sc_mcu9t5v0__endcap
X_14714_ _14714_/A1 _14714_/A2 _14715_/I0 VSS VSS VSS VSS gf180mcu_fd_sc_mcu9t5v0__xnor2_1
X_11926_ _12548_/A1 _11926_/A2 _11926_/B1 _12004_/B _11985_/B _11927_/B VSS VSS VSS
+ VSS gf180mcu_fd_sc_mcu9t5v0__oai221_4
X_15694_ _19915_/Q _19916_/Q _15695_/A2 VSS VSS VSS VSS gf180mcu_fd_sc_mcu9t5v0__xnor2_1
X_17433_ _18565_/Q _09688_/B _17436_/A2 VSS _17433_/VNW VSS VSS gf180mcu_fd_sc_mcu9t5v0__nand2_1
XTAP_TAPCELL_ROW_29_1771 VSS VSS gf180mcu_fd_sc_mcu9t5v0__filltie
X_14645_ _14715_/S _14645_/A2 _14645_/B _19522_/D VSS VSS VSS VSS gf180mcu_fd_sc_mcu9t5v0__oai21_1
X_11857_ _19116_/Q _11966_/B _11880_/B VSS VSS VSS VSS gf180mcu_fd_sc_mcu9t5v0__nand2_1
X_17364_ _18374_/Q _17405_/A2 _17366_/B1 VSS VSS VSS VSS gf180mcu_fd_sc_mcu9t5v0__nand2_1
X_11788_ _11807_/A3 _11789_/A2 _11788_/B _11789_/B VSS VSS VSS VSS gf180mcu_fd_sc_mcu9t5v0__aoi21_1
X_10808_ _19940_/Q _19892_/Q _20043_/Q _10808_/Z VSS _10809_/VNW VSS VSS gf180mcu_fd_sc_mcu9t5v0__mux2_1
XTAP_TAPCELL_ROW_29_1782 VSS VSS gf180mcu_fd_sc_mcu9t5v0__filltie
X_14576_ _19172_/Q _19138_/Q _14578_/A2 VSS _14576_/VNW VSS VSS gf180mcu_fd_sc_mcu9t5v0__nor2_1
XTAP_TAPCELL_ROW_29_1793 VSS VSS gf180mcu_fd_sc_mcu9t5v0__filltie
XTAP_TAPCELL_ROW_308_7531 VSS VSS gf180mcu_fd_sc_mcu9t5v0__filltie
X_17295_ _18499_/Q _17405_/A2 _17293_/Z _10514_/B _19827_/Q _17299_/A2 VSS _17295_/VNW
+ VSS VSS gf180mcu_fd_sc_mcu9t5v0__aoi221_1
X_16315_ _19234_/Q _16147_/C _16863_/S _16315_/Z VSS VSS VSS VSS gf180mcu_fd_sc_mcu9t5v0__mux2_1
XTAP_TAPCELL_ROW_114_4131 VSS VSS gf180mcu_fd_sc_mcu9t5v0__filltie
X_10739_ _10715_/C _10739_/A2 _10739_/A3 _10806_/B _10740_/A3 VSS VSS VSS VSS gf180mcu_fd_sc_mcu9t5v0__oai31_1
X_19103_ _19103_/D _20063_/RN _19680_/CLK _19103_/Q VSS VSS VSS VSS gf180mcu_fd_sc_mcu9t5v0__dffrnq_1
XTAP_TAPCELL_ROW_114_4120 VSS VSS gf180mcu_fd_sc_mcu9t5v0__filltie
X_13527_ _13527_/A1 _13527_/A2 _13527_/B _19266_/D VSS VSS VSS VSS gf180mcu_fd_sc_mcu9t5v0__oai21_1
XTAP_TAPCELL_ROW_25_1657 VSS VSS gf180mcu_fd_sc_mcu9t5v0__filltie
XTAP_TAPCELL_ROW_25_1668 VSS VSS gf180mcu_fd_sc_mcu9t5v0__filltie
XTAP_TAPCELL_ROW_25_1679 VSS VSS gf180mcu_fd_sc_mcu9t5v0__filltie
XTAP_TAPCELL_ROW_308_7553 VSS VSS gf180mcu_fd_sc_mcu9t5v0__filltie
XTAP_TAPCELL_ROW_308_7542 VSS VSS gf180mcu_fd_sc_mcu9t5v0__filltie
X_16246_ _16016_/B _16949_/S _16411_/A1 VSS VSS VSS VSS gf180mcu_fd_sc_mcu9t5v0__nand2_1
XTAP_TAPCELL_ROW_110_4006 VSS VSS gf180mcu_fd_sc_mcu9t5v0__filltie
X_19034_ _19034_/D _20058_/RN clkload32/I _19034_/Q VSS VSS VSS VSS gf180mcu_fd_sc_mcu9t5v0__dffrnq_1
XTAP_TAPCELL_ROW_304_7439 VSS VSS gf180mcu_fd_sc_mcu9t5v0__filltie
XTAP_TAPCELL_ROW_304_7428 VSS VSS gf180mcu_fd_sc_mcu9t5v0__filltie
XTAP_TAPCELL_ROW_304_7417 VSS VSS gf180mcu_fd_sc_mcu9t5v0__filltie
XPHY_EDGE_ROW_209_Right_136 VSS VSS gf180mcu_fd_sc_mcu9t5v0__endcap
XTAP_TAPCELL_ROW_110_4017 VSS VSS gf180mcu_fd_sc_mcu9t5v0__filltie
X_13458_ _13469_/A2 _19813_/Q _13474_/A2 VSS _13475_/VNW VSS VSS gf180mcu_fd_sc_mcu9t5v0__nand2_1
X_16177_ _16751_/A2 _16751_/A3 _16751_/B _16177_/C _16179_/B VSS VSS VSS VSS gf180mcu_fd_sc_mcu9t5v0__oai211_4
X_12409_ _18737_/Q wire198/Z _12543_/B1 _12409_/B2 _12410_/A3 VSS _12409_/VNW VSS
+ VSS gf180mcu_fd_sc_mcu9t5v0__aoi22_2
XTAP_TAPCELL_ROW_209_4803 VSS VSS gf180mcu_fd_sc_mcu9t5v0__filltie
XPHY_EDGE_ROW_200_1_Left_523 VSS VSS gf180mcu_fd_sc_mcu9t5v0__endcap
X_13389_ _13416_/A1 _13618_/A2 _13389_/Z VSS VSS VSS VSS gf180mcu_fd_sc_mcu9t5v0__or2_1
XTAP_TAPCELL_ROW_296_7218 VSS VSS gf180mcu_fd_sc_mcu9t5v0__filltie
XTAP_TAPCELL_ROW_296_7207 VSS VSS gf180mcu_fd_sc_mcu9t5v0__filltie
XTAP_TAPCELL_ROW_209_4825 VSS VSS gf180mcu_fd_sc_mcu9t5v0__filltie
XTAP_TAPCELL_ROW_209_4814 VSS VSS gf180mcu_fd_sc_mcu9t5v0__filltie
X_15128_ _19670_/Q _19510_/Q _15163_/S _19670_/D VSS VSS VSS VSS gf180mcu_fd_sc_mcu9t5v0__mux2_1
X_19936_ _19936_/D _20064_/RN clkload71/I _19936_/Q VSS VSS VSS VSS gf180mcu_fd_sc_mcu9t5v0__dffrnq_1
X_15059_ _19307_/Q _19392_/Q _15063_/A2 VSS VSS VSS VSS gf180mcu_fd_sc_mcu9t5v0__nand2_1
X_19867_ _19867_/D _20059_/RN clkload56/I _19867_/Q VSS VSS VSS VSS gf180mcu_fd_sc_mcu9t5v0__dffrnq_1
X_09620_ _15834_/B2 _15827_/A2 _20072_/D VSS VSS VSS VSS gf180mcu_fd_sc_mcu9t5v0__nand2_1
X_18818_ _18818_/D _20034_/RN clkload36/I _18818_/Q VSS VSS VSS VSS gf180mcu_fd_sc_mcu9t5v0__dffrnq_1
X_19798_ _19798_/D _20054_/RN _19798_/CLK _19798_/Q VSS VSS VSS VSS gf180mcu_fd_sc_mcu9t5v0__dffrnq_1
X_09551_ _15819_/S _19998_/D VSS VSS VSS VSS gf180mcu_fd_sc_mcu9t5v0__clkinv_1
X_18749_ _18749_/D clkload25/I _18749_/Q VSS VSS VSS VSS gf180mcu_fd_sc_mcu9t5v0__dffq_1
XTAP_TAPCELL_ROW_272_6561 VSS VSS gf180mcu_fd_sc_mcu9t5v0__filltie
XTAP_TAPCELL_ROW_272_6550 VSS VSS gf180mcu_fd_sc_mcu9t5v0__filltie
X_09482_ _18578_/Q _12689_/A2 _12618_/B _18569_/Q _09483_/A2 VSS VSS VSS VSS gf180mcu_fd_sc_mcu9t5v0__oai22_4
XTAP_TAPCELL_ROW_285_6911 VSS VSS gf180mcu_fd_sc_mcu9t5v0__filltie
XTAP_TAPCELL_ROW_285_6900 VSS VSS gf180mcu_fd_sc_mcu9t5v0__filltie
XTAP_TAPCELL_ROW_99_3694 VSS VSS gf180mcu_fd_sc_mcu9t5v0__filltie
XTAP_TAPCELL_ROW_281_6808 VSS VSS gf180mcu_fd_sc_mcu9t5v0__filltie
XTAP_TAPCELL_ROW_266_6398 VSS VSS gf180mcu_fd_sc_mcu9t5v0__filltie
XTAP_TAPCELL_ROW_266_6387 VSS VSS gf180mcu_fd_sc_mcu9t5v0__filltie
XTAP_TAPCELL_ROW_266_6376 VSS VSS gf180mcu_fd_sc_mcu9t5v0__filltie
XTAP_TAPCELL_ROW_279_6737 VSS VSS gf180mcu_fd_sc_mcu9t5v0__filltie
XTAP_TAPCELL_ROW_279_6748 VSS VSS gf180mcu_fd_sc_mcu9t5v0__filltie
XTAP_TAPCELL_ROW_106_3908 VSS VSS gf180mcu_fd_sc_mcu9t5v0__filltie
X_20007_ _20007_/D _20071_/RN _20049_/CLK _20007_/Q VSS VSS VSS VSS gf180mcu_fd_sc_mcu9t5v0__dffrnq_1
X_09818_ _09818_/I _10783_/A1 VSS _17909_/VNW VSS VSS gf180mcu_fd_sc_mcu9t5v0__clkinv_1
X_09749_ _20016_/Q _15850_/A2 _09749_/B _09750_/I VSS VSS VSS VSS gf180mcu_fd_sc_mcu9t5v0__aoi21_1
XPHY_EDGE_ROW_183_3_Left_841 VSS VSS gf180mcu_fd_sc_mcu9t5v0__endcap
XTAP_TAPCELL_ROW_48_2303 VSS VSS gf180mcu_fd_sc_mcu9t5v0__filltie
XTAP_TAPCELL_ROW_48_2314 VSS VSS gf180mcu_fd_sc_mcu9t5v0__filltie
X_12760_ _13304_/B _12761_/B _12758_/Z _12760_/B _19199_/D VSS VSS VSS VSS gf180mcu_fd_sc_mcu9t5v0__oai31_1
X_11711_ _18219_/Q _12315_/S _12322_/B _11714_/A2 VSS VSS VSS VSS gf180mcu_fd_sc_mcu9t5v0__aoi21_1
X_12691_ _12724_/C _17479_/A2 VSS VSS VSS VSS gf180mcu_fd_sc_mcu9t5v0__clkinv_1
XTAP_TAPCELL_ROW_251_5977 VSS VSS gf180mcu_fd_sc_mcu9t5v0__filltie
XTAP_TAPCELL_ROW_251_5966 VSS VSS gf180mcu_fd_sc_mcu9t5v0__filltie
X_11642_ _12632_/C _11667_/B1 _12665_/B _11643_/B2 VSS _11664_/VNW VSS VSS gf180mcu_fd_sc_mcu9t5v0__aoi21_1
X_14430_ _19154_/Q _19120_/Q _14699_/B VSS VSS VSS VSS gf180mcu_fd_sc_mcu9t5v0__nor2_1
X_14361_ _13904_/Z _19431_/Q _14367_/S _19431_/D VSS VSS VSS VSS gf180mcu_fd_sc_mcu9t5v0__mux2_1
X_16100_ _19243_/Q _16751_/A2 wire71/Z _16102_/A3 VSS VSS VSS VSS gf180mcu_fd_sc_mcu9t5v0__nor3_1
X_11573_ _11573_/A1 _11573_/A2 _11573_/B1 _11573_/B2 _12116_/C _11574_/A3 VSS VSS
+ VSS VSS gf180mcu_fd_sc_mcu9t5v0__aoi221_4
X_13312_ _13313_/A1 _13313_/A2 _13594_/B _13333_/A1 VSS _13595_/VNW VSS VSS gf180mcu_fd_sc_mcu9t5v0__oai21_1
X_10524_ _18597_/Q _17306_/C _10524_/B _10648_/C _10525_/A3 VSS VSS VSS VSS gf180mcu_fd_sc_mcu9t5v0__aoi211_1
X_17080_ _19826_/Q _17080_/A2 _17080_/A3 _17080_/B _17089_/A2 VSS VSS VSS VSS gf180mcu_fd_sc_mcu9t5v0__oai31_1
XTAP_TAPCELL_ROW_20_1521 VSS VSS gf180mcu_fd_sc_mcu9t5v0__filltie
X_14292_ _14359_/I0 _19365_/Q _14304_/S _19365_/D VSS VSS VSS VSS gf180mcu_fd_sc_mcu9t5v0__mux2_1
XTAP_TAPCELL_ROW_20_1532 VSS VSS gf180mcu_fd_sc_mcu9t5v0__filltie
XTAP_TAPCELL_ROW_20_1543 VSS VSS gf180mcu_fd_sc_mcu9t5v0__filltie
X_16031_ _19232_/Q _16744_/A2 wire71/I _16032_/A3 VSS VSS VSS VSS gf180mcu_fd_sc_mcu9t5v0__nor3_1
X_10455_ _17358_/A1 _18257_/Q _10457_/A3 VSS VSS VSS VSS gf180mcu_fd_sc_mcu9t5v0__nor2_1
X_13243_ _13574_/A2 _13576_/B _13261_/A2 VSS _13243_/VNW VSS VSS gf180mcu_fd_sc_mcu9t5v0__nand2_1
X_13174_ _13183_/A1 _13171_/Z _13561_/A1 VSS VSS VSS VSS gf180mcu_fd_sc_mcu9t5v0__nand2_1
X_10386_ _20083_/Q wire168/I _10386_/B1 _10386_/B2 _17409_/B _10389_/B1 VSS VSS VSS
+ VSS gf180mcu_fd_sc_mcu9t5v0__oai221_1
X_12125_ _14495_/A2 _12311_/B _12125_/B1 _12125_/B2 _19128_/D VSS VSS VSS VSS gf180mcu_fd_sc_mcu9t5v0__aoi22_1
X_17982_ _18869_/Q _18032_/I0 wire128/Z _18869_/D VSS _17982_/VNW VSS VSS gf180mcu_fd_sc_mcu9t5v0__mux2_1
X_16933_ _16933_/A1 _16933_/A2 _16934_/I0 VSS VSS VSS VSS gf180mcu_fd_sc_mcu9t5v0__nand2_1
X_12056_ _18723_/Q _12527_/A2 _12073_/A1 VSS VSS VSS VSS gf180mcu_fd_sc_mcu9t5v0__nand2_1
XTAP_TAPCELL_ROW_18_1472 VSS VSS gf180mcu_fd_sc_mcu9t5v0__filltie
XTAP_TAPCELL_ROW_18_1483 VSS VSS gf180mcu_fd_sc_mcu9t5v0__filltie
X_19721_ _19721_/D _20041_/RN clkload9/I _19721_/Q VSS VSS VSS VSS gf180mcu_fd_sc_mcu9t5v0__dffrnq_1
X_16864_ _18424_/Q _16863_/Z _16864_/S _18424_/D VSS VSS VSS VSS gf180mcu_fd_sc_mcu9t5v0__mux2_1
X_11007_ _11007_/I _18053_/A2 VSS VSS VSS VSS gf180mcu_fd_sc_mcu9t5v0__clkinv_1
XTAP_TAPCELL_ROW_14_1358 VSS VSS gf180mcu_fd_sc_mcu9t5v0__filltie
X_19652_ _19652_/D _20036_/RN clkload24/I _19652_/Q VSS VSS VSS VSS gf180mcu_fd_sc_mcu9t5v0__dffrnq_1
X_18603_ _18603_/D clkload59/I _18603_/Q VSS VSS VSS VSS gf180mcu_fd_sc_mcu9t5v0__dffq_1
X_15815_ input4/Z _19984_/Q _15819_/S _19984_/D VSS VSS VSS VSS gf180mcu_fd_sc_mcu9t5v0__mux2_1
XTAP_TAPCELL_ROW_14_1369 VSS VSS gf180mcu_fd_sc_mcu9t5v0__filltie
X_16795_ _19279_/Q _16592_/B _16949_/S _16795_/Z VSS VSS VSS VSS gf180mcu_fd_sc_mcu9t5v0__mux2_1
X_19583_ _19583_/D _20031_/RN clkload7/I _19583_/Q VSS VSS VSS VSS gf180mcu_fd_sc_mcu9t5v0__dffrnq_1
XTAP_TAPCELL_ROW_289_7022 VSS VSS gf180mcu_fd_sc_mcu9t5v0__filltie
XTAP_TAPCELL_ROW_289_7011 VSS VSS gf180mcu_fd_sc_mcu9t5v0__filltie
X_18534_ _18534_/D clkload82/I _18534_/Q VSS VSS VSS VSS gf180mcu_fd_sc_mcu9t5v0__dffq_1
X_15746_ _19999_/Q _15746_/A2 _15747_/B VSS _15755_/VNW VSS VSS gf180mcu_fd_sc_mcu9t5v0__nand2_1
XPHY_EDGE_ROW_204_1_Right_788 VSS VSS gf180mcu_fd_sc_mcu9t5v0__endcap
X_12958_ _19751_/Q _12958_/A2 _12983_/A1 VSS _12958_/VNW VSS VSS gf180mcu_fd_sc_mcu9t5v0__nand2_1
X_18465_ _18465_/D clkload73/I _18465_/Q VSS VSS VSS VSS gf180mcu_fd_sc_mcu9t5v0__dffq_1
X_11909_ _11909_/A1 _11909_/A2 _12237_/B _11924_/A1 VSS VSS VSS VSS gf180mcu_fd_sc_mcu9t5v0__oai21_4
X_15677_ _19912_/Q _15678_/A2 _15677_/B _15678_/B VSS VSS VSS VSS gf180mcu_fd_sc_mcu9t5v0__oai21_1
XTAP_TAPCELL_ROW_27_1719 VSS VSS gf180mcu_fd_sc_mcu9t5v0__filltie
X_12889_ _12889_/A1 _12889_/A2 _12889_/B _12889_/C _12891_/A3 VSS VSS VSS VSS gf180mcu_fd_sc_mcu9t5v0__aoi211_1
X_18396_ _18396_/D clkload61/I _18396_/Q VSS VSS VSS VSS gf180mcu_fd_sc_mcu9t5v0__dffq_1
X_17416_ _17416_/I0 _18555_/Q _17420_/S _18555_/D VSS VSS VSS VSS gf180mcu_fd_sc_mcu9t5v0__mux2_1
X_14628_ _19090_/Q _19506_/Q _14730_/S _19506_/D VSS VSS VSS VSS gf180mcu_fd_sc_mcu9t5v0__mux2_1
X_17347_ _20135_/Q _17407_/C _17408_/B _17347_/C _17350_/A1 VSS VSS VSS VSS gf180mcu_fd_sc_mcu9t5v0__aoi211_1
XPHY_EDGE_ROW_220_Right_147 VSS VSS gf180mcu_fd_sc_mcu9t5v0__endcap
X_14559_ _14560_/A1 _19135_/Q _14562_/A2 VSS VSS VSS VSS gf180mcu_fd_sc_mcu9t5v0__nand2_1
X_17278_ _18418_/Q _17282_/A2 _17282_/B1 _18434_/Q _17278_/C _17279_/B2 VSS _17278_/VNW
+ VSS VSS gf180mcu_fd_sc_mcu9t5v0__aoi221_1
X_16229_ _16228_/Z _18199_/Q _16782_/S _18199_/D VSS _16229_/VNW VSS VSS gf180mcu_fd_sc_mcu9t5v0__mux2_1
XTAP_TAPCELL_ROW_94_3580 VSS VSS gf180mcu_fd_sc_mcu9t5v0__filltie
X_19017_ _19017_/D _20041_/RN clkload44/I _19017_/Q VSS VSS VSS VSS gf180mcu_fd_sc_mcu9t5v0__dffrnq_1
XTAP_TAPCELL_ROW_261_6251 VSS VSS gf180mcu_fd_sc_mcu9t5v0__filltie
XTAP_TAPCELL_ROW_261_6240 VSS VSS gf180mcu_fd_sc_mcu9t5v0__filltie
XTAP_TAPCELL_ROW_90_3466 VSS VSS gf180mcu_fd_sc_mcu9t5v0__filltie
XTAP_TAPCELL_ROW_90_3455 VSS VSS gf180mcu_fd_sc_mcu9t5v0__filltie
XTAP_TAPCELL_ROW_90_3444 VSS VSS gf180mcu_fd_sc_mcu9t5v0__filltie
X_19919_ _19919_/D _20047_/RN _20049_/CLK _19919_/Q VSS VSS VSS VSS gf180mcu_fd_sc_mcu9t5v0__dffrnq_1
XTAP_TAPCELL_ROW_274_6612 VSS VSS gf180mcu_fd_sc_mcu9t5v0__filltie
XTAP_TAPCELL_ROW_274_6601 VSS VSS gf180mcu_fd_sc_mcu9t5v0__filltie
XTAP_TAPCELL_ROW_259_6191 VSS VSS gf180mcu_fd_sc_mcu9t5v0__filltie
XTAP_TAPCELL_ROW_259_6180 VSS VSS gf180mcu_fd_sc_mcu9t5v0__filltie
X_09603_ _10843_/A1 _09451_/Z _09604_/I VSS _15821_/VNW VSS VSS gf180mcu_fd_sc_mcu9t5v0__or2_1
XTAP_TAPCELL_ROW_88_3395 VSS VSS gf180mcu_fd_sc_mcu9t5v0__filltie
XTAP_TAPCELL_ROW_270_6509 VSS VSS gf180mcu_fd_sc_mcu9t5v0__filltie
XTAP_TAPCELL_ROW_255_6077 VSS VSS gf180mcu_fd_sc_mcu9t5v0__filltie
XTAP_TAPCELL_ROW_255_6088 VSS VSS gf180mcu_fd_sc_mcu9t5v0__filltie
X_09534_ _20020_/Q _20139_/Q _20138_/Q _20022_/Q _09538_/A1 VSS VSS VSS VSS gf180mcu_fd_sc_mcu9t5v0__nor4_1
XTAP_TAPCELL_ROW_4_1081 VSS VSS gf180mcu_fd_sc_mcu9t5v0__filltie
XTAP_TAPCELL_ROW_4_1092 VSS VSS gf180mcu_fd_sc_mcu9t5v0__filltie
X_09465_ _19069_/Q _19070_/Q _09465_/A3 _09496_/B VSS VSS VSS VSS gf180mcu_fd_sc_mcu9t5v0__nand3_1
XTAP_TAPCELL_ROW_268_6449 VSS VSS gf180mcu_fd_sc_mcu9t5v0__filltie
XTAP_TAPCELL_ROW_268_6438 VSS VSS gf180mcu_fd_sc_mcu9t5v0__filltie
XTAP_TAPCELL_ROW_268_6427 VSS VSS gf180mcu_fd_sc_mcu9t5v0__filltie
X_09396_ _09916_/B _20043_/Q wire216/I VSS VSS VSS VSS gf180mcu_fd_sc_mcu9t5v0__nor2_4
Xu_transform_scheduler_core.u_fft_scratch_sram.u_lo.g_pin_drive\[3\].u_data_driver
+ eco5_buf_10340/Z u_transform_scheduler_core.u_fft_scratch_sram.u_lo.u_sram/D[3]
+ VSS VSS VSS VSS gf180mcu_fd_sc_mcu9t5v0__buf_8
XTAP_TAPCELL_ROW_37_2004 VSS VSS gf180mcu_fd_sc_mcu9t5v0__filltie
X_10240_ _10516_/C _17255_/B1 _17409_/B VSS VSS VSS VSS gf180mcu_fd_sc_mcu9t5v0__nand2_2
XTAP_TAPCELL_ROW_244_5792 VSS VSS gf180mcu_fd_sc_mcu9t5v0__filltie
XTAP_TAPCELL_ROW_244_5781 VSS VSS gf180mcu_fd_sc_mcu9t5v0__filltie
X_10171_ _18970_/Q _09898_/C wire297/Z _18994_/Q _10173_/A2 VSS _10174_/VNW VSS VSS
+ gf180mcu_fd_sc_mcu9t5v0__aoi22_1
XTAP_TAPCELL_ROW_244_5770 VSS VSS gf180mcu_fd_sc_mcu9t5v0__filltie
XTAP_TAPCELL_ROW_73_2996 VSS VSS gf180mcu_fd_sc_mcu9t5v0__filltie
XTAP_TAPCELL_ROW_73_2985 VSS VSS gf180mcu_fd_sc_mcu9t5v0__filltie
XTAP_TAPCELL_ROW_240_5667 VSS VSS gf180mcu_fd_sc_mcu9t5v0__filltie
XPHY_EDGE_ROW_110_Right_110 VSS VSS gf180mcu_fd_sc_mcu9t5v0__endcap
XTAP_TAPCELL_ROW_240_5678 VSS VSS gf180mcu_fd_sc_mcu9t5v0__filltie
X_13930_ _19294_/Q _19322_/Q _13934_/A2 VSS _13930_/VNW VSS VSS gf180mcu_fd_sc_mcu9t5v0__nand2_1
Xclkbuf_leaf_49_clk_regs clkload5/I clkload71/I VSS VSS VSS VSS gf180mcu_fd_sc_mcu9t5v0__clkbuf_8
X_15600_ _18560_/Q _15608_/A1 _15657_/B VSS VSS VSS VSS gf180mcu_fd_sc_mcu9t5v0__nand2_1
X_13861_ _13861_/A1 _13872_/A1 _13858_/Z _13863_/A2 VSS VSS VSS VSS gf180mcu_fd_sc_mcu9t5v0__xnor3_1
XPHY_EDGE_ROW_322_Right_249 VSS VSS gf180mcu_fd_sc_mcu9t5v0__endcap
X_16580_ _19278_/Q _15996_/B _16586_/B VSS _17153_/VNW VSS VSS gf180mcu_fd_sc_mcu9t5v0__nand2_1
X_12812_ _12809_/I _12812_/A2 _12813_/I0 VSS _13139_/VNW VSS VSS gf180mcu_fd_sc_mcu9t5v0__xnor2_1
X_13792_ _13803_/B2 _13795_/A3 _13810_/A1 VSS VSS VSS VSS gf180mcu_fd_sc_mcu9t5v0__nand2_1
X_15531_ _19849_/Q _19832_/Q _15544_/S _19849_/D VSS VSS VSS VSS gf180mcu_fd_sc_mcu9t5v0__mux2_1
X_12743_ _19751_/Q _12737_/Z _12740_/Z _12744_/I0 VSS VSS VSS VSS gf180mcu_fd_sc_mcu9t5v0__xnor3_1
X_15462_ _17231_/B _15462_/A2 _15463_/A2 _15464_/A2 VSS VSS VSS VSS gf180mcu_fd_sc_mcu9t5v0__nand3_1
X_18250_ _18250_/D clkload52/I _18250_/Q VSS VSS VSS VSS gf180mcu_fd_sc_mcu9t5v0__dffq_1
X_17201_ _20128_/Q _17177_/B _17408_/B _17201_/C _17203_/A2 VSS _17201_/VNW VSS VSS
+ gf180mcu_fd_sc_mcu9t5v0__aoi211_1
X_12674_ _12716_/S _12716_/I0 _12677_/B VSS VSS VSS VSS gf180mcu_fd_sc_mcu9t5v0__nand2_1
X_14413_ wire199/Z _14413_/A2 _14414_/C VSS VSS VSS VSS gf180mcu_fd_sc_mcu9t5v0__nand2_1
X_18181_ _18181_/D clkload68/I _18181_/Q VSS VSS VSS VSS gf180mcu_fd_sc_mcu9t5v0__dffq_4
X_15393_ _19678_/Q _19778_/Q _15420_/S _19778_/D VSS VSS VSS VSS gf180mcu_fd_sc_mcu9t5v0__mux2_1
X_11625_ _12632_/C _12632_/A1 _12649_/A3 _11626_/B VSS VSS VSS VSS gf180mcu_fd_sc_mcu9t5v0__nand3_1
X_17132_ _18411_/Q _17380_/A2 _17380_/B1 _18427_/Q _17133_/B VSS _17132_/VNW VSS VSS
+ gf180mcu_fd_sc_mcu9t5v0__aoi22_1
X_11556_ _18564_/Q _18565_/Q _11558_/B VSS VSS VSS VSS gf180mcu_fd_sc_mcu9t5v0__xnor2_1
X_14344_ _14359_/I0 _19415_/Q _14352_/S _19415_/D VSS VSS VSS VSS gf180mcu_fd_sc_mcu9t5v0__mux2_1
X_17063_ _18525_/Q _16599_/B _17067_/S _18525_/D VSS VSS VSS VSS gf180mcu_fd_sc_mcu9t5v0__mux2_4
X_10507_ _18997_/Q _10654_/A2 _10507_/B wire160/Z _10527_/A1 VSS _10507_/VNW VSS VSS
+ gf180mcu_fd_sc_mcu9t5v0__oai211_1
X_14275_ _13904_/Z _19349_/Q _14285_/S _19349_/D VSS VSS VSS VSS gf180mcu_fd_sc_mcu9t5v0__mux2_1
X_11487_ _11526_/B _11487_/A2 _11487_/B _11488_/A2 VSS VSS VSS VSS gf180mcu_fd_sc_mcu9t5v0__oai21_2
X_16014_ _18675_/Q _18772_/Q _16619_/S _16014_/Z VSS _16014_/VNW VSS VSS gf180mcu_fd_sc_mcu9t5v0__mux2_1
X_13226_ _13497_/A1 _13225_/Z _13497_/B _13227_/B2 VSS _13226_/VNW VSS VSS gf180mcu_fd_sc_mcu9t5v0__aoi21_1
X_10438_ _20100_/Q _17407_/C _10439_/B VSS _10438_/VNW VSS VSS gf180mcu_fd_sc_mcu9t5v0__nand2_1
X_10369_ _18670_/Q _10821_/B _10389_/A2 VSS VSS VSS VSS gf180mcu_fd_sc_mcu9t5v0__nand2_1
X_13157_ _19729_/Q _13155_/I _13158_/I VSS _13161_/VNW VSS VSS gf180mcu_fd_sc_mcu9t5v0__xor2_1
XTAP_TAPCELL_ROW_16_1409 VSS VSS gf180mcu_fd_sc_mcu9t5v0__filltie
X_12108_ _18429_/Q _12203_/A2 _12112_/A1 VSS _17172_/VNW VSS VSS gf180mcu_fd_sc_mcu9t5v0__nand2_1
X_13088_ _13088_/A1 _19757_/Q _13106_/A1 _13089_/A2 VSS VSS VSS VSS gf180mcu_fd_sc_mcu9t5v0__xnor3_1
X_17965_ _18857_/Q _17885_/S _17966_/A2 VSS _17965_/VNW VSS VSS gf180mcu_fd_sc_mcu9t5v0__nand2_1
X_16916_ _16915_/Z _18450_/Q _16928_/S _18450_/D VSS VSS VSS VSS gf180mcu_fd_sc_mcu9t5v0__mux2_1
X_12039_ _18378_/Q _12090_/B _12040_/A2 VSS VSS VSS VSS gf180mcu_fd_sc_mcu9t5v0__nand2_1
X_19704_ _19704_/D _19960_/RN clkload27/I _19704_/Q VSS VSS VSS VSS gf180mcu_fd_sc_mcu9t5v0__dffrnq_1
X_17896_ _17913_/A1 _17926_/A1 _17901_/A2 VSS VSS VSS VSS gf180mcu_fd_sc_mcu9t5v0__nand2_1
X_16847_ _19251_/Q _16622_/B _16861_/S _16847_/Z VSS _17009_/VNW VSS VSS gf180mcu_fd_sc_mcu9t5v0__mux2_1
X_19635_ _19635_/D _20019_/RN clkload21/I _19635_/Q VSS VSS VSS VSS gf180mcu_fd_sc_mcu9t5v0__dffrnq_1
X_16778_ _16777_/Z _18388_/Q _16784_/S _18388_/D VSS VSS VSS VSS gf180mcu_fd_sc_mcu9t5v0__mux2_1
XTAP_TAPCELL_ROW_83_3270 VSS VSS gf180mcu_fd_sc_mcu9t5v0__filltie
X_19566_ _19566_/D _20142_/RN clkload7/I _19566_/Q VSS VSS VSS VSS gf180mcu_fd_sc_mcu9t5v0__dffrnq_1
X_18517_ _18517_/D clkload79/I _18517_/Q VSS VSS VSS VSS gf180mcu_fd_sc_mcu9t5v0__dffq_1
Xu_transform_scheduler_core.u_fft_scratch_sram.u_hi.g_pin_drive\[5\].u_data_driver
+ _10604_/ZN u_transform_scheduler_core.u_fft_scratch_sram.u_hi.u_sram/D[5] VSS VSS
+ VSS VSS gf180mcu_fd_sc_mcu9t5v0__buf_8
X_15729_ _15729_/A1 _15729_/A2 _19923_/D VSS _15729_/VNW VSS VSS gf180mcu_fd_sc_mcu9t5v0__nor2_1
XPHY_EDGE_ROW_205_1_Right_789 VSS VSS gf180mcu_fd_sc_mcu9t5v0__endcap
X_19497_ _19497_/D _20073_/RN clkload36/I _19497_/Q VSS VSS VSS VSS gf180mcu_fd_sc_mcu9t5v0__dffrnq_1
X_09250_ _18837_/Q _17900_/A1 VSS _17900_/VNW VSS VSS gf180mcu_fd_sc_mcu9t5v0__clkinv_1
X_18448_ _18448_/D _20099_/CLK _18448_/Q VSS VSS VSS VSS gf180mcu_fd_sc_mcu9t5v0__dffq_1
X_18379_ _18379_/D clkload62/I _18379_/Q VSS VSS VSS VSS gf180mcu_fd_sc_mcu9t5v0__dffq_1
XTAP_TAPCELL_ROW_172_1_4756 VSS VSS gf180mcu_fd_sc_mcu9t5v0__filltie
XTAP_TAPCELL_ROW_96_3631 VSS VSS gf180mcu_fd_sc_mcu9t5v0__filltie
XTAP_TAPCELL_ROW_96_3620 VSS VSS gf180mcu_fd_sc_mcu9t5v0__filltie
X_09181_ _19119_/Q _14417_/A2 VSS VSS VSS VSS gf180mcu_fd_sc_mcu9t5v0__clkinv_1
XTAP_TAPCELL_ROW_263_6302 VSS VSS gf180mcu_fd_sc_mcu9t5v0__filltie
XTAP_TAPCELL_ROW_92_3517 VSS VSS gf180mcu_fd_sc_mcu9t5v0__filltie
XTAP_TAPCELL_ROW_92_3506 VSS VSS gf180mcu_fd_sc_mcu9t5v0__filltie
XTAP_TAPCELL_ROW_263_6313 VSS VSS gf180mcu_fd_sc_mcu9t5v0__filltie
XTAP_TAPCELL_ROW_77_3096 VSS VSS gf180mcu_fd_sc_mcu9t5v0__filltie
XTAP_TAPCELL_ROW_257_6128 VSS VSS gf180mcu_fd_sc_mcu9t5v0__filltie
XTAP_TAPCELL_ROW_257_6139 VSS VSS gf180mcu_fd_sc_mcu9t5v0__filltie
XTAP_TAPCELL_ROW_6_1143 VSS VSS gf180mcu_fd_sc_mcu9t5v0__filltie
XTAP_TAPCELL_ROW_6_1154 VSS VSS gf180mcu_fd_sc_mcu9t5v0__filltie
X_09517_ _09517_/I _17747_/A4 VSS VSS VSS VSS gf180mcu_fd_sc_mcu9t5v0__clkinv_1
XTAP_TAPCELL_ROW_2_1029 VSS VSS gf180mcu_fd_sc_mcu9t5v0__filltie
XTAP_TAPCELL_ROW_233_5471 VSS VSS gf180mcu_fd_sc_mcu9t5v0__filltie
X_09448_ _20055_/Q _09889_/A2 _09448_/B _09617_/A1 VSS VSS VSS VSS gf180mcu_fd_sc_mcu9t5v0__oai21_1
XTAP_TAPCELL_ROW_62_2675 VSS VSS gf180mcu_fd_sc_mcu9t5v0__filltie
XTAP_TAPCELL_ROW_62_2686 VSS VSS gf180mcu_fd_sc_mcu9t5v0__filltie
XTAP_TAPCELL_ROW_233_5482 VSS VSS gf180mcu_fd_sc_mcu9t5v0__filltie
X_09379_ _18898_/Q _11838_/A1 VSS VSS VSS VSS gf180mcu_fd_sc_mcu9t5v0__clkinv_1
XTAP_TAPCELL_ROW_62_2697 VSS VSS gf180mcu_fd_sc_mcu9t5v0__filltie
X_12390_ _18253_/Q _12607_/A2 _12392_/B1 VSS _12390_/VNW VSS VSS gf180mcu_fd_sc_mcu9t5v0__nor2_1
X_11410_ _19096_/Q _11423_/A1 _11423_/B VSS _11421_/VNW VSS VSS gf180mcu_fd_sc_mcu9t5v0__nand2_1
X_11341_ _19091_/Q _11423_/A1 _11354_/B VSS VSS VSS VSS gf180mcu_fd_sc_mcu9t5v0__nand2_1
XTAP_TAPCELL_ROW_246_5843 VSS VSS gf180mcu_fd_sc_mcu9t5v0__filltie
XTAP_TAPCELL_ROW_246_5832 VSS VSS gf180mcu_fd_sc_mcu9t5v0__filltie
X_11272_ _18261_/Q _11509_/A2 _11274_/A1 VSS VSS VSS VSS gf180mcu_fd_sc_mcu9t5v0__nor2_1
XTAP_TAPCELL_ROW_242_5718 VSS VSS gf180mcu_fd_sc_mcu9t5v0__filltie
X_14060_ _14061_/A2 _14061_/A3 _14060_/Z VSS VSS VSS VSS gf180mcu_fd_sc_mcu9t5v0__or2_1
X_10223_ _10543_/C _19827_/Q _10643_/B2 VSS VSS VSS VSS gf180mcu_fd_sc_mcu9t5v0__nor2_2
XTAP_TAPCELL_ROW_242_5729 VSS VSS gf180mcu_fd_sc_mcu9t5v0__filltie
X_13011_ _13011_/I0 _19231_/Q _13304_/B _19231_/D VSS VSS VSS VSS gf180mcu_fd_sc_mcu9t5v0__mux2_1
X_10154_ _18797_/Q _10154_/A2 _10154_/B _10155_/A3 VSS VSS VSS VSS gf180mcu_fd_sc_mcu9t5v0__oai21_1
X_17750_ _18747_/Q _18751_/Q _17753_/S _18751_/D VSS VSS VSS VSS gf180mcu_fd_sc_mcu9t5v0__mux2_1
X_14962_ _20039_/D _14962_/A2 _14962_/B _19615_/D VSS _14962_/VNW VSS VSS gf180mcu_fd_sc_mcu9t5v0__aoi21_1
X_10085_ _10180_/B1 _10085_/A2 _10085_/A3 _10088_/A1 VSS VSS VSS VSS gf180mcu_fd_sc_mcu9t5v0__nand3_1
X_16701_ _16730_/A1 _16606_/B _16701_/B _16730_/C _16703_/A3 VSS VSS VSS VSS gf180mcu_fd_sc_mcu9t5v0__aoi211_1
X_17681_ _18644_/Q _18720_/Q _17681_/S _18720_/D VSS VSS VSS VSS gf180mcu_fd_sc_mcu9t5v0__mux2_1
X_14893_ _19415_/Q _19356_/Q _14896_/A1 _14894_/I1 VSS VSS VSS VSS gf180mcu_fd_sc_mcu9t5v0__xnor3_1
X_13913_ _19317_/Q _19300_/Q _13955_/A1 VSS VSS VSS VSS gf180mcu_fd_sc_mcu9t5v0__nand2_1
X_16632_ _19285_/Q _16675_/A1 _16636_/B VSS VSS VSS VSS gf180mcu_fd_sc_mcu9t5v0__nand2_1
X_13844_ _13846_/A2 _13846_/A3 _13871_/B VSS VSS VSS VSS gf180mcu_fd_sc_mcu9t5v0__nand2_1
X_19420_ _19420_/D _20060_/RN clkload8/I _19420_/Q VSS VSS VSS VSS gf180mcu_fd_sc_mcu9t5v0__dffrnq_1
X_19351_ _19351_/D _20055_/RN clkload7/I _19351_/Q VSS VSS VSS VSS gf180mcu_fd_sc_mcu9t5v0__dffrnq_1
X_18302_ _18302_/D _18497_/CLK _18302_/Q VSS VSS VSS VSS gf180mcu_fd_sc_mcu9t5v0__dffq_4
X_16563_ _17765_/A1 _16563_/I1 _16619_/S _16563_/Z VSS _16563_/VNW VSS VSS gf180mcu_fd_sc_mcu9t5v0__mux2_1
XPHY_EDGE_ROW_146_3_Left_804 VSS VSS gf180mcu_fd_sc_mcu9t5v0__endcap
X_10987_ _10987_/I _10992_/A1 VSS VSS VSS VSS gf180mcu_fd_sc_mcu9t5v0__clkinv_1
X_13775_ _19292_/Q _19319_/Q _13823_/A1 VSS VSS VSS VSS gf180mcu_fd_sc_mcu9t5v0__nand2_1
X_16494_ _18304_/Q _16493_/Z _17020_/S _18304_/D VSS _16494_/VNW VSS VSS gf180mcu_fd_sc_mcu9t5v0__mux2_4
X_15514_ _19842_/Q _15515_/A2 _15516_/A2 VSS _15514_/VNW VSS VSS gf180mcu_fd_sc_mcu9t5v0__nor2_1
X_12726_ _12726_/A1 _12726_/A2 _19191_/D VSS _12726_/VNW VSS VSS gf180mcu_fd_sc_mcu9t5v0__nor2_1
X_19282_ _19282_/D _20050_/RN clkload26/I _19282_/Q VSS VSS VSS VSS gf180mcu_fd_sc_mcu9t5v0__dffrnq_1
X_15445_ _15470_/A1 _15462_/A2 _15445_/B _19817_/D VSS VSS VSS VSS gf180mcu_fd_sc_mcu9t5v0__oai21_1
X_18233_ _18233_/D clkload63/I _18233_/Q VSS VSS VSS VSS gf180mcu_fd_sc_mcu9t5v0__dffq_1
X_12657_ _11632_/B _12658_/A2 _12676_/A2 VSS _12710_/VNW VSS VSS gf180mcu_fd_sc_mcu9t5v0__nor2_1
X_18164_ _18164_/D clkload78/I _18164_/Q VSS VSS VSS VSS gf180mcu_fd_sc_mcu9t5v0__dffq_1
X_15376_ _19661_/Q _19761_/Q _15420_/S _19761_/D VSS VSS VSS VSS gf180mcu_fd_sc_mcu9t5v0__mux2_1
X_11608_ _11590_/Z _12672_/A2 _12680_/A2 VSS _12651_/VNW VSS VSS gf180mcu_fd_sc_mcu9t5v0__nor2_1
X_17115_ _20109_/Q _17408_/B _17159_/B _17115_/C _17117_/B1 VSS VSS VSS VSS gf180mcu_fd_sc_mcu9t5v0__aoi211_1
XPHY_EDGE_ROW_208_3_Left_866 VSS VSS gf180mcu_fd_sc_mcu9t5v0__endcap
XTAP_TAPCELL_ROW_212_4887 VSS VSS gf180mcu_fd_sc_mcu9t5v0__filltie
X_12588_ _12620_/A1 _12620_/A2 _12588_/A3 _12588_/B _19169_/D VSS VSS VSS VSS gf180mcu_fd_sc_mcu9t5v0__oai31_1
XTAP_TAPCELL_ROW_130_4554 VSS VSS gf180mcu_fd_sc_mcu9t5v0__filltie
X_14327_ _14357_/I0 _19399_/Q _14337_/S _19399_/D VSS VSS VSS VSS gf180mcu_fd_sc_mcu9t5v0__mux2_1
X_11539_ _11538_/B _11539_/A2 _11539_/B1 _11539_/B2 _11788_/B _11540_/B2 VSS VSS VSS
+ VSS gf180mcu_fd_sc_mcu9t5v0__aoi221_4
Xmax_cap115 _15544_/S _15551_/S VSS VSS VSS VSS gf180mcu_fd_sc_mcu9t5v0__buf_4
XTAP_TAPCELL_ROW_212_4898 VSS VSS gf180mcu_fd_sc_mcu9t5v0__filltie
Xmax_cap126 _18148_/S _18152_/S VSS VSS VSS VSS gf180mcu_fd_sc_mcu9t5v0__clkbuf_16
XPHY_EDGE_ROW_142_1_Left_465 VSS VSS gf180mcu_fd_sc_mcu9t5v0__endcap
XTAP_TAPCELL_ROW_130_4565 VSS VSS gf180mcu_fd_sc_mcu9t5v0__filltie
X_18095_ _18936_/Q _11018_/B _18097_/B VSS VSS VSS VSS gf180mcu_fd_sc_mcu9t5v0__nand2_1
Xmax_cap104 _12217_/B _12336_/B VSS max_cap104/VNW VSS VSS gf180mcu_fd_sc_mcu9t5v0__clkbuf_4
X_17046_ _17045_/Z _18514_/Q _17054_/S _18514_/D VSS VSS VSS VSS gf180mcu_fd_sc_mcu9t5v0__mux2_4
X_14258_ _14259_/A1 _14259_/A2 _14265_/A2 VSS VSS VSS VSS gf180mcu_fd_sc_mcu9t5v0__nor2_1
X_13209_ _13190_/Z _13209_/A2 _13566_/B _13222_/A2 VSS VSS VSS VSS gf180mcu_fd_sc_mcu9t5v0__aoi21_1
X_14189_ _14262_/A1 _14263_/A1 _14190_/I VSS _14263_/VNW VSS VSS gf180mcu_fd_sc_mcu9t5v0__and2_1
X_18997_ _18997_/D _20021_/RN clkload70/I _18997_/Q VSS VSS VSS VSS gf180mcu_fd_sc_mcu9t5v0__dffrnq_1
XTAP_TAPCELL_ROW_128_4494 VSS VSS gf180mcu_fd_sc_mcu9t5v0__filltie
XTAP_TAPCELL_ROW_85_3332 VSS VSS gf180mcu_fd_sc_mcu9t5v0__filltie
XTAP_TAPCELL_ROW_85_3321 VSS VSS gf180mcu_fd_sc_mcu9t5v0__filltie
X_17948_ _17968_/A1 _17948_/A2 _18853_/D VSS VSS VSS VSS gf180mcu_fd_sc_mcu9t5v0__nor2_1
XTAP_TAPCELL_ROW_85_3310 VSS VSS gf180mcu_fd_sc_mcu9t5v0__filltie
X_17879_ _17879_/A1 _17879_/A2 _17879_/B1 _17879_/B2 _18832_/D VSS VSS VSS VSS gf180mcu_fd_sc_mcu9t5v0__aoi22_1
XTAP_TAPCELL_ROW_252_6014 VSS VSS gf180mcu_fd_sc_mcu9t5v0__filltie
XTAP_TAPCELL_ROW_252_6003 VSS VSS gf180mcu_fd_sc_mcu9t5v0__filltie
XTAP_TAPCELL_ROW_81_3218 VSS VSS gf180mcu_fd_sc_mcu9t5v0__filltie
XTAP_TAPCELL_ROW_81_3207 VSS VSS gf180mcu_fd_sc_mcu9t5v0__filltie
X_19618_ _19618_/D _20066_/RN clkload21/I _19618_/Q VSS VSS VSS VSS gf180mcu_fd_sc_mcu9t5v0__dffrnq_1
X_09302_ _19225_/Q _16658_/A1 VSS VSS VSS VSS gf180mcu_fd_sc_mcu9t5v0__clkinv_1
X_19549_ _19549_/D _20061_/RN clkload37/I _19549_/Q VSS VSS VSS VSS gf180mcu_fd_sc_mcu9t5v0__dffrnq_1
XTAP_TAPCELL_ROW_79_3158 VSS VSS gf180mcu_fd_sc_mcu9t5v0__filltie
X_09233_ _19323_/Q _14245_/A1 VSS VSS VSS VSS gf180mcu_fd_sc_mcu9t5v0__clkinv_1
XTAP_TAPCELL_ROW_79_3147 VSS VSS gf180mcu_fd_sc_mcu9t5v0__filltie
X_09164_ _19812_/Q _13439_/A2 VSS VSS VSS VSS gf180mcu_fd_sc_mcu9t5v0__clkinv_1
XPHY_EDGE_ROW_192_3_Left_850 VSS VSS gf180mcu_fd_sc_mcu9t5v0__endcap
X_09095_ _18832_/Q _17879_/B2 VSS VSS VSS VSS gf180mcu_fd_sc_mcu9t5v0__clkinv_1
XTAP_TAPCELL_ROW_70_2911 VSS VSS gf180mcu_fd_sc_mcu9t5v0__filltie
XTAP_TAPCELL_ROW_70_2900 VSS VSS gf180mcu_fd_sc_mcu9t5v0__filltie
Xu_transform_scheduler_core.u_fft_scratch_sram.u_hi.g_pin_drive\[0\].u_addr_driver
+ _10662_/Z u_transform_scheduler_core.u_fft_scratch_sram.u_hi.u_sram/A[0] VSS VSS
+ VSS VSS gf180mcu_fd_sc_mcu9t5v0__buf_8
XTAP_TAPCELL_ROW_55_2490 VSS VSS gf180mcu_fd_sc_mcu9t5v0__filltie
X_09997_ _19230_/Q _10028_/B _10004_/A1 VSS _09997_/VNW VSS VSS gf180mcu_fd_sc_mcu9t5v0__nor2_1
XTAP_TAPCELL_ROW_8_1205 VSS VSS gf180mcu_fd_sc_mcu9t5v0__filltie
XTAP_TAPCELL_ROW_222_5183 VSS VSS gf180mcu_fd_sc_mcu9t5v0__filltie
XTAP_TAPCELL_ROW_222_5172 VSS VSS gf180mcu_fd_sc_mcu9t5v0__filltie
XTAP_TAPCELL_ROW_51_2376 VSS VSS gf180mcu_fd_sc_mcu9t5v0__filltie
XTAP_TAPCELL_ROW_51_2387 VSS VSS gf180mcu_fd_sc_mcu9t5v0__filltie
XTAP_TAPCELL_ROW_8_1216 VSS VSS gf180mcu_fd_sc_mcu9t5v0__filltie
XTAP_TAPCELL_ROW_51_2398 VSS VSS gf180mcu_fd_sc_mcu9t5v0__filltie
XTAP_TAPCELL_ROW_68_2840 VSS VSS gf180mcu_fd_sc_mcu9t5v0__filltie
X_10910_ _10909_/Z _18994_/Q _18152_/S _18994_/D VSS VSS VSS VSS gf180mcu_fd_sc_mcu9t5v0__mux2_1
XTAP_TAPCELL_ROW_68_2862 VSS VSS gf180mcu_fd_sc_mcu9t5v0__filltie
XTAP_TAPCELL_ROW_68_2851 VSS VSS gf180mcu_fd_sc_mcu9t5v0__filltie
Xrst_tree_mid_2 rst_tree_root/Z rst_tree_mid_2/Z VSS VSS VSS VSS gf180mcu_fd_sc_mcu9t5v0__clkbuf_16
X_11890_ _18227_/Q _12345_/A2 _11892_/B1 VSS VSS VSS VSS gf180mcu_fd_sc_mcu9t5v0__nor2_1
XTAP_TAPCELL_ROW_235_5522 VSS VSS gf180mcu_fd_sc_mcu9t5v0__filltie
XTAP_TAPCELL_ROW_64_2737 VSS VSS gf180mcu_fd_sc_mcu9t5v0__filltie
XTAP_TAPCELL_ROW_235_5544 VSS VSS gf180mcu_fd_sc_mcu9t5v0__filltie
XTAP_TAPCELL_ROW_235_5533 VSS VSS gf180mcu_fd_sc_mcu9t5v0__filltie
X_10841_ _10841_/A1 _10841_/A2 _10842_/A3 VSS _10841_/VNW VSS VSS gf180mcu_fd_sc_mcu9t5v0__nor2_1
XTAP_TAPCELL_ROW_64_2748 VSS VSS gf180mcu_fd_sc_mcu9t5v0__filltie
X_10772_ _17195_/A1 _17225_/B _10389_/C _19823_/Q _17412_/B _10773_/B2 VSS VSS VSS
+ VSS gf180mcu_fd_sc_mcu9t5v0__aoi221_1
XTAP_TAPCELL_ROW_231_5419 VSS VSS gf180mcu_fd_sc_mcu9t5v0__filltie
X_13560_ _13561_/A1 _13561_/B _13561_/A2 _13560_/Z VSS _13562_/VNW VSS VSS gf180mcu_fd_sc_mcu9t5v0__and3_1
X_12511_ _18741_/Q _12527_/A2 _12543_/B1 _12511_/B2 _12513_/A3 VSS VSS VSS VSS gf180mcu_fd_sc_mcu9t5v0__aoi22_2
X_13491_ _19815_/Q _13491_/A2 _13496_/A1 _13645_/B VSS VSS VSS VSS gf180mcu_fd_sc_mcu9t5v0__xor3_1
X_12442_ wire146/Z _12442_/A2 _12442_/A3 _12442_/B1 _12442_/B2 wire123/I VSS VSS VSS
+ VSS gf180mcu_fd_sc_mcu9t5v0__oai32_1
X_15230_ _19596_/Q _15231_/A2 _15237_/B VSS VSS VSS VSS gf180mcu_fd_sc_mcu9t5v0__nor2_1
X_12373_ _19143_/Q _12355_/I _12380_/B VSS _12373_/VNW VSS VSS gf180mcu_fd_sc_mcu9t5v0__nand2_1
X_15161_ _19703_/Q _19543_/Q _15163_/S _19703_/D VSS VSS VSS VSS gf180mcu_fd_sc_mcu9t5v0__mux2_1
XTAP_TAPCELL_ROW_229_5359 VSS VSS gf180mcu_fd_sc_mcu9t5v0__filltie
X_14112_ _19320_/Q _19319_/Q _19301_/Q _14188_/A2 VSS _14191_/VNW VSS VSS gf180mcu_fd_sc_mcu9t5v0__nand3_1
X_11324_ _11325_/A1 _11325_/A2 _11540_/C VSS VSS VSS VSS gf180mcu_fd_sc_mcu9t5v0__and2_1
X_15092_ _15092_/A1 _15092_/A2 _15092_/B _19646_/D VSS _15092_/VNW VSS VSS gf180mcu_fd_sc_mcu9t5v0__oai21_1
X_11255_ _18869_/Q _11878_/A1 _11320_/B1 _11255_/B2 _11320_/C _11257_/A1 VSS VSS VSS
+ VSS gf180mcu_fd_sc_mcu9t5v0__oai221_1
X_14043_ _14044_/A1 _14106_/B2 _14043_/Z VSS VSS VSS VSS gf180mcu_fd_sc_mcu9t5v0__and2_1
X_18920_ _18920_/D _20072_/RN clkload31/I _18920_/Q VSS VSS VSS VSS gf180mcu_fd_sc_mcu9t5v0__dffrnq_1
X_10206_ _17378_/A1 _10514_/B _17380_/A2 VSS VSS VSS VSS gf180mcu_fd_sc_mcu9t5v0__nor2_4
Xclkbuf_leaf_64_clk_regs clkload1/I _19806_/CLK VSS _11796_/VNW VSS VSS gf180mcu_fd_sc_mcu9t5v0__clkbuf_8
X_18851_ _18851_/D _20067_/RN clkload44/I _18851_/Q VSS VSS VSS VSS gf180mcu_fd_sc_mcu9t5v0__dffrnq_1
X_11186_ _19079_/Q _11321_/A2 _11199_/B VSS _11186_/VNW VSS VSS gf180mcu_fd_sc_mcu9t5v0__nand2_1
X_10137_ _10137_/A1 _10137_/A2 _10138_/C VSS VSS VSS VSS gf180mcu_fd_sc_mcu9t5v0__nand2_1
X_17802_ wire300/Z _18780_/Q _17807_/S _18780_/D VSS VSS VSS VSS gf180mcu_fd_sc_mcu9t5v0__mux2_1
X_15994_ _17430_/A2 _15988_/B _16569_/A1 VSS VSS VSS VSS gf180mcu_fd_sc_mcu9t5v0__nor2_2
X_18782_ _18782_/D _20062_/RN clkload53/I _18782_/Q VSS VSS VSS VSS gf180mcu_fd_sc_mcu9t5v0__dffrnq_1
X_10068_ _18990_/Q wire297/Z _10172_/A2 _18942_/Q _10071_/A1 VSS VSS VSS VSS gf180mcu_fd_sc_mcu9t5v0__aoi22_1
X_17733_ _17733_/A1 _17673_/S _17733_/B _18742_/D VSS VSS VSS VSS gf180mcu_fd_sc_mcu9t5v0__oai21_1
X_14945_ _19609_/Q _19365_/Q _20039_/D _19609_/D VSS VSS VSS VSS gf180mcu_fd_sc_mcu9t5v0__mux2_1
XPHY_EDGE_ROW_13_Right_13 VSS VSS gf180mcu_fd_sc_mcu9t5v0__endcap
XTAP_TAPCELL_ROW_317_7791 VSS VSS gf180mcu_fd_sc_mcu9t5v0__filltie
XTAP_TAPCELL_ROW_317_7780 VSS VSS gf180mcu_fd_sc_mcu9t5v0__filltie
XTAP_TAPCELL_ROW_292_7095 VSS VSS gf180mcu_fd_sc_mcu9t5v0__filltie
XTAP_TAPCELL_ROW_313_7666 VSS VSS gf180mcu_fd_sc_mcu9t5v0__filltie
X_17664_ _18627_/Q _18703_/Q _17685_/S _18703_/D VSS VSS VSS VSS gf180mcu_fd_sc_mcu9t5v0__mux2_1
X_14876_ _14876_/A1 _14874_/Z _14877_/A2 VSS VSS VSS VSS gf180mcu_fd_sc_mcu9t5v0__xnor2_1
X_19403_ _19403_/D _20043_/RN clkload17/I _19403_/Q VSS VSS VSS VSS gf180mcu_fd_sc_mcu9t5v0__dffrnq_1
XTAP_TAPCELL_ROW_313_7688 VSS VSS gf180mcu_fd_sc_mcu9t5v0__filltie
XTAP_TAPCELL_ROW_313_7677 VSS VSS gf180mcu_fd_sc_mcu9t5v0__filltie
X_16615_ _19282_/Q _16675_/A1 _16616_/B VSS VSS VSS VSS gf180mcu_fd_sc_mcu9t5v0__nand2_1
X_17595_ input6/Z _18660_/Q _17597_/S _18660_/D VSS VSS VSS VSS gf180mcu_fd_sc_mcu9t5v0__mux2_1
X_13827_ _13818_/Z _13828_/A2 _13863_/A1 VSS VSS VSS VSS gf180mcu_fd_sc_mcu9t5v0__nor2_1
X_16546_ _18329_/Q _16117_/C _17067_/S _18329_/D VSS VSS VSS VSS gf180mcu_fd_sc_mcu9t5v0__mux2_4
X_19334_ _19334_/D _20038_/RN clkload7/I _19334_/Q VSS VSS VSS VSS gf180mcu_fd_sc_mcu9t5v0__dffrnq_1
X_13758_ _13757_/Z _19302_/Q _13763_/S _19302_/D VSS _13758_/VNW VSS VSS gf180mcu_fd_sc_mcu9t5v0__mux2_1
X_19265_ _19265_/D _20033_/RN clkload45/I _19265_/Q VSS VSS VSS VSS gf180mcu_fd_sc_mcu9t5v0__dffrnq_1
XTAP_TAPCELL_ROW_132_4605 VSS VSS gf180mcu_fd_sc_mcu9t5v0__filltie
X_12709_ _12722_/A1 _12708_/Z _12709_/B _19187_/D VSS _12714_/VNW VSS VSS gf180mcu_fd_sc_mcu9t5v0__oai21_1
X_18216_ _18216_/D clkload81/I _18216_/Q VSS VSS VSS VSS gf180mcu_fd_sc_mcu9t5v0__dffq_1
X_16477_ _16477_/A1 _16477_/A2 _16477_/ZN VSS _16477_/VNW VSS VSS gf180mcu_fd_sc_mcu9t5v0__nand2_4
XTAP_TAPCELL_ROW_214_4949 VSS VSS gf180mcu_fd_sc_mcu9t5v0__filltie
XTAP_TAPCELL_ROW_132_4616 VSS VSS gf180mcu_fd_sc_mcu9t5v0__filltie
X_13689_ _14546_/S _13689_/A2 _14378_/A1 VSS _13694_/VNW VSS VSS gf180mcu_fd_sc_mcu9t5v0__nand2_1
XTAP_TAPCELL_ROW_117_4195 VSS VSS gf180mcu_fd_sc_mcu9t5v0__filltie
X_15428_ _19713_/Q _19813_/Q _15430_/S _19813_/D VSS _15428_/VNW VSS VSS gf180mcu_fd_sc_mcu9t5v0__mux2_1
XPHY_EDGE_ROW_22_Right_22 VSS VSS gf180mcu_fd_sc_mcu9t5v0__endcap
XTAP_TAPCELL_ROW_74_3011 VSS VSS gf180mcu_fd_sc_mcu9t5v0__filltie
X_19196_ _19196_/D _20028_/RN clkload24/I _19196_/Q VSS VSS VSS VSS gf180mcu_fd_sc_mcu9t5v0__dffrnq_1
X_18147_ _19218_/Q _19224_/Q _18147_/S _18147_/Z VSS _18147_/VNW VSS VSS gf180mcu_fd_sc_mcu9t5v0__mux2_1
XTAP_TAPCELL_ROW_74_3022 VSS VSS gf180mcu_fd_sc_mcu9t5v0__filltie
X_15359_ _19648_/Q _19625_/Q _15362_/A2 VSS _15362_/VNW VSS VSS gf180mcu_fd_sc_mcu9t5v0__nor2_1
X_18078_ _18078_/A1 _18048_/Z _18079_/A3 VSS _18078_/VNW VSS VSS gf180mcu_fd_sc_mcu9t5v0__nand2_1
X_17029_ _16576_/B _19245_/Q _17033_/S _17029_/Z VSS VSS VSS VSS gf180mcu_fd_sc_mcu9t5v0__mux2_1
X_09920_ _10659_/C _20055_/Q _10841_/A2 VSS _10006_/VNW VSS VSS gf180mcu_fd_sc_mcu9t5v0__nand2_1
X_20040_ _20040_/D _20040_/RN clkload44/I _20040_/Q VSS VSS VSS VSS gf180mcu_fd_sc_mcu9t5v0__dffrnq_1
X_09851_ _09851_/A1 _20053_/Q _09851_/B _20029_/D VSS _15323_/VNW VSS VSS gf180mcu_fd_sc_mcu9t5v0__oai21_1
Xload_slew140 _10724_/C _17161_/C VSS VSS VSS VSS gf180mcu_fd_sc_mcu9t5v0__clkbuf_8
X_09782_ _18837_/Q _18836_/Q _09782_/Z VSS _09782_/VNW VSS VSS gf180mcu_fd_sc_mcu9t5v0__or2_1
XPHY_EDGE_ROW_31_Right_31 VSS VSS gf180mcu_fd_sc_mcu9t5v0__endcap
XTAP_TAPCELL_ROW_102_3774 VSS VSS gf180mcu_fd_sc_mcu9t5v0__filltie
XTAP_TAPCELL_ROW_102_3796 VSS VSS gf180mcu_fd_sc_mcu9t5v0__filltie
XTAP_TAPCELL_ROW_102_3785 VSS VSS gf180mcu_fd_sc_mcu9t5v0__filltie
XTAP_TAPCELL_ROW_44_2180 VSS VSS gf180mcu_fd_sc_mcu9t5v0__filltie
XTAP_TAPCELL_ROW_288_6997 VSS VSS gf180mcu_fd_sc_mcu9t5v0__filltie
XTAP_TAPCELL_ROW_288_6986 VSS VSS gf180mcu_fd_sc_mcu9t5v0__filltie
X_09216_ _19593_/Q _15217_/A1 VSS VSS VSS VSS gf180mcu_fd_sc_mcu9t5v0__clkinv_1
XTAP_TAPCELL_ROW_44_2191 VSS VSS gf180mcu_fd_sc_mcu9t5v0__filltie
XPHY_EDGE_ROW_40_Right_40 VSS VSS gf180mcu_fd_sc_mcu9t5v0__endcap
XTAP_TAPCELL_ROW_40_2077 VSS VSS gf180mcu_fd_sc_mcu9t5v0__filltie
XTAP_TAPCELL_ROW_40_2088 VSS VSS gf180mcu_fd_sc_mcu9t5v0__filltie
Xu_transform_scheduler_core.u_fft_scratch_sram.u_lo.u_cen_driver _20019_/RN _09885_/ZN
+ u_transform_scheduler_core.u_fft_scratch_sram.u_lo.u_sram/CEN VSS VSS VSS VSS gf180mcu_fd_sc_mcu9t5v0__nand2_4
X_09147_ _19738_/Q _13294_/A1 VSS VSS VSS VSS gf180mcu_fd_sc_mcu9t5v0__clkinv_1
X_09078_ input9/Z _09698_/B VSS _09698_/VNW VSS VSS gf180mcu_fd_sc_mcu9t5v0__clkinv_1
XTAP_TAPCELL_ROW_57_2541 VSS VSS gf180mcu_fd_sc_mcu9t5v0__filltie
XTAP_TAPCELL_ROW_57_2552 VSS VSS gf180mcu_fd_sc_mcu9t5v0__filltie
XTAP_TAPCELL_ROW_57_2563 VSS VSS gf180mcu_fd_sc_mcu9t5v0__filltie
XTAP_TAPCELL_ROW_224_5234 VSS VSS gf180mcu_fd_sc_mcu9t5v0__filltie
XTAP_TAPCELL_ROW_224_5223 VSS VSS gf180mcu_fd_sc_mcu9t5v0__filltie
XTAP_TAPCELL_ROW_53_2427 VSS VSS gf180mcu_fd_sc_mcu9t5v0__filltie
XTAP_TAPCELL_ROW_53_2438 VSS VSS gf180mcu_fd_sc_mcu9t5v0__filltie
XTAP_TAPCELL_ROW_53_2449 VSS VSS gf180mcu_fd_sc_mcu9t5v0__filltie
XTAP_TAPCELL_ROW_220_5109 VSS VSS gf180mcu_fd_sc_mcu9t5v0__filltie
X_11040_ _18026_/I0 _19041_/Q wire174/Z _19041_/D VSS VSS VSS VSS gf180mcu_fd_sc_mcu9t5v0__mux2_1
X_12991_ _13008_/A2 _12991_/A2 _13003_/A2 _12991_/B2 _12992_/I0 VSS VSS VSS VSS gf180mcu_fd_sc_mcu9t5v0__oai22_1
X_11942_ _12348_/C _11931_/Z _11942_/B1 _11942_/B2 _11944_/B VSS _11942_/VNW VSS VSS
+ gf180mcu_fd_sc_mcu9t5v0__oai22_1
X_14730_ _14729_/Z _19545_/Q _14730_/S _19545_/D VSS VSS VSS VSS gf180mcu_fd_sc_mcu9t5v0__mux2_1
X_11873_ _12345_/B _11873_/A2 _11874_/A3 VSS VSS VSS VSS gf180mcu_fd_sc_mcu9t5v0__nand2_1
X_14661_ _14662_/A1 _14662_/A2 _14661_/Z VSS VSS VSS VSS gf180mcu_fd_sc_mcu9t5v0__and2_1
X_17380_ _18423_/Q _17380_/A2 _17380_/B1 _18439_/Q _17381_/B VSS VSS VSS VSS gf180mcu_fd_sc_mcu9t5v0__aoi22_1
X_10824_ _10821_/B _10824_/A2 _10825_/B2 VSS VSS VSS VSS gf180mcu_fd_sc_mcu9t5v0__nand2_1
X_16400_ _16399_/Z _18263_/Q _16924_/S _18263_/D VSS _16400_/VNW VSS VSS gf180mcu_fd_sc_mcu9t5v0__mux2_1
X_13612_ _13615_/A3 _13612_/A2 _13612_/B _19284_/D VSS VSS VSS VSS gf180mcu_fd_sc_mcu9t5v0__oai21_1
X_14592_ _19139_/Q _14590_/B _14624_/S _14595_/B1 VSS VSS VSS VSS gf180mcu_fd_sc_mcu9t5v0__aoi21_1
X_16331_ _19242_/Q _16187_/C _16833_/S _16331_/Z VSS VSS VSS VSS gf180mcu_fd_sc_mcu9t5v0__mux2_1
X_13543_ _19270_/Q _13419_/B _13548_/B VSS VSS VSS VSS gf180mcu_fd_sc_mcu9t5v0__nand2_1
X_10755_ _18841_/Q _18848_/Q _10755_/B _10757_/A2 VSS VSS VSS VSS gf180mcu_fd_sc_mcu9t5v0__aoi21_1
X_16262_ _16151_/B _16955_/S _16422_/B VSS _16262_/VNW VSS VSS gf180mcu_fd_sc_mcu9t5v0__nand2_1
X_13474_ _13474_/A1 _13474_/A2 _13474_/B _13489_/A2 VSS _13475_/VNW VSS VSS gf180mcu_fd_sc_mcu9t5v0__aoi21_1
X_10686_ _10686_/I _10688_/C VSS VSS VSS VSS gf180mcu_fd_sc_mcu9t5v0__clkinv_1
X_19050_ _19050_/D _20138_/RN clkload34/I _19050_/Q VSS VSS VSS VSS gf180mcu_fd_sc_mcu9t5v0__dffrnq_1
X_16193_ _16438_/A1 _16751_/A2 _16751_/A3 _16751_/B _16194_/B VSS VSS VSS VSS gf180mcu_fd_sc_mcu9t5v0__oai31_1
X_12425_ _18305_/Q _12616_/A2 _12616_/B _12426_/B2 VSS _12425_/VNW VSS VSS gf180mcu_fd_sc_mcu9t5v0__oai21_1
X_18001_ _18887_/Q _18034_/I0 _18004_/S _18887_/D VSS VSS VSS VSS gf180mcu_fd_sc_mcu9t5v0__mux2_1
X_15213_ _15213_/I0 _19722_/Q _15417_/S _19722_/D VSS VSS VSS VSS gf180mcu_fd_sc_mcu9t5v0__mux2_1
XTAP_TAPCELL_ROW_321_7902 VSS VSS gf180mcu_fd_sc_mcu9t5v0__filltie
XTAP_TAPCELL_ROW_112_4070 VSS VSS gf180mcu_fd_sc_mcu9t5v0__filltie
X_15144_ _19686_/Q _19526_/Q wire108/I _19686_/D VSS _15144_/VNW VSS VSS gf180mcu_fd_sc_mcu9t5v0__mux2_1
X_12356_ _12356_/A1 _12355_/I _19140_/D VSS _18023_/VNW VSS VSS gf180mcu_fd_sc_mcu9t5v0__nand2_1
XTAP_TAPCELL_ROW_306_7492 VSS VSS gf180mcu_fd_sc_mcu9t5v0__filltie
XTAP_TAPCELL_ROW_306_7481 VSS VSS gf180mcu_fd_sc_mcu9t5v0__filltie
X_11307_ _19087_/Q _11321_/A2 _11308_/A2 VSS VSS VSS VSS gf180mcu_fd_sc_mcu9t5v0__nand2_1
X_12287_ _18485_/Q _12315_/S _12289_/A2 VSS VSS VSS VSS gf180mcu_fd_sc_mcu9t5v0__nand2_1
XTAP_TAPCELL_ROW_302_7378 VSS VSS gf180mcu_fd_sc_mcu9t5v0__filltie
XTAP_TAPCELL_ROW_298_7271 VSS VSS gf180mcu_fd_sc_mcu9t5v0__filltie
XTAP_TAPCELL_ROW_302_7367 VSS VSS gf180mcu_fd_sc_mcu9t5v0__filltie
XTAP_TAPCELL_ROW_298_7260 VSS VSS gf180mcu_fd_sc_mcu9t5v0__filltie
X_19952_ _19952_/D _20144_/RN clkload65/I _19952_/Q VSS VSS VSS VSS gf180mcu_fd_sc_mcu9t5v0__dffrnq_1
X_15075_ _19310_/Q _19395_/Q _15099_/A1 VSS VSS VSS VSS gf180mcu_fd_sc_mcu9t5v0__nand2_1
XTAP_TAPCELL_ROW_302_7389 VSS VSS gf180mcu_fd_sc_mcu9t5v0__filltie
X_11238_ _11485_/C _11234_/Z _11238_/B _11510_/B _11241_/B1 VSS VSS VSS VSS gf180mcu_fd_sc_mcu9t5v0__oai211_1
X_19883_ _19883_/D _20139_/RN clkload45/I _19883_/Q VSS VSS VSS VSS gf180mcu_fd_sc_mcu9t5v0__dffrnq_1
X_14026_ _14031_/B1 _14025_/Z _14031_/A2 VSS VSS VSS VSS gf180mcu_fd_sc_mcu9t5v0__xnor2_1
X_18903_ _18903_/D _20055_/RN clkload30/I _18903_/Q VSS VSS VSS VSS gf180mcu_fd_sc_mcu9t5v0__dffrnq_1
XTAP_TAPCELL_ROW_294_7168 VSS VSS gf180mcu_fd_sc_mcu9t5v0__filltie
XTAP_TAPCELL_ROW_319_7842 VSS VSS gf180mcu_fd_sc_mcu9t5v0__filltie
X_11169_ _18254_/Q _11524_/S _11171_/A2 VSS _11169_/VNW VSS VSS gf180mcu_fd_sc_mcu9t5v0__nand2_1
XTAP_TAPCELL_ROW_294_7157 VSS VSS gf180mcu_fd_sc_mcu9t5v0__filltie
XTAP_TAPCELL_ROW_319_7831 VSS VSS gf180mcu_fd_sc_mcu9t5v0__filltie
XTAP_TAPCELL_ROW_294_7146 VSS VSS gf180mcu_fd_sc_mcu9t5v0__filltie
XTAP_TAPCELL_ROW_125_4431 VSS VSS gf180mcu_fd_sc_mcu9t5v0__filltie
XTAP_TAPCELL_ROW_125_4420 VSS VSS gf180mcu_fd_sc_mcu9t5v0__filltie
X_18834_ _18834_/D _20050_/RN clkload25/I _18834_/Q VSS VSS VSS VSS gf180mcu_fd_sc_mcu9t5v0__dffrnq_1
XTAP_TAPCELL_ROW_36_1968 VSS VSS gf180mcu_fd_sc_mcu9t5v0__filltie
XTAP_TAPCELL_ROW_36_1979 VSS VSS gf180mcu_fd_sc_mcu9t5v0__filltie
XTAP_TAPCELL_ROW_319_7853 VSS VSS gf180mcu_fd_sc_mcu9t5v0__filltie
XTAP_TAPCELL_ROW_121_4317 VSS VSS gf180mcu_fd_sc_mcu9t5v0__filltie
XTAP_TAPCELL_ROW_121_4306 VSS VSS gf180mcu_fd_sc_mcu9t5v0__filltie
XTAP_TAPCELL_ROW_315_7739 VSS VSS gf180mcu_fd_sc_mcu9t5v0__filltie
XTAP_TAPCELL_ROW_315_7728 VSS VSS gf180mcu_fd_sc_mcu9t5v0__filltie
X_15977_ _16199_/A1 _16545_/A3 _16197_/C _16105_/A1 _16003_/A2 VSS VSS VSS VSS gf180mcu_fd_sc_mcu9t5v0__nand4_4
X_18765_ _18765_/D _20045_/RN clkload51/I _18765_/Q VSS VSS VSS VSS gf180mcu_fd_sc_mcu9t5v0__dffrnq_1
X_18696_ _18696_/D clkload59/I _18696_/Q VSS VSS VSS VSS gf180mcu_fd_sc_mcu9t5v0__dffq_1
X_17716_ _18734_/Q _17742_/S _17743_/B _18658_/Q _17717_/I VSS VSS VSS VSS gf180mcu_fd_sc_mcu9t5v0__aoi22_1
X_14928_ _14928_/A1 _14927_/Z _14928_/Z VSS _14930_/VNW VSS VSS gf180mcu_fd_sc_mcu9t5v0__xor2_1
X_17647_ _18691_/Q _18692_/Q _17648_/I0 VSS VSS VSS VSS gf180mcu_fd_sc_mcu9t5v0__nor2_1
X_14859_ _19585_/Q _19346_/Q _15148_/S _19585_/D VSS VSS VSS VSS gf180mcu_fd_sc_mcu9t5v0__mux2_1
X_17578_ _18646_/Q _17578_/I1 _17584_/S _18646_/D VSS VSS VSS VSS gf180mcu_fd_sc_mcu9t5v0__mux2_1
XTAP_TAPCELL_ROW_119_4268 VSS VSS gf180mcu_fd_sc_mcu9t5v0__filltie
XTAP_TAPCELL_ROW_119_4257 VSS VSS gf180mcu_fd_sc_mcu9t5v0__filltie
XTAP_TAPCELL_ROW_119_4246 VSS VSS gf180mcu_fd_sc_mcu9t5v0__filltie
X_19317_ _19317_/D _20021_/RN clkload14/I _19317_/Q VSS VSS VSS VSS gf180mcu_fd_sc_mcu9t5v0__dffrnq_1
X_16529_ _16058_/B _19236_/Q _17057_/S _16529_/Z VSS VSS VSS VSS gf180mcu_fd_sc_mcu9t5v0__mux2_1
X_19248_ _19248_/D _20144_/RN clkload27/I _19248_/Q VSS VSS VSS VSS gf180mcu_fd_sc_mcu9t5v0__dffrnq_2
XTAP_TAPCELL_ROW_283_6850 VSS VSS gf180mcu_fd_sc_mcu9t5v0__filltie
X_19179_ _19179_/D _20139_/RN clkload13/I _19179_/Q VSS VSS VSS VSS gf180mcu_fd_sc_mcu9t5v0__dffrnq_1
XTAP_TAPCELL_ROW_283_6861 VSS VSS gf180mcu_fd_sc_mcu9t5v0__filltie
X_09903_ _15827_/B _15829_/B2 _09924_/A1 VSS _10040_/VNW VSS VSS gf180mcu_fd_sc_mcu9t5v0__nand2_1
X_20023_ _20023_/D _20023_/RN _20049_/CLK _20023_/Q VSS VSS VSS VSS gf180mcu_fd_sc_mcu9t5v0__dffrnq_1
X_09834_ _09835_/C _09773_/B _09834_/A3 _09834_/A4 _09837_/A2 VSS _09834_/VNW VSS
+ VSS gf180mcu_fd_sc_mcu9t5v0__nor4_1
XTAP_TAPCELL_ROW_277_6676 VSS VSS gf180mcu_fd_sc_mcu9t5v0__filltie
XTAP_TAPCELL_ROW_108_3950 VSS VSS gf180mcu_fd_sc_mcu9t5v0__filltie
XTAP_TAPCELL_ROW_277_6698 VSS VSS gf180mcu_fd_sc_mcu9t5v0__filltie
XTAP_TAPCELL_ROW_277_6687 VSS VSS gf180mcu_fd_sc_mcu9t5v0__filltie
XTAP_TAPCELL_ROW_108_3961 VSS VSS gf180mcu_fd_sc_mcu9t5v0__filltie
X_09765_ _09768_/A1 _17869_/A1 _09578_/Z _09765_/B _09835_/C VSS VSS VSS VSS gf180mcu_fd_sc_mcu9t5v0__oai31_1
XTAP_TAPCELL_ROW_104_3847 VSS VSS gf180mcu_fd_sc_mcu9t5v0__filltie
X_09696_ _17444_/A2 _09696_/A2 _20010_/D VSS VSS VSS VSS gf180mcu_fd_sc_mcu9t5v0__nand2_1
XPHY_EDGE_ROW_6_Left_330 VSS VSS gf180mcu_fd_sc_mcu9t5v0__endcap
XTAP_TAPCELL_ROW_104_3836 VSS VSS gf180mcu_fd_sc_mcu9t5v0__filltie
XTAP_TAPCELL_ROW_46_2242 VSS VSS gf180mcu_fd_sc_mcu9t5v0__filltie
XTAP_TAPCELL_ROW_46_2253 VSS VSS gf180mcu_fd_sc_mcu9t5v0__filltie
XTAP_TAPCELL_ROW_42_2128 VSS VSS gf180mcu_fd_sc_mcu9t5v0__filltie
XTAP_TAPCELL_ROW_42_2139 VSS VSS gf180mcu_fd_sc_mcu9t5v0__filltie
X_10540_ _17404_/S _11915_/A1 _10541_/B VSS VSS VSS VSS gf180mcu_fd_sc_mcu9t5v0__nand2_1
XTAP_TAPCELL_ROW_59_2603 VSS VSS gf180mcu_fd_sc_mcu9t5v0__filltie
XPHY_EDGE_ROW_280_Right_207 VSS VSS gf180mcu_fd_sc_mcu9t5v0__endcap
X_10471_ _18545_/Q wire80/Z _10650_/B1 _10471_/B2 _10477_/A2 VSS VSS VSS VSS gf180mcu_fd_sc_mcu9t5v0__aoi22_4
XTAP_TAPCELL_ROW_59_2614 VSS VSS gf180mcu_fd_sc_mcu9t5v0__filltie
X_12210_ _12261_/B _12210_/A2 _12210_/B _12212_/A2 VSS VSS VSS VSS gf180mcu_fd_sc_mcu9t5v0__aoi21_1
X_13190_ _13198_/A1 _13564_/A2 _13190_/Z VSS VSS VSS VSS gf180mcu_fd_sc_mcu9t5v0__or2_1
X_12141_ _12141_/A1 _12141_/A2 _12140_/Z _12322_/B _12142_/B1 VSS VSS VSS VSS gf180mcu_fd_sc_mcu9t5v0__aoi22_1
X_12072_ _12058_/Z _12106_/A2 _12072_/B _12073_/A2 VSS VSS VSS VSS gf180mcu_fd_sc_mcu9t5v0__oai21_1
XPHY_EDGE_ROW_155_3_Left_813 VSS VSS gf180mcu_fd_sc_mcu9t5v0__endcap
X_15900_ _20109_/Q _19245_/Q _15905_/S _20109_/D VSS VSS VSS VSS gf180mcu_fd_sc_mcu9t5v0__mux2_1
X_11023_ _19056_/Q _19024_/Q wire174/Z _19024_/D VSS VSS VSS VSS gf180mcu_fd_sc_mcu9t5v0__mux2_1
X_16880_ _18432_/Q _16879_/Z _16882_/S _18432_/D VSS VSS VSS VSS gf180mcu_fd_sc_mcu9t5v0__mux2_4
XTAP_TAPCELL_ROW_140_3_8014 VSS VSS gf180mcu_fd_sc_mcu9t5v0__filltie
X_15831_ _15833_/A2 _15831_/A2 _15832_/B1 VSS VSS VSS VSS gf180mcu_fd_sc_mcu9t5v0__nand2_1
XTAP_TAPCELL_ROW_31_1832 VSS VSS gf180mcu_fd_sc_mcu9t5v0__filltie
XTAP_TAPCELL_ROW_31_1843 VSS VSS gf180mcu_fd_sc_mcu9t5v0__filltie
X_18550_ _18550_/D _20050_/RN clkload76/I _18550_/Q VSS VSS VSS VSS gf180mcu_fd_sc_mcu9t5v0__dffrnq_4
X_15762_ _20001_/Q _20007_/Q input9/Z _15770_/S VSS VSS VSS VSS gf180mcu_fd_sc_mcu9t5v0__oai21_2
X_12974_ _16408_/I0 _13304_/B _12974_/B _19229_/D VSS VSS VSS VSS gf180mcu_fd_sc_mcu9t5v0__aoi21_1
X_18481_ _18481_/D _18497_/CLK _18481_/Q VSS VSS VSS VSS gf180mcu_fd_sc_mcu9t5v0__dffq_1
XTAP_TAPCELL_ROW_310_7603 VSS VSS gf180mcu_fd_sc_mcu9t5v0__filltie
X_17501_ _18606_/Q _19247_/Q _17504_/S _18606_/D VSS VSS VSS VSS gf180mcu_fd_sc_mcu9t5v0__mux2_1
X_11925_ _12071_/B _11925_/A2 _11924_/Z _11926_/B1 VSS VSS VSS VSS gf180mcu_fd_sc_mcu9t5v0__nor3_4
XPHY_EDGE_ROW_151_1_Left_474 VSS VSS gf180mcu_fd_sc_mcu9t5v0__endcap
X_14713_ _14473_/B _14714_/A2 _14717_/A3 VSS _14716_/VNW VSS VSS gf180mcu_fd_sc_mcu9t5v0__nand2_1
X_17432_ _09688_/B _17431_/Z _18564_/D VSS VSS VSS VSS gf180mcu_fd_sc_mcu9t5v0__and2_1
X_15693_ _15705_/B _19915_/Q _15693_/A3 _15693_/B _19915_/D VSS _15693_/VNW VSS VSS
+ gf180mcu_fd_sc_mcu9t5v0__oai31_1
XTAP_TAPCELL_ROW_29_1772 VSS VSS gf180mcu_fd_sc_mcu9t5v0__filltie
X_14644_ _19522_/Q _14715_/S _14645_/B VSS VSS VSS VSS gf180mcu_fd_sc_mcu9t5v0__nand2_1
X_11856_ _11856_/A1 _11856_/A2 _19115_/D VSS VSS VSS VSS gf180mcu_fd_sc_mcu9t5v0__nand2_1
X_17363_ _18406_/Q _18390_/Q _17404_/S _17363_/Z VSS _17363_/VNW VSS VSS gf180mcu_fd_sc_mcu9t5v0__mux2_1
X_11787_ _12164_/B _11787_/A2 _11789_/A2 VSS VSS VSS VSS gf180mcu_fd_sc_mcu9t5v0__nand2_1
X_10807_ _10693_/B _10807_/A2 _10807_/A3 _10810_/B1 VSS VSS VSS VSS gf180mcu_fd_sc_mcu9t5v0__nand3_1
XTAP_TAPCELL_ROW_29_1783 VSS VSS gf180mcu_fd_sc_mcu9t5v0__filltie
X_14575_ _19172_/Q _19138_/Q _14762_/B VSS _14576_/VNW VSS VSS gf180mcu_fd_sc_mcu9t5v0__and2_1
X_16314_ _18222_/Q _16313_/Z _16850_/S _18222_/D VSS VSS VSS VSS gf180mcu_fd_sc_mcu9t5v0__mux2_4
XTAP_TAPCELL_ROW_308_7532 VSS VSS gf180mcu_fd_sc_mcu9t5v0__filltie
X_17294_ _18483_/Q _17406_/A2 _17299_/A1 VSS VSS VSS VSS gf180mcu_fd_sc_mcu9t5v0__nand2_1
X_10738_ _19013_/Q _17878_/A1 _10739_/A3 VSS VSS VSS VSS gf180mcu_fd_sc_mcu9t5v0__nor2_1
XTAP_TAPCELL_ROW_114_4121 VSS VSS gf180mcu_fd_sc_mcu9t5v0__filltie
X_19102_ _19102_/D _20062_/RN _19680_/CLK _19102_/Q VSS VSS VSS VSS gf180mcu_fd_sc_mcu9t5v0__dffrnq_1
X_13526_ _13615_/B _13529_/B _13527_/A2 VSS VSS VSS VSS gf180mcu_fd_sc_mcu9t5v0__nand2_1
XTAP_TAPCELL_ROW_114_4110 VSS VSS gf180mcu_fd_sc_mcu9t5v0__filltie
XTAP_TAPCELL_ROW_25_1658 VSS VSS gf180mcu_fd_sc_mcu9t5v0__filltie
XTAP_TAPCELL_ROW_25_1669 VSS VSS gf180mcu_fd_sc_mcu9t5v0__filltie
XTAP_TAPCELL_ROW_308_7554 VSS VSS gf180mcu_fd_sc_mcu9t5v0__filltie
XTAP_TAPCELL_ROW_308_7543 VSS VSS gf180mcu_fd_sc_mcu9t5v0__filltie
X_16245_ _19262_/Q _16932_/A2 _16247_/A1 VSS VSS VSS VSS gf180mcu_fd_sc_mcu9t5v0__nand2_1
X_13457_ _13440_/Z _13457_/A2 _13457_/B _13474_/A1 VSS VSS VSS VSS gf180mcu_fd_sc_mcu9t5v0__oai21_1
X_19033_ _19033_/D _20057_/RN clkload32/I _19033_/Q VSS VSS VSS VSS gf180mcu_fd_sc_mcu9t5v0__dffrnq_1
XTAP_TAPCELL_ROW_304_7429 VSS VSS gf180mcu_fd_sc_mcu9t5v0__filltie
XTAP_TAPCELL_ROW_304_7418 VSS VSS gf180mcu_fd_sc_mcu9t5v0__filltie
X_12408_ wire146/I _12408_/A2 _12408_/A3 _12408_/B1 _12408_/B2 _12409_/B2 VSS VSS
+ VSS VSS gf180mcu_fd_sc_mcu9t5v0__oai32_1
XPHY_EDGE_ROW_124_Right_124 VSS VSS gf180mcu_fd_sc_mcu9t5v0__endcap
XTAP_TAPCELL_ROW_110_4018 VSS VSS gf180mcu_fd_sc_mcu9t5v0__filltie
XTAP_TAPCELL_ROW_110_4007 VSS VSS gf180mcu_fd_sc_mcu9t5v0__filltie
X_10669_ _18845_/Q _09784_/Z _18852_/Q _10669_/Z VSS _10690_/VNW VSS VSS gf180mcu_fd_sc_mcu9t5v0__mux2_1
X_16176_ _19240_/Q _16751_/B _16179_/A2 VSS VSS VSS VSS gf180mcu_fd_sc_mcu9t5v0__nand2_1
XTAP_TAPCELL_ROW_209_4804 VSS VSS gf180mcu_fd_sc_mcu9t5v0__filltie
X_13388_ _19775_/Q _19809_/Q _13388_/A3 _13618_/A2 VSS VSS VSS VSS gf180mcu_fd_sc_mcu9t5v0__xnor3_1
XTAP_TAPCELL_ROW_296_7219 VSS VSS gf180mcu_fd_sc_mcu9t5v0__filltie
XTAP_TAPCELL_ROW_296_7208 VSS VSS gf180mcu_fd_sc_mcu9t5v0__filltie
XTAP_TAPCELL_ROW_209_4826 VSS VSS gf180mcu_fd_sc_mcu9t5v0__filltie
X_12339_ _12237_/B _12339_/A2 _12350_/A1 VSS VSS VSS VSS gf180mcu_fd_sc_mcu9t5v0__nand2_4
XTAP_TAPCELL_ROW_209_4815 VSS VSS gf180mcu_fd_sc_mcu9t5v0__filltie
X_15127_ _19669_/Q _19509_/Q _15163_/S _19669_/D VSS VSS VSS VSS gf180mcu_fd_sc_mcu9t5v0__mux2_1
X_19935_ _19935_/D _20063_/RN _20054_/CLK _19935_/Q VSS VSS VSS VSS gf180mcu_fd_sc_mcu9t5v0__dffrnq_1
X_15058_ _19306_/Q _19391_/Q _15058_/B _15063_/A1 VSS VSS VSS VSS gf180mcu_fd_sc_mcu9t5v0__aoi21_1
X_14009_ _19296_/Q _19322_/Q _14013_/A2 VSS _14013_/VNW VSS VSS gf180mcu_fd_sc_mcu9t5v0__nand2_1
X_19866_ _19866_/D _20058_/RN clkload55/I _19866_/Q VSS VSS VSS VSS gf180mcu_fd_sc_mcu9t5v0__dffrnq_1
X_19797_ _19797_/D _20053_/RN _19798_/CLK _19797_/Q VSS VSS VSS VSS gf180mcu_fd_sc_mcu9t5v0__dffrnq_1
X_18817_ _18817_/D _20033_/RN clkload34/I _18817_/Q VSS VSS VSS VSS gf180mcu_fd_sc_mcu9t5v0__dffrnq_1
X_18748_ _18748_/D clkload47/I _18748_/Q VSS VSS VSS VSS gf180mcu_fd_sc_mcu9t5v0__dffq_1
X_09550_ _20006_/Q input9/Z _15819_/S VSS VSS VSS VSS gf180mcu_fd_sc_mcu9t5v0__nand2_1
XTAP_TAPCELL_ROW_272_6562 VSS VSS gf180mcu_fd_sc_mcu9t5v0__filltie
XTAP_TAPCELL_ROW_272_6551 VSS VSS gf180mcu_fd_sc_mcu9t5v0__filltie
XTAP_TAPCELL_ROW_272_6540 VSS VSS gf180mcu_fd_sc_mcu9t5v0__filltie
X_09481_ _20055_/Q _20010_/Q _09481_/ZN VSS VSS VSS VSS gf180mcu_fd_sc_mcu9t5v0__nand2_4
X_18679_ _18679_/D _20019_/RN clkload50/I _18679_/Q VSS VSS VSS VSS gf180mcu_fd_sc_mcu9t5v0__dffrnq_1
XTAP_TAPCELL_ROW_285_6901 VSS VSS gf180mcu_fd_sc_mcu9t5v0__filltie
XTAP_TAPCELL_ROW_285_6912 VSS VSS gf180mcu_fd_sc_mcu9t5v0__filltie
XTAP_TAPCELL_ROW_99_3695 VSS VSS gf180mcu_fd_sc_mcu9t5v0__filltie
XTAP_TAPCELL_ROW_281_6809 VSS VSS gf180mcu_fd_sc_mcu9t5v0__filltie
XTAP_TAPCELL_ROW_266_6388 VSS VSS gf180mcu_fd_sc_mcu9t5v0__filltie
XTAP_TAPCELL_ROW_266_6377 VSS VSS gf180mcu_fd_sc_mcu9t5v0__filltie
XTAP_TAPCELL_ROW_266_6399 VSS VSS gf180mcu_fd_sc_mcu9t5v0__filltie
XTAP_TAPCELL_ROW_279_6749 VSS VSS gf180mcu_fd_sc_mcu9t5v0__filltie
XTAP_TAPCELL_ROW_279_6738 VSS VSS gf180mcu_fd_sc_mcu9t5v0__filltie
XTAP_TAPCELL_ROW_106_3909 VSS VSS gf180mcu_fd_sc_mcu9t5v0__filltie
X_20006_ _20006_/D _20070_/RN _20049_/CLK _20006_/Q VSS VSS VSS VSS gf180mcu_fd_sc_mcu9t5v0__dffrnq_1
X_09817_ _17900_/A1 _18836_/Q _18838_/Q _09818_/I VSS VSS VSS VSS gf180mcu_fd_sc_mcu9t5v0__nand3_1
XTAP_TAPCELL_ROW_219_5100 VSS VSS gf180mcu_fd_sc_mcu9t5v0__filltie
X_09748_ _17601_/A2 _15703_/A3 _09748_/B _09749_/B VSS VSS VSS VSS gf180mcu_fd_sc_mcu9t5v0__oai21_1
XTAP_TAPCELL_ROW_48_2304 VSS VSS gf180mcu_fd_sc_mcu9t5v0__filltie
XTAP_TAPCELL_ROW_48_2315 VSS VSS gf180mcu_fd_sc_mcu9t5v0__filltie
X_11710_ _18235_/Q _12203_/A2 _11714_/A1 VSS VSS VSS VSS gf180mcu_fd_sc_mcu9t5v0__nand2_1
X_09679_ _19996_/Q _09662_/S _09679_/B1 _19999_/Q _09680_/A4 VSS VSS VSS VSS gf180mcu_fd_sc_mcu9t5v0__aoi22_1
X_12690_ _17961_/A4 _12690_/A2 _12724_/C VSS _12690_/VNW VSS VSS gf180mcu_fd_sc_mcu9t5v0__nand2_1
XTAP_TAPCELL_ROW_251_5978 VSS VSS gf180mcu_fd_sc_mcu9t5v0__filltie
XTAP_TAPCELL_ROW_251_5967 VSS VSS gf180mcu_fd_sc_mcu9t5v0__filltie
X_11641_ _11654_/C _12670_/A2 _12661_/A3 _11643_/B1 VSS _12641_/VNW VSS VSS gf180mcu_fd_sc_mcu9t5v0__nand3_1
X_11572_ _18265_/Q _12181_/A2 _12092_/B _11573_/B2 VSS VSS VSS VSS gf180mcu_fd_sc_mcu9t5v0__aoi21_1
X_14360_ _13867_/Z _19430_/Q _14367_/S _19430_/D VSS VSS VSS VSS gf180mcu_fd_sc_mcu9t5v0__mux2_1
X_10523_ _10523_/A1 _17408_/B _10523_/B1 _10523_/B2 _17306_/C _10524_/B VSS VSS VSS
+ VSS gf180mcu_fd_sc_mcu9t5v0__aoi221_1
X_13311_ _19739_/Q _13309_/I _13594_/B VSS VSS VSS VSS gf180mcu_fd_sc_mcu9t5v0__xnor2_1
XTAP_TAPCELL_ROW_20_1522 VSS VSS gf180mcu_fd_sc_mcu9t5v0__filltie
X_14291_ _13807_/Z _19364_/Q _14304_/S _19364_/D VSS VSS VSS VSS gf180mcu_fd_sc_mcu9t5v0__mux2_1
XTAP_TAPCELL_ROW_20_1533 VSS VSS gf180mcu_fd_sc_mcu9t5v0__filltie
X_16030_ _16668_/A1 _16628_/A2 _16137_/C _16032_/A2 VSS VSS VSS VSS gf180mcu_fd_sc_mcu9t5v0__aoi21_1
X_10454_ _17404_/S _18273_/Q _10457_/A2 VSS _10457_/VNW VSS VSS gf180mcu_fd_sc_mcu9t5v0__nor2_1
X_13242_ _13574_/A2 _13576_/B _13242_/Z VSS _13244_/VNW VSS VSS gf180mcu_fd_sc_mcu9t5v0__and2_1
XTAP_TAPCELL_ROW_20_1544 VSS VSS gf180mcu_fd_sc_mcu9t5v0__filltie
X_10385_ wire168/I _10385_/A2 _10386_/B2 VSS VSS VSS VSS gf180mcu_fd_sc_mcu9t5v0__nand2_1
X_13173_ _13173_/I _13194_/A1 VSS VSS VSS VSS gf180mcu_fd_sc_mcu9t5v0__clkinv_1
X_12124_ _12147_/S _12124_/A2 _12311_/B _12125_/B2 VSS VSS VSS VSS gf180mcu_fd_sc_mcu9t5v0__aoi21_1
X_17981_ _18868_/Q _18031_/I0 wire128/Z _18868_/D VSS VSS VSS VSS gf180mcu_fd_sc_mcu9t5v0__mux2_1
X_19720_ _19720_/D _20040_/RN clkload8/I _19720_/Q VSS VSS VSS VSS gf180mcu_fd_sc_mcu9t5v0__dffrnq_1
X_16932_ _19245_/Q _16932_/A2 _16933_/A2 VSS VSS VSS VSS gf180mcu_fd_sc_mcu9t5v0__nand2_1
XTAP_TAPCELL_ROW_18_1473 VSS VSS gf180mcu_fd_sc_mcu9t5v0__filltie
X_12055_ _18909_/Q _12055_/A2 _12074_/A2 VSS _18024_/VNW VSS VSS gf180mcu_fd_sc_mcu9t5v0__xnor2_1
XTAP_TAPCELL_ROW_18_1484 VSS VSS gf180mcu_fd_sc_mcu9t5v0__filltie
X_16863_ _19259_/Q _16750_/B _16863_/S _16863_/Z VSS VSS VSS VSS gf180mcu_fd_sc_mcu9t5v0__mux2_1
X_11006_ _11006_/A1 _11006_/A2 _11006_/A3 _11007_/I VSS VSS VSS VSS gf180mcu_fd_sc_mcu9t5v0__and3_1
XTAP_TAPCELL_ROW_14_1359 VSS VSS gf180mcu_fd_sc_mcu9t5v0__filltie
X_19651_ _19651_/D _20035_/RN clkload24/I _19651_/Q VSS VSS VSS VSS gf180mcu_fd_sc_mcu9t5v0__dffrnq_1
X_18602_ _18602_/D clkload77/I _18602_/Q VSS VSS VSS VSS gf180mcu_fd_sc_mcu9t5v0__dffq_1
X_15814_ wire300/Z _19983_/Q _15819_/S _19983_/D VSS VSS VSS VSS gf180mcu_fd_sc_mcu9t5v0__mux2_1
X_19582_ _19582_/D _20030_/RN clkload7/I _19582_/Q VSS VSS VSS VSS gf180mcu_fd_sc_mcu9t5v0__dffrnq_1
X_18533_ _18533_/D clkload79/I _18533_/Q VSS VSS VSS VSS gf180mcu_fd_sc_mcu9t5v0__dffq_1
X_16794_ _18395_/Q _16793_/Z _16798_/S _18395_/D VSS VSS VSS VSS gf180mcu_fd_sc_mcu9t5v0__mux2_1
XTAP_TAPCELL_ROW_289_7023 VSS VSS gf180mcu_fd_sc_mcu9t5v0__filltie
XTAP_TAPCELL_ROW_289_7012 VSS VSS gf180mcu_fd_sc_mcu9t5v0__filltie
X_15745_ _19928_/Q _15740_/Z _15746_/A2 VSS _15755_/VNW VSS VSS gf180mcu_fd_sc_mcu9t5v0__xnor2_1
X_12957_ _12957_/I0 _19228_/Q _13304_/B _19228_/D VSS _12957_/VNW VSS VSS gf180mcu_fd_sc_mcu9t5v0__mux2_1
X_18464_ _18464_/D clkload72/I _18464_/Q VSS VSS VSS VSS gf180mcu_fd_sc_mcu9t5v0__dffq_1
X_15676_ _15676_/A1 _15676_/A2 _19911_/D VSS VSS VSS VSS gf180mcu_fd_sc_mcu9t5v0__nand2_1
X_12888_ _19772_/Q _12886_/Z _12890_/B VSS VSS VSS VSS gf180mcu_fd_sc_mcu9t5v0__xnor2_1
X_11908_ _11908_/A1 _11908_/A2 _11926_/A2 VSS VSS VSS VSS gf180mcu_fd_sc_mcu9t5v0__xnor2_1
X_18395_ _18395_/D clkload61/I _18395_/Q VSS VSS VSS VSS gf180mcu_fd_sc_mcu9t5v0__dffq_1
X_14627_ _19088_/Q _19505_/Q _14730_/S _19505_/D VSS VSS VSS VSS gf180mcu_fd_sc_mcu9t5v0__mux2_1
X_17415_ _10682_/Z _18554_/Q _17420_/S _18554_/D VSS VSS VSS VSS gf180mcu_fd_sc_mcu9t5v0__mux2_1
X_11839_ _18899_/Q _11882_/A3 _11839_/Z VSS _15172_/VNW VSS VSS gf180mcu_fd_sc_mcu9t5v0__xor2_1
X_17346_ _17407_/C _17346_/A2 _17347_/C VSS _17346_/VNW VSS VSS gf180mcu_fd_sc_mcu9t5v0__nor2_1
XTAP_TAPCELL_ROW_136_3_7999 VSS VSS gf180mcu_fd_sc_mcu9t5v0__filltie
XPHY_EDGE_ROW_78_Left_402 VSS VSS gf180mcu_fd_sc_mcu9t5v0__endcap
X_14558_ _14752_/B _14751_/B VSS _14558_/VNW VSS VSS gf180mcu_fd_sc_mcu9t5v0__clkinv_1
X_17277_ _10514_/B _17276_/Z _17279_/B1 VSS VSS VSS VSS gf180mcu_fd_sc_mcu9t5v0__nand2_1
X_14489_ _14489_/I _14722_/A1 VSS VSS VSS VSS gf180mcu_fd_sc_mcu9t5v0__clkinv_1
X_13509_ wire277/Z _13508_/Z _13509_/B _19262_/D VSS VSS VSS VSS gf180mcu_fd_sc_mcu9t5v0__oai21_1
X_16228_ _16187_/C _19274_/Q _16785_/S _16228_/Z VSS VSS VSS VSS gf180mcu_fd_sc_mcu9t5v0__mux2_1
XTAP_TAPCELL_ROW_94_3581 VSS VSS gf180mcu_fd_sc_mcu9t5v0__filltie
X_19016_ _19016_/D _20040_/RN clkload38/I _19016_/Q VSS VSS VSS VSS gf180mcu_fd_sc_mcu9t5v0__dffrnq_1
XTAP_TAPCELL_ROW_94_3570 VSS VSS gf180mcu_fd_sc_mcu9t5v0__filltie
XTAP_TAPCELL_ROW_261_6252 VSS VSS gf180mcu_fd_sc_mcu9t5v0__filltie
X_16159_ _16058_/B _16730_/A1 _16159_/B _16160_/A3 VSS _16159_/VNW VSS VSS gf180mcu_fd_sc_mcu9t5v0__aoi21_1
XTAP_TAPCELL_ROW_261_6241 VSS VSS gf180mcu_fd_sc_mcu9t5v0__filltie
XTAP_TAPCELL_ROW_90_3467 VSS VSS gf180mcu_fd_sc_mcu9t5v0__filltie
XTAP_TAPCELL_ROW_90_3456 VSS VSS gf180mcu_fd_sc_mcu9t5v0__filltie
XTAP_TAPCELL_ROW_90_3445 VSS VSS gf180mcu_fd_sc_mcu9t5v0__filltie
XPHY_EDGE_ROW_87_Left_411 VSS VSS gf180mcu_fd_sc_mcu9t5v0__endcap
X_19918_ _19918_/D _20046_/RN clkload49/I _19918_/Q VSS VSS VSS VSS gf180mcu_fd_sc_mcu9t5v0__dffrnq_1
XTAP_TAPCELL_ROW_274_6613 VSS VSS gf180mcu_fd_sc_mcu9t5v0__filltie
XTAP_TAPCELL_ROW_274_6602 VSS VSS gf180mcu_fd_sc_mcu9t5v0__filltie
X_19849_ _19849_/D _20041_/RN clkload51/I _19849_/Q VSS VSS VSS VSS gf180mcu_fd_sc_mcu9t5v0__dffrnq_1
XTAP_TAPCELL_ROW_259_6192 VSS VSS gf180mcu_fd_sc_mcu9t5v0__filltie
XTAP_TAPCELL_ROW_259_6181 VSS VSS gf180mcu_fd_sc_mcu9t5v0__filltie
X_09602_ _10194_/A1 _09601_/I _20044_/D _20043_/D VSS _10194_/VNW VSS VSS gf180mcu_fd_sc_mcu9t5v0__aoi21_1
XTAP_TAPCELL_ROW_88_3396 VSS VSS gf180mcu_fd_sc_mcu9t5v0__filltie
X_09533_ _09533_/A1 _10213_/A1 _19829_/Q _20021_/Q _09542_/B VSS VSS VSS VSS gf180mcu_fd_sc_mcu9t5v0__oai211_1
XTAP_TAPCELL_ROW_255_6089 VSS VSS gf180mcu_fd_sc_mcu9t5v0__filltie
XTAP_TAPCELL_ROW_255_6078 VSS VSS gf180mcu_fd_sc_mcu9t5v0__filltie
X_09464_ _19192_/Q _09462_/I _13756_/A1 VSS _13755_/VNW VSS VSS gf180mcu_fd_sc_mcu9t5v0__nand2_1
XTAP_TAPCELL_ROW_4_1082 VSS VSS gf180mcu_fd_sc_mcu9t5v0__filltie
XTAP_TAPCELL_ROW_4_1093 VSS VSS gf180mcu_fd_sc_mcu9t5v0__filltie
X_09395_ _09395_/I wire175/I VSS VSS VSS VSS gf180mcu_fd_sc_mcu9t5v0__clkinv_4
XPHY_EDGE_ROW_96_Left_420 VSS VSS gf180mcu_fd_sc_mcu9t5v0__endcap
XTAP_TAPCELL_ROW_268_6439 VSS VSS gf180mcu_fd_sc_mcu9t5v0__filltie
XTAP_TAPCELL_ROW_268_6428 VSS VSS gf180mcu_fd_sc_mcu9t5v0__filltie
XTAP_TAPCELL_ROW_37_2005 VSS VSS gf180mcu_fd_sc_mcu9t5v0__filltie
XTAP_TAPCELL_ROW_244_5793 VSS VSS gf180mcu_fd_sc_mcu9t5v0__filltie
XTAP_TAPCELL_ROW_244_5782 VSS VSS gf180mcu_fd_sc_mcu9t5v0__filltie
X_10170_ _10170_/A1 _10170_/A2 _10174_/B VSS VSS VSS VSS gf180mcu_fd_sc_mcu9t5v0__nand2_1
XTAP_TAPCELL_ROW_244_5771 VSS VSS gf180mcu_fd_sc_mcu9t5v0__filltie
XTAP_TAPCELL_ROW_73_2997 VSS VSS gf180mcu_fd_sc_mcu9t5v0__filltie
XTAP_TAPCELL_ROW_73_2986 VSS VSS gf180mcu_fd_sc_mcu9t5v0__filltie
XTAP_TAPCELL_ROW_240_5657 VSS VSS gf180mcu_fd_sc_mcu9t5v0__filltie
XTAP_TAPCELL_ROW_240_5679 VSS VSS gf180mcu_fd_sc_mcu9t5v0__filltie
XTAP_TAPCELL_ROW_240_5668 VSS VSS gf180mcu_fd_sc_mcu9t5v0__filltie
X_13860_ _13861_/A1 _13858_/Z _13860_/Z VSS VSS VSS VSS gf180mcu_fd_sc_mcu9t5v0__and2_1
X_12811_ _12811_/A1 _12812_/A2 _12822_/A2 VSS _12811_/VNW VSS VSS gf180mcu_fd_sc_mcu9t5v0__nand2_1
X_13791_ _13803_/B2 _13795_/A3 _13809_/B VSS VSS VSS VSS gf180mcu_fd_sc_mcu9t5v0__and2_1
X_15530_ _19848_/Q _19831_/Q _15544_/S _19848_/D VSS VSS VSS VSS gf180mcu_fd_sc_mcu9t5v0__mux2_1
X_12742_ _19751_/Q _12740_/Z _12745_/A2 VSS VSS VSS VSS gf180mcu_fd_sc_mcu9t5v0__nor2_1
Xclkbuf_leaf_18_clk_regs clkload4/I clkload57/I VSS VSS VSS VSS gf180mcu_fd_sc_mcu9t5v0__clkbuf_8
X_15461_ _15472_/A2 _15465_/A2 _15463_/A2 VSS VSS VSS VSS gf180mcu_fd_sc_mcu9t5v0__nand2_1
XPHY_EDGE_ROW_239_Left_562 VSS VSS gf180mcu_fd_sc_mcu9t5v0__endcap
XPHY_EDGE_ROW_69_Right_69 VSS VSS gf180mcu_fd_sc_mcu9t5v0__endcap
X_12673_ _12673_/A1 _12673_/A2 _12716_/I0 VSS _12677_/VNW VSS VSS gf180mcu_fd_sc_mcu9t5v0__nor2_1
X_17200_ _17177_/B _17200_/A2 _17201_/C VSS _17200_/VNW VSS VSS gf180mcu_fd_sc_mcu9t5v0__nor2_1
X_11624_ _11632_/B _11659_/A2 _12649_/A3 VSS _11624_/VNW VSS VSS gf180mcu_fd_sc_mcu9t5v0__nand2_1
X_14412_ _14421_/A1 _14689_/A1 _14413_/A2 VSS _14689_/VNW VSS VSS gf180mcu_fd_sc_mcu9t5v0__xnor2_1
X_18180_ _18180_/D clkload82/I _18180_/Q VSS VSS VSS VSS gf180mcu_fd_sc_mcu9t5v0__dffq_4
X_15392_ _19677_/Q _19777_/Q _15420_/S _19777_/D VSS VSS VSS VSS gf180mcu_fd_sc_mcu9t5v0__mux2_1
X_17131_ _17260_/S _18459_/Q _17133_/A3 VSS _17133_/VNW VSS VSS gf180mcu_fd_sc_mcu9t5v0__nor2_1
X_11555_ _18564_/Q _18565_/Q _11557_/B VSS VSS VSS VSS gf180mcu_fd_sc_mcu9t5v0__xor2_1
XPHY_EDGE_ROW_180_1_Right_764 VSS VSS gf180mcu_fd_sc_mcu9t5v0__endcap
X_14343_ _13807_/Z _19414_/Q _14352_/S _19414_/D VSS VSS VSS VSS gf180mcu_fd_sc_mcu9t5v0__mux2_1
X_11486_ _11485_/C _11481_/Z _11486_/B _11526_/B _11487_/B VSS VSS VSS VSS gf180mcu_fd_sc_mcu9t5v0__oai211_1
X_17062_ _18524_/Q _16592_/B _17062_/S _18524_/D VSS VSS VSS VSS gf180mcu_fd_sc_mcu9t5v0__mux2_1
X_10506_ _10654_/A2 _10506_/A2 _10506_/A3 _10507_/B VSS VSS VSS VSS gf180mcu_fd_sc_mcu9t5v0__nand3_1
X_14274_ _13867_/Z _19348_/Q _14285_/S _19348_/D VSS VSS VSS VSS gf180mcu_fd_sc_mcu9t5v0__mux2_1
X_10437_ _10353_/C _10437_/A2 _10437_/B1 _10516_/C _10543_/C _10437_/C2 _10439_/A2
+ VSS VSS VSS VSS gf180mcu_fd_sc_mcu9t5v0__aoi222_1
X_16013_ _19262_/Q _15996_/B _16018_/B VSS VSS VSS VSS gf180mcu_fd_sc_mcu9t5v0__nand2_1
X_13225_ _13225_/A1 _13225_/A2 _13225_/Z VSS VSS VSS VSS gf180mcu_fd_sc_mcu9t5v0__xor2_1
XPHY_EDGE_ROW_78_Right_78 VSS VSS gf180mcu_fd_sc_mcu9t5v0__endcap
XPHY_EDGE_ROW_248_Left_571 VSS VSS gf180mcu_fd_sc_mcu9t5v0__endcap
X_10368_ _10368_/A1 _10368_/A2 _10368_/B1 _10368_/B2 _10368_/ZN VSS VSS VSS VSS gf180mcu_fd_sc_mcu9t5v0__aoi22_4
X_13156_ _19729_/Q _13156_/A2 _13177_/A1 VSS _13156_/VNW VSS VSS gf180mcu_fd_sc_mcu9t5v0__nand2_1
X_10299_ _17198_/A1 _10299_/A2 _10299_/A3 _10299_/B _10300_/B VSS VSS VSS VSS gf180mcu_fd_sc_mcu9t5v0__oai31_1
X_12107_ _18365_/Q _18349_/Q _12315_/S _12107_/Z VSS VSS VSS VSS gf180mcu_fd_sc_mcu9t5v0__mux2_1
X_13087_ _13088_/A1 _19757_/Q _13106_/A2 VSS VSS VSS VSS gf180mcu_fd_sc_mcu9t5v0__nor2_1
X_17964_ _17888_/B _18855_/Q _17951_/Z _18037_/S VSS _17964_/VNW VSS VSS gf180mcu_fd_sc_mcu9t5v0__nand3_2
X_16915_ _16634_/B _19253_/Q _16927_/S _16915_/Z VSS VSS VSS VSS gf180mcu_fd_sc_mcu9t5v0__mux2_1
X_12038_ _12090_/B _12038_/A2 _12038_/A3 _12049_/B1 VSS VSS VSS VSS gf180mcu_fd_sc_mcu9t5v0__nor3_1
X_19703_ _19703_/D _20023_/RN clkload10/I _19703_/Q VSS VSS VSS VSS gf180mcu_fd_sc_mcu9t5v0__dffrnq_1
X_17895_ _17887_/I _17894_/I _17939_/A1 VSS VSS VSS VSS gf180mcu_fd_sc_mcu9t5v0__nor2_1
X_19634_ _19634_/D _20018_/RN clkload21/I _19634_/Q VSS VSS VSS VSS gf180mcu_fd_sc_mcu9t5v0__dffrnq_1
X_16846_ _18415_/Q _16845_/Z _16850_/S _18415_/D VSS VSS VSS VSS gf180mcu_fd_sc_mcu9t5v0__mux2_4
X_16777_ _16647_/B _19287_/Q _16783_/S _16777_/Z VSS VSS VSS VSS gf180mcu_fd_sc_mcu9t5v0__mux2_1
Xeco5_buf_10445 _10445_/ZN _10650_/B1 VSS VSS VSS VSS gf180mcu_fd_sc_mcu9t5v0__clkbuf_16
XTAP_TAPCELL_ROW_83_3271 VSS VSS gf180mcu_fd_sc_mcu9t5v0__filltie
X_13989_ _13915_/I _13989_/A2 _13989_/B _14025_/A1 VSS _14062_/VNW VSS VSS gf180mcu_fd_sc_mcu9t5v0__oai21_1
X_19565_ _19565_/D _20141_/RN clkload8/I _19565_/Q VSS VSS VSS VSS gf180mcu_fd_sc_mcu9t5v0__dffrnq_1
XTAP_TAPCELL_ROW_83_3260 VSS VSS gf180mcu_fd_sc_mcu9t5v0__filltie
X_18516_ _18516_/D _18516_/CLK _18516_/Q VSS VSS VSS VSS gf180mcu_fd_sc_mcu9t5v0__dffq_4
XPHY_EDGE_ROW_257_Left_580 VSS VSS gf180mcu_fd_sc_mcu9t5v0__endcap
X_15728_ _19923_/Q _15728_/A2 _15729_/A2 VSS _15728_/VNW VSS VSS gf180mcu_fd_sc_mcu9t5v0__xnor2_1
XPHY_EDGE_ROW_87_Right_87 VSS VSS gf180mcu_fd_sc_mcu9t5v0__endcap
X_19496_ _19496_/D _20072_/RN clkload35/I _19496_/Q VSS VSS VSS VSS gf180mcu_fd_sc_mcu9t5v0__dffrnq_1
X_18447_ _18447_/D clkload63/I _18447_/Q VSS VSS VSS VSS gf180mcu_fd_sc_mcu9t5v0__dffq_1
X_15659_ _15659_/I _15663_/A2 VSS VSS VSS VSS gf180mcu_fd_sc_mcu9t5v0__clkinv_1
XTAP_TAPCELL_ROW_96_3610 VSS VSS gf180mcu_fd_sc_mcu9t5v0__filltie
X_18378_ _18378_/D _20129_/CLK _18378_/Q VSS VSS VSS VSS gf180mcu_fd_sc_mcu9t5v0__dffq_1
XTAP_TAPCELL_ROW_96_3632 VSS VSS gf180mcu_fd_sc_mcu9t5v0__filltie
XTAP_TAPCELL_ROW_96_3621 VSS VSS gf180mcu_fd_sc_mcu9t5v0__filltie
X_09180_ _19118_/Q _14422_/A2 VSS VSS VSS VSS gf180mcu_fd_sc_mcu9t5v0__clkinv_1
X_17329_ _17306_/C _17329_/A2 _17329_/B _17411_/C _17330_/A2 VSS VSS VSS VSS gf180mcu_fd_sc_mcu9t5v0__oai211_1
XTAP_TAPCELL_ROW_263_6303 VSS VSS gf180mcu_fd_sc_mcu9t5v0__filltie
XTAP_TAPCELL_ROW_92_3518 VSS VSS gf180mcu_fd_sc_mcu9t5v0__filltie
XTAP_TAPCELL_ROW_92_3507 VSS VSS gf180mcu_fd_sc_mcu9t5v0__filltie
XTAP_TAPCELL_ROW_263_6314 VSS VSS gf180mcu_fd_sc_mcu9t5v0__filltie
XTAP_TAPCELL_ROW_77_3097 VSS VSS gf180mcu_fd_sc_mcu9t5v0__filltie
XPHY_EDGE_ROW_96_Right_96 VSS VSS gf180mcu_fd_sc_mcu9t5v0__endcap
XTAP_TAPCELL_ROW_257_6129 VSS VSS gf180mcu_fd_sc_mcu9t5v0__filltie
XTAP_TAPCELL_ROW_6_1144 VSS VSS gf180mcu_fd_sc_mcu9t5v0__filltie
XTAP_TAPCELL_ROW_6_1155 VSS VSS gf180mcu_fd_sc_mcu9t5v0__filltie
X_09516_ _09518_/A1 _09518_/A2 _09517_/I VSS VSS VSS VSS gf180mcu_fd_sc_mcu9t5v0__and2_1
X_09447_ _19913_/Q _09446_/Z _17869_/A1 VSS _09619_/VNW VSS VSS gf180mcu_fd_sc_mcu9t5v0__nand2_1
XTAP_TAPCELL_ROW_66_2790 VSS VSS gf180mcu_fd_sc_mcu9t5v0__filltie
XTAP_TAPCELL_ROW_233_5472 VSS VSS gf180mcu_fd_sc_mcu9t5v0__filltie
XTAP_TAPCELL_ROW_62_2676 VSS VSS gf180mcu_fd_sc_mcu9t5v0__filltie
XTAP_TAPCELL_ROW_62_2687 VSS VSS gf180mcu_fd_sc_mcu9t5v0__filltie
XTAP_TAPCELL_ROW_233_5483 VSS VSS gf180mcu_fd_sc_mcu9t5v0__filltie
XPHY_EDGE_ROW_164_3_Left_822 VSS VSS gf180mcu_fd_sc_mcu9t5v0__endcap
X_09378_ _18895_/Q _11768_/A1 VSS _11768_/VNW VSS VSS gf180mcu_fd_sc_mcu9t5v0__clkinv_1
XTAP_TAPCELL_ROW_62_2698 VSS VSS gf180mcu_fd_sc_mcu9t5v0__filltie
X_11340_ _11423_/A1 _11340_/A2 _11340_/A3 _11340_/B _19090_/D VSS VSS VSS VSS gf180mcu_fd_sc_mcu9t5v0__oai31_1
XTAP_TAPCELL_ROW_246_5844 VSS VSS gf180mcu_fd_sc_mcu9t5v0__filltie
XTAP_TAPCELL_ROW_246_5833 VSS VSS gf180mcu_fd_sc_mcu9t5v0__filltie
XTAP_TAPCELL_ROW_246_5822 VSS VSS gf180mcu_fd_sc_mcu9t5v0__filltie
X_11271_ _18245_/Q wire136/Z _11274_/C VSS VSS VSS VSS gf180mcu_fd_sc_mcu9t5v0__nand2_1
XPHY_EDGE_ROW_170_3_Right_285 VSS VSS gf180mcu_fd_sc_mcu9t5v0__endcap
X_13010_ _13010_/A1 _13010_/A2 _13010_/B1 _13244_/B _13011_/I0 VSS _13010_/VNW VSS
+ VSS gf180mcu_fd_sc_mcu9t5v0__oai22_1
X_10222_ _10237_/A1 _17255_/B1 _17326_/A1 VSS VSS VSS VSS gf180mcu_fd_sc_mcu9t5v0__nand2_1
XTAP_TAPCELL_ROW_242_5719 VSS VSS gf180mcu_fd_sc_mcu9t5v0__filltie
XPHY_EDGE_ROW_160_1_Left_483 VSS VSS gf180mcu_fd_sc_mcu9t5v0__endcap
X_10153_ _18813_/Q _10153_/A2 _10153_/B _10155_/A2 VSS VSS VSS VSS gf180mcu_fd_sc_mcu9t5v0__oai21_1
X_16700_ _16700_/A1 _16700_/A2 _16714_/A3 _16701_/B VSS VSS VSS VSS gf180mcu_fd_sc_mcu9t5v0__nor3_1
X_10084_ _18795_/Q _10154_/A2 _10154_/B _10085_/A3 VSS _10084_/VNW VSS VSS gf180mcu_fd_sc_mcu9t5v0__oai21_1
X_14961_ _14961_/A1 _14959_/Z _14962_/A2 VSS VSS VSS VSS gf180mcu_fd_sc_mcu9t5v0__xnor2_1
X_17680_ _18643_/Q _18719_/Q _17681_/S _18719_/D VSS VSS VSS VSS gf180mcu_fd_sc_mcu9t5v0__mux2_1
X_13912_ _19317_/Q _19299_/Q _19300_/Q _19316_/Q _13916_/A1 VSS VSS VSS VSS gf180mcu_fd_sc_mcu9t5v0__aoi22_1
X_14892_ _19415_/Q _19356_/Q _14896_/A2 VSS VSS VSS VSS gf180mcu_fd_sc_mcu9t5v0__nand2_1
X_16631_ _18353_/Q _16631_/I1 _16670_/S _18353_/D VSS _16807_/VNW VSS VSS gf180mcu_fd_sc_mcu9t5v0__mux2_1
X_13843_ _13843_/A1 _13851_/A1 _13843_/B1 _13843_/B2 _13846_/A3 VSS VSS VSS VSS gf180mcu_fd_sc_mcu9t5v0__oai22_1
X_16562_ _19244_/Q _16750_/A1 _16628_/A2 _16562_/Z VSS VSS VSS VSS gf180mcu_fd_sc_mcu9t5v0__and3_1
X_19350_ _19350_/D _20054_/RN clkload7/I _19350_/Q VSS VSS VSS VSS gf180mcu_fd_sc_mcu9t5v0__dffrnq_1
X_18301_ _18301_/D _18497_/CLK _18301_/Q VSS VSS VSS VSS gf180mcu_fd_sc_mcu9t5v0__dffq_4
X_15513_ _15566_/A1 _15513_/A2 _15515_/A2 _19841_/D VSS VSS VSS VSS gf180mcu_fd_sc_mcu9t5v0__nor3_1
X_10986_ _10986_/A1 _10998_/A3 _10986_/B _10987_/I VSS _10986_/VNW VSS VSS gf180mcu_fd_sc_mcu9t5v0__oai21_1
X_13774_ _19293_/Q _19319_/Q _13843_/A1 VSS _13800_/VNW VSS VSS gf180mcu_fd_sc_mcu9t5v0__nand2_1
X_16493_ _19235_/Q _16151_/B _17023_/S _16493_/Z VSS VSS VSS VSS gf180mcu_fd_sc_mcu9t5v0__mux2_1
X_19281_ _19281_/D _20049_/RN _20054_/CLK _19281_/Q VSS VSS VSS VSS gf180mcu_fd_sc_mcu9t5v0__dffrnq_1
X_12725_ _19191_/Q _17479_/A2 _12726_/A2 VSS VSS VSS VSS gf180mcu_fd_sc_mcu9t5v0__nor2_1
X_18232_ _18232_/D clkload81/I _18232_/Q VSS VSS VSS VSS gf180mcu_fd_sc_mcu9t5v0__dffq_1
X_15444_ _17231_/B _15444_/A2 _15462_/A2 _15445_/B VSS VSS VSS VSS gf180mcu_fd_sc_mcu9t5v0__nand3_1
X_12656_ _12632_/C _11672_/Z _12658_/B VSS _12656_/VNW VSS VSS gf180mcu_fd_sc_mcu9t5v0__nor2_1
X_18163_ _18163_/D clkload79/I _18163_/Q VSS VSS VSS VSS gf180mcu_fd_sc_mcu9t5v0__dffq_1
XTAP_TAPCELL_ROW_134_4680 VSS VSS gf180mcu_fd_sc_mcu9t5v0__filltie
X_15375_ _19660_/Q _19760_/Q _15430_/S _19760_/D VSS VSS VSS VSS gf180mcu_fd_sc_mcu9t5v0__mux2_1
X_12587_ _19169_/Q _12620_/A1 _12588_/B VSS VSS VSS VSS gf180mcu_fd_sc_mcu9t5v0__nand2_1
X_11607_ _12632_/C _11656_/B _12672_/A2 VSS _12654_/VNW VSS VSS gf180mcu_fd_sc_mcu9t5v0__nand2_1
X_17114_ _17326_/A1 _17114_/A2 _17114_/B _17408_/B _17115_/C VSS VSS VSS VSS gf180mcu_fd_sc_mcu9t5v0__aoi211_1
XPHY_EDGE_ROW_181_1_Right_765 VSS VSS gf180mcu_fd_sc_mcu9t5v0__endcap
XTAP_TAPCELL_ROW_130_4544 VSS VSS gf180mcu_fd_sc_mcu9t5v0__filltie
X_14326_ _13772_/Z _19398_/Q _14337_/S _19398_/D VSS VSS VSS VSS gf180mcu_fd_sc_mcu9t5v0__mux2_1
X_11538_ _11469_/B _11537_/Z _11538_/B _11539_/B2 VSS _11538_/VNW VSS VSS gf180mcu_fd_sc_mcu9t5v0__aoi21_1
XTAP_TAPCELL_ROW_212_4899 VSS VSS gf180mcu_fd_sc_mcu9t5v0__filltie
XTAP_TAPCELL_ROW_212_4888 VSS VSS gf180mcu_fd_sc_mcu9t5v0__filltie
XTAP_TAPCELL_ROW_146_3_8034 VSS VSS gf180mcu_fd_sc_mcu9t5v0__filltie
XTAP_TAPCELL_ROW_130_4566 VSS VSS gf180mcu_fd_sc_mcu9t5v0__filltie
XTAP_TAPCELL_ROW_130_4555 VSS VSS gf180mcu_fd_sc_mcu9t5v0__filltie
X_18094_ _18097_/A1 _18094_/A2 _18098_/B _18094_/B _18935_/D VSS _18097_/VNW VSS VSS
+ gf180mcu_fd_sc_mcu9t5v0__oai31_1
Xmax_cap105 _12076_/B _12217_/B VSS max_cap105/VNW VSS VSS gf180mcu_fd_sc_mcu9t5v0__clkbuf_4
X_17045_ _16634_/B _19253_/Q _17055_/S _17045_/Z VSS VSS VSS VSS gf180mcu_fd_sc_mcu9t5v0__mux2_1
X_11469_ _11469_/A1 _11469_/A2 _11469_/B _11469_/C _11470_/B VSS VSS VSS VSS gf180mcu_fd_sc_mcu9t5v0__oai211_1
Xmax_cap138 _11534_/S _11524_/S VSS VSS VSS VSS gf180mcu_fd_sc_mcu9t5v0__clkbuf_8
X_14257_ _14257_/A1 _14257_/A2 _14259_/A2 VSS _14257_/VNW VSS VSS gf180mcu_fd_sc_mcu9t5v0__xnor2_1
X_13208_ _13190_/Z _13209_/A2 _13566_/B _13211_/A1 VSS VSS VSS VSS gf180mcu_fd_sc_mcu9t5v0__nand3_1
X_14188_ _13994_/B _14188_/A2 _14114_/Z _14263_/A1 VSS VSS VSS VSS gf180mcu_fd_sc_mcu9t5v0__nand3_1
X_13139_ _13118_/Z _13140_/A2 _13546_/B _13142_/A1 VSS _13139_/VNW VSS VSS gf180mcu_fd_sc_mcu9t5v0__nand3_1
X_18996_ _18996_/D _20020_/RN clkload67/I _18996_/Q VSS VSS VSS VSS gf180mcu_fd_sc_mcu9t5v0__dffrnq_1
XTAP_TAPCELL_ROW_128_4495 VSS VSS gf180mcu_fd_sc_mcu9t5v0__filltie
XTAP_TAPCELL_ROW_85_3322 VSS VSS gf180mcu_fd_sc_mcu9t5v0__filltie
X_17947_ _18852_/Q _17941_/Z _18853_/Q _17948_/A2 VSS _17947_/VNW VSS VSS gf180mcu_fd_sc_mcu9t5v0__aoi21_1
XTAP_TAPCELL_ROW_85_3311 VSS VSS gf180mcu_fd_sc_mcu9t5v0__filltie
XTAP_TAPCELL_ROW_85_3333 VSS VSS gf180mcu_fd_sc_mcu9t5v0__filltie
X_17878_ _17878_/A1 _17878_/A2 _17878_/B1 _17879_/A2 _18831_/D VSS VSS VSS VSS gf180mcu_fd_sc_mcu9t5v0__aoi22_1
X_16829_ _19291_/Q _16829_/A2 _16831_/A2 VSS _16829_/VNW VSS VSS gf180mcu_fd_sc_mcu9t5v0__nand2_1
XTAP_TAPCELL_ROW_252_6004 VSS VSS gf180mcu_fd_sc_mcu9t5v0__filltie
XTAP_TAPCELL_ROW_81_3219 VSS VSS gf180mcu_fd_sc_mcu9t5v0__filltie
XTAP_TAPCELL_ROW_81_3208 VSS VSS gf180mcu_fd_sc_mcu9t5v0__filltie
X_19617_ _19617_/D _20065_/RN clkload20/I _19617_/Q VSS VSS VSS VSS gf180mcu_fd_sc_mcu9t5v0__dffrnq_1
X_19548_ _19548_/D _20060_/RN clkload36/I _19548_/Q VSS VSS VSS VSS gf180mcu_fd_sc_mcu9t5v0__dffrnq_1
X_09301_ _19256_/Q _16734_/A1 VSS VSS VSS VSS gf180mcu_fd_sc_mcu9t5v0__clkinv_1
X_19479_ _19479_/D _20055_/RN clkload13/I _19479_/Q VSS VSS VSS VSS gf180mcu_fd_sc_mcu9t5v0__dffrnq_1
X_09232_ _19298_/Q _14120_/A1 VSS VSS VSS VSS gf180mcu_fd_sc_mcu9t5v0__clkinv_1
XTAP_TAPCELL_ROW_79_3148 VSS VSS gf180mcu_fd_sc_mcu9t5v0__filltie
X_09163_ _19747_/Q _13469_/A1 VSS _11503_/VNW VSS VSS gf180mcu_fd_sc_mcu9t5v0__clkinv_1
XTAP_TAPCELL_ROW_79_3159 VSS VSS gf180mcu_fd_sc_mcu9t5v0__filltie
X_09094_ _19019_/Q _09768_/A1 VSS VSS VSS VSS gf180mcu_fd_sc_mcu9t5v0__clkinv_1
XPHY_EDGE_ROW_15_Left_339 VSS VSS gf180mcu_fd_sc_mcu9t5v0__endcap
XTAP_TAPCELL_ROW_70_2912 VSS VSS gf180mcu_fd_sc_mcu9t5v0__filltie
XTAP_TAPCELL_ROW_70_2901 VSS VSS gf180mcu_fd_sc_mcu9t5v0__filltie
XTAP_TAPCELL_ROW_55_2491 VSS VSS gf180mcu_fd_sc_mcu9t5v0__filltie
X_09996_ _10028_/B _10030_/A1 _09996_/B _10005_/A2 VSS _09997_/VNW VSS VSS gf180mcu_fd_sc_mcu9t5v0__oai21_1
XTAP_TAPCELL_ROW_8_1206 VSS VSS gf180mcu_fd_sc_mcu9t5v0__filltie
XTAP_TAPCELL_ROW_222_5184 VSS VSS gf180mcu_fd_sc_mcu9t5v0__filltie
XTAP_TAPCELL_ROW_222_5173 VSS VSS gf180mcu_fd_sc_mcu9t5v0__filltie
XTAP_TAPCELL_ROW_222_5162 VSS VSS gf180mcu_fd_sc_mcu9t5v0__filltie
XTAP_TAPCELL_ROW_51_2377 VSS VSS gf180mcu_fd_sc_mcu9t5v0__filltie
XTAP_TAPCELL_ROW_51_2388 VSS VSS gf180mcu_fd_sc_mcu9t5v0__filltie
XTAP_TAPCELL_ROW_68_2863 VSS VSS gf180mcu_fd_sc_mcu9t5v0__filltie
XTAP_TAPCELL_ROW_68_2852 VSS VSS gf180mcu_fd_sc_mcu9t5v0__filltie
XPHY_EDGE_ROW_24_Left_348 VSS VSS gf180mcu_fd_sc_mcu9t5v0__endcap
Xrst_tree_mid_3 rst_tree_root/Z rst_tree_mid_3/Z VSS VSS VSS VSS gf180mcu_fd_sc_mcu9t5v0__clkbuf_16
XTAP_TAPCELL_ROW_68_2841 VSS VSS gf180mcu_fd_sc_mcu9t5v0__filltie
XTAP_TAPCELL_ROW_235_5523 VSS VSS gf180mcu_fd_sc_mcu9t5v0__filltie
X_10840_ _09753_/B _10840_/A2 _10840_/B _20071_/D VSS VSS VSS VSS gf180mcu_fd_sc_mcu9t5v0__aoi21_1
XTAP_TAPCELL_ROW_64_2738 VSS VSS gf180mcu_fd_sc_mcu9t5v0__filltie
XTAP_TAPCELL_ROW_235_5545 VSS VSS gf180mcu_fd_sc_mcu9t5v0__filltie
XTAP_TAPCELL_ROW_235_5534 VSS VSS gf180mcu_fd_sc_mcu9t5v0__filltie
XTAP_TAPCELL_ROW_152_3_8055 VSS VSS gf180mcu_fd_sc_mcu9t5v0__filltie
XTAP_TAPCELL_ROW_64_2749 VSS VSS gf180mcu_fd_sc_mcu9t5v0__filltie
X_10771_ _10648_/C _20059_/Q _10821_/B _10773_/B1 VSS VSS VSS VSS gf180mcu_fd_sc_mcu9t5v0__nand3_1
X_12510_ _12541_/B _12510_/A2 _12510_/A3 _12510_/B _12511_/B2 VSS VSS VSS VSS gf180mcu_fd_sc_mcu9t5v0__oai31_2
X_13490_ _19749_/Q _19781_/Q _13496_/A1 VSS VSS VSS VSS gf180mcu_fd_sc_mcu9t5v0__xnor2_1
X_12441_ _18307_/Q _12608_/A2 wire146/Z _12442_/B2 VSS VSS VSS VSS gf180mcu_fd_sc_mcu9t5v0__oai21_1
XPHY_EDGE_ROW_33_Left_357 VSS VSS gf180mcu_fd_sc_mcu9t5v0__endcap
X_12372_ _12628_/A1 _12355_/I _12372_/A3 _12372_/B _19142_/D VSS VSS VSS VSS gf180mcu_fd_sc_mcu9t5v0__oai31_1
X_15160_ _19702_/Q _19542_/Q _15163_/S _19702_/D VSS VSS VSS VSS gf180mcu_fd_sc_mcu9t5v0__mux2_1
XPHY_EDGE_ROW_193_2_Left_705 VSS VSS gf180mcu_fd_sc_mcu9t5v0__endcap
X_14111_ _14111_/A1 _14111_/A2 _14113_/A1 VSS VSS VSS VSS gf180mcu_fd_sc_mcu9t5v0__nand2_1
X_11323_ _18580_/Q _12689_/A2 _12028_/A1 _18571_/Q _12689_/C _11325_/A2 VSS VSS VSS
+ VSS gf180mcu_fd_sc_mcu9t5v0__oai221_1
X_15091_ _20039_/Q _15093_/A2 _15092_/A2 VSS _15091_/VNW VSS VSS gf180mcu_fd_sc_mcu9t5v0__nand2_1
X_11254_ _11526_/B _11254_/A2 _11254_/B1 _11254_/B2 _11788_/B _11255_/B2 VSS VSS VSS
+ VSS gf180mcu_fd_sc_mcu9t5v0__aoi221_2
X_14042_ _19319_/Q _19300_/Q _14106_/B2 VSS _14074_/VNW VSS VSS gf180mcu_fd_sc_mcu9t5v0__nand2_1
X_10205_ _18769_/Q _18790_/Q _17807_/S _20049_/D VSS _10205_/VNW VSS VSS gf180mcu_fd_sc_mcu9t5v0__and3_1
XPHY_EDGE_ROW_171_3_Right_286 VSS VSS gf180mcu_fd_sc_mcu9t5v0__endcap
X_18850_ _18850_/D _20066_/RN clkload33/I _18850_/Q VSS VSS VSS VSS gf180mcu_fd_sc_mcu9t5v0__dffrnq_1
X_17801_ wire301/Z _18779_/Q _17807_/S _18779_/D VSS VSS VSS VSS gf180mcu_fd_sc_mcu9t5v0__mux2_1
X_11185_ _11321_/A2 _11185_/A2 _11185_/A3 _11185_/B _19078_/D VSS VSS VSS VSS gf180mcu_fd_sc_mcu9t5v0__oai31_1
X_10136_ _18961_/Q wire172/Z _10136_/B1 _18985_/Q _10137_/A2 VSS _10420_/VNW VSS VSS
+ gf180mcu_fd_sc_mcu9t5v0__aoi22_1
X_18781_ _18781_/D _20061_/RN clkload64/I _18781_/Q VSS VSS VSS VSS gf180mcu_fd_sc_mcu9t5v0__dffrnq_1
X_15993_ _16106_/A1 _16511_/A1 _16107_/B _16107_/C wire71/I VSS VSS VSS VSS gf180mcu_fd_sc_mcu9t5v0__nand4_4
X_10067_ _10067_/A1 _10067_/A2 _10067_/A3 _10067_/A4 _10081_/B VSS VSS VSS VSS gf180mcu_fd_sc_mcu9t5v0__nand4_1
X_17732_ _18742_/Q _17673_/S _17733_/B VSS _17732_/VNW VSS VSS gf180mcu_fd_sc_mcu9t5v0__nand2_1
XPHY_EDGE_ROW_42_Left_366 VSS VSS gf180mcu_fd_sc_mcu9t5v0__endcap
X_14944_ _19608_/Q _19364_/Q _20039_/D _19608_/D VSS VSS VSS VSS gf180mcu_fd_sc_mcu9t5v0__mux2_1
XTAP_TAPCELL_ROW_317_7792 VSS VSS gf180mcu_fd_sc_mcu9t5v0__filltie
XTAP_TAPCELL_ROW_317_7781 VSS VSS gf180mcu_fd_sc_mcu9t5v0__filltie
XTAP_TAPCELL_ROW_292_7096 VSS VSS gf180mcu_fd_sc_mcu9t5v0__filltie
Xclkbuf_leaf_33_clk_regs clkload5/I _20132_/CLK VSS VSS VSS VSS gf180mcu_fd_sc_mcu9t5v0__clkbuf_8
X_17663_ _18626_/Q _18702_/Q _17681_/S _18702_/D VSS VSS VSS VSS gf180mcu_fd_sc_mcu9t5v0__mux2_1
XTAP_TAPCELL_ROW_123_4370 VSS VSS gf180mcu_fd_sc_mcu9t5v0__filltie
X_16614_ _16668_/A1 _16668_/A2 _16614_/B _16616_/A3 VSS VSS VSS VSS gf180mcu_fd_sc_mcu9t5v0__aoi21_1
X_14875_ _14876_/A1 _14874_/Z _14879_/A2 VSS VSS VSS VSS gf180mcu_fd_sc_mcu9t5v0__nand2_1
X_19402_ _19402_/D _20042_/RN clkload17/I _19402_/Q VSS VSS VSS VSS gf180mcu_fd_sc_mcu9t5v0__dffrnq_1
XTAP_TAPCELL_ROW_313_7689 VSS VSS gf180mcu_fd_sc_mcu9t5v0__filltie
XTAP_TAPCELL_ROW_313_7678 VSS VSS gf180mcu_fd_sc_mcu9t5v0__filltie
XTAP_TAPCELL_ROW_313_7667 VSS VSS gf180mcu_fd_sc_mcu9t5v0__filltie
X_17594_ input5/Z _18659_/Q _17597_/S _18659_/D VSS _17594_/VNW VSS VSS gf180mcu_fd_sc_mcu9t5v0__mux2_1
X_13826_ _13788_/Z _13838_/A1 _13838_/A2 _13828_/A2 VSS VSS VSS VSS gf180mcu_fd_sc_mcu9t5v0__xnor3_1
X_16545_ _16198_/C _16545_/A2 _16545_/A3 _16545_/ZN VSS VSS VSS VSS gf180mcu_fd_sc_mcu9t5v0__nor3_4
X_10969_ _10969_/A1 _10969_/A2 _10972_/A2 VSS _10969_/VNW VSS VSS gf180mcu_fd_sc_mcu9t5v0__nor2_1
X_13757_ _19316_/Q _19292_/Q _13757_/Z VSS VSS VSS VSS gf180mcu_fd_sc_mcu9t5v0__and2_1
X_19333_ _19333_/D _20037_/RN clkload7/I _19333_/Q VSS VSS VSS VSS gf180mcu_fd_sc_mcu9t5v0__dffrnq_1
X_16476_ _18296_/Q _16475_/Z _16990_/S _18296_/D VSS VSS VSS VSS gf180mcu_fd_sc_mcu9t5v0__mux2_4
X_12708_ _12724_/A2 _12707_/Z _12708_/Z VSS _12708_/VNW VSS VSS gf180mcu_fd_sc_mcu9t5v0__xor2_1
X_19264_ _19264_/D _09246_/I clkload27/I _19264_/Q VSS VSS VSS VSS gf180mcu_fd_sc_mcu9t5v0__dffrnq_1
X_18215_ _18215_/D clkload69/I _18215_/Q VSS VSS VSS VSS gf180mcu_fd_sc_mcu9t5v0__dffq_1
XTAP_TAPCELL_ROW_132_4617 VSS VSS gf180mcu_fd_sc_mcu9t5v0__filltie
X_15427_ _19712_/Q _19812_/Q _15430_/S _19812_/D VSS VSS VSS VSS gf180mcu_fd_sc_mcu9t5v0__mux2_1
XTAP_TAPCELL_ROW_132_4606 VSS VSS gf180mcu_fd_sc_mcu9t5v0__filltie
X_13688_ _13698_/A2 _14590_/B _13688_/B _13689_/A2 VSS _13688_/VNW VSS VSS gf180mcu_fd_sc_mcu9t5v0__aoi21_1
XPHY_EDGE_ROW_51_Left_375 VSS VSS gf180mcu_fd_sc_mcu9t5v0__endcap
X_19195_ _19195_/D _19963_/RN _20054_/CLK _19195_/Q VSS VSS VSS VSS gf180mcu_fd_sc_mcu9t5v0__dffrnq_1
XTAP_TAPCELL_ROW_117_4196 VSS VSS gf180mcu_fd_sc_mcu9t5v0__filltie
X_12639_ _12632_/C _12670_/A2 _12675_/B VSS _12639_/VNW VSS VSS gf180mcu_fd_sc_mcu9t5v0__nand2_1
XTAP_TAPCELL_ROW_74_3012 VSS VSS gf180mcu_fd_sc_mcu9t5v0__filltie
X_18146_ _18145_/Z _18960_/Q _18152_/S _18960_/D VSS VSS VSS VSS gf180mcu_fd_sc_mcu9t5v0__mux2_1
XTAP_TAPCELL_ROW_74_3023 VSS VSS gf180mcu_fd_sc_mcu9t5v0__filltie
X_15358_ _19648_/Q _19625_/Q _15362_/B VSS VSS VSS VSS gf180mcu_fd_sc_mcu9t5v0__nand2_1
XPHY_EDGE_ROW_182_1_Right_766 VSS VSS gf180mcu_fd_sc_mcu9t5v0__endcap
X_18077_ _18930_/Q _18062_/I _18080_/A1 VSS VSS VSS VSS gf180mcu_fd_sc_mcu9t5v0__nand2_1
X_15289_ _15271_/Z _15289_/A2 _15288_/B _15289_/Z VSS VSS VSS VSS gf180mcu_fd_sc_mcu9t5v0__or3_1
X_14309_ _13807_/Z _19382_/Q _14322_/S _19382_/D VSS VSS VSS VSS gf180mcu_fd_sc_mcu9t5v0__mux2_1
X_17028_ _17027_/Z _18505_/Q _17034_/S _18505_/D VSS VSS VSS VSS gf180mcu_fd_sc_mcu9t5v0__mux2_1
Xload_slew130 _12153_/B _12261_/B VSS _16625_/VNW VSS VSS gf180mcu_fd_sc_mcu9t5v0__clkbuf_8
X_09850_ _20030_/Q _09849_/B _09851_/B VSS VSS VSS VSS gf180mcu_fd_sc_mcu9t5v0__nand2_1
XPHY_EDGE_ROW_60_Left_384 VSS VSS gf180mcu_fd_sc_mcu9t5v0__endcap
X_18979_ _18979_/D _20067_/RN _20132_/CLK _18979_/Q VSS VSS VSS VSS gf180mcu_fd_sc_mcu9t5v0__dffrnq_1
Xload_slew152 _12501_/A2 _12615_/A2 VSS VSS VSS VSS gf180mcu_fd_sc_mcu9t5v0__clkbuf_8
X_09781_ _18837_/Q _18836_/Q _18838_/Q _17902_/A1 VSS VSS VSS VSS gf180mcu_fd_sc_mcu9t5v0__aoi21_1
XTAP_TAPCELL_ROW_102_3797 VSS VSS gf180mcu_fd_sc_mcu9t5v0__filltie
XTAP_TAPCELL_ROW_102_3786 VSS VSS gf180mcu_fd_sc_mcu9t5v0__filltie
XTAP_TAPCELL_ROW_102_3775 VSS VSS gf180mcu_fd_sc_mcu9t5v0__filltie
XTAP_TAPCELL_ROW_288_6987 VSS VSS gf180mcu_fd_sc_mcu9t5v0__filltie
X_09215_ _19569_/Q _15211_/A2 VSS VSS VSS VSS gf180mcu_fd_sc_mcu9t5v0__clkinv_1
XTAP_TAPCELL_ROW_44_2181 VSS VSS gf180mcu_fd_sc_mcu9t5v0__filltie
XTAP_TAPCELL_ROW_44_2192 VSS VSS gf180mcu_fd_sc_mcu9t5v0__filltie
XTAP_TAPCELL_ROW_288_6998 VSS VSS gf180mcu_fd_sc_mcu9t5v0__filltie
XTAP_TAPCELL_ROW_40_2078 VSS VSS gf180mcu_fd_sc_mcu9t5v0__filltie
XTAP_TAPCELL_ROW_40_2089 VSS VSS gf180mcu_fd_sc_mcu9t5v0__filltie
X_09146_ _19737_/Q _13281_/A1 VSS VSS VSS VSS gf180mcu_fd_sc_mcu9t5v0__clkinv_1
X_09077_ _20003_/Q _15705_/B VSS _09638_/VNW VSS VSS gf180mcu_fd_sc_mcu9t5v0__clkinv_1
XTAP_TAPCELL_ROW_57_2542 VSS VSS gf180mcu_fd_sc_mcu9t5v0__filltie
XTAP_TAPCELL_ROW_57_2553 VSS VSS gf180mcu_fd_sc_mcu9t5v0__filltie
XTAP_TAPCELL_ROW_224_5235 VSS VSS gf180mcu_fd_sc_mcu9t5v0__filltie
XTAP_TAPCELL_ROW_224_5224 VSS VSS gf180mcu_fd_sc_mcu9t5v0__filltie
XTAP_TAPCELL_ROW_53_2428 VSS VSS gf180mcu_fd_sc_mcu9t5v0__filltie
XTAP_TAPCELL_ROW_53_2439 VSS VSS gf180mcu_fd_sc_mcu9t5v0__filltie
X_09979_ _15827_/B _19993_/Q _09979_/A3 _10006_/B1 VSS _10629_/VNW VSS VSS gf180mcu_fd_sc_mcu9t5v0__nand3_1
X_20099_ _20099_/D _20099_/CLK _20099_/Q VSS VSS VSS VSS gf180mcu_fd_sc_mcu9t5v0__dffq_1
X_12990_ _13244_/B _12990_/A2 _12991_/B2 VSS _12990_/VNW VSS VSS gf180mcu_fd_sc_mcu9t5v0__nand2_1
X_11941_ _12348_/C _11941_/A2 _11942_/B2 VSS _11941_/VNW VSS VSS gf180mcu_fd_sc_mcu9t5v0__nand2_1
X_11872_ _11872_/A1 _11872_/A2 _11872_/B1 _11872_/B2 _11873_/A2 VSS VSS VSS VSS gf180mcu_fd_sc_mcu9t5v0__aoi22_1
X_14660_ _19144_/Q _19110_/Q _14660_/B _14662_/A2 VSS _14660_/VNW VSS VSS gf180mcu_fd_sc_mcu9t5v0__aoi21_1
X_10823_ _20064_/Q _10823_/A2 _10825_/B1 VSS VSS VSS VSS gf180mcu_fd_sc_mcu9t5v0__nor2_1
XPHY_EDGE_ROW_105_Right_105 VSS VSS gf180mcu_fd_sc_mcu9t5v0__endcap
X_13611_ _13608_/B _13374_/B _13605_/Z _13615_/B _13612_/A2 VSS VSS VSS VSS gf180mcu_fd_sc_mcu9t5v0__oai31_1
X_14591_ _14591_/A1 _14764_/A1 _14594_/B _14593_/B1 VSS _14591_/VNW VSS VSS gf180mcu_fd_sc_mcu9t5v0__oai21_1
X_16330_ _18230_/Q _16329_/Z _16854_/S _18230_/D VSS VSS VSS VSS gf180mcu_fd_sc_mcu9t5v0__mux2_4
X_13542_ _13546_/A1 _13542_/A2 _13542_/B _19269_/D VSS VSS VSS VSS gf180mcu_fd_sc_mcu9t5v0__oai21_1
X_10754_ _10754_/I _10755_/B VSS _10754_/VNW VSS VSS gf180mcu_fd_sc_mcu9t5v0__clkinv_1
X_16261_ _19267_/Q _16815_/A2 _16263_/A1 VSS _16262_/VNW VSS VSS gf180mcu_fd_sc_mcu9t5v0__nand2_1
X_18000_ _18886_/Q _18033_/I0 _18004_/S _18886_/D VSS VSS VSS VSS gf180mcu_fd_sc_mcu9t5v0__mux2_1
X_13473_ _19780_/Q _13475_/A2 _13489_/A1 VSS VSS VSS VSS gf180mcu_fd_sc_mcu9t5v0__nor2_1
X_10685_ _18839_/Q _18846_/Q _10686_/I VSS _10685_/VNW VSS VSS gf180mcu_fd_sc_mcu9t5v0__xnor2_1
X_16192_ _19275_/Q _16751_/B _16195_/A2 VSS VSS VSS VSS gf180mcu_fd_sc_mcu9t5v0__nor2_1
X_12424_ _18257_/Q _12615_/A2 _12426_/B1 VSS VSS VSS VSS gf180mcu_fd_sc_mcu9t5v0__nor2_1
X_15212_ _19592_/Q _19569_/Q _15216_/A1 _15213_/I0 VSS VSS VSS VSS gf180mcu_fd_sc_mcu9t5v0__xnor3_1
XTAP_TAPCELL_ROW_321_7903 VSS VSS gf180mcu_fd_sc_mcu9t5v0__filltie
XTAP_TAPCELL_ROW_112_4071 VSS VSS gf180mcu_fd_sc_mcu9t5v0__filltie
XTAP_TAPCELL_ROW_112_4060 VSS VSS gf180mcu_fd_sc_mcu9t5v0__filltie
X_15143_ _19685_/Q _19525_/Q _15148_/S _19685_/D VSS VSS VSS VSS gf180mcu_fd_sc_mcu9t5v0__mux2_1
X_12355_ _12355_/I _17473_/A2 VSS VSS VSS VSS gf180mcu_fd_sc_mcu9t5v0__clkinv_1
XTAP_TAPCELL_ROW_306_7493 VSS VSS gf180mcu_fd_sc_mcu9t5v0__filltie
XTAP_TAPCELL_ROW_306_7482 VSS VSS gf180mcu_fd_sc_mcu9t5v0__filltie
X_11306_ _18873_/Q _11878_/A1 _11320_/B1 _11306_/B2 _11320_/C _11308_/A1 VSS VSS VSS
+ VSS gf180mcu_fd_sc_mcu9t5v0__oai221_1
X_12286_ _12286_/A1 _12286_/A2 _12286_/B1 _12286_/B2 _12320_/C _12292_/B1 VSS _12286_/VNW
+ VSS VSS gf180mcu_fd_sc_mcu9t5v0__aoi221_1
XTAP_TAPCELL_ROW_302_7379 VSS VSS gf180mcu_fd_sc_mcu9t5v0__filltie
XTAP_TAPCELL_ROW_302_7368 VSS VSS gf180mcu_fd_sc_mcu9t5v0__filltie
XTAP_TAPCELL_ROW_298_7261 VSS VSS gf180mcu_fd_sc_mcu9t5v0__filltie
X_19951_ _19951_/D _20143_/RN clkload66/I _19951_/Q VSS VSS VSS VSS gf180mcu_fd_sc_mcu9t5v0__dffrnq_1
X_15074_ _19310_/Q _19395_/Q _15074_/Z VSS _15077_/VNW VSS VSS gf180mcu_fd_sc_mcu9t5v0__or2_1
X_11237_ _11485_/C _11237_/A2 _11237_/A3 _11238_/B VSS VSS VSS VSS gf180mcu_fd_sc_mcu9t5v0__nand3_1
XTAP_TAPCELL_ROW_298_7272 VSS VSS gf180mcu_fd_sc_mcu9t5v0__filltie
XPHY_EDGE_ROW_172_3_Right_287 VSS VSS gf180mcu_fd_sc_mcu9t5v0__endcap
X_19882_ _19882_/D _20138_/RN clkload45/I _19882_/Q VSS VSS VSS VSS gf180mcu_fd_sc_mcu9t5v0__dffrnq_1
XTAP_TAPCELL_ROW_125_4410 VSS VSS gf180mcu_fd_sc_mcu9t5v0__filltie
X_14025_ _14025_/A1 _14023_/I _14025_/Z VSS VSS VSS VSS gf180mcu_fd_sc_mcu9t5v0__xor2_1
X_18902_ _18902_/D _20054_/RN clkload43/I _18902_/Q VSS VSS VSS VSS gf180mcu_fd_sc_mcu9t5v0__dffrnq_1
XTAP_TAPCELL_ROW_294_7169 VSS VSS gf180mcu_fd_sc_mcu9t5v0__filltie
XTAP_TAPCELL_ROW_319_7843 VSS VSS gf180mcu_fd_sc_mcu9t5v0__filltie
X_11168_ _18334_/Q _18318_/Q _11524_/S _11168_/Z VSS VSS VSS VSS gf180mcu_fd_sc_mcu9t5v0__mux2_1
XTAP_TAPCELL_ROW_294_7158 VSS VSS gf180mcu_fd_sc_mcu9t5v0__filltie
XTAP_TAPCELL_ROW_319_7832 VSS VSS gf180mcu_fd_sc_mcu9t5v0__filltie
XTAP_TAPCELL_ROW_294_7147 VSS VSS gf180mcu_fd_sc_mcu9t5v0__filltie
XTAP_TAPCELL_ROW_125_4432 VSS VSS gf180mcu_fd_sc_mcu9t5v0__filltie
XTAP_TAPCELL_ROW_125_4421 VSS VSS gf180mcu_fd_sc_mcu9t5v0__filltie
XTAP_TAPCELL_ROW_36_1969 VSS VSS gf180mcu_fd_sc_mcu9t5v0__filltie
X_18833_ _18833_/D _20049_/RN clkload13/I _18833_/Q VSS VSS VSS VSS gf180mcu_fd_sc_mcu9t5v0__dffrnq_1
XTAP_TAPCELL_ROW_319_7854 VSS VSS gf180mcu_fd_sc_mcu9t5v0__filltie
X_10119_ _19258_/Q wire285/I _09998_/C _19234_/Q _10119_/C _10141_/A2 VSS _10175_/VNW
+ VSS VSS gf180mcu_fd_sc_mcu9t5v0__aoi221_1
X_18764_ _18764_/D _20044_/RN clkload51/I _18764_/Q VSS VSS VSS VSS gf180mcu_fd_sc_mcu9t5v0__dffrnq_1
XTAP_TAPCELL_ROW_121_4318 VSS VSS gf180mcu_fd_sc_mcu9t5v0__filltie
XTAP_TAPCELL_ROW_121_4307 VSS VSS gf180mcu_fd_sc_mcu9t5v0__filltie
XTAP_TAPCELL_ROW_315_7729 VSS VSS gf180mcu_fd_sc_mcu9t5v0__filltie
X_11099_ _18297_/Q _11403_/S _11099_/B _11100_/B1 VSS VSS VSS VSS gf180mcu_fd_sc_mcu9t5v0__oai21_1
X_15976_ _16199_/A1 _16545_/A3 _16197_/C _16105_/A1 _15976_/Z VSS VSS VSS VSS gf180mcu_fd_sc_mcu9t5v0__and4_1
X_17715_ _17715_/I _18733_/D VSS _17732_/VNW VSS VSS gf180mcu_fd_sc_mcu9t5v0__clkinv_1
X_18695_ _18695_/D clkload48/I _18695_/Q VSS VSS VSS VSS gf180mcu_fd_sc_mcu9t5v0__dffq_1
XTAP_TAPCELL_ROW_144_1_4742 VSS VSS gf180mcu_fd_sc_mcu9t5v0__filltie
X_14927_ _19359_/Q _19421_/Q _14927_/Z VSS VSS VSS VSS gf180mcu_fd_sc_mcu9t5v0__xor2_1
X_17646_ _18690_/Q _17646_/A2 _17646_/B _18690_/D VSS _17646_/VNW VSS VSS gf180mcu_fd_sc_mcu9t5v0__oai21_1
X_14858_ _19584_/Q _19345_/Q wire108/I _19584_/D VSS VSS VSS VSS gf180mcu_fd_sc_mcu9t5v0__mux2_1
X_17577_ _09065_/I _18645_/Q _17577_/S _18645_/D VSS VSS VSS VSS gf180mcu_fd_sc_mcu9t5v0__mux2_1
X_13809_ _13781_/B _13793_/Z _13809_/B _13831_/A2 VSS _13831_/VNW VSS VSS gf180mcu_fd_sc_mcu9t5v0__aoi21_1
X_16528_ _16527_/Z _18320_/Q _17050_/S _18320_/D VSS VSS VSS VSS gf180mcu_fd_sc_mcu9t5v0__mux2_4
XTAP_TAPCELL_ROW_270_6490 VSS VSS gf180mcu_fd_sc_mcu9t5v0__filltie
XTAP_TAPCELL_ROW_119_4258 VSS VSS gf180mcu_fd_sc_mcu9t5v0__filltie
XTAP_TAPCELL_ROW_119_4247 VSS VSS gf180mcu_fd_sc_mcu9t5v0__filltie
X_19316_ _19316_/D _20020_/RN clkload12/I _19316_/Q VSS VSS VSS VSS gf180mcu_fd_sc_mcu9t5v0__dffrnq_1
X_14789_ _14790_/A1 _14788_/Z _14793_/A2 VSS VSS VSS VSS gf180mcu_fd_sc_mcu9t5v0__nand2_1
X_16459_ _19235_/Q _16151_/B _16991_/S _16459_/Z VSS VSS VSS VSS gf180mcu_fd_sc_mcu9t5v0__mux2_1
X_19247_ _19247_/D _20143_/RN clkload25/I _19247_/Q VSS VSS VSS VSS gf180mcu_fd_sc_mcu9t5v0__dffrnq_2
XTAP_TAPCELL_ROW_283_6851 VSS VSS gf180mcu_fd_sc_mcu9t5v0__filltie
XTAP_TAPCELL_ROW_283_6840 VSS VSS gf180mcu_fd_sc_mcu9t5v0__filltie
X_19178_ _19178_/D _20138_/RN clkload13/I _19178_/Q VSS VSS VSS VSS gf180mcu_fd_sc_mcu9t5v0__dffrnq_1
XTAP_TAPCELL_ROW_283_6862 VSS VSS gf180mcu_fd_sc_mcu9t5v0__filltie
X_18129_ _18129_/I0 _18951_/Q _18148_/S _18951_/D VSS VSS VSS VSS gf180mcu_fd_sc_mcu9t5v0__mux2_1
XPHY_EDGE_ROW_183_1_Right_767 VSS VSS gf180mcu_fd_sc_mcu9t5v0__endcap
X_09902_ _10659_/C _18987_/Q _09981_/B _19244_/Q wire297/Z _09939_/B2 VSS _18103_/VNW
+ VSS VSS gf180mcu_fd_sc_mcu9t5v0__oai221_1
XPHY_EDGE_ROW_256_Right_183 VSS VSS gf180mcu_fd_sc_mcu9t5v0__endcap
X_20022_ _20022_/D _20022_/RN clkload50/I _20022_/Q VSS VSS VSS VSS gf180mcu_fd_sc_mcu9t5v0__dffrnq_1
X_09833_ _09416_/C _10657_/B _17888_/A2 _18060_/B _09833_/B2 _09834_/A4 VSS _10190_/VNW
+ VSS VSS gf180mcu_fd_sc_mcu9t5v0__oai32_1
XPHY_EDGE_ROW_173_3_Left_831 VSS VSS gf180mcu_fd_sc_mcu9t5v0__endcap
XTAP_TAPCELL_ROW_108_3951 VSS VSS gf180mcu_fd_sc_mcu9t5v0__filltie
XTAP_TAPCELL_ROW_108_3940 VSS VSS gf180mcu_fd_sc_mcu9t5v0__filltie
XTAP_TAPCELL_ROW_277_6699 VSS VSS gf180mcu_fd_sc_mcu9t5v0__filltie
XTAP_TAPCELL_ROW_277_6688 VSS VSS gf180mcu_fd_sc_mcu9t5v0__filltie
XTAP_TAPCELL_ROW_277_6677 VSS VSS gf180mcu_fd_sc_mcu9t5v0__filltie
XTAP_TAPCELL_ROW_108_3962 VSS VSS gf180mcu_fd_sc_mcu9t5v0__filltie
X_09764_ _09767_/A2 _09835_/A1 _09765_/B VSS VSS VSS VSS gf180mcu_fd_sc_mcu9t5v0__nand2_1
XTAP_TAPCELL_ROW_104_3848 VSS VSS gf180mcu_fd_sc_mcu9t5v0__filltie
X_09695_ _20010_/Q _09688_/B _09695_/A3 _09696_/A2 VSS VSS VSS VSS gf180mcu_fd_sc_mcu9t5v0__nand3_1
XTAP_TAPCELL_ROW_104_3837 VSS VSS gf180mcu_fd_sc_mcu9t5v0__filltie
XTAP_TAPCELL_ROW_217_5050 VSS VSS gf180mcu_fd_sc_mcu9t5v0__filltie
XTAP_TAPCELL_ROW_46_2243 VSS VSS gf180mcu_fd_sc_mcu9t5v0__filltie
XTAP_TAPCELL_ROW_46_2254 VSS VSS gf180mcu_fd_sc_mcu9t5v0__filltie
XTAP_TAPCELL_ROW_42_2129 VSS VSS gf180mcu_fd_sc_mcu9t5v0__filltie
XTAP_TAPCELL_ROW_59_2604 VSS VSS gf180mcu_fd_sc_mcu9t5v0__filltie
X_10470_ _10389_/C _10649_/A2 _10470_/A3 _17161_/C _10471_/B2 VSS VSS VSS VSS gf180mcu_fd_sc_mcu9t5v0__oai31_1
XTAP_TAPCELL_ROW_59_2615 VSS VSS gf180mcu_fd_sc_mcu9t5v0__filltie
X_09129_ _19759_/Q _13116_/A1 VSS VSS VSS VSS gf180mcu_fd_sc_mcu9t5v0__clkinv_1
X_12140_ _18510_/Q _12133_/Z _12208_/C _12140_/Z VSS VSS VSS VSS gf180mcu_fd_sc_mcu9t5v0__mux2_1
XPHY_EDGE_ROW_107_Left_431 VSS VSS gf180mcu_fd_sc_mcu9t5v0__endcap
X_12071_ _12058_/Z _12106_/A2 _12071_/B _12072_/B VSS VSS VSS VSS gf180mcu_fd_sc_mcu9t5v0__aoi21_1
XPHY_EDGE_ROW_211_Left_534 VSS VSS gf180mcu_fd_sc_mcu9t5v0__endcap
X_11022_ _19055_/Q _19023_/Q wire174/Z _19023_/D VSS _17816_/VNW VSS VSS gf180mcu_fd_sc_mcu9t5v0__mux2_1
XPHY_EDGE_ROW_223_Right_150 VSS VSS gf180mcu_fd_sc_mcu9t5v0__endcap
X_15830_ _15832_/A1 _15830_/A2 _15831_/A2 VSS _15830_/VNW VSS VSS gf180mcu_fd_sc_mcu9t5v0__nand2_1
XTAP_TAPCELL_ROW_140_3_8015 VSS VSS gf180mcu_fd_sc_mcu9t5v0__filltie
XTAP_TAPCELL_ROW_139_3_8009 VSS VSS gf180mcu_fd_sc_mcu9t5v0__filltie
XTAP_TAPCELL_ROW_31_1822 VSS VSS gf180mcu_fd_sc_mcu9t5v0__filltie
XTAP_TAPCELL_ROW_31_1833 VSS VSS gf180mcu_fd_sc_mcu9t5v0__filltie
XTAP_TAPCELL_ROW_31_1844 VSS VSS gf180mcu_fd_sc_mcu9t5v0__filltie
X_15761_ _15761_/A1 _15760_/Z _19932_/D VSS _15761_/VNW VSS VSS gf180mcu_fd_sc_mcu9t5v0__nor2_1
XPHY_EDGE_ROW_116_Left_440 VSS VSS gf180mcu_fd_sc_mcu9t5v0__endcap
X_12973_ _12989_/A2 _12973_/A2 _12978_/A2 _12973_/B2 _13304_/B _12974_/B VSS _12973_/VNW
+ VSS VSS gf180mcu_fd_sc_mcu9t5v0__aoi221_1
XTAP_TAPCELL_ROW_310_7604 VSS VSS gf180mcu_fd_sc_mcu9t5v0__filltie
X_18480_ _18480_/D clkload72/I _18480_/Q VSS VSS VSS VSS gf180mcu_fd_sc_mcu9t5v0__dffq_1
X_17500_ _18605_/Q _19246_/Q _17504_/S _18605_/D VSS VSS VSS VSS gf180mcu_fd_sc_mcu9t5v0__mux2_1
X_11924_ _11924_/A1 _11924_/A2 _11924_/Z VSS VSS VSS VSS gf180mcu_fd_sc_mcu9t5v0__and2_4
X_15692_ _19915_/Q _15726_/S _15693_/B VSS VSS VSS VSS gf180mcu_fd_sc_mcu9t5v0__nand2_1
X_14712_ _14465_/B _14712_/A2 _14712_/B _14714_/A2 VSS VSS VSS VSS gf180mcu_fd_sc_mcu9t5v0__oai21_1
X_17431_ _18564_/Q _17434_/A1 _17431_/S _17431_/Z VSS VSS VSS VSS gf180mcu_fd_sc_mcu9t5v0__mux2_1
XPHY_EDGE_ROW_220_Left_543 VSS VSS gf180mcu_fd_sc_mcu9t5v0__endcap
X_14643_ _19105_/Q _19521_/Q _14730_/S _19521_/D VSS _14643_/VNW VSS VSS gf180mcu_fd_sc_mcu9t5v0__mux2_1
X_11855_ _19115_/Q _11966_/B _11856_/A2 VSS _14400_/VNW VSS VSS gf180mcu_fd_sc_mcu9t5v0__nand2_1
X_17362_ _17362_/A1 _17362_/A2 _17366_/A2 VSS VSS VSS VSS gf180mcu_fd_sc_mcu9t5v0__nand2_1
X_11786_ _11807_/A1 _11807_/A2 _11787_/A2 VSS VSS VSS VSS gf180mcu_fd_sc_mcu9t5v0__nand2_1
X_10806_ _10715_/C _10806_/A2 _10806_/A3 _10806_/B _10807_/A3 VSS VSS VSS VSS gf180mcu_fd_sc_mcu9t5v0__oai31_1
X_19101_ _19101_/D _20061_/RN _19680_/CLK _19101_/Q VSS VSS VSS VSS gf180mcu_fd_sc_mcu9t5v0__dffrnq_1
XTAP_TAPCELL_ROW_29_1773 VSS VSS gf180mcu_fd_sc_mcu9t5v0__filltie
XTAP_TAPCELL_ROW_29_1784 VSS VSS gf180mcu_fd_sc_mcu9t5v0__filltie
X_14574_ _14574_/A1 _14574_/A2 _19470_/D VSS VSS VSS VSS gf180mcu_fd_sc_mcu9t5v0__nand2_1
X_16313_ _19233_/Q _16142_/C _16861_/S _16313_/Z VSS VSS VSS VSS gf180mcu_fd_sc_mcu9t5v0__mux2_1
X_17293_ _18531_/Q _18515_/Q _17404_/S _17293_/Z VSS VSS VSS VSS gf180mcu_fd_sc_mcu9t5v0__mux2_1
X_10737_ _19006_/Q _10804_/A2 _10739_/A2 VSS VSS VSS VSS gf180mcu_fd_sc_mcu9t5v0__nor2_1
XTAP_TAPCELL_ROW_114_4122 VSS VSS gf180mcu_fd_sc_mcu9t5v0__filltie
X_13525_ _13525_/A1 _13525_/A2 _13525_/B _13529_/B VSS _13525_/VNW VSS VSS gf180mcu_fd_sc_mcu9t5v0__oai21_1
XTAP_TAPCELL_ROW_114_4111 VSS VSS gf180mcu_fd_sc_mcu9t5v0__filltie
XTAP_TAPCELL_ROW_25_1659 VSS VSS gf180mcu_fd_sc_mcu9t5v0__filltie
XTAP_TAPCELL_ROW_308_7544 VSS VSS gf180mcu_fd_sc_mcu9t5v0__filltie
XTAP_TAPCELL_ROW_308_7533 VSS VSS gf180mcu_fd_sc_mcu9t5v0__filltie
X_16244_ _18202_/Q _16244_/I1 _16798_/S _18202_/D VSS VSS VSS VSS gf180mcu_fd_sc_mcu9t5v0__mux2_1
X_13456_ _16734_/A1 _13497_/B _13456_/B1 _13456_/B2 _19256_/D VSS VSS VSS VSS gf180mcu_fd_sc_mcu9t5v0__aoi22_1
X_19032_ _19032_/D _19992_/RN clkload31/I _19032_/Q VSS VSS VSS VSS gf180mcu_fd_sc_mcu9t5v0__dffrnq_1
XTAP_TAPCELL_ROW_304_7419 VSS VSS gf180mcu_fd_sc_mcu9t5v0__filltie
X_12407_ _18303_/Q _11091_/B wire146/I _12408_/B2 VSS _15980_/VNW VSS VSS gf180mcu_fd_sc_mcu9t5v0__oai21_1
XTAP_TAPCELL_ROW_110_4019 VSS VSS gf180mcu_fd_sc_mcu9t5v0__filltie
XTAP_TAPCELL_ROW_110_4008 VSS VSS gf180mcu_fd_sc_mcu9t5v0__filltie
X_10668_ _18553_/Q _10796_/A2 _17414_/I0 _17075_/A1 wire282/Z _10676_/B VSS VSS VSS
+ VSS gf180mcu_fd_sc_mcu9t5v0__aoi221_4
X_16175_ _18180_/Q _16175_/I1 _16753_/S _18180_/D VSS VSS VSS VSS gf180mcu_fd_sc_mcu9t5v0__mux2_4
X_10599_ _18952_/Q wire166/Z _10601_/A2 VSS VSS VSS VSS gf180mcu_fd_sc_mcu9t5v0__nand2_1
X_13387_ _13387_/A1 _19809_/Q _13403_/A3 VSS _13387_/VNW VSS VSS gf180mcu_fd_sc_mcu9t5v0__nor2_1
XTAP_TAPCELL_ROW_296_7209 VSS VSS gf180mcu_fd_sc_mcu9t5v0__filltie
XTAP_TAPCELL_ROW_209_4827 VSS VSS gf180mcu_fd_sc_mcu9t5v0__filltie
XTAP_TAPCELL_ROW_209_4816 VSS VSS gf180mcu_fd_sc_mcu9t5v0__filltie
XTAP_TAPCELL_ROW_209_4805 VSS VSS gf180mcu_fd_sc_mcu9t5v0__filltie
X_15126_ _19668_/Q _19508_/Q _15163_/S _19668_/D VSS VSS VSS VSS gf180mcu_fd_sc_mcu9t5v0__mux2_1
X_12338_ _18922_/Q _12338_/A2 _12338_/B _12352_/A2 VSS VSS VSS VSS gf180mcu_fd_sc_mcu9t5v0__aoi21_1
X_12269_ _12320_/C _12268_/Z _12269_/B _12270_/B1 VSS _12269_/VNW VSS VSS gf180mcu_fd_sc_mcu9t5v0__aoi21_1
X_19934_ _19934_/D _20062_/RN clkload46/I _19934_/Q VSS VSS VSS VSS gf180mcu_fd_sc_mcu9t5v0__dffrnq_1
X_15057_ _15090_/A2 _15057_/A2 _15057_/B _19640_/D VSS VSS VSS VSS gf180mcu_fd_sc_mcu9t5v0__oai21_1
X_14008_ _19321_/Q _19297_/Q _14045_/A1 VSS _14045_/VNW VSS VSS gf180mcu_fd_sc_mcu9t5v0__nand2_1
X_19865_ _19865_/D _20057_/RN clkload55/I _19865_/Q VSS VSS VSS VSS gf180mcu_fd_sc_mcu9t5v0__dffrnq_1
XPHY_EDGE_ROW_173_3_Right_288 VSS VSS gf180mcu_fd_sc_mcu9t5v0__endcap
X_18816_ _18816_/D _09246_/I clkload34/I _18816_/Q VSS VSS VSS VSS gf180mcu_fd_sc_mcu9t5v0__dffrnq_1
X_19796_ _19796_/D _20052_/RN _19798_/CLK _19796_/Q VSS VSS VSS VSS gf180mcu_fd_sc_mcu9t5v0__dffrnq_1
X_15959_ _15959_/A1 _16198_/A2 _15963_/C VSS VSS VSS VSS gf180mcu_fd_sc_mcu9t5v0__nand2_1
X_18747_ _18747_/D clkload48/I _18747_/Q VSS VSS VSS VSS gf180mcu_fd_sc_mcu9t5v0__dffq_1
XTAP_TAPCELL_ROW_272_6563 VSS VSS gf180mcu_fd_sc_mcu9t5v0__filltie
XTAP_TAPCELL_ROW_272_6552 VSS VSS gf180mcu_fd_sc_mcu9t5v0__filltie
XTAP_TAPCELL_ROW_272_6541 VSS VSS gf180mcu_fd_sc_mcu9t5v0__filltie
X_18678_ _18678_/D _20018_/RN clkload55/I _18678_/Q VSS VSS VSS VSS gf180mcu_fd_sc_mcu9t5v0__dffrnq_1
X_09480_ _20055_/Q _20010_/Q wire208/I VSS VSS VSS VSS gf180mcu_fd_sc_mcu9t5v0__and2_2
XTAP_TAPCELL_ROW_153_3_8060 VSS VSS gf180mcu_fd_sc_mcu9t5v0__filltie
X_17629_ _17631_/A1 _17631_/A3 _17649_/S VSS _17631_/VNW VSS VSS gf180mcu_fd_sc_mcu9t5v0__nand2_1
XTAP_TAPCELL_ROW_285_6902 VSS VSS gf180mcu_fd_sc_mcu9t5v0__filltie
XTAP_TAPCELL_ROW_285_6913 VSS VSS gf180mcu_fd_sc_mcu9t5v0__filltie
XTAP_TAPCELL_ROW_99_3696 VSS VSS gf180mcu_fd_sc_mcu9t5v0__filltie
XTAP_TAPCELL_ROW_266_6389 VSS VSS gf180mcu_fd_sc_mcu9t5v0__filltie
XTAP_TAPCELL_ROW_266_6378 VSS VSS gf180mcu_fd_sc_mcu9t5v0__filltie
XPHY_EDGE_ROW_184_1_Right_768 VSS VSS gf180mcu_fd_sc_mcu9t5v0__endcap
XTAP_TAPCELL_ROW_279_6739 VSS VSS gf180mcu_fd_sc_mcu9t5v0__filltie
X_20005_ _20005_/D _20069_/RN clkload47/I _20005_/Q VSS VSS VSS VSS gf180mcu_fd_sc_mcu9t5v0__dffrnq_1
X_09816_ _09832_/A3 _09825_/A2 _17909_/A2 _09823_/B VSS VSS VSS VSS gf180mcu_fd_sc_mcu9t5v0__nand3_1
XTAP_TAPCELL_ROW_219_5101 VSS VSS gf180mcu_fd_sc_mcu9t5v0__filltie
X_09747_ _15936_/C _09751_/A3 _09748_/B VSS VSS VSS VSS gf180mcu_fd_sc_mcu9t5v0__or2_1
XTAP_TAPCELL_ROW_48_2305 VSS VSS gf180mcu_fd_sc_mcu9t5v0__filltie
XTAP_TAPCELL_ROW_48_2316 VSS VSS gf180mcu_fd_sc_mcu9t5v0__filltie
Xu_transform_scheduler_core.u_fft_scratch_sram.u_hi.g_pin_drive\[0\].u_data_driver
+ _10477_/ZN u_transform_scheduler_core.u_fft_scratch_sram.u_hi.u_sram/D[0] VSS VSS
+ VSS VSS gf180mcu_fd_sc_mcu9t5v0__buf_8
X_09678_ _20005_/Q _19989_/Q _10049_/A1 _15821_/A1 VSS VSS VSS VSS gf180mcu_fd_sc_mcu9t5v0__nand3_1
XTAP_TAPCELL_ROW_251_5979 VSS VSS gf180mcu_fd_sc_mcu9t5v0__filltie
XTAP_TAPCELL_ROW_251_5968 VSS VSS gf180mcu_fd_sc_mcu9t5v0__filltie
X_11640_ _12661_/A3 _12635_/B _11667_/B1 VSS VSS VSS VSS gf180mcu_fd_sc_mcu9t5v0__nand2_1
X_11571_ _18249_/Q _12046_/S _11573_/B1 VSS VSS VSS VSS gf180mcu_fd_sc_mcu9t5v0__nand2_1
X_10522_ _20103_/Q _17407_/C _17408_/B _10523_/B2 VSS _10522_/VNW VSS VSS gf180mcu_fd_sc_mcu9t5v0__aoi21_1
X_13310_ _19739_/Q _13309_/I _13599_/A1 VSS VSS VSS VSS gf180mcu_fd_sc_mcu9t5v0__nor2_1
XTAP_TAPCELL_ROW_20_1523 VSS VSS gf180mcu_fd_sc_mcu9t5v0__filltie
X_14290_ _14357_/I0 _19363_/Q _14304_/S _19363_/D VSS VSS VSS VSS gf180mcu_fd_sc_mcu9t5v0__mux2_1
XTAP_TAPCELL_ROW_20_1534 VSS VSS gf180mcu_fd_sc_mcu9t5v0__filltie
X_10453_ _20086_/Q _17408_/B _10468_/A1 VSS _10621_/VNW VSS VSS gf180mcu_fd_sc_mcu9t5v0__nand2_1
X_13241_ _13245_/A1 _13238_/Z _13576_/B VSS VSS VSS VSS gf180mcu_fd_sc_mcu9t5v0__xnor2_1
XTAP_TAPCELL_ROW_20_1545 VSS VSS gf180mcu_fd_sc_mcu9t5v0__filltie
X_10384_ _20098_/Q _17177_/B _10385_/A2 VSS _16872_/VNW VSS VSS gf180mcu_fd_sc_mcu9t5v0__nand2_1
X_13172_ _19730_/Q _13171_/Z _13173_/I VSS _13175_/VNW VSS VSS gf180mcu_fd_sc_mcu9t5v0__nand2_1
X_12123_ _12071_/B _12123_/A2 _12122_/Z _12123_/B _12124_/A2 VSS VSS VSS VSS gf180mcu_fd_sc_mcu9t5v0__oai31_4
X_17980_ _18867_/Q _18030_/I0 wire128/Z _18867_/D VSS VSS VSS VSS gf180mcu_fd_sc_mcu9t5v0__mux2_1
X_16931_ _16931_/I0 _18457_/Q wire33/I _18457_/D VSS VSS VSS VSS gf180mcu_fd_sc_mcu9t5v0__mux2_1
X_12054_ _18907_/Q _18908_/Q _12076_/B _12055_/A2 VSS VSS VSS VSS gf180mcu_fd_sc_mcu9t5v0__oai21_1
XTAP_TAPCELL_ROW_18_1474 VSS VSS gf180mcu_fd_sc_mcu9t5v0__filltie
XTAP_TAPCELL_ROW_18_1485 VSS VSS gf180mcu_fd_sc_mcu9t5v0__filltie
X_16862_ _18423_/Q _16861_/Z _16862_/S _18423_/D VSS VSS VSS VSS gf180mcu_fd_sc_mcu9t5v0__mux2_1
X_11005_ _18937_/Q _11005_/A2 _11005_/B1 _18925_/Q _11005_/C _11006_/A3 VSS VSS VSS
+ VSS gf180mcu_fd_sc_mcu9t5v0__aoi221_1
X_19650_ _19650_/D _20034_/RN clkload23/I _19650_/Q VSS VSS VSS VSS gf180mcu_fd_sc_mcu9t5v0__dffrnq_1
X_16793_ _19278_/Q _16584_/B _16949_/S _16793_/Z VSS VSS VSS VSS gf180mcu_fd_sc_mcu9t5v0__mux2_1
X_18601_ _18601_/D clkload76/I _18601_/Q VSS VSS VSS VSS gf180mcu_fd_sc_mcu9t5v0__dffq_1
X_15813_ wire301/Z _19982_/Q _15819_/S _19982_/D VSS VSS VSS VSS gf180mcu_fd_sc_mcu9t5v0__mux2_1
X_19581_ _19581_/D _20029_/RN clkload7/I _19581_/Q VSS VSS VSS VSS gf180mcu_fd_sc_mcu9t5v0__dffrnq_1
X_18532_ _18532_/D clkload75/I _18532_/Q VSS VSS VSS VSS gf180mcu_fd_sc_mcu9t5v0__dffq_1
X_15744_ _15744_/A1 _15757_/B _15744_/B _19927_/D VSS _15758_/VNW VSS VSS gf180mcu_fd_sc_mcu9t5v0__aoi21_1
XPHY_EDGE_ROW_146_1_Right_730 VSS VSS gf180mcu_fd_sc_mcu9t5v0__endcap
XTAP_TAPCELL_ROW_289_7024 VSS VSS gf180mcu_fd_sc_mcu9t5v0__filltie
XTAP_TAPCELL_ROW_289_7013 VSS VSS gf180mcu_fd_sc_mcu9t5v0__filltie
X_12956_ _12735_/B _12956_/A2 _13503_/A2 _12957_/I0 VSS _12956_/VNW VSS VSS gf180mcu_fd_sc_mcu9t5v0__xnor3_1
X_18463_ _18463_/D clkload63/I _18463_/Q VSS VSS VSS VSS gf180mcu_fd_sc_mcu9t5v0__dffq_1
X_15675_ _15672_/B _15678_/A2 _15676_/A2 VSS _15678_/VNW VSS VSS gf180mcu_fd_sc_mcu9t5v0__nor2_1
X_12887_ _19772_/Q _12886_/Z _12898_/A1 VSS _13338_/VNW VSS VSS gf180mcu_fd_sc_mcu9t5v0__nand2_1
X_11907_ _11908_/A1 _11907_/A2 _11907_/A3 _11963_/A2 VSS VSS VSS VSS gf180mcu_fd_sc_mcu9t5v0__nand3_1
X_18394_ _18394_/D clkload64/I _18394_/Q VSS VSS VSS VSS gf180mcu_fd_sc_mcu9t5v0__dffq_1
X_14626_ _19087_/Q _19504_/Q _14730_/S _19504_/D VSS VSS VSS VSS gf180mcu_fd_sc_mcu9t5v0__mux2_1
X_17414_ _17414_/I0 _18553_/Q _17420_/S _18553_/D VSS VSS VSS VSS gf180mcu_fd_sc_mcu9t5v0__mux2_1
X_11838_ _11838_/A1 _11838_/A2 _12235_/B _11882_/A3 VSS VSS VSS VSS gf180mcu_fd_sc_mcu9t5v0__aoi21_1
X_17345_ _10516_/C _17345_/A2 _17345_/B1 _10353_/C _17345_/C1 _10543_/C _17346_/A2
+ VSS _17345_/VNW VSS VSS gf180mcu_fd_sc_mcu9t5v0__aoi222_1
X_14557_ _19170_/Q _19136_/Q _14752_/B VSS VSS VSS VSS gf180mcu_fd_sc_mcu9t5v0__xnor2_1
X_11769_ _12217_/B _11814_/A3 _11770_/A2 VSS VSS VSS VSS gf180mcu_fd_sc_mcu9t5v0__nand2_1
X_13508_ _13507_/B _13508_/A2 _13508_/Z VSS VSS VSS VSS gf180mcu_fd_sc_mcu9t5v0__xor2_1
X_17276_ _18466_/Q _18450_/Q _17404_/S _17276_/Z VSS VSS VSS VSS gf180mcu_fd_sc_mcu9t5v0__mux2_1
X_19015_ _19015_/D _20039_/RN clkload38/I _19015_/Q VSS VSS VSS VSS gf180mcu_fd_sc_mcu9t5v0__dffrnq_1
X_14488_ _19162_/Q _19128_/Q _14489_/I VSS VSS VSS VSS gf180mcu_fd_sc_mcu9t5v0__xor2_1
X_16227_ _16226_/Z _18198_/Q _16782_/S _18198_/D VSS VSS VSS VSS gf180mcu_fd_sc_mcu9t5v0__mux2_1
XTAP_TAPCELL_ROW_94_3571 VSS VSS gf180mcu_fd_sc_mcu9t5v0__filltie
X_13439_ _19778_/Q _13439_/A2 _13457_/B VSS VSS VSS VSS gf180mcu_fd_sc_mcu9t5v0__nand2_1
XTAP_TAPCELL_ROW_94_3560 VSS VSS gf180mcu_fd_sc_mcu9t5v0__filltie
X_16158_ _16424_/A1 _16751_/A2 _16751_/A3 _16751_/B _16159_/B VSS VSS VSS VSS gf180mcu_fd_sc_mcu9t5v0__oai31_1
XTAP_TAPCELL_ROW_261_6242 VSS VSS gf180mcu_fd_sc_mcu9t5v0__filltie
XTAP_TAPCELL_ROW_90_3457 VSS VSS gf180mcu_fd_sc_mcu9t5v0__filltie
XTAP_TAPCELL_ROW_90_3446 VSS VSS gf180mcu_fd_sc_mcu9t5v0__filltie
XTAP_TAPCELL_ROW_261_6253 VSS VSS gf180mcu_fd_sc_mcu9t5v0__filltie
XTAP_TAPCELL_ROW_90_3468 VSS VSS gf180mcu_fd_sc_mcu9t5v0__filltie
X_15109_ _19651_/Q _19491_/Q _15163_/S _19651_/D VSS VSS VSS VSS gf180mcu_fd_sc_mcu9t5v0__mux2_1
X_16089_ _19273_/Q _16675_/A1 _16090_/B VSS VSS VSS VSS gf180mcu_fd_sc_mcu9t5v0__nand2_1
X_19917_ _19917_/D _20045_/RN _20049_/CLK _19917_/Q VSS VSS VSS VSS gf180mcu_fd_sc_mcu9t5v0__dffrnq_1
XTAP_TAPCELL_ROW_274_6614 VSS VSS gf180mcu_fd_sc_mcu9t5v0__filltie
XTAP_TAPCELL_ROW_274_6603 VSS VSS gf180mcu_fd_sc_mcu9t5v0__filltie
X_19848_ _19848_/D _20040_/RN clkload55/I _19848_/Q VSS VSS VSS VSS gf180mcu_fd_sc_mcu9t5v0__dffrnq_1
XPHY_EDGE_ROW_174_3_Right_289 VSS VSS gf180mcu_fd_sc_mcu9t5v0__endcap
XTAP_TAPCELL_ROW_259_6193 VSS VSS gf180mcu_fd_sc_mcu9t5v0__filltie
XTAP_TAPCELL_ROW_259_6182 VSS VSS gf180mcu_fd_sc_mcu9t5v0__filltie
X_09601_ _09601_/I _17625_/A1 VSS VSS VSS VSS gf180mcu_fd_sc_mcu9t5v0__clkinv_1
XTAP_TAPCELL_ROW_88_3397 VSS VSS gf180mcu_fd_sc_mcu9t5v0__filltie
XPHY_EDGE_ROW_316_Left_639 VSS VSS gf180mcu_fd_sc_mcu9t5v0__endcap
X_09532_ _19830_/Q _09532_/A2 _10213_/A1 VSS VSS VSS VSS gf180mcu_fd_sc_mcu9t5v0__nand2_1
X_19779_ _19779_/D _20035_/RN clkload42/I _19779_/Q VSS VSS VSS VSS gf180mcu_fd_sc_mcu9t5v0__dffrnq_1
XTAP_TAPCELL_ROW_255_6079 VSS VSS gf180mcu_fd_sc_mcu9t5v0__filltie
Xwire33 wire33/I wire33/Z VSS VSS VSS VSS gf180mcu_fd_sc_mcu9t5v0__clkbuf_16
XTAP_TAPCELL_ROW_4_1083 VSS VSS gf180mcu_fd_sc_mcu9t5v0__filltie
X_09463_ _10187_/A2 wire108/I _14143_/B2 VSS VSS VSS VSS gf180mcu_fd_sc_mcu9t5v0__nor2_1
XTAP_TAPCELL_ROW_4_1094 VSS VSS gf180mcu_fd_sc_mcu9t5v0__filltie
X_09394_ _11558_/C _11988_/B _09395_/I VSS VSS VSS VSS gf180mcu_fd_sc_mcu9t5v0__nand2_4
XTAP_TAPCELL_ROW_268_6429 VSS VSS gf180mcu_fd_sc_mcu9t5v0__filltie
XTAP_TAPCELL_ROW_37_2006 VSS VSS gf180mcu_fd_sc_mcu9t5v0__filltie
XTAP_TAPCELL_ROW_244_5783 VSS VSS gf180mcu_fd_sc_mcu9t5v0__filltie
XTAP_TAPCELL_ROW_244_5772 VSS VSS gf180mcu_fd_sc_mcu9t5v0__filltie
XPHY_EDGE_ROW_185_1_Right_769 VSS VSS gf180mcu_fd_sc_mcu9t5v0__endcap
XTAP_TAPCELL_ROW_73_2998 VSS VSS gf180mcu_fd_sc_mcu9t5v0__filltie
XTAP_TAPCELL_ROW_73_2987 VSS VSS gf180mcu_fd_sc_mcu9t5v0__filltie
XTAP_TAPCELL_ROW_244_5794 VSS VSS gf180mcu_fd_sc_mcu9t5v0__filltie
XTAP_TAPCELL_ROW_240_5658 VSS VSS gf180mcu_fd_sc_mcu9t5v0__filltie
XTAP_TAPCELL_ROW_240_5669 VSS VSS gf180mcu_fd_sc_mcu9t5v0__filltie
X_12810_ _12810_/A1 _12810_/A2 _12810_/B _12812_/A2 VSS VSS VSS VSS gf180mcu_fd_sc_mcu9t5v0__oai21_1
X_13790_ _13788_/Z _13790_/A2 _13795_/A3 VSS VSS VSS VSS gf180mcu_fd_sc_mcu9t5v0__nor2_1
Xeco6_buf_09848 _09848_/ZN _17075_/A1 VSS VSS VSS VSS gf180mcu_fd_sc_mcu9t5v0__clkbuf_16
X_12741_ _19751_/Q _12740_/Z _12745_/B VSS VSS VSS VSS gf180mcu_fd_sc_mcu9t5v0__nand2_1
X_15460_ _15438_/Z _15447_/S _19823_/Q _15463_/B VSS VSS VSS VSS gf180mcu_fd_sc_mcu9t5v0__aoi21_1
X_12672_ _12664_/C _12672_/A2 _12673_/A2 VSS VSS VSS VSS gf180mcu_fd_sc_mcu9t5v0__nor2_1
XTAP_TAPCELL_ROW_26_1710 VSS VSS gf180mcu_fd_sc_mcu9t5v0__filltie
XPHY_EDGE_ROW_136_3_Right_251 VSS VSS gf180mcu_fd_sc_mcu9t5v0__endcap
X_11623_ _11656_/A1 _11604_/Z _11663_/A2 VSS VSS VSS VSS gf180mcu_fd_sc_mcu9t5v0__nand2_1
X_14411_ _14692_/A1 _14410_/Z _14689_/A1 VSS _14421_/VNW VSS VSS gf180mcu_fd_sc_mcu9t5v0__nand2_1
X_17130_ _17378_/A1 _18443_/Q _17133_/A2 VSS VSS VSS VSS gf180mcu_fd_sc_mcu9t5v0__nor2_1
X_15391_ _19676_/Q _19776_/Q _15430_/S _19776_/D VSS VSS VSS VSS gf180mcu_fd_sc_mcu9t5v0__mux2_1
Xclkbuf_leaf_58_clk_regs clkload1/I clkload29/I VSS VSS VSS VSS gf180mcu_fd_sc_mcu9t5v0__clkbuf_8
X_11554_ _18567_/Q _17443_/B2 wire175/I _12208_/C VSS VSS VSS VSS gf180mcu_fd_sc_mcu9t5v0__mux2_2
X_14342_ _14357_/I0 _19413_/Q _14352_/S _19413_/D VSS VSS VSS VSS gf180mcu_fd_sc_mcu9t5v0__mux2_1
X_11485_ _11485_/A1 _11485_/A2 _11485_/B _11485_/C _11486_/B VSS _11485_/VNW VSS VSS
+ gf180mcu_fd_sc_mcu9t5v0__oai211_1
X_17061_ _18523_/Q _16584_/B _17067_/S _18523_/D VSS VSS VSS VSS gf180mcu_fd_sc_mcu9t5v0__mux2_4
X_10505_ _18981_/Q _10804_/A2 wire165/Z _18965_/Q _10506_/A3 VSS VSS VSS VSS gf180mcu_fd_sc_mcu9t5v0__aoi22_1
X_14273_ _14359_/I0 _19347_/Q _14285_/S _19347_/D VSS VSS VSS VSS gf180mcu_fd_sc_mcu9t5v0__mux2_1
X_10436_ _09261_/I _10436_/A2 _10436_/A3 _10436_/B _10437_/C2 VSS _10436_/VNW VSS
+ VSS gf180mcu_fd_sc_mcu9t5v0__oai31_1
X_16012_ _18154_/Q _16012_/I1 _16602_/S _18154_/D VSS VSS VSS VSS gf180mcu_fd_sc_mcu9t5v0__mux2_4
X_13224_ _13224_/A1 _13224_/A2 _13224_/B _13225_/A2 VSS _13224_/VNW VSS VSS gf180mcu_fd_sc_mcu9t5v0__oai21_1
X_10367_ _19945_/Q wire216/Z _10655_/B _10368_/B2 VSS VSS VSS VSS gf180mcu_fd_sc_mcu9t5v0__aoi21_1
X_13155_ _13155_/I _13156_/A2 VSS VSS VSS VSS gf180mcu_fd_sc_mcu9t5v0__clkinv_1
X_10298_ _18283_/Q _17380_/A2 _17380_/B1 _18299_/Q _17275_/C _10299_/B VSS VSS VSS
+ VSS gf180mcu_fd_sc_mcu9t5v0__aoi221_1
X_12106_ _12057_/Z _12106_/A2 _12095_/B _12164_/A1 VSS _12106_/VNW VSS VSS gf180mcu_fd_sc_mcu9t5v0__nand3_4
X_13086_ _13088_/A1 _19757_/Q _13106_/B VSS VSS VSS VSS gf180mcu_fd_sc_mcu9t5v0__nand2_1
X_17963_ _17888_/B _17951_/Z _17988_/A2 VSS _17963_/VNW VSS VSS gf180mcu_fd_sc_mcu9t5v0__nand2_1
X_16914_ _16913_/Z _18449_/Q _16926_/S _18449_/D VSS VSS VSS VSS gf180mcu_fd_sc_mcu9t5v0__mux2_4
X_12037_ _18346_/Q _12203_/A2 _12038_/A3 VSS VSS VSS VSS gf180mcu_fd_sc_mcu9t5v0__nor2_1
X_19702_ _19702_/D _20022_/RN clkload16/I _19702_/Q VSS VSS VSS VSS gf180mcu_fd_sc_mcu9t5v0__dffrnq_1
X_17894_ _17894_/I _17926_/A1 VSS _17914_/VNW VSS VSS gf180mcu_fd_sc_mcu9t5v0__clkinv_1
X_19633_ _19633_/D _20145_/RN _19633_/CLK _19633_/Q VSS VSS VSS VSS gf180mcu_fd_sc_mcu9t5v0__dffrnq_1
X_16845_ _19250_/Q _16614_/B _16861_/S _16845_/Z VSS VSS VSS VSS gf180mcu_fd_sc_mcu9t5v0__mux2_1
X_16776_ _16775_/Z _18387_/Q _16782_/S _18387_/D VSS VSS VSS VSS gf180mcu_fd_sc_mcu9t5v0__mux2_1
XTAP_TAPCELL_ROW_83_3272 VSS VSS gf180mcu_fd_sc_mcu9t5v0__filltie
X_19564_ _19564_/D _20140_/RN clkload18/I _19564_/Q VSS VSS VSS VSS gf180mcu_fd_sc_mcu9t5v0__dffrnq_1
X_13988_ _13988_/A1 _13981_/Z _13988_/B _14031_/B1 VSS _13988_/VNW VSS VSS gf180mcu_fd_sc_mcu9t5v0__aoi21_1
XTAP_TAPCELL_ROW_83_3261 VSS VSS gf180mcu_fd_sc_mcu9t5v0__filltie
X_18515_ _18515_/D _18515_/CLK _18515_/Q VSS VSS VSS VSS gf180mcu_fd_sc_mcu9t5v0__dffq_4
X_15727_ _15726_/S _15727_/A2 _15728_/A2 VSS _15727_/VNW VSS VSS gf180mcu_fd_sc_mcu9t5v0__nor2_1
XPHY_EDGE_ROW_147_1_Right_731 VSS VSS gf180mcu_fd_sc_mcu9t5v0__endcap
X_12939_ _19779_/Q _12944_/A1 _12936_/Z _12940_/I0 VSS VSS VSS VSS gf180mcu_fd_sc_mcu9t5v0__xnor3_1
X_19495_ _19495_/D _20071_/RN _19806_/CLK _19495_/Q VSS VSS VSS VSS gf180mcu_fd_sc_mcu9t5v0__dffrnq_1
X_18446_ _18446_/D clkload62/I _18446_/Q VSS VSS VSS VSS gf180mcu_fd_sc_mcu9t5v0__dffq_1
X_15658_ _15598_/S _15677_/B _19904_/Q _19905_/Q _15659_/I VSS VSS VSS VSS gf180mcu_fd_sc_mcu9t5v0__aoi211_1
X_14609_ _19189_/Q _19487_/Q _14715_/S _19487_/D VSS VSS VSS VSS gf180mcu_fd_sc_mcu9t5v0__mux2_1
X_18377_ _18377_/D clkload53/I _18377_/Q VSS VSS VSS VSS gf180mcu_fd_sc_mcu9t5v0__dffq_1
XTAP_TAPCELL_ROW_96_3633 VSS VSS gf180mcu_fd_sc_mcu9t5v0__filltie
X_15589_ _15597_/B1 _15589_/A2 _15589_/B _19880_/D VSS VSS VSS VSS gf180mcu_fd_sc_mcu9t5v0__oai21_1
XTAP_TAPCELL_ROW_96_3622 VSS VSS gf180mcu_fd_sc_mcu9t5v0__filltie
XTAP_TAPCELL_ROW_96_3611 VSS VSS gf180mcu_fd_sc_mcu9t5v0__filltie
X_17328_ _18614_/Q _17306_/C _17329_/B VSS _17328_/VNW VSS VSS gf180mcu_fd_sc_mcu9t5v0__nand2_1
XTAP_TAPCELL_ROW_92_3508 VSS VSS gf180mcu_fd_sc_mcu9t5v0__filltie
X_17259_ _18417_/Q _17380_/A2 _17380_/B1 _18433_/Q _17278_/C _17263_/A2 VSS _17259_/VNW
+ VSS VSS gf180mcu_fd_sc_mcu9t5v0__aoi221_1
XTAP_TAPCELL_ROW_263_6315 VSS VSS gf180mcu_fd_sc_mcu9t5v0__filltie
XTAP_TAPCELL_ROW_263_6304 VSS VSS gf180mcu_fd_sc_mcu9t5v0__filltie
XPHY_EDGE_ROW_182_3_Left_840 VSS VSS gf180mcu_fd_sc_mcu9t5v0__endcap
XTAP_TAPCELL_ROW_92_3519 VSS VSS gf180mcu_fd_sc_mcu9t5v0__filltie
XTAP_TAPCELL_ROW_77_3087 VSS VSS gf180mcu_fd_sc_mcu9t5v0__filltie
XTAP_TAPCELL_ROW_77_3098 VSS VSS gf180mcu_fd_sc_mcu9t5v0__filltie
XTAP_TAPCELL_ROW_6_1134 VSS VSS gf180mcu_fd_sc_mcu9t5v0__filltie
XTAP_TAPCELL_ROW_6_1145 VSS VSS gf180mcu_fd_sc_mcu9t5v0__filltie
XTAP_TAPCELL_ROW_6_1156 VSS VSS gf180mcu_fd_sc_mcu9t5v0__filltie
XPHY_EDGE_ROW_149_2_Right_880 VSS VSS gf180mcu_fd_sc_mcu9t5v0__endcap
X_09515_ _09519_/A2 _09515_/A2 _09515_/A3 _09518_/A2 VSS VSS VSS VSS gf180mcu_fd_sc_mcu9t5v0__nor3_4
X_09446_ _10063_/C _09614_/A2 _09446_/Z VSS VSS VSS VSS gf180mcu_fd_sc_mcu9t5v0__or2_1
XTAP_TAPCELL_ROW_66_2791 VSS VSS gf180mcu_fd_sc_mcu9t5v0__filltie
XTAP_TAPCELL_ROW_62_2677 VSS VSS gf180mcu_fd_sc_mcu9t5v0__filltie
X_09377_ _18408_/Q _16832_/A1 VSS wire123/VNW VSS VSS gf180mcu_fd_sc_mcu9t5v0__clkinv_1
XTAP_TAPCELL_ROW_233_5484 VSS VSS gf180mcu_fd_sc_mcu9t5v0__filltie
XTAP_TAPCELL_ROW_233_5473 VSS VSS gf180mcu_fd_sc_mcu9t5v0__filltie
XTAP_TAPCELL_ROW_62_2688 VSS VSS gf180mcu_fd_sc_mcu9t5v0__filltie
XTAP_TAPCELL_ROW_62_2699 VSS VSS gf180mcu_fd_sc_mcu9t5v0__filltie
XTAP_TAPCELL_ROW_246_5834 VSS VSS gf180mcu_fd_sc_mcu9t5v0__filltie
XTAP_TAPCELL_ROW_246_5823 VSS VSS gf180mcu_fd_sc_mcu9t5v0__filltie
XTAP_TAPCELL_ROW_246_5845 VSS VSS gf180mcu_fd_sc_mcu9t5v0__filltie
X_11270_ _11270_/A1 _11270_/A2 _19084_/D VSS _13226_/VNW VSS VSS gf180mcu_fd_sc_mcu9t5v0__nand2_1
X_10221_ _10237_/A1 _17255_/B1 _17177_/B VSS VSS VSS VSS gf180mcu_fd_sc_mcu9t5v0__and2_1
X_10152_ _09896_/Z _10152_/A2 _10152_/B _10152_/C _10159_/A2 VSS VSS VSS VSS gf180mcu_fd_sc_mcu9t5v0__aoi211_1
XTAP_TAPCELL_ROW_15_1400 VSS VSS gf180mcu_fd_sc_mcu9t5v0__filltie
X_10083_ _18811_/Q _10153_/A2 _10153_/B _10085_/A2 VSS _10084_/VNW VSS VSS gf180mcu_fd_sc_mcu9t5v0__oai21_1
X_14960_ _14961_/A1 _14959_/Z _14964_/A2 VSS VSS VSS VSS gf180mcu_fd_sc_mcu9t5v0__nand2_1
X_13911_ _19323_/Q _13876_/Z _13911_/B _13951_/A1 VSS _13924_/VNW VSS VSS gf180mcu_fd_sc_mcu9t5v0__aoi21_1
X_14891_ _14891_/A1 _14888_/Z _14891_/B _14896_/A1 VSS _14891_/VNW VSS VSS gf180mcu_fd_sc_mcu9t5v0__aoi21_1
X_16630_ _15996_/B _16630_/A2 _16630_/A3 _16630_/B _16631_/I1 VSS VSS VSS VSS gf180mcu_fd_sc_mcu9t5v0__oai31_1
X_13842_ _13842_/A1 _13841_/Z _13846_/A2 VSS _13845_/VNW VSS VSS gf180mcu_fd_sc_mcu9t5v0__nor2_1
X_16561_ _18344_/Q _16099_/B _17069_/S _18344_/D VSS _16561_/VNW VSS VSS gf180mcu_fd_sc_mcu9t5v0__mux2_1
X_13773_ _19304_/Q _13772_/Z _14139_/S _19304_/D VSS _14968_/VNW VSS VSS gf180mcu_fd_sc_mcu9t5v0__mux2_1
X_18300_ _18300_/D clkload59/I _18300_/Q VSS VSS VSS VSS gf180mcu_fd_sc_mcu9t5v0__dffq_1
X_15512_ _15512_/A1 _17422_/S _15512_/B _15512_/C _15515_/A2 VSS VSS VSS VSS gf180mcu_fd_sc_mcu9t5v0__aoi211_1
XTAP_TAPCELL_ROW_166_3_8104 VSS VSS gf180mcu_fd_sc_mcu9t5v0__filltie
X_10985_ _19014_/Q _10984_/Z _10996_/S _19014_/D VSS VSS VSS VSS gf180mcu_fd_sc_mcu9t5v0__mux2_1
X_19280_ _19280_/D _20048_/RN clkload27/I _19280_/Q VSS VSS VSS VSS gf180mcu_fd_sc_mcu9t5v0__dffrnq_1
X_12724_ _12682_/C _12724_/A2 _12724_/B1 _12147_/S _12724_/C _12726_/A1 VSS VSS VSS
+ VSS gf180mcu_fd_sc_mcu9t5v0__aoi221_1
X_16492_ _18303_/Q _16491_/Z _16496_/S _18303_/D VSS VSS VSS VSS gf180mcu_fd_sc_mcu9t5v0__mux2_1
X_18231_ _18231_/D clkload69/I _18231_/Q VSS VSS VSS VSS gf180mcu_fd_sc_mcu9t5v0__dffq_4
X_15443_ _17231_/B _15444_/A2 _15462_/A2 _15447_/S VSS VSS VSS VSS gf180mcu_fd_sc_mcu9t5v0__and3_1
XPHY_EDGE_ROW_137_3_Right_252 VSS VSS gf180mcu_fd_sc_mcu9t5v0__endcap
X_12655_ _12655_/I0 _19178_/Q _12655_/S _19178_/D VSS VSS VSS VSS gf180mcu_fd_sc_mcu9t5v0__mux2_1
X_18162_ _18162_/D clkload78/I _18162_/Q VSS VSS VSS VSS gf180mcu_fd_sc_mcu9t5v0__dffq_1
XTAP_TAPCELL_ROW_134_4670 VSS VSS gf180mcu_fd_sc_mcu9t5v0__filltie
X_15374_ _19659_/Q _19759_/Q _15430_/S _19759_/D VSS _15374_/VNW VSS VSS gf180mcu_fd_sc_mcu9t5v0__mux2_1
X_12586_ wire175/Z wire121/Z _12618_/B _12588_/A3 VSS VSS VSS VSS gf180mcu_fd_sc_mcu9t5v0__aoi21_1
X_11606_ _11659_/A1 _11604_/Z _11656_/B VSS _12650_/VNW VSS VSS gf180mcu_fd_sc_mcu9t5v0__nor2_1
X_11537_ _18440_/Q _11534_/Z _11537_/S _11537_/Z VSS VSS VSS VSS gf180mcu_fd_sc_mcu9t5v0__mux2_1
X_17113_ _20124_/Q _17326_/A1 _17114_/B VSS VSS VSS VSS gf180mcu_fd_sc_mcu9t5v0__nor2_1
XTAP_TAPCELL_ROW_134_4681 VSS VSS gf180mcu_fd_sc_mcu9t5v0__filltie
X_18093_ _18935_/Q _18089_/Z _18098_/B VSS _18097_/VNW VSS VSS gf180mcu_fd_sc_mcu9t5v0__and2_1
XTAP_TAPCELL_ROW_130_4545 VSS VSS gf180mcu_fd_sc_mcu9t5v0__filltie
X_14325_ _14355_/I0 _19397_/Q _14337_/S _19397_/D VSS _14785_/VNW VSS VSS gf180mcu_fd_sc_mcu9t5v0__mux2_1
X_17044_ _17043_/Z _18513_/Q _17050_/S _18513_/D VSS VSS VSS VSS gf180mcu_fd_sc_mcu9t5v0__mux2_4
Xmax_cap117 _17773_/A2 _17779_/A2 VSS _17770_/VNW VSS VSS gf180mcu_fd_sc_mcu9t5v0__clkbuf_4
XTAP_TAPCELL_ROW_212_4889 VSS VSS gf180mcu_fd_sc_mcu9t5v0__filltie
XTAP_TAPCELL_ROW_146_3_8035 VSS VSS gf180mcu_fd_sc_mcu9t5v0__filltie
XTAP_TAPCELL_ROW_130_4567 VSS VSS gf180mcu_fd_sc_mcu9t5v0__filltie
XTAP_TAPCELL_ROW_130_4556 VSS VSS gf180mcu_fd_sc_mcu9t5v0__filltie
Xmax_cap106 _09472_/ZN _14730_/S VSS VSS VSS VSS gf180mcu_fd_sc_mcu9t5v0__clkbuf_16
X_11468_ _18531_/Q _18515_/Q _18499_/Q _18483_/Q _11534_/S wire136/Z _11468_/Z VSS
+ VSS VSS VSS gf180mcu_fd_sc_mcu9t5v0__mux4_1
Xmax_cap139 _11334_/A2 _11534_/S VSS VSS VSS VSS gf180mcu_fd_sc_mcu9t5v0__clkbuf_8
X_14256_ _14257_/A1 _14257_/A2 _14265_/A1 VSS _14265_/VNW VSS VSS gf180mcu_fd_sc_mcu9t5v0__nor2_1
X_11399_ _18462_/Q _11524_/S _11428_/B _11401_/A2 VSS VSS VSS VSS gf180mcu_fd_sc_mcu9t5v0__oai21_1
X_10419_ _18961_/Q wire165/Z _10652_/B1 _18977_/Q _10420_/A3 VSS _10420_/VNW VSS VSS
+ gf180mcu_fd_sc_mcu9t5v0__aoi22_1
X_13207_ _19732_/Q _13207_/A2 _13566_/B VSS VSS VSS VSS gf180mcu_fd_sc_mcu9t5v0__xnor2_1
X_14187_ _14034_/B _14187_/A2 _14262_/A1 VSS _14190_/VNW VSS VSS gf180mcu_fd_sc_mcu9t5v0__nand2_1
X_13138_ _19728_/Q _13138_/A2 _13546_/B VSS _13141_/VNW VSS VSS gf180mcu_fd_sc_mcu9t5v0__xnor2_1
X_18995_ _18995_/D _20019_/RN _20132_/CLK _18995_/Q VSS VSS VSS VSS gf180mcu_fd_sc_mcu9t5v0__dffrnq_1
XTAP_TAPCELL_ROW_128_4496 VSS VSS gf180mcu_fd_sc_mcu9t5v0__filltie
XTAP_TAPCELL_ROW_85_3323 VSS VSS gf180mcu_fd_sc_mcu9t5v0__filltie
X_13069_ _16420_/A1 _13320_/B _13062_/Z _13069_/B2 _19234_/D VSS VSS VSS VSS gf180mcu_fd_sc_mcu9t5v0__aoi22_1
X_17946_ _17889_/I _17946_/A2 _17946_/B _18852_/D VSS VSS VSS VSS gf180mcu_fd_sc_mcu9t5v0__oai21_1
XTAP_TAPCELL_ROW_85_3312 VSS VSS gf180mcu_fd_sc_mcu9t5v0__filltie
XPHY_EDGE_ROW_119_Right_119 VSS VSS gf180mcu_fd_sc_mcu9t5v0__endcap
X_17877_ _17877_/I _17878_/B1 VSS VSS VSS VSS gf180mcu_fd_sc_mcu9t5v0__clkinv_1
Xclone230 _15148_/S _10187_/A2 _09473_/B _14670_/S VSS VSS VSS VSS gf180mcu_fd_sc_mcu9t5v0__oai21_2
X_16828_ _18407_/Q _16828_/I1 _16828_/S _18407_/D VSS VSS VSS VSS gf180mcu_fd_sc_mcu9t5v0__mux2_1
XTAP_TAPCELL_ROW_252_6005 VSS VSS gf180mcu_fd_sc_mcu9t5v0__filltie
XTAP_TAPCELL_ROW_81_3209 VSS VSS gf180mcu_fd_sc_mcu9t5v0__filltie
X_19616_ _19616_/D _20064_/RN clkload20/I _19616_/Q VSS VSS VSS VSS gf180mcu_fd_sc_mcu9t5v0__dffrnq_1
X_19547_ _19547_/D _20059_/RN clkload35/I _19547_/Q VSS VSS VSS VSS gf180mcu_fd_sc_mcu9t5v0__dffrnq_1
X_16759_ _16584_/B _19278_/Q _16783_/S _16759_/Z VSS _16760_/VNW VSS VSS gf180mcu_fd_sc_mcu9t5v0__mux2_1
X_09300_ _19224_/Q _16652_/A1 VSS VSS VSS VSS gf180mcu_fd_sc_mcu9t5v0__clkinv_1
XPHY_EDGE_ROW_148_1_Right_732 VSS VSS gf180mcu_fd_sc_mcu9t5v0__endcap
XTAP_TAPCELL_ROW_1_1020 VSS VSS gf180mcu_fd_sc_mcu9t5v0__filltie
X_19478_ _19478_/D _20054_/RN clkload13/I _19478_/Q VSS VSS VSS VSS gf180mcu_fd_sc_mcu9t5v0__dffrnq_1
X_18429_ _18429_/D _18509_/CLK _18429_/Q VSS VSS VSS VSS gf180mcu_fd_sc_mcu9t5v0__dffq_4
X_09231_ _19296_/Q _14048_/A1 VSS VSS VSS VSS gf180mcu_fd_sc_mcu9t5v0__clkinv_1
XTAP_TAPCELL_ROW_79_3149 VSS VSS gf180mcu_fd_sc_mcu9t5v0__filltie
X_09162_ _19746_/Q _13454_/A1 VSS VSS VSS VSS gf180mcu_fd_sc_mcu9t5v0__clkinv_1
X_09093_ _19195_/Q _10843_/A1 VSS VSS VSS VSS gf180mcu_fd_sc_mcu9t5v0__clkinv_1
Xclkbuf_leaf_3_clk_regs clkbuf_3_0_0_clk_regs/Z clkload9/I VSS VSS VSS VSS gf180mcu_fd_sc_mcu9t5v0__clkbuf_8
XTAP_TAPCELL_ROW_70_2913 VSS VSS gf180mcu_fd_sc_mcu9t5v0__filltie
XTAP_TAPCELL_ROW_70_2902 VSS VSS gf180mcu_fd_sc_mcu9t5v0__filltie
XTAP_TAPCELL_ROW_55_2492 VSS VSS gf180mcu_fd_sc_mcu9t5v0__filltie
X_09995_ _10138_/B1 _09995_/A2 _09995_/B _09995_/C _09996_/B VSS VSS VSS VSS gf180mcu_fd_sc_mcu9t5v0__aoi211_1
XTAP_TAPCELL_ROW_159_3_8080 VSS VSS gf180mcu_fd_sc_mcu9t5v0__filltie
XTAP_TAPCELL_ROW_222_5185 VSS VSS gf180mcu_fd_sc_mcu9t5v0__filltie
XTAP_TAPCELL_ROW_222_5174 VSS VSS gf180mcu_fd_sc_mcu9t5v0__filltie
XTAP_TAPCELL_ROW_222_5163 VSS VSS gf180mcu_fd_sc_mcu9t5v0__filltie
XTAP_TAPCELL_ROW_172_3_8125 VSS VSS gf180mcu_fd_sc_mcu9t5v0__filltie
XTAP_TAPCELL_ROW_51_2378 VSS VSS gf180mcu_fd_sc_mcu9t5v0__filltie
XTAP_TAPCELL_ROW_8_1207 VSS VSS gf180mcu_fd_sc_mcu9t5v0__filltie
XTAP_TAPCELL_ROW_51_2389 VSS VSS gf180mcu_fd_sc_mcu9t5v0__filltie
XTAP_TAPCELL_ROW_68_2864 VSS VSS gf180mcu_fd_sc_mcu9t5v0__filltie
XTAP_TAPCELL_ROW_68_2853 VSS VSS gf180mcu_fd_sc_mcu9t5v0__filltie
Xrst_tree_mid_4 rst_tree_root/Z rst_tree_mid_4/Z VSS VSS VSS VSS gf180mcu_fd_sc_mcu9t5v0__clkbuf_16
XTAP_TAPCELL_ROW_68_2842 VSS VSS gf180mcu_fd_sc_mcu9t5v0__filltie
XTAP_TAPCELL_ROW_235_5546 VSS VSS gf180mcu_fd_sc_mcu9t5v0__filltie
XTAP_TAPCELL_ROW_235_5535 VSS VSS gf180mcu_fd_sc_mcu9t5v0__filltie
XTAP_TAPCELL_ROW_235_5524 VSS VSS gf180mcu_fd_sc_mcu9t5v0__filltie
XTAP_TAPCELL_ROW_152_3_8056 VSS VSS gf180mcu_fd_sc_mcu9t5v0__filltie
XTAP_TAPCELL_ROW_64_2739 VSS VSS gf180mcu_fd_sc_mcu9t5v0__filltie
X_10770_ _10770_/A1 _10770_/A2 _10770_/B _10770_/ZN VSS VSS VSS VSS gf180mcu_fd_sc_mcu9t5v0__aoi21_4
X_09429_ _09887_/A1 _18692_/Q _09429_/A3 _09435_/A2 VSS VSS VSS VSS gf180mcu_fd_sc_mcu9t5v0__nor3_2
X_12440_ _18259_/Q _12607_/A2 _12442_/B1 VSS VSS VSS VSS gf180mcu_fd_sc_mcu9t5v0__nor2_1
XPHY_EDGE_ROW_276_Left_599 VSS VSS gf180mcu_fd_sc_mcu9t5v0__endcap
X_12371_ _18732_/Q _12527_/A2 _12543_/B1 _12371_/B2 _12372_/A3 VSS VSS VSS VSS gf180mcu_fd_sc_mcu9t5v0__aoi22_4
X_14110_ _14110_/A1 _14110_/A2 _14129_/A1 VSS _14110_/VNW VSS VSS gf180mcu_fd_sc_mcu9t5v0__nand2_1
X_11322_ _11322_/A1 _11322_/A2 _19088_/D VSS VSS VSS VSS gf180mcu_fd_sc_mcu9t5v0__nand2_1
X_15090_ _19646_/Q _15090_/A2 _15092_/B VSS _15091_/VNW VSS VSS gf180mcu_fd_sc_mcu9t5v0__nand2_1
X_11253_ _18179_/Q _11485_/C _11526_/B _11254_/B2 VSS VSS VSS VSS gf180mcu_fd_sc_mcu9t5v0__aoi21_1
X_14041_ _19320_/Q _19300_/Q _14079_/A2 VSS VSS VSS VSS gf180mcu_fd_sc_mcu9t5v0__nand2_1
X_10204_ _17807_/S _18769_/D VSS _10204_/VNW VSS VSS gf180mcu_fd_sc_mcu9t5v0__clkinv_1
X_17800_ _09065_/I _18778_/Q _17807_/S _18778_/D VSS VSS VSS VSS gf180mcu_fd_sc_mcu9t5v0__mux2_1
X_11184_ _19078_/Q _11321_/A2 _11185_/B VSS VSS VSS VSS gf180mcu_fd_sc_mcu9t5v0__nand2_1
X_10135_ _18969_/Q _09898_/C wire297/Z _18993_/Q _10139_/A2 VSS VSS VSS VSS gf180mcu_fd_sc_mcu9t5v0__aoi22_1
X_18780_ _18780_/D _20060_/RN clkload63/I _18780_/Q VSS VSS VSS VSS gf180mcu_fd_sc_mcu9t5v0__dffrnq_1
X_15992_ _16106_/B _16107_/A2 _16106_/C _16107_/A1 _16299_/A1 VSS VSS VSS VSS gf180mcu_fd_sc_mcu9t5v0__nor4_4
X_10066_ _19263_/Q _10165_/A2 _10166_/A2 _19271_/Q _10165_/B1 _19279_/Q _10067_/A4
+ VSS VSS VSS VSS gf180mcu_fd_sc_mcu9t5v0__aoi222_1
X_17731_ _17731_/A1 _17685_/S _17731_/B _18741_/D VSS _17731_/VNW VSS VSS gf180mcu_fd_sc_mcu9t5v0__oai21_1
X_14943_ _19607_/Q _19363_/Q _20039_/D _19607_/D VSS _14943_/VNW VSS VSS gf180mcu_fd_sc_mcu9t5v0__mux2_1
XTAP_TAPCELL_ROW_317_7782 VSS VSS gf180mcu_fd_sc_mcu9t5v0__filltie
XTAP_TAPCELL_ROW_292_7097 VSS VSS gf180mcu_fd_sc_mcu9t5v0__filltie
X_17662_ _18625_/Q _18701_/Q _17685_/S _18701_/D VSS VSS VSS VSS gf180mcu_fd_sc_mcu9t5v0__mux2_1
XTAP_TAPCELL_ROW_138_2_8005 VSS VSS gf180mcu_fd_sc_mcu9t5v0__filltie
XTAP_TAPCELL_ROW_123_4371 VSS VSS gf180mcu_fd_sc_mcu9t5v0__filltie
XTAP_TAPCELL_ROW_123_4360 VSS VSS gf180mcu_fd_sc_mcu9t5v0__filltie
X_14874_ _19412_/Q _19353_/Q _14874_/Z VSS VSS VSS VSS gf180mcu_fd_sc_mcu9t5v0__xor2_1
XTAP_TAPCELL_ROW_317_7793 VSS VSS gf180mcu_fd_sc_mcu9t5v0__filltie
X_16613_ _16614_/B _16706_/A2 VSS VSS VSS VSS gf180mcu_fd_sc_mcu9t5v0__clkinv_1
X_13825_ _14148_/A1 _14048_/A1 _13825_/A3 _13825_/A4 _13838_/B VSS _13825_/VNW VSS
+ VSS gf180mcu_fd_sc_mcu9t5v0__nor4_1
X_19401_ _19401_/D _20041_/RN clkload18/I _19401_/Q VSS VSS VSS VSS gf180mcu_fd_sc_mcu9t5v0__dffrnq_1
XTAP_TAPCELL_ROW_313_7679 VSS VSS gf180mcu_fd_sc_mcu9t5v0__filltie
XTAP_TAPCELL_ROW_313_7668 VSS VSS gf180mcu_fd_sc_mcu9t5v0__filltie
X_17593_ input4/Z _18658_/Q _17597_/S _18658_/D VSS VSS VSS VSS gf180mcu_fd_sc_mcu9t5v0__mux2_1
XTAP_TAPCELL_ROW_185_3_8170 VSS VSS gf180mcu_fd_sc_mcu9t5v0__filltie
Xclkbuf_leaf_73_clk_regs clkload0/I clkload27/I VSS _13316_/VNW VSS VSS gf180mcu_fd_sc_mcu9t5v0__clkbuf_8
X_16544_ _16543_/Z _18328_/Q _17054_/S _18328_/D VSS VSS VSS VSS gf180mcu_fd_sc_mcu9t5v0__mux2_4
X_10968_ _10969_/A2 _10967_/Z _10968_/Z VSS VSS VSS VSS gf180mcu_fd_sc_mcu9t5v0__and2_1
X_13756_ _13756_/A1 _13734_/I _13756_/B _19301_/D VSS VSS VSS VSS gf180mcu_fd_sc_mcu9t5v0__oai21_1
X_19332_ _19332_/D _20036_/RN clkload7/I _19332_/Q VSS VSS VSS VSS gf180mcu_fd_sc_mcu9t5v0__dffrnq_1
X_16475_ _19243_/Q _16099_/B _16993_/S _16475_/Z VSS VSS VSS VSS gf180mcu_fd_sc_mcu9t5v0__mux2_1
X_12707_ _12707_/I0 _12707_/I1 _12716_/S _12707_/Z VSS VSS VSS VSS gf180mcu_fd_sc_mcu9t5v0__mux2_1
X_13687_ _13698_/B _13686_/Z _14590_/B _13688_/B VSS _13688_/VNW VSS VSS gf180mcu_fd_sc_mcu9t5v0__aoi21_1
X_19263_ _19263_/D _20031_/RN clkload28/I _19263_/Q VSS VSS VSS VSS gf180mcu_fd_sc_mcu9t5v0__dffrnq_1
X_18214_ _18214_/D clkload82/I _18214_/Q VSS VSS VSS VSS gf180mcu_fd_sc_mcu9t5v0__dffq_1
X_10899_ _19246_/Q _19252_/Q _18151_/S _10899_/Z VSS VSS VSS VSS gf180mcu_fd_sc_mcu9t5v0__mux2_1
XTAP_TAPCELL_ROW_132_4618 VSS VSS gf180mcu_fd_sc_mcu9t5v0__filltie
X_15426_ _19711_/Q _19811_/Q _15430_/S _19811_/D VSS VSS VSS VSS gf180mcu_fd_sc_mcu9t5v0__mux2_1
XTAP_TAPCELL_ROW_132_4607 VSS VSS gf180mcu_fd_sc_mcu9t5v0__filltie
X_19194_ _19194_/D _20026_/RN _20054_/CLK _19194_/Q VSS VSS VSS VSS gf180mcu_fd_sc_mcu9t5v0__dffrnq_1
X_12638_ _12638_/I0 _19176_/Q _12655_/S _19176_/D VSS VSS VSS VSS gf180mcu_fd_sc_mcu9t5v0__mux2_1
XPHY_EDGE_ROW_138_3_Right_253 VSS VSS gf180mcu_fd_sc_mcu9t5v0__endcap
XTAP_TAPCELL_ROW_117_4197 VSS VSS gf180mcu_fd_sc_mcu9t5v0__filltie
X_12569_ wire146/Z _12569_/A2 _12569_/A3 _12569_/B1 _12569_/B2 _12570_/A2 VSS VSS
+ VSS VSS gf180mcu_fd_sc_mcu9t5v0__oai32_4
X_18145_ _19217_/Q _19223_/Q _18145_/S _18145_/Z VSS VSS VSS VSS gf180mcu_fd_sc_mcu9t5v0__mux2_1
XTAP_TAPCELL_ROW_74_3024 VSS VSS gf180mcu_fd_sc_mcu9t5v0__filltie
XTAP_TAPCELL_ROW_74_3013 VSS VSS gf180mcu_fd_sc_mcu9t5v0__filltie
X_15357_ _15352_/Z _15357_/A2 _15357_/B _15362_/A1 VSS VSS VSS VSS gf180mcu_fd_sc_mcu9t5v0__aoi21_1
XPHY_EDGE_ROW_237_Right_164 VSS VSS gf180mcu_fd_sc_mcu9t5v0__endcap
X_18076_ _18076_/A1 _18076_/A2 _18929_/D VSS _18076_/VNW VSS VSS gf180mcu_fd_sc_mcu9t5v0__nand2_1
X_15288_ _15271_/Z _15289_/A2 _15288_/B _15300_/A2 VSS _15288_/VNW VSS VSS gf180mcu_fd_sc_mcu9t5v0__oai21_1
X_14308_ _14357_/I0 _19381_/Q _14322_/S _19381_/D VSS VSS VSS VSS gf180mcu_fd_sc_mcu9t5v0__mux2_1
XTAP_TAPCELL_ROW_281_6790 VSS VSS gf180mcu_fd_sc_mcu9t5v0__filltie
X_17027_ _17059_/I1 _19244_/Q _17033_/S _17027_/Z VSS VSS VSS VSS gf180mcu_fd_sc_mcu9t5v0__mux2_1
X_14239_ _14320_/I0 _19339_/Q _14266_/S _19339_/D VSS VSS VSS VSS gf180mcu_fd_sc_mcu9t5v0__mux2_1
XPHY_EDGE_ROW_283_Right_210 VSS VSS gf180mcu_fd_sc_mcu9t5v0__endcap
Xload_slew131 _12153_/B _12348_/C VSS VSS VSS VSS gf180mcu_fd_sc_mcu9t5v0__clkbuf_8
X_18978_ _18978_/D _20066_/RN clkload67/I _18978_/Q VSS VSS VSS VSS gf180mcu_fd_sc_mcu9t5v0__dffrnq_1
X_09780_ _18837_/Q _18836_/Q _11600_/C VSS _09780_/VNW VSS VSS gf180mcu_fd_sc_mcu9t5v0__nand2_1
XPHY_EDGE_ROW_7_Right_7 VSS VSS gf180mcu_fd_sc_mcu9t5v0__endcap
Xeco14_skew_0 clkload81/I _18328_/CLK VSS VSS VSS VSS gf180mcu_fd_sc_mcu9t5v0__clkbuf_16
Xload_slew197 wire198/Z _12527_/A2 VSS VSS VSS VSS gf180mcu_fd_sc_mcu9t5v0__clkbuf_8
X_17929_ _18845_/Q _18846_/Q _18847_/Q _17929_/Z VSS VSS VSS VSS gf180mcu_fd_sc_mcu9t5v0__and3_1
XTAP_TAPCELL_ROW_106_3890 VSS VSS gf180mcu_fd_sc_mcu9t5v0__filltie
XTAP_TAPCELL_ROW_102_3798 VSS VSS gf180mcu_fd_sc_mcu9t5v0__filltie
XTAP_TAPCELL_ROW_102_3787 VSS VSS gf180mcu_fd_sc_mcu9t5v0__filltie
XTAP_TAPCELL_ROW_102_3776 VSS VSS gf180mcu_fd_sc_mcu9t5v0__filltie
XPHY_EDGE_ROW_149_1_Right_733 VSS VSS gf180mcu_fd_sc_mcu9t5v0__endcap
XTAP_TAPCELL_ROW_288_6988 VSS VSS gf180mcu_fd_sc_mcu9t5v0__filltie
XTAP_TAPCELL_ROW_288_6977 VSS VSS gf180mcu_fd_sc_mcu9t5v0__filltie
XTAP_TAPCELL_ROW_44_2182 VSS VSS gf180mcu_fd_sc_mcu9t5v0__filltie
X_09214_ _19591_/Q _15206_/A1 VSS VSS VSS VSS gf180mcu_fd_sc_mcu9t5v0__clkinv_1
XTAP_TAPCELL_ROW_44_2193 VSS VSS gf180mcu_fd_sc_mcu9t5v0__filltie
XTAP_TAPCELL_ROW_288_6999 VSS VSS gf180mcu_fd_sc_mcu9t5v0__filltie
XTAP_TAPCELL_ROW_40_2079 VSS VSS gf180mcu_fd_sc_mcu9t5v0__filltie
X_09145_ _19768_/Q _13253_/A1 VSS _13258_/VNW VSS VSS gf180mcu_fd_sc_mcu9t5v0__clkinv_1
X_09076_ _20142_/Q _15842_/A1 VSS _15847_/VNW VSS VSS gf180mcu_fd_sc_mcu9t5v0__clkinv_1
XTAP_TAPCELL_ROW_57_2543 VSS VSS gf180mcu_fd_sc_mcu9t5v0__filltie
XTAP_TAPCELL_ROW_228_5350 VSS VSS gf180mcu_fd_sc_mcu9t5v0__filltie
XTAP_TAPCELL_ROW_57_2554 VSS VSS gf180mcu_fd_sc_mcu9t5v0__filltie
XTAP_TAPCELL_ROW_224_5236 VSS VSS gf180mcu_fd_sc_mcu9t5v0__filltie
XTAP_TAPCELL_ROW_224_5225 VSS VSS gf180mcu_fd_sc_mcu9t5v0__filltie
XPHY_EDGE_ROW_145_3_Left_803 VSS VSS gf180mcu_fd_sc_mcu9t5v0__endcap
XTAP_TAPCELL_ROW_144_2_8026 VSS VSS gf180mcu_fd_sc_mcu9t5v0__filltie
XTAP_TAPCELL_ROW_53_2429 VSS VSS gf180mcu_fd_sc_mcu9t5v0__filltie
X_09978_ _10054_/A2 _09978_/A2 _09978_/A3 _09978_/B1 _09438_/B _09979_/A3 VSS _09978_/VNW
+ VSS VSS gf180mcu_fd_sc_mcu9t5v0__oai32_1
XTAP_TAPCELL_ROW_206_1_4773 VSS VSS gf180mcu_fd_sc_mcu9t5v0__filltie
XTAP_TAPCELL_ROW_191_3_8191 VSS VSS gf180mcu_fd_sc_mcu9t5v0__filltie
X_20098_ _20098_/D clkload60/I _20098_/Q VSS VSS VSS VSS gf180mcu_fd_sc_mcu9t5v0__dffq_1
XPHY_EDGE_ROW_207_3_Left_865 VSS VSS gf180mcu_fd_sc_mcu9t5v0__endcap
X_11940_ _18325_/Q _12299_/S _11940_/B _12116_/C _11941_/A2 VSS _11941_/VNW VSS VSS
+ gf180mcu_fd_sc_mcu9t5v0__oai211_1
XPHY_EDGE_ROW_141_1_Left_464 VSS VSS gf180mcu_fd_sc_mcu9t5v0__endcap
X_11871_ _18274_/Q _12345_/A2 _12299_/S _11872_/B2 VSS VSS VSS VSS gf180mcu_fd_sc_mcu9t5v0__aoi21_1
X_10822_ _10822_/A1 _09721_/B _10822_/B1 _10823_/A2 _20063_/D VSS VSS VSS VSS gf180mcu_fd_sc_mcu9t5v0__oai22_1
X_13610_ _13610_/A1 _13610_/A2 _13610_/Z VSS VSS VSS VSS gf180mcu_fd_sc_mcu9t5v0__or2_1
X_14590_ _14591_/A1 _14764_/A1 _14590_/B _14594_/B VSS _14590_/VNW VSS VSS gf180mcu_fd_sc_mcu9t5v0__aoi21_1
XPHY_EDGE_ROW_284_Left_607 VSS VSS gf180mcu_fd_sc_mcu9t5v0__endcap
X_13541_ _13098_/I _13541_/A2 _13541_/A3 _13615_/B _13542_/A2 VSS VSS VSS VSS gf180mcu_fd_sc_mcu9t5v0__oai31_1
X_10753_ _18841_/Q _18848_/Q _10753_/B _10754_/I VSS VSS VSS VSS gf180mcu_fd_sc_mcu9t5v0__oai21_1
X_16260_ _18207_/Q _16260_/I1 _16824_/S _18207_/D VSS VSS VSS VSS gf180mcu_fd_sc_mcu9t5v0__mux2_1
XTAP_TAPCELL_ROW_213_4940 VSS VSS gf180mcu_fd_sc_mcu9t5v0__filltie
X_13472_ _19780_/Q _13475_/A2 _13489_/B VSS _13472_/VNW VSS VSS gf180mcu_fd_sc_mcu9t5v0__nand2_1
X_15211_ _19592_/Q _15211_/A2 _15216_/A2 VSS VSS VSS VSS gf180mcu_fd_sc_mcu9t5v0__nor2_1
X_10684_ _18839_/Q _18846_/Q _10708_/A1 VSS VSS VSS VSS gf180mcu_fd_sc_mcu9t5v0__nand2_1
X_16191_ _18184_/Q _16747_/A2 _16741_/A1 _16195_/B VSS VSS VSS VSS gf180mcu_fd_sc_mcu9t5v0__nand3_1
X_12423_ _18209_/Q wire163/Z _12426_/A3 VSS _16217_/VNW VSS VSS gf180mcu_fd_sc_mcu9t5v0__nor2_1
XTAP_TAPCELL_ROW_321_7904 VSS VSS gf180mcu_fd_sc_mcu9t5v0__filltie
XTAP_TAPCELL_ROW_112_4072 VSS VSS gf180mcu_fd_sc_mcu9t5v0__filltie
XTAP_TAPCELL_ROW_112_4061 VSS VSS gf180mcu_fd_sc_mcu9t5v0__filltie
XTAP_TAPCELL_ROW_112_4050 VSS VSS gf180mcu_fd_sc_mcu9t5v0__filltie
X_15142_ _19684_/Q _19524_/Q _15163_/S _19684_/D VSS VSS VSS VSS gf180mcu_fd_sc_mcu9t5v0__mux2_1
X_12354_ _12354_/A1 _12354_/A2 _12355_/I VSS VSS VSS VSS gf180mcu_fd_sc_mcu9t5v0__nand2_2
XTAP_TAPCELL_ROW_306_7494 VSS VSS gf180mcu_fd_sc_mcu9t5v0__filltie
XTAP_TAPCELL_ROW_306_7483 VSS VSS gf180mcu_fd_sc_mcu9t5v0__filltie
XTAP_TAPCELL_ROW_306_7472 VSS VSS gf180mcu_fd_sc_mcu9t5v0__filltie
X_19950_ _19950_/D _20142_/RN clkload66/I _19950_/Q VSS VSS VSS VSS gf180mcu_fd_sc_mcu9t5v0__dffrnq_1
X_11305_ wire283/Z _11305_/A2 _11305_/B _12071_/B _11306_/B2 VSS _11305_/VNW VSS VSS
+ gf180mcu_fd_sc_mcu9t5v0__aoi211_2
X_15073_ _15073_/A1 _15073_/A2 _15073_/B _15077_/A3 VSS _15073_/VNW VSS VSS gf180mcu_fd_sc_mcu9t5v0__oai21_1
X_12285_ _18469_/Q _12345_/A2 _12324_/B _12286_/B2 VSS _12285_/VNW VSS VSS gf180mcu_fd_sc_mcu9t5v0__aoi21_1
XTAP_TAPCELL_ROW_302_7369 VSS VSS gf180mcu_fd_sc_mcu9t5v0__filltie
XTAP_TAPCELL_ROW_298_7262 VSS VSS gf180mcu_fd_sc_mcu9t5v0__filltie
X_14024_ _14025_/A1 _14024_/A2 _14064_/A2 VSS VSS VSS VSS gf180mcu_fd_sc_mcu9t5v0__nand2_1
X_18901_ _18901_/D _20053_/RN clkload43/I _18901_/Q VSS VSS VSS VSS gf180mcu_fd_sc_mcu9t5v0__dffrnq_1
X_11236_ _18290_/Q _11524_/S _11237_/A3 VSS _11236_/VNW VSS VSS gf180mcu_fd_sc_mcu9t5v0__nand2_1
XTAP_TAPCELL_ROW_298_7273 VSS VSS gf180mcu_fd_sc_mcu9t5v0__filltie
XPHY_EDGE_ROW_293_Left_616 VSS VSS gf180mcu_fd_sc_mcu9t5v0__endcap
X_19881_ _19881_/D _20073_/RN clkload45/I _19881_/Q VSS VSS VSS VSS gf180mcu_fd_sc_mcu9t5v0__dffrnq_1
XTAP_TAPCELL_ROW_294_7159 VSS VSS gf180mcu_fd_sc_mcu9t5v0__filltie
XTAP_TAPCELL_ROW_319_7833 VSS VSS gf180mcu_fd_sc_mcu9t5v0__filltie
XTAP_TAPCELL_ROW_294_7148 VSS VSS gf180mcu_fd_sc_mcu9t5v0__filltie
XTAP_TAPCELL_ROW_125_4433 VSS VSS gf180mcu_fd_sc_mcu9t5v0__filltie
XTAP_TAPCELL_ROW_125_4422 VSS VSS gf180mcu_fd_sc_mcu9t5v0__filltie
X_18832_ _18832_/D _20048_/RN clkload38/I _18832_/Q VSS VSS VSS VSS gf180mcu_fd_sc_mcu9t5v0__dffrnq_1
X_11167_ _11321_/A2 _11167_/A2 _11167_/A3 _11167_/B _19077_/D VSS VSS VSS VSS gf180mcu_fd_sc_mcu9t5v0__oai31_1
XTAP_TAPCELL_ROW_125_4411 VSS VSS gf180mcu_fd_sc_mcu9t5v0__filltie
XTAP_TAPCELL_ROW_36_1959 VSS VSS gf180mcu_fd_sc_mcu9t5v0__filltie
XTAP_TAPCELL_ROW_319_7855 VSS VSS gf180mcu_fd_sc_mcu9t5v0__filltie
XTAP_TAPCELL_ROW_319_7844 VSS VSS gf180mcu_fd_sc_mcu9t5v0__filltie
X_10118_ _10118_/A1 _10118_/A2 _10118_/A3 _10119_/C VSS _10118_/VNW VSS VSS gf180mcu_fd_sc_mcu9t5v0__nand3_1
X_18763_ _18763_/D _20043_/RN _20049_/CLK _18763_/Q VSS VSS VSS VSS gf180mcu_fd_sc_mcu9t5v0__dffrnq_1
XTAP_TAPCELL_ROW_121_4308 VSS VSS gf180mcu_fd_sc_mcu9t5v0__filltie
X_11098_ _18313_/Q _11403_/S _11098_/B _11100_/A2 VSS VSS VSS VSS gf180mcu_fd_sc_mcu9t5v0__aoi21_1
X_15975_ _16545_/A3 _16197_/C _16105_/A1 _16444_/A1 VSS VSS VSS VSS gf180mcu_fd_sc_mcu9t5v0__nand3_4
X_17714_ _18733_/Q _17673_/S _17743_/B _18657_/Q _17715_/I VSS VSS VSS VSS gf180mcu_fd_sc_mcu9t5v0__aoi22_1
XTAP_TAPCELL_ROW_121_4319 VSS VSS gf180mcu_fd_sc_mcu9t5v0__filltie
X_10049_ _10049_/A1 _15822_/A1 _10051_/A2 VSS _15825_/VNW VSS VSS gf180mcu_fd_sc_mcu9t5v0__nand2_1
X_18694_ _18694_/D _20034_/RN clkload25/I _18694_/Q VSS VSS VSS VSS gf180mcu_fd_sc_mcu9t5v0__dffrnq_1
X_14926_ _14926_/A1 _14926_/A2 _14928_/A1 VSS VSS VSS VSS gf180mcu_fd_sc_mcu9t5v0__nand2_1
X_17645_ _18689_/Q _09517_/I _17646_/A2 VSS _17646_/VNW VSS VSS gf180mcu_fd_sc_mcu9t5v0__nand2_1
X_14857_ _19583_/Q _19344_/Q _15148_/S _19583_/D VSS VSS VSS VSS gf180mcu_fd_sc_mcu9t5v0__mux2_1
X_17576_ _17576_/A1 _17576_/A2 _18644_/D VSS VSS VSS VSS gf180mcu_fd_sc_mcu9t5v0__nand2_1
X_14788_ _19398_/Q _19335_/Q _14788_/Z VSS _14877_/VNW VSS VSS gf180mcu_fd_sc_mcu9t5v0__xor2_1
X_13808_ _19306_/Q _13807_/Z _14139_/S _19306_/D VSS _15324_/VNW VSS VSS gf180mcu_fd_sc_mcu9t5v0__mux2_1
XPHY_EDGE_ROW_306_Right_233 VSS VSS gf180mcu_fd_sc_mcu9t5v0__endcap
X_16527_ _16151_/B _19235_/Q _17055_/S _16527_/Z VSS VSS VSS VSS gf180mcu_fd_sc_mcu9t5v0__mux2_1
XTAP_TAPCELL_ROW_270_6491 VSS VSS gf180mcu_fd_sc_mcu9t5v0__filltie
XTAP_TAPCELL_ROW_119_4259 VSS VSS gf180mcu_fd_sc_mcu9t5v0__filltie
XTAP_TAPCELL_ROW_119_4248 VSS VSS gf180mcu_fd_sc_mcu9t5v0__filltie
X_13739_ _19148_/Q _13739_/A2 _13748_/B VSS VSS VSS VSS gf180mcu_fd_sc_mcu9t5v0__nor2_1
X_19315_ _19315_/D _20019_/RN clkload20/I _19315_/Q VSS VSS VSS VSS gf180mcu_fd_sc_mcu9t5v0__dffrnq_1
XTAP_TAPCELL_ROW_150_2_8047 VSS VSS gf180mcu_fd_sc_mcu9t5v0__filltie
X_16458_ _18287_/Q _16457_/Z wire28/I _18287_/D VSS VSS VSS VSS gf180mcu_fd_sc_mcu9t5v0__mux2_1
X_19246_ _19246_/D _20142_/RN clkload25/I _19246_/Q VSS VSS VSS VSS gf180mcu_fd_sc_mcu9t5v0__dffrnq_2
X_16389_ _16162_/B _19237_/Q _16927_/S _16389_/Z VSS VSS VSS VSS gf180mcu_fd_sc_mcu9t5v0__mux2_1
XTAP_TAPCELL_ROW_283_6841 VSS VSS gf180mcu_fd_sc_mcu9t5v0__filltie
XPHY_EDGE_ROW_139_3_Right_254 VSS VSS gf180mcu_fd_sc_mcu9t5v0__endcap
X_19177_ _19177_/D _20073_/RN clkload13/I _19177_/Q VSS VSS VSS VSS gf180mcu_fd_sc_mcu9t5v0__dffrnq_1
X_15409_ _19694_/Q _19794_/Q _15430_/S _19794_/D VSS VSS VSS VSS gf180mcu_fd_sc_mcu9t5v0__mux2_1
XTAP_TAPCELL_ROW_283_6863 VSS VSS gf180mcu_fd_sc_mcu9t5v0__filltie
XTAP_TAPCELL_ROW_283_6852 VSS VSS gf180mcu_fd_sc_mcu9t5v0__filltie
X_18128_ _18128_/A1 _18147_/S _18132_/B _18129_/I0 VSS _18128_/VNW VSS VSS gf180mcu_fd_sc_mcu9t5v0__oai21_1
X_09901_ _10057_/A1 _09978_/B1 wire297/I VSS _09930_/VNW VSS VSS gf180mcu_fd_sc_mcu9t5v0__nor2_2
X_18059_ _18060_/B _18059_/A2 _18056_/S _18059_/B _18924_/D VSS VSS VSS VSS gf180mcu_fd_sc_mcu9t5v0__oai31_1
X_20021_ _20021_/D _20021_/RN clkload51/I _20021_/Q VSS VSS VSS VSS gf180mcu_fd_sc_mcu9t5v0__dffrnq_1
X_09832_ _19019_/Q _19018_/Q _09832_/A3 _17888_/A2 _09834_/A3 VSS _10190_/VNW VSS
+ VSS gf180mcu_fd_sc_mcu9t5v0__nor4_1
X_09763_ _19019_/Q _09578_/Z _09835_/A1 VSS VSS VSS VSS gf180mcu_fd_sc_mcu9t5v0__nor2_1
XTAP_TAPCELL_ROW_108_3941 VSS VSS gf180mcu_fd_sc_mcu9t5v0__filltie
XTAP_TAPCELL_ROW_277_6689 VSS VSS gf180mcu_fd_sc_mcu9t5v0__filltie
XTAP_TAPCELL_ROW_277_6678 VSS VSS gf180mcu_fd_sc_mcu9t5v0__filltie
XTAP_TAPCELL_ROW_108_3963 VSS VSS gf180mcu_fd_sc_mcu9t5v0__filltie
XTAP_TAPCELL_ROW_108_3952 VSS VSS gf180mcu_fd_sc_mcu9t5v0__filltie
X_09694_ _09694_/A1 _17439_/A1 _20011_/D VSS VSS VSS VSS gf180mcu_fd_sc_mcu9t5v0__nand2_1
XTAP_TAPCELL_ROW_104_3849 VSS VSS gf180mcu_fd_sc_mcu9t5v0__filltie
XTAP_TAPCELL_ROW_104_3838 VSS VSS gf180mcu_fd_sc_mcu9t5v0__filltie
XTAP_TAPCELL_ROW_217_5051 VSS VSS gf180mcu_fd_sc_mcu9t5v0__filltie
XTAP_TAPCELL_ROW_217_5040 VSS VSS gf180mcu_fd_sc_mcu9t5v0__filltie
XTAP_TAPCELL_ROW_46_2244 VSS VSS gf180mcu_fd_sc_mcu9t5v0__filltie
XTAP_TAPCELL_ROW_46_2255 VSS VSS gf180mcu_fd_sc_mcu9t5v0__filltie
XTAP_TAPCELL_ROW_59_2605 VSS VSS gf180mcu_fd_sc_mcu9t5v0__filltie
XTAP_TAPCELL_ROW_59_2616 VSS VSS gf180mcu_fd_sc_mcu9t5v0__filltie
X_09128_ _19727_/Q _13145_/A1 VSS _13162_/VNW VSS VSS gf180mcu_fd_sc_mcu9t5v0__clkinv_1
X_09059_ input7/Z _17777_/A1 VSS VSS VSS VSS gf180mcu_fd_sc_mcu9t5v0__clkinv_1
X_12070_ _12261_/B _12062_/Z _12070_/B1 _12070_/B2 _12106_/A2 VSS VSS VSS VSS gf180mcu_fd_sc_mcu9t5v0__oai22_2
X_11021_ _19054_/Q _19022_/Q wire174/Z _19022_/D VSS VSS VSS VSS gf180mcu_fd_sc_mcu9t5v0__mux2_1
XTAP_TAPCELL_ROW_31_1823 VSS VSS gf180mcu_fd_sc_mcu9t5v0__filltie
XTAP_TAPCELL_ROW_31_1834 VSS VSS gf180mcu_fd_sc_mcu9t5v0__filltie
XTAP_TAPCELL_ROW_31_1845 VSS VSS gf180mcu_fd_sc_mcu9t5v0__filltie
Xdelaybuf_1_core_clk delaybuf_1_core_clk/I delaybuf_2_core_clk/I VSS VSS VSS VSS gf180mcu_fd_sc_mcu9t5v0__clkbuf_16
X_15760_ _19932_/Q _15760_/A2 _15760_/Z VSS _15760_/VNW VSS VSS gf180mcu_fd_sc_mcu9t5v0__xor2_1
X_12972_ _13244_/B _12972_/A2 _12973_/B2 VSS _12972_/VNW VSS VSS gf180mcu_fd_sc_mcu9t5v0__nor2_1
XTAP_TAPCELL_ROW_310_7605 VSS VSS gf180mcu_fd_sc_mcu9t5v0__filltie
X_11923_ _11924_/A1 _11924_/A2 _11925_/A2 VSS VSS VSS VSS gf180mcu_fd_sc_mcu9t5v0__nor2_4
X_15691_ _20003_/Q _19996_/Q _15691_/B _15691_/C _15726_/S VSS VSS VSS VSS gf180mcu_fd_sc_mcu9t5v0__oai211_1
XTAP_TAPCELL_ROW_12_1299 VSS VSS gf180mcu_fd_sc_mcu9t5v0__filltie
X_14711_ _19159_/Q _19125_/Q _14712_/B VSS VSS VSS VSS gf180mcu_fd_sc_mcu9t5v0__nand2_1
X_17430_ wire175/I _17430_/A2 _17430_/B _17431_/S VSS VSS VSS VSS gf180mcu_fd_sc_mcu9t5v0__aoi21_1
X_14642_ _19104_/Q _19520_/Q _14730_/S _19520_/D VSS _14642_/VNW VSS VSS gf180mcu_fd_sc_mcu9t5v0__mux2_1
X_11854_ _12548_/A1 _11839_/Z _11854_/B _11985_/B _11856_/A1 VSS _11854_/VNW VSS VSS
+ gf180mcu_fd_sc_mcu9t5v0__oai211_1
X_10805_ _19016_/Q _17878_/A1 _10806_/A3 VSS _10805_/VNW VSS VSS gf180mcu_fd_sc_mcu9t5v0__nor2_1
X_11785_ _12342_/C _11785_/A2 _11785_/A3 _11785_/B _11807_/A3 VSS VSS VSS VSS gf180mcu_fd_sc_mcu9t5v0__oai31_2
X_17361_ _10459_/C _17361_/A2 _17361_/A3 _17361_/B _17362_/A2 VSS VSS VSS VSS gf180mcu_fd_sc_mcu9t5v0__oai31_1
X_19100_ _19100_/D _20060_/RN _19680_/CLK _19100_/Q VSS VSS VSS VSS gf180mcu_fd_sc_mcu9t5v0__dffrnq_1
XTAP_TAPCELL_ROW_29_1774 VSS VSS gf180mcu_fd_sc_mcu9t5v0__filltie
XTAP_TAPCELL_ROW_29_1785 VSS VSS gf180mcu_fd_sc_mcu9t5v0__filltie
X_14573_ _19137_/Q wire199/Z _14764_/B _14573_/C _14574_/A2 VSS VSS VSS VSS gf180mcu_fd_sc_mcu9t5v0__oai211_1
X_16312_ _18221_/Q _16311_/Z _16850_/S _18221_/D VSS VSS VSS VSS gf180mcu_fd_sc_mcu9t5v0__mux2_4
X_17292_ _18547_/Q _17394_/A2 _17310_/B VSS VSS VSS VSS gf180mcu_fd_sc_mcu9t5v0__nand2_1
XTAP_TAPCELL_ROW_114_4123 VSS VSS gf180mcu_fd_sc_mcu9t5v0__filltie
X_13524_ _13525_/A1 _13525_/B _13525_/A2 _13527_/A1 VSS VSS VSS VSS gf180mcu_fd_sc_mcu9t5v0__nor3_1
XTAP_TAPCELL_ROW_114_4112 VSS VSS gf180mcu_fd_sc_mcu9t5v0__filltie
X_10736_ _18852_/Q _10751_/A3 _10736_/B1 _10736_/B2 _10803_/C _10740_/A2 VSS _10736_/VNW
+ VSS VSS gf180mcu_fd_sc_mcu9t5v0__oai221_1
XTAP_TAPCELL_ROW_308_7545 VSS VSS gf180mcu_fd_sc_mcu9t5v0__filltie
XTAP_TAPCELL_ROW_308_7534 VSS VSS gf180mcu_fd_sc_mcu9t5v0__filltie
X_10667_ _20030_/Q _10667_/A2 _10667_/A3 _10667_/B _17414_/I0 VSS VSS VSS VSS gf180mcu_fd_sc_mcu9t5v0__oai31_4
X_16243_ _16243_/A1 _16409_/B2 _16244_/I1 VSS _16582_/VNW VSS VSS gf180mcu_fd_sc_mcu9t5v0__nand2_1
X_13455_ _13497_/A1 _13455_/A2 _13497_/B _13456_/B2 VSS VSS VSS VSS gf180mcu_fd_sc_mcu9t5v0__aoi21_1
X_19031_ _19031_/D _20055_/RN clkload32/I _19031_/Q VSS VSS VSS VSS gf180mcu_fd_sc_mcu9t5v0__dffrnq_1
X_16174_ _16730_/A1 _16174_/A2 _16174_/B _16174_/C _16175_/I1 VSS VSS VSS VSS gf180mcu_fd_sc_mcu9t5v0__oai211_4
X_12406_ _18255_/Q _12615_/A2 _12408_/B1 VSS VSS VSS VSS gf180mcu_fd_sc_mcu9t5v0__nor2_1
XTAP_TAPCELL_ROW_110_4009 VSS VSS gf180mcu_fd_sc_mcu9t5v0__filltie
X_10598_ _18550_/Q wire80/Z _10650_/B1 _10598_/B2 _10604_/A2 VSS VSS VSS VSS gf180mcu_fd_sc_mcu9t5v0__aoi22_4
X_13386_ _13386_/I _13422_/A1 VSS VSS VSS VSS gf180mcu_fd_sc_mcu9t5v0__clkinv_1
X_15125_ _19667_/Q _19507_/Q _15163_/S _19667_/D VSS _15125_/VNW VSS VSS gf180mcu_fd_sc_mcu9t5v0__mux2_1
XTAP_TAPCELL_ROW_209_4828 VSS VSS gf180mcu_fd_sc_mcu9t5v0__filltie
XTAP_TAPCELL_ROW_209_4817 VSS VSS gf180mcu_fd_sc_mcu9t5v0__filltie
XTAP_TAPCELL_ROW_209_4806 VSS VSS gf180mcu_fd_sc_mcu9t5v0__filltie
X_12337_ _18922_/Q _12338_/A2 wire213/I _12338_/B VSS _12337_/VNW VSS VSS gf180mcu_fd_sc_mcu9t5v0__oai21_1
X_12268_ _18516_/Q _12267_/Z _12324_/B _12268_/Z VSS VSS VSS VSS gf180mcu_fd_sc_mcu9t5v0__mux2_1
X_19933_ _19933_/D _20061_/RN clkload46/I _19933_/Q VSS VSS VSS VSS gf180mcu_fd_sc_mcu9t5v0__dffrnq_1
X_15056_ _19640_/Q _15090_/A2 _15057_/B VSS _15056_/VNW VSS VSS gf180mcu_fd_sc_mcu9t5v0__nand2_1
X_19864_ _19864_/D _19992_/RN clkload55/I _19864_/Q VSS VSS VSS VSS gf180mcu_fd_sc_mcu9t5v0__dffrnq_1
X_11219_ _11219_/A1 _11219_/A2 _11469_/B _11219_/C _11221_/B VSS VSS VSS VSS gf180mcu_fd_sc_mcu9t5v0__oai211_1
X_14007_ _14007_/A1 _13972_/Z _14007_/B _14015_/A1 VSS VSS VSS VSS gf180mcu_fd_sc_mcu9t5v0__oai21_1
X_12199_ _12199_/A1 _12199_/A2 _12261_/B _12210_/B VSS _16626_/VNW VSS VSS gf180mcu_fd_sc_mcu9t5v0__aoi21_1
XTAP_TAPCELL_ROW_173_3_8130 VSS VSS gf180mcu_fd_sc_mcu9t5v0__filltie
X_18815_ _18815_/D _20031_/RN clkload35/I _18815_/Q VSS VSS VSS VSS gf180mcu_fd_sc_mcu9t5v0__dffrnq_1
X_19795_ _19795_/D _20051_/RN clkload29/I _19795_/Q VSS VSS VSS VSS gf180mcu_fd_sc_mcu9t5v0__dffrnq_1
X_15958_ _16196_/A1 _15973_/B _15962_/C VSS VSS VSS VSS gf180mcu_fd_sc_mcu9t5v0__nor2_1
X_18746_ _18746_/D clkload65/I _18746_/Q VSS VSS VSS VSS gf180mcu_fd_sc_mcu9t5v0__dffq_1
XTAP_TAPCELL_ROW_272_6564 VSS VSS gf180mcu_fd_sc_mcu9t5v0__filltie
XTAP_TAPCELL_ROW_272_6553 VSS VSS gf180mcu_fd_sc_mcu9t5v0__filltie
XTAP_TAPCELL_ROW_272_6542 VSS VSS gf180mcu_fd_sc_mcu9t5v0__filltie
X_18677_ _18677_/D _20145_/RN _20049_/CLK _18677_/Q VSS VSS VSS VSS gf180mcu_fd_sc_mcu9t5v0__dffrnq_1
X_14909_ _19418_/Q _19359_/Q _14909_/Z VSS VSS VSS VSS gf180mcu_fd_sc_mcu9t5v0__xor2_1
X_15889_ _20098_/Q _19233_/Q _15920_/S _20098_/D VSS VSS VSS VSS gf180mcu_fd_sc_mcu9t5v0__mux2_1
X_17628_ _17628_/A1 _17702_/A3 _18685_/D VSS _17628_/VNW VSS VSS gf180mcu_fd_sc_mcu9t5v0__xnor2_1
X_17559_ input7/Z _17553_/Z _17569_/A2 VSS VSS VSS VSS gf180mcu_fd_sc_mcu9t5v0__nor2_1
XTAP_TAPCELL_ROW_285_6914 VSS VSS gf180mcu_fd_sc_mcu9t5v0__filltie
XTAP_TAPCELL_ROW_285_6903 VSS VSS gf180mcu_fd_sc_mcu9t5v0__filltie
X_19229_ _19229_/D _20061_/RN clkload25/I _19229_/Q VSS VSS VSS VSS gf180mcu_fd_sc_mcu9t5v0__dffrnq_2
XTAP_TAPCELL_ROW_99_3697 VSS VSS gf180mcu_fd_sc_mcu9t5v0__filltie
XTAP_TAPCELL_ROW_266_6379 VSS VSS gf180mcu_fd_sc_mcu9t5v0__filltie
X_20004_ _20004_/D _20068_/RN clkload26/I _20004_/Q VSS VSS VSS VSS gf180mcu_fd_sc_mcu9t5v0__dffrnq_1
X_09815_ _09815_/I _17909_/A2 VSS VSS VSS VSS gf180mcu_fd_sc_mcu9t5v0__clkinv_1
XTAP_TAPCELL_ROW_219_5102 VSS VSS gf180mcu_fd_sc_mcu9t5v0__filltie
X_09746_ _20068_/Q _09745_/I _09751_/A3 VSS _10828_/VNW VSS VSS gf180mcu_fd_sc_mcu9t5v0__nor2_1
XTAP_TAPCELL_ROW_48_2306 VSS VSS gf180mcu_fd_sc_mcu9t5v0__filltie
X_09677_ _09677_/I _09679_/B1 VSS VSS VSS VSS gf180mcu_fd_sc_mcu9t5v0__clkinv_1
XTAP_TAPCELL_ROW_251_5969 VSS VSS gf180mcu_fd_sc_mcu9t5v0__filltie
XTAP_TAPCELL_ROW_190_1_4765 VSS VSS gf180mcu_fd_sc_mcu9t5v0__filltie
X_11570_ _18217_/Q _12046_/S _12090_/B _11573_/A2 VSS _17221_/VNW VSS VSS gf180mcu_fd_sc_mcu9t5v0__aoi21_1
X_10521_ _17304_/C _10521_/A2 _10521_/A3 _10521_/A4 _10523_/B1 VSS VSS VSS VSS gf180mcu_fd_sc_mcu9t5v0__nand4_1
X_13240_ _19735_/Q _13238_/Z _13261_/A1 VSS VSS VSS VSS gf180mcu_fd_sc_mcu9t5v0__nand2_1
XTAP_TAPCELL_ROW_20_1524 VSS VSS gf180mcu_fd_sc_mcu9t5v0__filltie
X_10452_ _10655_/B _10452_/A2 _10452_/B1 _10452_/B2 _10452_/ZN VSS VSS VSS VSS gf180mcu_fd_sc_mcu9t5v0__aoi22_4
XTAP_TAPCELL_ROW_20_1535 VSS VSS gf180mcu_fd_sc_mcu9t5v0__filltie
XTAP_TAPCELL_ROW_20_1546 VSS VSS gf180mcu_fd_sc_mcu9t5v0__filltie
X_10383_ _17177_/B _10383_/A2 _10386_/B1 VSS VSS VSS VSS gf180mcu_fd_sc_mcu9t5v0__nor2_1
X_13171_ _13169_/Z _13186_/A2 _13171_/Z VSS _13171_/VNW VSS VSS gf180mcu_fd_sc_mcu9t5v0__xor2_1
X_12122_ _12164_/B _12164_/A1 _12121_/B _12122_/Z VSS VSS VSS VSS gf180mcu_fd_sc_mcu9t5v0__and3_1
X_16930_ _16932_/A2 _16678_/B _16930_/B _16931_/I0 VSS VSS VSS VSS gf180mcu_fd_sc_mcu9t5v0__oai21_1
X_12053_ _19125_/Q _12053_/I1 _12333_/B _19125_/D VSS VSS VSS VSS gf180mcu_fd_sc_mcu9t5v0__mux2_1
XTAP_TAPCELL_ROW_158_3_8076 VSS VSS gf180mcu_fd_sc_mcu9t5v0__filltie
X_11004_ _18937_/Q _11004_/A2 _10981_/I _18936_/Q _18935_/Q _11005_/B1 VSS VSS VSS
+ VSS gf180mcu_fd_sc_mcu9t5v0__oai221_1
XTAP_TAPCELL_ROW_18_1464 VSS VSS gf180mcu_fd_sc_mcu9t5v0__filltie
XTAP_TAPCELL_ROW_18_1475 VSS VSS gf180mcu_fd_sc_mcu9t5v0__filltie
X_16861_ _19258_/Q _16668_/B _16861_/S _16861_/Z VSS VSS VSS VSS gf180mcu_fd_sc_mcu9t5v0__mux2_1
XTAP_TAPCELL_ROW_18_1486 VSS VSS gf180mcu_fd_sc_mcu9t5v0__filltie
X_16792_ _18394_/Q _16792_/I1 _16798_/S _18394_/D VSS VSS VSS VSS gf180mcu_fd_sc_mcu9t5v0__mux2_1
X_18600_ _18600_/D clkload77/I _18600_/Q VSS VSS VSS VSS gf180mcu_fd_sc_mcu9t5v0__dffq_1
X_15812_ _09065_/I _19981_/Q _15819_/S _19981_/D VSS VSS VSS VSS gf180mcu_fd_sc_mcu9t5v0__mux2_1
X_19580_ _19580_/D _20028_/RN clkload9/I _19580_/Q VSS VSS VSS VSS gf180mcu_fd_sc_mcu9t5v0__dffrnq_1
X_18531_ _18531_/D clkload76/I _18531_/Q VSS VSS VSS VSS gf180mcu_fd_sc_mcu9t5v0__dffq_1
X_15743_ _19999_/Q _15743_/A2 _15757_/B _15743_/C _15744_/B VSS _15743_/VNW VSS VSS
+ gf180mcu_fd_sc_mcu9t5v0__aoi211_1
X_12955_ _12735_/B _13503_/A2 _12955_/Z VSS VSS VSS VSS gf180mcu_fd_sc_mcu9t5v0__and2_1
XTAP_TAPCELL_ROW_289_7025 VSS VSS gf180mcu_fd_sc_mcu9t5v0__filltie
XTAP_TAPCELL_ROW_289_7014 VSS VSS gf180mcu_fd_sc_mcu9t5v0__filltie
X_11906_ _11907_/A2 _11907_/A3 _11908_/A2 VSS _11906_/VNW VSS VSS gf180mcu_fd_sc_mcu9t5v0__nand2_1
X_18462_ _18462_/D clkload73/I _18462_/Q VSS VSS VSS VSS gf180mcu_fd_sc_mcu9t5v0__dffq_1
X_15674_ _19911_/Q _15674_/A2 _15678_/A2 VSS VSS VSS VSS gf180mcu_fd_sc_mcu9t5v0__nor2_1
X_12886_ _19740_/Q _19805_/Q _13244_/B _12886_/Z VSS VSS VSS VSS gf180mcu_fd_sc_mcu9t5v0__mux2_1
X_17413_ _17250_/Z _17413_/A2 _17413_/B _18552_/D VSS VSS VSS VSS gf180mcu_fd_sc_mcu9t5v0__oai21_4
X_18393_ _18393_/D clkload52/I _18393_/Q VSS VSS VSS VSS gf180mcu_fd_sc_mcu9t5v0__dffq_1
X_14625_ _19086_/Q _19503_/Q _14670_/S _19503_/D VSS VSS VSS VSS gf180mcu_fd_sc_mcu9t5v0__mux2_1
X_11837_ _13739_/A2 _11985_/B _11837_/B _19114_/D VSS _11837_/VNW VSS VSS gf180mcu_fd_sc_mcu9t5v0__oai21_1
X_17344_ _09261_/I _17344_/A2 _17344_/A3 _17344_/B _17345_/B1 VSS VSS VSS VSS gf180mcu_fd_sc_mcu9t5v0__oai31_1
X_11768_ _11768_/A1 _11768_/A2 _11814_/A3 VSS _11768_/VNW VSS VSS gf180mcu_fd_sc_mcu9t5v0__nand2_1
X_14556_ _19469_/Q _14766_/A2 _14565_/A1 VSS VSS VSS VSS gf180mcu_fd_sc_mcu9t5v0__nand2_1
X_10719_ _10719_/A1 _10719_/A2 _10719_/ZN VSS VSS VSS VSS gf180mcu_fd_sc_mcu9t5v0__nor2_4
X_13507_ _12962_/Z _13507_/A2 _13507_/B _13512_/A3 VSS VSS VSS VSS gf180mcu_fd_sc_mcu9t5v0__oai21_1
X_17275_ _18482_/Q _17282_/A2 _17282_/B1 _18498_/Q _17275_/C _17279_/A2 VSS VSS VSS
+ VSS gf180mcu_fd_sc_mcu9t5v0__aoi221_1
X_11699_ _18712_/Q _12527_/A2 wire208/Z _11699_/B2 _11700_/A2 VSS VSS VSS VSS gf180mcu_fd_sc_mcu9t5v0__aoi22_1
X_19014_ _19014_/D _20038_/RN clkload38/I _19014_/Q VSS VSS VSS VSS gf180mcu_fd_sc_mcu9t5v0__dffrnq_1
X_14487_ _19161_/Q _14487_/A2 _14487_/B _14507_/B1 VSS _14720_/VNW VSS VSS gf180mcu_fd_sc_mcu9t5v0__oai21_1
X_16226_ _16182_/B _19273_/Q _16785_/S _16226_/Z VSS _16226_/VNW VSS VSS gf180mcu_fd_sc_mcu9t5v0__mux2_1
X_13438_ _16953_/A1 _13497_/B _13438_/B1 _13438_/B2 _19255_/D VSS VSS VSS VSS gf180mcu_fd_sc_mcu9t5v0__aoi22_1
XTAP_TAPCELL_ROW_94_3572 VSS VSS gf180mcu_fd_sc_mcu9t5v0__filltie
XTAP_TAPCELL_ROW_94_3561 VSS VSS gf180mcu_fd_sc_mcu9t5v0__filltie
X_16157_ _19268_/Q _16751_/B _16160_/A2 VSS VSS VSS VSS gf180mcu_fd_sc_mcu9t5v0__nor2_1
XTAP_TAPCELL_ROW_261_6243 VSS VSS gf180mcu_fd_sc_mcu9t5v0__filltie
X_13369_ _13369_/I _13614_/A1 VSS _13369_/VNW VSS VSS gf180mcu_fd_sc_mcu9t5v0__clkinv_1
XTAP_TAPCELL_ROW_90_3458 VSS VSS gf180mcu_fd_sc_mcu9t5v0__filltie
XTAP_TAPCELL_ROW_90_3447 VSS VSS gf180mcu_fd_sc_mcu9t5v0__filltie
XTAP_TAPCELL_ROW_261_6254 VSS VSS gf180mcu_fd_sc_mcu9t5v0__filltie
X_16088_ _19241_/Q _16751_/A2 wire71/Z _16090_/A3 VSS VSS VSS VSS gf180mcu_fd_sc_mcu9t5v0__nor3_1
XTAP_TAPCELL_ROW_90_3469 VSS VSS gf180mcu_fd_sc_mcu9t5v0__filltie
X_15108_ _19650_/Q _19490_/Q _15163_/S _19650_/D VSS _15108_/VNW VSS VSS gf180mcu_fd_sc_mcu9t5v0__mux2_1
X_19916_ _19916_/D _20044_/RN _20049_/CLK _19916_/Q VSS VSS VSS VSS gf180mcu_fd_sc_mcu9t5v0__dffrnq_1
X_15039_ _19303_/Q _19388_/Q _15041_/A1 _15040_/I1 VSS VSS VSS VSS gf180mcu_fd_sc_mcu9t5v0__xnor3_1
XTAP_TAPCELL_ROW_274_6615 VSS VSS gf180mcu_fd_sc_mcu9t5v0__filltie
XTAP_TAPCELL_ROW_274_6604 VSS VSS gf180mcu_fd_sc_mcu9t5v0__filltie
X_19847_ _19847_/D _20039_/RN clkload51/I _19847_/Q VSS VSS VSS VSS gf180mcu_fd_sc_mcu9t5v0__dffrnq_1
XTAP_TAPCELL_ROW_259_6194 VSS VSS gf180mcu_fd_sc_mcu9t5v0__filltie
XTAP_TAPCELL_ROW_259_6183 VSS VSS gf180mcu_fd_sc_mcu9t5v0__filltie
X_19778_ _19778_/D _20034_/RN clkload43/I _19778_/Q VSS VSS VSS VSS gf180mcu_fd_sc_mcu9t5v0__dffrnq_1
X_09600_ _20040_/Q _18834_/Q _18835_/Q _09601_/I VSS _17625_/VNW VSS VSS gf180mcu_fd_sc_mcu9t5v0__nand3_1
XTAP_TAPCELL_ROW_88_3398 VSS VSS gf180mcu_fd_sc_mcu9t5v0__filltie
X_09531_ _09531_/A1 _09531_/A2 _09531_/A3 _09532_/A2 VSS VSS VSS VSS gf180mcu_fd_sc_mcu9t5v0__nand3_1
X_18729_ _18729_/D clkload47/I _18729_/Q VSS VSS VSS VSS gf180mcu_fd_sc_mcu9t5v0__dffq_1
X_09462_ _09462_/I _14900_/S VSS VSS VSS VSS gf180mcu_fd_sc_mcu9t5v0__clkinv_8
XTAP_TAPCELL_ROW_4_1084 VSS VSS gf180mcu_fd_sc_mcu9t5v0__filltie
X_09393_ _18566_/Q _18565_/Q _11547_/B VSS VSS VSS VSS gf180mcu_fd_sc_mcu9t5v0__or2_1
XPHY_EDGE_ROW_154_3_Left_812 VSS VSS gf180mcu_fd_sc_mcu9t5v0__endcap
XTAP_TAPCELL_ROW_4_1095 VSS VSS gf180mcu_fd_sc_mcu9t5v0__filltie
XPHY_EDGE_ROW_135_Left_459 VSS VSS gf180mcu_fd_sc_mcu9t5v0__endcap
XTAP_TAPCELL_ROW_164_3_8097 VSS VSS gf180mcu_fd_sc_mcu9t5v0__filltie
XPHY_EDGE_ROW_150_1_Left_473 VSS VSS gf180mcu_fd_sc_mcu9t5v0__endcap
XTAP_TAPCELL_ROW_37_2007 VSS VSS gf180mcu_fd_sc_mcu9t5v0__filltie
XTAP_TAPCELL_ROW_244_5784 VSS VSS gf180mcu_fd_sc_mcu9t5v0__filltie
XTAP_TAPCELL_ROW_244_5773 VSS VSS gf180mcu_fd_sc_mcu9t5v0__filltie
XTAP_TAPCELL_ROW_73_2988 VSS VSS gf180mcu_fd_sc_mcu9t5v0__filltie
XTAP_TAPCELL_ROW_73_2977 VSS VSS gf180mcu_fd_sc_mcu9t5v0__filltie
XTAP_TAPCELL_ROW_73_2999 VSS VSS gf180mcu_fd_sc_mcu9t5v0__filltie
XTAP_TAPCELL_ROW_240_5659 VSS VSS gf180mcu_fd_sc_mcu9t5v0__filltie
X_09729_ _20020_/Q _15850_/A2 _17584_/S _18664_/Q _09730_/I VSS VSS VSS VSS gf180mcu_fd_sc_mcu9t5v0__aoi22_1
XTAP_TAPCELL_ROW_13_1350 VSS VSS gf180mcu_fd_sc_mcu9t5v0__filltie
X_12740_ _19719_/Q _19784_/Q _13244_/B _12740_/Z VSS VSS VSS VSS gf180mcu_fd_sc_mcu9t5v0__mux2_1
X_12671_ _11672_/Z _12664_/B _12671_/B1 _12671_/B2 _12673_/A1 VSS _12671_/VNW VSS
+ VSS gf180mcu_fd_sc_mcu9t5v0__aoi22_1
XTAP_TAPCELL_ROW_26_1700 VSS VSS gf180mcu_fd_sc_mcu9t5v0__filltie
XTAP_TAPCELL_ROW_26_1711 VSS VSS gf180mcu_fd_sc_mcu9t5v0__filltie
X_15390_ _19675_/Q _19775_/Q _15420_/S _19775_/D VSS VSS VSS VSS gf180mcu_fd_sc_mcu9t5v0__mux2_1
X_11622_ _11590_/Z _12634_/A2 _11659_/A2 VSS VSS VSS VSS gf180mcu_fd_sc_mcu9t5v0__nor2_1
X_14410_ _19152_/Q _19118_/Q _14410_/Z VSS _14410_/VNW VSS VSS gf180mcu_fd_sc_mcu9t5v0__or2_1
X_14341_ _13772_/Z _19412_/Q _14352_/S _19412_/D VSS VSS VSS VSS gf180mcu_fd_sc_mcu9t5v0__mux2_1
X_11553_ _11095_/S _11550_/Z wire175/I _12116_/C VSS _11559_/VNW VSS VSS gf180mcu_fd_sc_mcu9t5v0__mux2_4
X_11484_ _18436_/Q _11521_/B _11485_/B VSS _11484_/VNW VSS VSS gf180mcu_fd_sc_mcu9t5v0__nand2_1
X_17060_ _18522_/Q _16576_/B _17062_/S _18522_/D VSS _17060_/VNW VSS VSS gf180mcu_fd_sc_mcu9t5v0__mux2_1
X_10504_ _18949_/Q wire166/Z _10506_/A2 VSS VSS VSS VSS gf180mcu_fd_sc_mcu9t5v0__nand2_1
X_14272_ _13807_/Z _19346_/Q _14285_/S _19346_/D VSS VSS VSS VSS gf180mcu_fd_sc_mcu9t5v0__mux2_1
X_10435_ _18160_/Q _17322_/A2 _17255_/B1 _18176_/Q _10436_/B VSS VSS VSS VSS gf180mcu_fd_sc_mcu9t5v0__aoi22_1
X_16011_ _16569_/A1 _16011_/A2 _16011_/A3 _16011_/B _16012_/I1 VSS VSS VSS VSS gf180mcu_fd_sc_mcu9t5v0__oai31_1
X_13223_ _12948_/S _13221_/Z _13223_/A3 _13227_/B1 VSS _13223_/VNW VSS VSS gf180mcu_fd_sc_mcu9t5v0__nand3_1
Xclkbuf_leaf_27_clk_regs clkload3/I clkload52/I VSS VSS VSS VSS gf180mcu_fd_sc_mcu9t5v0__clkbuf_8
X_13154_ _13164_/A2 _19795_/Q _13170_/A1 _13155_/I VSS VSS VSS VSS gf180mcu_fd_sc_mcu9t5v0__xnor3_1
X_10366_ _18991_/Q _10654_/A2 _10366_/B wire160/Z _10368_/B1 VSS _10904_/VNW VSS VSS
+ gf180mcu_fd_sc_mcu9t5v0__oai211_1
X_12105_ _18725_/Q _12527_/A2 _12123_/B VSS VSS VSS VSS gf180mcu_fd_sc_mcu9t5v0__nand2_1
X_10297_ _17260_/S _18331_/Q _10299_/A3 VSS _12090_/VNW VSS VSS gf180mcu_fd_sc_mcu9t5v0__nor2_1
X_13085_ _13085_/A1 _13085_/A2 _13106_/A1 VSS _13085_/VNW VSS VSS gf180mcu_fd_sc_mcu9t5v0__nor2_1
X_17962_ _17962_/A1 _17962_/A2 _17966_/B VSS VSS VSS VSS gf180mcu_fd_sc_mcu9t5v0__nor2_1
X_16913_ _16628_/B _19252_/Q _16925_/S _16913_/Z VSS VSS VSS VSS gf180mcu_fd_sc_mcu9t5v0__mux2_1
X_12036_ _18362_/Q _12046_/S _12038_/A2 VSS VSS VSS VSS gf180mcu_fd_sc_mcu9t5v0__nor2_1
X_17893_ _17958_/A2 _17922_/A2 _17894_/I VSS VSS VSS VSS gf180mcu_fd_sc_mcu9t5v0__or2_1
X_19701_ _19701_/D _20021_/RN clkload24/I _19701_/Q VSS VSS VSS VSS gf180mcu_fd_sc_mcu9t5v0__dffrnq_1
X_16844_ _18414_/Q _16843_/Z _16850_/S _18414_/D VSS VSS VSS VSS gf180mcu_fd_sc_mcu9t5v0__mux2_4
X_19632_ _19632_/D _20144_/RN _19633_/CLK _19632_/Q VSS VSS VSS VSS gf180mcu_fd_sc_mcu9t5v0__dffrnq_1
X_16775_ _16641_/B _19286_/Q _16785_/S _16775_/Z VSS _16775_/VNW VSS VSS gf180mcu_fd_sc_mcu9t5v0__mux2_1
XTAP_TAPCELL_ROW_83_3262 VSS VSS gf180mcu_fd_sc_mcu9t5v0__filltie
X_19563_ _19563_/D _20139_/RN clkload19/I _19563_/Q VSS VSS VSS VSS gf180mcu_fd_sc_mcu9t5v0__dffrnq_1
X_13987_ _19311_/Q _13986_/Z _14139_/S _19311_/D VSS VSS VSS VSS gf180mcu_fd_sc_mcu9t5v0__mux2_1
X_18514_ _18514_/D _18515_/CLK _18514_/Q VSS VSS VSS VSS gf180mcu_fd_sc_mcu9t5v0__dffq_4
X_15726_ _15726_/I0 _19922_/Q _15726_/S _19922_/D VSS VSS VSS VSS gf180mcu_fd_sc_mcu9t5v0__mux2_1
XTAP_TAPCELL_ROW_83_3273 VSS VSS gf180mcu_fd_sc_mcu9t5v0__filltie
X_12938_ _19779_/Q _12936_/Z _12944_/B VSS _13472_/VNW VSS VSS gf180mcu_fd_sc_mcu9t5v0__nand2_1
X_19494_ _19494_/D _20070_/RN clkload26/I _19494_/Q VSS VSS VSS VSS gf180mcu_fd_sc_mcu9t5v0__dffrnq_1
X_18445_ _18445_/D clkload60/I _18445_/Q VSS VSS VSS VSS gf180mcu_fd_sc_mcu9t5v0__dffq_1
X_15657_ _15672_/B _15657_/A2 _15657_/B _19905_/D VSS VSS VSS VSS gf180mcu_fd_sc_mcu9t5v0__oai21_1
X_14608_ _19188_/Q _19486_/Q _14715_/S _19486_/D VSS VSS VSS VSS gf180mcu_fd_sc_mcu9t5v0__mux2_1
X_12869_ _19769_/Q _12862_/Z _12869_/B _12879_/A1 VSS VSS VSS VSS gf180mcu_fd_sc_mcu9t5v0__aoi21_1
X_18376_ _18376_/D clkload77/I _18376_/Q VSS VSS VSS VSS gf180mcu_fd_sc_mcu9t5v0__dffq_4
XTAP_TAPCELL_ROW_96_3634 VSS VSS gf180mcu_fd_sc_mcu9t5v0__filltie
X_15588_ _18024_/I0 _15596_/A2 _15589_/A2 VSS _15588_/VNW VSS VSS gf180mcu_fd_sc_mcu9t5v0__nor2_1
XTAP_TAPCELL_ROW_96_3623 VSS VSS gf180mcu_fd_sc_mcu9t5v0__filltie
XTAP_TAPCELL_ROW_96_3612 VSS VSS gf180mcu_fd_sc_mcu9t5v0__filltie
X_17327_ _20119_/Q _17408_/B _17327_/B _17329_/A2 VSS _17327_/VNW VSS VSS gf180mcu_fd_sc_mcu9t5v0__aoi21_1
X_14539_ _14539_/A1 _19134_/Q _14548_/B VSS VSS VSS VSS gf180mcu_fd_sc_mcu9t5v0__nand2_1
XTAP_TAPCELL_ROW_92_3509 VSS VSS gf180mcu_fd_sc_mcu9t5v0__filltie
X_17258_ _10514_/B _17257_/Z _17263_/A1 VSS VSS VSS VSS gf180mcu_fd_sc_mcu9t5v0__nand2_1
XTAP_TAPCELL_ROW_263_6316 VSS VSS gf180mcu_fd_sc_mcu9t5v0__filltie
XTAP_TAPCELL_ROW_263_6305 VSS VSS gf180mcu_fd_sc_mcu9t5v0__filltie
XTAP_TAPCELL_ROW_77_3088 VSS VSS gf180mcu_fd_sc_mcu9t5v0__filltie
X_16209_ _16208_/Z _18189_/Q _16784_/S _18189_/D VSS VSS VSS VSS gf180mcu_fd_sc_mcu9t5v0__mux2_4
XTAP_TAPCELL_ROW_77_3099 VSS VSS gf180mcu_fd_sc_mcu9t5v0__filltie
X_17189_ _18414_/Q _17322_/A2 _17255_/B1 _18430_/Q _17190_/B VSS _17190_/VNW VSS VSS
+ gf180mcu_fd_sc_mcu9t5v0__aoi22_1
XTAP_TAPCELL_ROW_6_1135 VSS VSS gf180mcu_fd_sc_mcu9t5v0__filltie
XTAP_TAPCELL_ROW_6_1146 VSS VSS gf180mcu_fd_sc_mcu9t5v0__filltie
XTAP_TAPCELL_ROW_6_1157 VSS VSS gf180mcu_fd_sc_mcu9t5v0__filltie
X_09514_ _09515_/A2 _09515_/A3 _09514_/Z VSS VSS VSS VSS gf180mcu_fd_sc_mcu9t5v0__or2_4
X_09445_ _20072_/Q _09437_/Z _09445_/A3 _09445_/A4 _09445_/Z VSS VSS VSS VSS gf180mcu_fd_sc_mcu9t5v0__and4_4
XTAP_TAPCELL_ROW_66_2792 VSS VSS gf180mcu_fd_sc_mcu9t5v0__filltie
XTAP_TAPCELL_ROW_62_2678 VSS VSS gf180mcu_fd_sc_mcu9t5v0__filltie
X_09376_ _18492_/Q _12516_/A1 VSS _12088_/VNW VSS VSS gf180mcu_fd_sc_mcu9t5v0__clkinv_1
XTAP_TAPCELL_ROW_233_5485 VSS VSS gf180mcu_fd_sc_mcu9t5v0__filltie
XTAP_TAPCELL_ROW_233_5474 VSS VSS gf180mcu_fd_sc_mcu9t5v0__filltie
XTAP_TAPCELL_ROW_62_2689 VSS VSS gf180mcu_fd_sc_mcu9t5v0__filltie
XPHY_EDGE_ROW_297_Right_224 VSS VSS gf180mcu_fd_sc_mcu9t5v0__endcap
XTAP_TAPCELL_ROW_246_5835 VSS VSS gf180mcu_fd_sc_mcu9t5v0__filltie
XTAP_TAPCELL_ROW_246_5824 VSS VSS gf180mcu_fd_sc_mcu9t5v0__filltie
X_10220_ _10514_/B _10218_/Z _17282_/B1 _18233_/Q _18217_/Q _17282_/A2 _10234_/A2
+ VSS VSS VSS VSS gf180mcu_fd_sc_mcu9t5v0__aoi222_1
XTAP_TAPCELL_ROW_246_5846 VSS VSS gf180mcu_fd_sc_mcu9t5v0__filltie
X_10151_ _20072_/Q _10151_/A2 _10151_/A3 _10151_/A4 _10152_/B VSS _10151_/VNW VSS
+ VSS gf180mcu_fd_sc_mcu9t5v0__nand4_1
X_10082_ _10063_/C _10082_/A2 _10082_/B output14/I VSS VSS VSS VSS gf180mcu_fd_sc_mcu9t5v0__aoi21_2
XTAP_TAPCELL_ROW_15_1401 VSS VSS gf180mcu_fd_sc_mcu9t5v0__filltie
X_13910_ _13881_/Z _13910_/A2 _13910_/B _13942_/A1 VSS _13950_/VNW VSS VSS gf180mcu_fd_sc_mcu9t5v0__aoi21_1
X_14890_ _14900_/S _14890_/A2 _14890_/B _19594_/D VSS VSS VSS VSS gf180mcu_fd_sc_mcu9t5v0__aoi21_1
X_13841_ _19316_/Q _19317_/Q _19297_/Q _19298_/Q _13841_/Z VSS _13876_/VNW VSS VSS
+ gf180mcu_fd_sc_mcu9t5v0__and4_1
X_16560_ _18343_/Q _16187_/C _17069_/S _18343_/D VSS VSS VSS VSS gf180mcu_fd_sc_mcu9t5v0__mux2_1
X_10984_ _10984_/A1 _10984_/A2 _10984_/Z VSS _10984_/VNW VSS VSS gf180mcu_fd_sc_mcu9t5v0__xor2_1
X_13772_ _13776_/A1 _13772_/A2 _13772_/Z VSS _13785_/VNW VSS VSS gf180mcu_fd_sc_mcu9t5v0__xor2_1
X_15511_ _19841_/Q _15511_/A2 _15513_/A2 VSS VSS VSS VSS gf180mcu_fd_sc_mcu9t5v0__nor2_1
XTAP_TAPCELL_ROW_166_3_8105 VSS VSS gf180mcu_fd_sc_mcu9t5v0__filltie
X_12723_ _12164_/B _12618_/B _12723_/B _12724_/B1 VSS VSS VSS VSS gf180mcu_fd_sc_mcu9t5v0__oai21_1
XPHY_EDGE_ROW_218_Right_145 VSS VSS gf180mcu_fd_sc_mcu9t5v0__endcap
X_16491_ _19234_/Q _16147_/C _17025_/S _16491_/Z VSS _16491_/VNW VSS VSS gf180mcu_fd_sc_mcu9t5v0__mux2_1
X_18230_ _18230_/D clkload81/I _18230_/Q VSS VSS VSS VSS gf180mcu_fd_sc_mcu9t5v0__dffq_4
X_15442_ _15442_/A1 _15472_/A2 _15462_/A2 VSS VSS VSS VSS gf180mcu_fd_sc_mcu9t5v0__nand2_1
X_12654_ _12720_/S _12707_/I1 _12654_/B _12685_/B _12655_/I0 VSS _12654_/VNW VSS VSS
+ gf180mcu_fd_sc_mcu9t5v0__aoi211_1
X_12585_ wire146/Z _12585_/A2 _12585_/A3 _12585_/B1 _12585_/B2 wire121/I VSS VSS VSS
+ VSS gf180mcu_fd_sc_mcu9t5v0__oai32_1
X_18161_ _18161_/D clkload68/I _18161_/Q VSS VSS VSS VSS gf180mcu_fd_sc_mcu9t5v0__dffq_1
XTAP_TAPCELL_ROW_134_4671 VSS VSS gf180mcu_fd_sc_mcu9t5v0__filltie
X_15373_ _19658_/Q _19758_/Q _15430_/S _19758_/D VSS VSS VSS VSS gf180mcu_fd_sc_mcu9t5v0__mux2_1
XTAP_TAPCELL_ROW_134_4660 VSS VSS gf180mcu_fd_sc_mcu9t5v0__filltie
X_11605_ _18838_/Q _11600_/C _09782_/Z _11592_/Z _12634_/A2 VSS _11605_/VNW VSS VSS
+ gf180mcu_fd_sc_mcu9t5v0__nand4_1
X_11536_ _11510_/B _11535_/Z _11539_/B1 VSS VSS VSS VSS gf180mcu_fd_sc_mcu9t5v0__nand2_1
X_17112_ _17112_/A1 _17112_/A2 _17112_/A3 _17114_/A2 VSS _17112_/VNW VSS VSS gf180mcu_fd_sc_mcu9t5v0__nand3_1
X_18092_ _18935_/Q _18089_/Z _18094_/A2 VSS VSS VSS VSS gf180mcu_fd_sc_mcu9t5v0__nor2_1
X_14324_ _13757_/Z _19396_/Q _14337_/S _19396_/D VSS VSS VSS VSS gf180mcu_fd_sc_mcu9t5v0__mux2_1
X_17043_ _16628_/B _19252_/Q _17055_/S _17043_/Z VSS VSS VSS VSS gf180mcu_fd_sc_mcu9t5v0__mux2_1
XTAP_TAPCELL_ROW_146_3_8036 VSS VSS gf180mcu_fd_sc_mcu9t5v0__filltie
XTAP_TAPCELL_ROW_130_4568 VSS VSS gf180mcu_fd_sc_mcu9t5v0__filltie
XTAP_TAPCELL_ROW_130_4557 VSS VSS gf180mcu_fd_sc_mcu9t5v0__filltie
XTAP_TAPCELL_ROW_130_4546 VSS VSS gf180mcu_fd_sc_mcu9t5v0__filltie
Xmax_cap107 _14624_/S _14715_/S VSS VSS VSS VSS gf180mcu_fd_sc_mcu9t5v0__clkbuf_8
X_14255_ _14262_/A1 _14262_/A2 _14257_/A2 VSS VSS VSS VSS gf180mcu_fd_sc_mcu9t5v0__xnor2_1
X_11467_ _18467_/Q _11534_/S _11537_/S _11469_/A2 VSS VSS VSS VSS gf180mcu_fd_sc_mcu9t5v0__oai21_1
X_13206_ _19732_/Q _13207_/A2 _13206_/Z VSS _13224_/VNW VSS VSS gf180mcu_fd_sc_mcu9t5v0__and2_1
Xmax_cap118 _18004_/S _17997_/S VSS VSS VSS VSS gf180mcu_fd_sc_mcu9t5v0__buf_4
Xmax_cap129 wire128/I _17978_/S VSS VSS VSS VSS gf180mcu_fd_sc_mcu9t5v0__clkbuf_4
X_11398_ _18446_/Q _11519_/A2 _11401_/A1 VSS VSS VSS VSS gf180mcu_fd_sc_mcu9t5v0__nor2_1
X_10418_ _18945_/Q wire166/Z _10420_/A2 VSS _10420_/VNW VSS VSS gf180mcu_fd_sc_mcu9t5v0__nand2_1
X_14186_ _14188_/A2 _14114_/Z _14187_/A2 VSS VSS VSS VSS gf180mcu_fd_sc_mcu9t5v0__nand2_1
X_10349_ _09261_/I _10349_/A2 _10349_/A3 _10349_/B _10354_/B VSS VSS VSS VSS gf180mcu_fd_sc_mcu9t5v0__oai31_1
X_18994_ _18994_/D _20018_/RN clkload67/I _18994_/Q VSS VSS VSS VSS gf180mcu_fd_sc_mcu9t5v0__dffrnq_1
X_13137_ _13144_/A1 _13138_/A2 _13551_/A1 VSS VSS VSS VSS gf180mcu_fd_sc_mcu9t5v0__nand2_1
X_13068_ _13184_/A1 _13067_/Z _13320_/B _13069_/B2 VSS _13068_/VNW VSS VSS gf180mcu_fd_sc_mcu9t5v0__aoi21_1
X_17945_ _18852_/Q _17941_/Z _17946_/A2 VSS _17945_/VNW VSS VSS gf180mcu_fd_sc_mcu9t5v0__xnor2_1
X_12019_ _18505_/Q _12092_/B _12020_/B VSS VSS VSS VSS gf180mcu_fd_sc_mcu9t5v0__nor2_1
XTAP_TAPCELL_ROW_128_4497 VSS VSS gf180mcu_fd_sc_mcu9t5v0__filltie
XTAP_TAPCELL_ROW_85_3313 VSS VSS gf180mcu_fd_sc_mcu9t5v0__filltie
XTAP_TAPCELL_ROW_256_6120 VSS VSS gf180mcu_fd_sc_mcu9t5v0__filltie
X_17876_ _18830_/Q _18831_/Q _18060_/B _19019_/Q _17877_/I VSS _17876_/VNW VSS VSS
+ gf180mcu_fd_sc_mcu9t5v0__aoi211_1
XTAP_TAPCELL_ROW_85_3324 VSS VSS gf180mcu_fd_sc_mcu9t5v0__filltie
X_16827_ _16827_/A1 _16959_/B _16828_/I1 VSS VSS VSS VSS gf180mcu_fd_sc_mcu9t5v0__nand2_1
XTAP_TAPCELL_ROW_252_6006 VSS VSS gf180mcu_fd_sc_mcu9t5v0__filltie
X_19615_ _19615_/D _20063_/RN clkload22/I _19615_/Q VSS VSS VSS VSS gf180mcu_fd_sc_mcu9t5v0__dffrnq_1
X_16758_ _16757_/Z _18378_/Q _16764_/S _18378_/D VSS VSS VSS VSS gf180mcu_fd_sc_mcu9t5v0__mux2_1
X_19546_ _19546_/D _20058_/RN _19806_/CLK _19546_/Q VSS VSS VSS VSS gf180mcu_fd_sc_mcu9t5v0__dffrnq_1
X_15709_ _20003_/Q _15708_/Z _15710_/B VSS _15710_/VNW VSS VSS gf180mcu_fd_sc_mcu9t5v0__nand2_1
XTAP_TAPCELL_ROW_1_1010 VSS VSS gf180mcu_fd_sc_mcu9t5v0__filltie
XTAP_TAPCELL_ROW_1_1021 VSS VSS gf180mcu_fd_sc_mcu9t5v0__filltie
X_16689_ _18363_/Q _16689_/I1 _16707_/S _18363_/D VSS _16689_/VNW VSS VSS gf180mcu_fd_sc_mcu9t5v0__mux2_4
X_09230_ _19317_/Q _14148_/A1 VSS VSS VSS VSS gf180mcu_fd_sc_mcu9t5v0__clkinv_1
X_19477_ _19477_/D _20053_/RN clkload13/I _19477_/Q VSS VSS VSS VSS gf180mcu_fd_sc_mcu9t5v0__dffrnq_1
X_18428_ _18428_/D clkload60/I _18428_/Q VSS VSS VSS VSS gf180mcu_fd_sc_mcu9t5v0__dffq_1
X_18359_ _18359_/D clkload78/I _18359_/Q VSS VSS VSS VSS gf180mcu_fd_sc_mcu9t5v0__dffq_1
X_09161_ _19777_/Q _13435_/A2 VSS _12924_/VNW VSS VSS gf180mcu_fd_sc_mcu9t5v0__clkinv_1
X_09092_ _18685_/Q _09518_/B VSS _09092_/VNW VSS VSS gf180mcu_fd_sc_mcu9t5v0__clkinv_1
XTAP_TAPCELL_ROW_179_3_8150 VSS VSS gf180mcu_fd_sc_mcu9t5v0__filltie
XTAP_TAPCELL_ROW_70_2903 VSS VSS gf180mcu_fd_sc_mcu9t5v0__filltie
XTAP_TAPCELL_ROW_241_5710 VSS VSS gf180mcu_fd_sc_mcu9t5v0__filltie
X_09994_ _20072_/Q _09994_/A2 _09994_/A3 _09995_/C VSS _09994_/VNW VSS VSS gf180mcu_fd_sc_mcu9t5v0__nand3_1
XTAP_TAPCELL_ROW_70_2914 VSS VSS gf180mcu_fd_sc_mcu9t5v0__filltie
XTAP_TAPCELL_ROW_55_2482 VSS VSS gf180mcu_fd_sc_mcu9t5v0__filltie
XTAP_TAPCELL_ROW_159_3_8081 VSS VSS gf180mcu_fd_sc_mcu9t5v0__filltie
XTAP_TAPCELL_ROW_55_2493 VSS VSS gf180mcu_fd_sc_mcu9t5v0__filltie
XTAP_TAPCELL_ROW_222_5175 VSS VSS gf180mcu_fd_sc_mcu9t5v0__filltie
XTAP_TAPCELL_ROW_222_5164 VSS VSS gf180mcu_fd_sc_mcu9t5v0__filltie
XTAP_TAPCELL_ROW_172_3_8126 VSS VSS gf180mcu_fd_sc_mcu9t5v0__filltie
XTAP_TAPCELL_ROW_51_2379 VSS VSS gf180mcu_fd_sc_mcu9t5v0__filltie
XTAP_TAPCELL_ROW_8_1208 VSS VSS gf180mcu_fd_sc_mcu9t5v0__filltie
XTAP_TAPCELL_ROW_222_5186 VSS VSS gf180mcu_fd_sc_mcu9t5v0__filltie
XTAP_TAPCELL_ROW_68_2854 VSS VSS gf180mcu_fd_sc_mcu9t5v0__filltie
Xrst_tree_mid_5 rst_tree_root/Z rst_tree_mid_5/Z VSS VSS VSS VSS gf180mcu_fd_sc_mcu9t5v0__clkbuf_16
XTAP_TAPCELL_ROW_68_2843 VSS VSS gf180mcu_fd_sc_mcu9t5v0__filltie
XTAP_TAPCELL_ROW_239_5650 VSS VSS gf180mcu_fd_sc_mcu9t5v0__filltie
XTAP_TAPCELL_ROW_68_2865 VSS VSS gf180mcu_fd_sc_mcu9t5v0__filltie
XTAP_TAPCELL_ROW_64_2729 VSS VSS gf180mcu_fd_sc_mcu9t5v0__filltie
XPHY_EDGE_ROW_262_Right_189 VSS VSS gf180mcu_fd_sc_mcu9t5v0__endcap
XTAP_TAPCELL_ROW_235_5536 VSS VSS gf180mcu_fd_sc_mcu9t5v0__filltie
XTAP_TAPCELL_ROW_235_5525 VSS VSS gf180mcu_fd_sc_mcu9t5v0__filltie
XTAP_TAPCELL_ROW_152_3_8057 VSS VSS gf180mcu_fd_sc_mcu9t5v0__filltie
X_09428_ _18752_/Q _09888_/B1 _09428_/Z VSS _09428_/VNW VSS VSS gf180mcu_fd_sc_mcu9t5v0__and2_4
X_09359_ _18250_/Q _11688_/I1 VSS _15954_/VNW VSS VSS gf180mcu_fd_sc_mcu9t5v0__clkinv_1
X_12370_ _12541_/B _12370_/A2 _12370_/A3 _12370_/B _12371_/B2 VSS _12370_/VNW VSS
+ VSS gf180mcu_fd_sc_mcu9t5v0__oai31_1
X_11321_ _19088_/Q _11321_/A2 _11322_/A2 VSS VSS VSS VSS gf180mcu_fd_sc_mcu9t5v0__nand2_1
XTAP_TAPCELL_ROW_323_7990 VSS VSS gf180mcu_fd_sc_mcu9t5v0__filltie
X_11252_ _18211_/Q _11524_/S _11520_/B _11252_/C _11254_/B1 VSS _11252_/VNW VSS VSS
+ gf180mcu_fd_sc_mcu9t5v0__oai211_1
X_14040_ _19318_/Q _19301_/Q _14115_/A1 VSS _14040_/VNW VSS VSS gf180mcu_fd_sc_mcu9t5v0__nand2_1
X_11183_ _18700_/Q wire198/Z _11183_/B1 _11183_/B2 wire213/Z _11185_/A3 VSS VSS VSS
+ VSS gf180mcu_fd_sc_mcu9t5v0__aoi221_4
X_10203_ _18756_/Q _17761_/A2 _17807_/S VSS VSS VSS VSS gf180mcu_fd_sc_mcu9t5v0__nand2_1
X_10134_ _19001_/Q wire285/Z _10168_/B1 _18953_/Q _10139_/A1 VSS VSS VSS VSS gf180mcu_fd_sc_mcu9t5v0__aoi22_1
X_15991_ _10064_/S _16234_/A1 _15973_/B _18568_/Q _15954_/B _16106_/C VSS VSS VSS
+ VSS gf180mcu_fd_sc_mcu9t5v0__oai32_4
X_10065_ _10133_/B1 _10016_/B _10064_/Z _10067_/A3 VSS VSS VSS VSS gf180mcu_fd_sc_mcu9t5v0__nand3_1
X_17730_ _18741_/Q _17685_/S _17731_/B VSS _17731_/VNW VSS VSS gf180mcu_fd_sc_mcu9t5v0__nand2_1
X_14942_ _19606_/Q _19362_/Q _20039_/D _19606_/D VSS VSS VSS VSS gf180mcu_fd_sc_mcu9t5v0__mux2_1
XTAP_TAPCELL_ROW_292_7098 VSS VSS gf180mcu_fd_sc_mcu9t5v0__filltie
X_17661_ _18624_/Q _18700_/Q _17685_/S _18700_/D VSS VSS VSS VSS gf180mcu_fd_sc_mcu9t5v0__mux2_1
XTAP_TAPCELL_ROW_317_7783 VSS VSS gf180mcu_fd_sc_mcu9t5v0__filltie
XTAP_TAPCELL_ROW_292_7087 VSS VSS gf180mcu_fd_sc_mcu9t5v0__filltie
XTAP_TAPCELL_ROW_123_4372 VSS VSS gf180mcu_fd_sc_mcu9t5v0__filltie
XTAP_TAPCELL_ROW_123_4361 VSS VSS gf180mcu_fd_sc_mcu9t5v0__filltie
X_14873_ _19412_/Q _19353_/Q _14879_/A1 VSS VSS VSS VSS gf180mcu_fd_sc_mcu9t5v0__nand2_1
XTAP_TAPCELL_ROW_317_7794 VSS VSS gf180mcu_fd_sc_mcu9t5v0__filltie
X_16612_ _19218_/Q _16611_/Z _16612_/S _16614_/B VSS VSS VSS VSS gf180mcu_fd_sc_mcu9t5v0__mux2_1
X_13824_ _13838_/A1 _13838_/A2 _13825_/A4 VSS _13888_/VNW VSS VSS gf180mcu_fd_sc_mcu9t5v0__xnor2_1
X_19400_ _19400_/D _20040_/RN clkload18/I _19400_/Q VSS VSS VSS VSS gf180mcu_fd_sc_mcu9t5v0__dffrnq_1
XTAP_TAPCELL_ROW_313_7669 VSS VSS gf180mcu_fd_sc_mcu9t5v0__filltie
X_17592_ wire300/Z _18657_/Q _17597_/S _18657_/D VSS VSS VSS VSS gf180mcu_fd_sc_mcu9t5v0__mux2_1
X_19331_ _19331_/D _20035_/RN _19633_/CLK _19331_/Q VSS VSS VSS VSS gf180mcu_fd_sc_mcu9t5v0__dffrnq_1
X_16543_ _16099_/B _19243_/Q _17057_/S _16543_/Z VSS _16543_/VNW VSS VSS gf180mcu_fd_sc_mcu9t5v0__mux2_1
XTAP_TAPCELL_ROW_185_3_8171 VSS VSS gf180mcu_fd_sc_mcu9t5v0__filltie
X_10967_ _10967_/A1 _18070_/A2 _10967_/Z VSS VSS VSS VSS gf180mcu_fd_sc_mcu9t5v0__xor2_1
X_13755_ _19301_/Q _14166_/B _13756_/B VSS _13755_/VNW VSS VSS gf180mcu_fd_sc_mcu9t5v0__nand2_1
X_10898_ _10897_/Z _18988_/Q _18152_/S _18988_/D VSS _15980_/VNW VSS VSS gf180mcu_fd_sc_mcu9t5v0__mux2_1
X_16474_ _18295_/Q _16473_/Z _16990_/S _18295_/D VSS VSS VSS VSS gf180mcu_fd_sc_mcu9t5v0__mux2_4
X_12706_ _11678_/B _12706_/A2 _12706_/A3 _18833_/Q _12724_/A2 VSS _12706_/VNW VSS
+ VSS gf180mcu_fd_sc_mcu9t5v0__oai31_1
X_13686_ _13686_/A1 _13686_/A2 _14656_/B _13686_/Z VSS _14660_/VNW VSS VSS gf180mcu_fd_sc_mcu9t5v0__or3_1
X_19262_ _19262_/D _20030_/RN clkload28/I _19262_/Q VSS VSS VSS VSS gf180mcu_fd_sc_mcu9t5v0__dffrnq_1
X_18213_ _18213_/D clkload69/I _18213_/Q VSS VSS VSS VSS gf180mcu_fd_sc_mcu9t5v0__dffq_1
XTAP_TAPCELL_ROW_132_4619 VSS VSS gf180mcu_fd_sc_mcu9t5v0__filltie
X_15425_ _19710_/Q _19810_/Q _15430_/S _19810_/D VSS VSS VSS VSS gf180mcu_fd_sc_mcu9t5v0__mux2_1
XTAP_TAPCELL_ROW_132_4608 VSS VSS gf180mcu_fd_sc_mcu9t5v0__filltie
X_12637_ _12645_/C _12637_/A2 _12685_/B _12637_/C _12638_/I0 VSS _12637_/VNW VSS VSS
+ gf180mcu_fd_sc_mcu9t5v0__aoi211_1
X_19193_ _19193_/D _20025_/RN clkload23/I _19193_/Q VSS VSS VSS VSS gf180mcu_fd_sc_mcu9t5v0__dffrnq_1
Xclkbuf_leaf_42_clk_regs clkload6/I clkload79/I VSS VSS VSS VSS gf180mcu_fd_sc_mcu9t5v0__clkbuf_8
X_18144_ _18143_/Z _18959_/Q _18152_/S _18959_/D VSS _18144_/VNW VSS VSS gf180mcu_fd_sc_mcu9t5v0__mux2_1
XTAP_TAPCELL_ROW_117_4198 VSS VSS gf180mcu_fd_sc_mcu9t5v0__filltie
XTAP_TAPCELL_ROW_117_4187 VSS VSS gf180mcu_fd_sc_mcu9t5v0__filltie
X_12568_ _18498_/Q _11091_/B wire146/Z _12569_/B2 VSS VSS VSS VSS gf180mcu_fd_sc_mcu9t5v0__oai21_1
X_15356_ _19747_/Q _15355_/Z _15364_/S _19747_/D VSS VSS VSS VSS gf180mcu_fd_sc_mcu9t5v0__mux2_1
XTAP_TAPCELL_ROW_74_3025 VSS VSS gf180mcu_fd_sc_mcu9t5v0__filltie
XTAP_TAPCELL_ROW_74_3014 VSS VSS gf180mcu_fd_sc_mcu9t5v0__filltie
X_11519_ _18455_/Q _11519_/A2 _11521_/A1 VSS VSS VSS VSS gf180mcu_fd_sc_mcu9t5v0__nor2_1
X_12499_ _18394_/Q _12582_/A2 _12502_/A3 VSS VSS VSS VSS gf180mcu_fd_sc_mcu9t5v0__nor2_1
Xwire160 wire160/I wire160/Z VSS VSS VSS VSS gf180mcu_fd_sc_mcu9t5v0__buf_4
X_18075_ _18075_/A1 _18079_/A1 _18079_/A2 _18074_/Z _18076_/A2 VSS _18075_/VNW VSS
+ VSS gf180mcu_fd_sc_mcu9t5v0__nand4_1
X_15287_ _19635_/Q _19612_/Q _15288_/B VSS _15295_/VNW VSS VSS gf180mcu_fd_sc_mcu9t5v0__xor2_1
X_14307_ _13772_/Z _19380_/Q _14322_/S _19380_/D VSS VSS VSS VSS gf180mcu_fd_sc_mcu9t5v0__mux2_1
X_17026_ _18504_/Q _17025_/Z _17026_/S _18504_/D VSS _17026_/VNW VSS VSS gf180mcu_fd_sc_mcu9t5v0__mux2_1
XTAP_TAPCELL_ROW_281_6791 VSS VSS gf180mcu_fd_sc_mcu9t5v0__filltie
X_14238_ _14240_/A1 _14218_/I _14238_/A3 _14320_/I0 VSS VSS VSS VSS gf180mcu_fd_sc_mcu9t5v0__xnor3_1
X_14169_ _13757_/Z _19324_/Q _14266_/S _19324_/D VSS VSS VSS VSS gf180mcu_fd_sc_mcu9t5v0__mux2_1
Xload_slew110 wire108/I _20039_/D VSS VSS VSS VSS gf180mcu_fd_sc_mcu9t5v0__clkbuf_16
X_18977_ _18977_/D _20065_/RN clkload71/I _18977_/Q VSS VSS VSS VSS gf180mcu_fd_sc_mcu9t5v0__dffrnq_1
XPHY_EDGE_ROW_163_3_Left_821 VSS VSS gf180mcu_fd_sc_mcu9t5v0__endcap
Xload_slew176 _13184_/A1 _13497_/A1 VSS VSS VSS VSS gf180mcu_fd_sc_mcu9t5v0__clkbuf_8
X_17928_ _18845_/Q _18846_/Q _18847_/Q _17930_/A2 VSS VSS VSS VSS gf180mcu_fd_sc_mcu9t5v0__aoi21_1
Xeco14_skew_1 clkload73/I _18513_/CLK VSS VSS VSS VSS gf180mcu_fd_sc_mcu9t5v0__clkbuf_16
X_17859_ _18827_/Q _17856_/Z _17859_/Z VSS VSS VSS VSS gf180mcu_fd_sc_mcu9t5v0__and2_1
XTAP_TAPCELL_ROW_106_3891 VSS VSS gf180mcu_fd_sc_mcu9t5v0__filltie
XTAP_TAPCELL_ROW_102_3788 VSS VSS gf180mcu_fd_sc_mcu9t5v0__filltie
X_19529_ _19529_/D _20041_/RN clkload11/I _19529_/Q VSS VSS VSS VSS gf180mcu_fd_sc_mcu9t5v0__dffrnq_1
XTAP_TAPCELL_ROW_102_3777 VSS VSS gf180mcu_fd_sc_mcu9t5v0__filltie
XTAP_TAPCELL_ROW_230_5400 VSS VSS gf180mcu_fd_sc_mcu9t5v0__filltie
XTAP_TAPCELL_ROW_102_3799 VSS VSS gf180mcu_fd_sc_mcu9t5v0__filltie
XTAP_TAPCELL_ROW_288_6978 VSS VSS gf180mcu_fd_sc_mcu9t5v0__filltie
XTAP_TAPCELL_ROW_44_2183 VSS VSS gf180mcu_fd_sc_mcu9t5v0__filltie
X_09213_ _19590_/Q _15204_/A1 VSS VSS VSS VSS gf180mcu_fd_sc_mcu9t5v0__clkinv_1
XTAP_TAPCELL_ROW_44_2194 VSS VSS gf180mcu_fd_sc_mcu9t5v0__filltie
XTAP_TAPCELL_ROW_288_6989 VSS VSS gf180mcu_fd_sc_mcu9t5v0__filltie
XTAP_TAPCELL_ROW_40_2069 VSS VSS gf180mcu_fd_sc_mcu9t5v0__filltie
X_09144_ _19801_/Q _13235_/A2 VSS VSS VSS VSS gf180mcu_fd_sc_mcu9t5v0__clkinv_1
X_09075_ _20138_/Q _15855_/A1 VSS VSS VSS VSS gf180mcu_fd_sc_mcu9t5v0__clkinv_1
XTAP_TAPCELL_ROW_228_5351 VSS VSS gf180mcu_fd_sc_mcu9t5v0__filltie
XTAP_TAPCELL_ROW_228_5340 VSS VSS gf180mcu_fd_sc_mcu9t5v0__filltie
XTAP_TAPCELL_ROW_57_2544 VSS VSS gf180mcu_fd_sc_mcu9t5v0__filltie
XTAP_TAPCELL_ROW_57_2555 VSS VSS gf180mcu_fd_sc_mcu9t5v0__filltie
XTAP_TAPCELL_ROW_224_5226 VSS VSS gf180mcu_fd_sc_mcu9t5v0__filltie
XTAP_TAPCELL_ROW_224_5237 VSS VSS gf180mcu_fd_sc_mcu9t5v0__filltie
X_09977_ _10659_/C _18980_/Q _10028_/B _19238_/Q _09978_/A3 VSS VSS VSS VSS gf180mcu_fd_sc_mcu9t5v0__oai22_1
XTAP_TAPCELL_ROW_191_3_8192 VSS VSS gf180mcu_fd_sc_mcu9t5v0__filltie
X_20097_ _20097_/D clkload57/I _20097_/Q VSS VSS VSS VSS gf180mcu_fd_sc_mcu9t5v0__dffq_1
X_11870_ _18258_/Q _12340_/S _11872_/B1 VSS VSS VSS VSS gf180mcu_fd_sc_mcu9t5v0__nand2_1
X_10821_ _20063_/Q _10821_/A2 _10821_/B _10822_/B1 VSS VSS VSS VSS gf180mcu_fd_sc_mcu9t5v0__oai21_1
X_13540_ _13540_/A1 _13536_/Z _13540_/B _13546_/A1 VSS VSS VSS VSS gf180mcu_fd_sc_mcu9t5v0__aoi21_1
X_10752_ _18842_/Q _18849_/Q _10757_/A1 VSS _10752_/VNW VSS VSS gf180mcu_fd_sc_mcu9t5v0__xnor2_1
X_13471_ _16957_/A1 _13497_/B _13471_/B1 _13471_/B2 _19257_/D VSS VSS VSS VSS gf180mcu_fd_sc_mcu9t5v0__aoi22_1
XTAP_TAPCELL_ROW_213_4941 VSS VSS gf180mcu_fd_sc_mcu9t5v0__filltie
X_12422_ _18161_/Q _12613_/A2 _12426_/A2 VSS VSS VSS VSS gf180mcu_fd_sc_mcu9t5v0__nor2_1
XTAP_TAPCELL_ROW_213_4930 VSS VSS gf180mcu_fd_sc_mcu9t5v0__filltie
X_10683_ _18554_/Q _10796_/A2 _10682_/Z _17075_/A1 _10696_/A2 VSS VSS VSS VSS gf180mcu_fd_sc_mcu9t5v0__aoi22_4
X_15210_ _19592_/Q _15211_/A2 _15216_/B VSS VSS VSS VSS gf180mcu_fd_sc_mcu9t5v0__nand2_1
X_16190_ _18183_/Q _16190_/I1 _16753_/S _18183_/D VSS VSS VSS VSS gf180mcu_fd_sc_mcu9t5v0__mux2_4
XTAP_TAPCELL_ROW_321_7905 VSS VSS gf180mcu_fd_sc_mcu9t5v0__filltie
XTAP_TAPCELL_ROW_112_4062 VSS VSS gf180mcu_fd_sc_mcu9t5v0__filltie
XTAP_TAPCELL_ROW_112_4051 VSS VSS gf180mcu_fd_sc_mcu9t5v0__filltie
X_12353_ _18583_/Q _12723_/B _12486_/B1 _18574_/Q _12354_/A2 VSS VSS VSS VSS gf180mcu_fd_sc_mcu9t5v0__oai22_1
X_15141_ _19683_/Q _19523_/Q _15163_/S _19683_/D VSS _15141_/VNW VSS VSS gf180mcu_fd_sc_mcu9t5v0__mux2_1
XTAP_TAPCELL_ROW_306_7495 VSS VSS gf180mcu_fd_sc_mcu9t5v0__filltie
X_12284_ _18453_/Q _12315_/S _12286_/B1 VSS _12284_/VNW VSS VSS gf180mcu_fd_sc_mcu9t5v0__nand2_1
XTAP_TAPCELL_ROW_306_7484 VSS VSS gf180mcu_fd_sc_mcu9t5v0__filltie
XTAP_TAPCELL_ROW_306_7473 VSS VSS gf180mcu_fd_sc_mcu9t5v0__filltie
X_11304_ _18566_/Q _18183_/Q _11537_/S _11303_/Z wire283/Z _11305_/B VSS VSS VSS VSS
+ gf180mcu_fd_sc_mcu9t5v0__aoi221_1
XTAP_TAPCELL_ROW_112_4073 VSS VSS gf180mcu_fd_sc_mcu9t5v0__filltie
X_15072_ _19643_/Q _15072_/I1 _20039_/Q _19643_/D VSS _15072_/VNW VSS VSS gf180mcu_fd_sc_mcu9t5v0__mux2_1
X_11235_ _18306_/Q _11509_/A2 _11237_/A2 VSS VSS VSS VSS gf180mcu_fd_sc_mcu9t5v0__nand2_1
XTAP_TAPCELL_ROW_298_7252 VSS VSS gf180mcu_fd_sc_mcu9t5v0__filltie
X_14023_ _14023_/I _14024_/A2 VSS VSS VSS VSS gf180mcu_fd_sc_mcu9t5v0__clkinv_1
X_18900_ _18900_/D _20052_/RN clkload30/I _18900_/Q VSS VSS VSS VSS gf180mcu_fd_sc_mcu9t5v0__dffrnq_1
XTAP_TAPCELL_ROW_298_7274 VSS VSS gf180mcu_fd_sc_mcu9t5v0__filltie
XTAP_TAPCELL_ROW_298_7263 VSS VSS gf180mcu_fd_sc_mcu9t5v0__filltie
X_19880_ _19880_/D _20072_/RN clkload45/I _19880_/Q VSS VSS VSS VSS gf180mcu_fd_sc_mcu9t5v0__dffrnq_1
XTAP_TAPCELL_ROW_319_7834 VSS VSS gf180mcu_fd_sc_mcu9t5v0__filltie
XTAP_TAPCELL_ROW_294_7149 VSS VSS gf180mcu_fd_sc_mcu9t5v0__filltie
XTAP_TAPCELL_ROW_125_4423 VSS VSS gf180mcu_fd_sc_mcu9t5v0__filltie
X_18831_ _18831_/D _20047_/RN clkload38/I _18831_/Q VSS VSS VSS VSS gf180mcu_fd_sc_mcu9t5v0__dffrnq_4
XTAP_TAPCELL_ROW_125_4412 VSS VSS gf180mcu_fd_sc_mcu9t5v0__filltie
X_11166_ _19077_/Q _11321_/A2 _11167_/B VSS VSS VSS VSS gf180mcu_fd_sc_mcu9t5v0__nand2_1
XTAP_TAPCELL_ROW_319_7856 VSS VSS gf180mcu_fd_sc_mcu9t5v0__filltie
XTAP_TAPCELL_ROW_319_7845 VSS VSS gf180mcu_fd_sc_mcu9t5v0__filltie
X_11097_ _18329_/Q _11519_/A2 _11100_/A1 VSS VSS VSS VSS gf180mcu_fd_sc_mcu9t5v0__nand2_1
X_10117_ _19218_/Q wire172/Z _10172_/A2 _19202_/Q _10118_/A3 VSS _10117_/VNW VSS VSS
+ gf180mcu_fd_sc_mcu9t5v0__aoi22_1
X_15974_ _16197_/A1 _16197_/A2 _16197_/B _16105_/A1 VSS VSS VSS VSS gf180mcu_fd_sc_mcu9t5v0__oai21_4
X_18762_ _18762_/D _20042_/RN clkload51/I _18762_/Q VSS VSS VSS VSS gf180mcu_fd_sc_mcu9t5v0__dffrnq_1
XTAP_TAPCELL_ROW_121_4309 VSS VSS gf180mcu_fd_sc_mcu9t5v0__filltie
X_17713_ _17713_/I _18732_/D VSS VSS VSS VSS gf180mcu_fd_sc_mcu9t5v0__clkinv_1
X_10048_ _15820_/A2 _19989_/Q _15822_/A1 VSS _15822_/VNW VSS VSS gf180mcu_fd_sc_mcu9t5v0__nor2_1
X_14925_ _19600_/Q _14925_/I1 _15163_/S _19600_/D VSS VSS VSS VSS gf180mcu_fd_sc_mcu9t5v0__mux2_1
XTAP_TAPCELL_ROW_170_2_8117 VSS VSS gf180mcu_fd_sc_mcu9t5v0__filltie
X_18693_ _18693_/D _20033_/RN clkload25/I _18693_/Q VSS VSS VSS VSS gf180mcu_fd_sc_mcu9t5v0__dffrnq_4
X_17644_ _18690_/Q _17747_/A4 _17646_/B VSS VSS VSS VSS gf180mcu_fd_sc_mcu9t5v0__nand2_1
X_14856_ _19582_/Q _19343_/Q wire108/I _19582_/D VSS _14856_/VNW VSS VSS gf180mcu_fd_sc_mcu9t5v0__mux2_1
X_17575_ _18644_/Q _17571_/S _17576_/A2 VSS VSS VSS VSS gf180mcu_fd_sc_mcu9t5v0__nand2_1
X_13807_ _13807_/A1 _13805_/Z _13807_/Z VSS _14904_/VNW VSS VSS gf180mcu_fd_sc_mcu9t5v0__xor2_1
X_14787_ _19398_/Q _19335_/Q _14793_/A1 VSS VSS VSS VSS gf180mcu_fd_sc_mcu9t5v0__nand2_1
X_16526_ _16525_/Z _18319_/Q _17042_/S _18319_/D VSS VSS VSS VSS gf180mcu_fd_sc_mcu9t5v0__mux2_1
X_11999_ _12345_/B _11999_/A2 _11999_/A3 _12000_/C VSS VSS VSS VSS gf180mcu_fd_sc_mcu9t5v0__nand3_1
XTAP_TAPCELL_ROW_270_6492 VSS VSS gf180mcu_fd_sc_mcu9t5v0__filltie
XTAP_TAPCELL_ROW_119_4249 VSS VSS gf180mcu_fd_sc_mcu9t5v0__filltie
X_13738_ _14671_/A1 _13738_/A2 _13738_/A3 _13738_/B _13748_/A1 VSS _14671_/VNW VSS
+ VSS gf180mcu_fd_sc_mcu9t5v0__oai31_1
X_19314_ _19314_/D _20018_/RN clkload20/I _19314_/Q VSS VSS VSS VSS gf180mcu_fd_sc_mcu9t5v0__dffrnq_1
X_19245_ _19245_/D _20141_/RN clkload25/I _19245_/Q VSS VSS VSS VSS gf180mcu_fd_sc_mcu9t5v0__dffrnq_2
X_16457_ _19234_/Q _16147_/C _16991_/S _16457_/Z VSS VSS VSS VSS gf180mcu_fd_sc_mcu9t5v0__mux2_1
X_13669_ _14546_/S _13668_/Z _14374_/A1 VSS _14478_/VNW VSS VSS gf180mcu_fd_sc_mcu9t5v0__nand2_1
XTAP_TAPCELL_ROW_283_6842 VSS VSS gf180mcu_fd_sc_mcu9t5v0__filltie
X_16388_ _16387_/Z _18257_/Q _16924_/S _18257_/D VSS VSS VSS VSS gf180mcu_fd_sc_mcu9t5v0__mux2_1
X_19176_ _19176_/D _20072_/RN clkload13/I _19176_/Q VSS VSS VSS VSS gf180mcu_fd_sc_mcu9t5v0__dffrnq_1
X_15408_ _19693_/Q _19793_/Q _15430_/S _19793_/D VSS VSS VSS VSS gf180mcu_fd_sc_mcu9t5v0__mux2_1
XTAP_TAPCELL_ROW_283_6864 VSS VSS gf180mcu_fd_sc_mcu9t5v0__filltie
XTAP_TAPCELL_ROW_283_6853 VSS VSS gf180mcu_fd_sc_mcu9t5v0__filltie
X_18127_ _18127_/I0 _18950_/Q _18148_/S _18950_/D VSS VSS VSS VSS gf180mcu_fd_sc_mcu9t5v0__mux2_1
X_15339_ _19645_/Q _19622_/Q _15345_/B VSS VSS VSS VSS gf180mcu_fd_sc_mcu9t5v0__nand2_1
X_18058_ _18056_/S _18058_/A2 _18924_/Q _18059_/B VSS _18058_/VNW VSS VSS gf180mcu_fd_sc_mcu9t5v0__oai21_1
X_17009_ _19251_/Q _16622_/B _17023_/S _17009_/Z VSS _17009_/VNW VSS VSS gf180mcu_fd_sc_mcu9t5v0__mux2_1
X_09900_ _19995_/Q _15832_/A1 _09978_/B1 VSS VSS VSS VSS gf180mcu_fd_sc_mcu9t5v0__nand2_1
X_20020_ _20020_/D _20020_/RN clkload48/I _20020_/Q VSS VSS VSS VSS gf180mcu_fd_sc_mcu9t5v0__dffrnq_1
X_09831_ _09815_/I _17909_/A3 _09831_/B _20025_/D VSS VSS VSS VSS gf180mcu_fd_sc_mcu9t5v0__oai21_1
X_09762_ _20026_/Q _18858_/Q _09767_/A2 VSS _09814_/VNW VSS VSS gf180mcu_fd_sc_mcu9t5v0__nand2_1
XTAP_TAPCELL_ROW_108_3942 VSS VSS gf180mcu_fd_sc_mcu9t5v0__filltie
XTAP_TAPCELL_ROW_277_6679 VSS VSS gf180mcu_fd_sc_mcu9t5v0__filltie
XTAP_TAPCELL_ROW_108_3964 VSS VSS gf180mcu_fd_sc_mcu9t5v0__filltie
XTAP_TAPCELL_ROW_108_3953 VSS VSS gf180mcu_fd_sc_mcu9t5v0__filltie
X_09693_ _17438_/C _09692_/I _17439_/A1 VSS VSS VSS VSS gf180mcu_fd_sc_mcu9t5v0__nor2_1
XTAP_TAPCELL_ROW_104_3839 VSS VSS gf180mcu_fd_sc_mcu9t5v0__filltie
XPHY_EDGE_ROW_192_2_Left_704 VSS VSS gf180mcu_fd_sc_mcu9t5v0__endcap
XTAP_TAPCELL_ROW_217_5041 VSS VSS gf180mcu_fd_sc_mcu9t5v0__filltie
XTAP_TAPCELL_ROW_217_5030 VSS VSS gf180mcu_fd_sc_mcu9t5v0__filltie
XTAP_TAPCELL_ROW_46_2234 VSS VSS gf180mcu_fd_sc_mcu9t5v0__filltie
XTAP_TAPCELL_ROW_46_2245 VSS VSS gf180mcu_fd_sc_mcu9t5v0__filltie
XTAP_TAPCELL_ROW_46_2256 VSS VSS gf180mcu_fd_sc_mcu9t5v0__filltie
XTAP_TAPCELL_ROW_59_2606 VSS VSS gf180mcu_fd_sc_mcu9t5v0__filltie
XTAP_TAPCELL_ROW_59_2617 VSS VSS gf180mcu_fd_sc_mcu9t5v0__filltie
X_09127_ _19758_/Q _13107_/A2 VSS VSS VSS VSS gf180mcu_fd_sc_mcu9t5v0__clkinv_1
X_09058_ input8/Z _17779_/A1 VSS _15493_/VNW VSS VSS gf180mcu_fd_sc_mcu9t5v0__clkinv_1
XPHY_EDGE_ROW_187_2_Left_699 VSS VSS gf180mcu_fd_sc_mcu9t5v0__endcap
X_11020_ _19053_/Q _19021_/Q _11051_/S _19021_/D VSS _17814_/VNW VSS VSS gf180mcu_fd_sc_mcu9t5v0__mux2_1
XTAP_TAPCELL_ROW_31_1824 VSS VSS gf180mcu_fd_sc_mcu9t5v0__filltie
XTAP_TAPCELL_ROW_31_1835 VSS VSS gf180mcu_fd_sc_mcu9t5v0__filltie
XTAP_TAPCELL_ROW_31_1846 VSS VSS gf180mcu_fd_sc_mcu9t5v0__filltie
X_12971_ _12735_/B _19750_/Q _12970_/B _12972_/A2 VSS VSS VSS VSS gf180mcu_fd_sc_mcu9t5v0__nor3_1
X_11922_ _12342_/C _11922_/A2 _11922_/A3 _11922_/B _11924_/A2 VSS VSS VSS VSS gf180mcu_fd_sc_mcu9t5v0__oai31_2
X_15690_ _15691_/B _15691_/C _15693_/A3 VSS VSS VSS VSS gf180mcu_fd_sc_mcu9t5v0__nand2_1
X_14710_ _14710_/I0 _19540_/Q _14715_/S _19540_/D VSS VSS VSS VSS gf180mcu_fd_sc_mcu9t5v0__mux2_1
XTAP_TAPCELL_ROW_310_7606 VSS VSS gf180mcu_fd_sc_mcu9t5v0__filltie
X_11853_ _12071_/B _11851_/Z _11853_/B _11854_/B VSS _11853_/VNW VSS VSS gf180mcu_fd_sc_mcu9t5v0__oai21_2
X_14641_ _19103_/Q _19519_/Q _14730_/S _19519_/D VSS VSS VSS VSS gf180mcu_fd_sc_mcu9t5v0__mux2_1
X_17360_ _18486_/Q _17406_/A2 _17405_/A2 _18502_/Q _19827_/Q _17361_/B VSS VSS VSS
+ VSS gf180mcu_fd_sc_mcu9t5v0__aoi221_1
X_10804_ _19009_/Q _10804_/A2 _10806_/A2 VSS _10804_/VNW VSS VSS gf180mcu_fd_sc_mcu9t5v0__nor2_1
X_16311_ _19232_/Q _16137_/C _16861_/S _16311_/Z VSS VSS VSS VSS gf180mcu_fd_sc_mcu9t5v0__mux2_1
X_11784_ _11784_/A1 _11784_/A2 _11784_/B1 _11784_/B2 _12320_/C _11785_/A3 VSS VSS
+ VSS VSS gf180mcu_fd_sc_mcu9t5v0__aoi221_1
XTAP_TAPCELL_ROW_29_1775 VSS VSS gf180mcu_fd_sc_mcu9t5v0__filltie
XTAP_TAPCELL_ROW_29_1786 VSS VSS gf180mcu_fd_sc_mcu9t5v0__filltie
X_14572_ _14581_/A1 _14756_/A1 _14572_/B _14573_/C VSS VSS VSS VSS gf180mcu_fd_sc_mcu9t5v0__oai21_1
X_17291_ _17250_/Z _17291_/A2 _17291_/B _18546_/D VSS VSS VSS VSS gf180mcu_fd_sc_mcu9t5v0__oai21_4
X_13523_ _19266_/Q _13320_/B _13527_/B VSS _13523_/VNW VSS VSS gf180mcu_fd_sc_mcu9t5v0__nand2_1
XTAP_TAPCELL_ROW_114_4113 VSS VSS gf180mcu_fd_sc_mcu9t5v0__filltie
X_10735_ _18852_/Q _10751_/B _10736_/B2 VSS _10736_/VNW VSS VSS gf180mcu_fd_sc_mcu9t5v0__nand2_1
XTAP_TAPCELL_ROW_308_7546 VSS VSS gf180mcu_fd_sc_mcu9t5v0__filltie
XTAP_TAPCELL_ROW_308_7535 VSS VSS gf180mcu_fd_sc_mcu9t5v0__filltie
X_10666_ _19869_/Q _10724_/C _10667_/A3 VSS VSS VSS VSS gf180mcu_fd_sc_mcu9t5v0__nor2_1
X_16242_ _16009_/B _16787_/S _16409_/B2 VSS VSS VSS VSS gf180mcu_fd_sc_mcu9t5v0__nand2_1
XTAP_TAPCELL_ROW_114_4124 VSS VSS gf180mcu_fd_sc_mcu9t5v0__filltie
X_13454_ _13454_/A1 _19778_/Q _13466_/A2 _13455_/A2 VSS _13454_/VNW VSS VSS gf180mcu_fd_sc_mcu9t5v0__xnor3_1
X_19030_ _19030_/D _20054_/RN clkload31/I _19030_/Q VSS VSS VSS VSS gf180mcu_fd_sc_mcu9t5v0__dffrnq_1
X_16173_ _19271_/Q _16725_/C _16174_/C VSS VSS VSS VSS gf180mcu_fd_sc_mcu9t5v0__nand2_1
X_12405_ _18207_/Q wire163/I _12408_/A3 VSS VSS VSS VSS gf180mcu_fd_sc_mcu9t5v0__nor2_1
X_13385_ _13387_/A1 _19809_/Q _13386_/I VSS _13387_/VNW VSS VSS gf180mcu_fd_sc_mcu9t5v0__nand2_1
X_10597_ _10389_/C _10649_/A2 _10597_/A3 _17161_/C _10598_/B2 VSS VSS VSS VSS gf180mcu_fd_sc_mcu9t5v0__oai31_1
XTAP_TAPCELL_ROW_193_3_8200 VSS VSS gf180mcu_fd_sc_mcu9t5v0__filltie
X_15124_ _19666_/Q _19506_/Q _15163_/S _19666_/D VSS _15125_/VNW VSS VSS gf180mcu_fd_sc_mcu9t5v0__mux2_1
XTAP_TAPCELL_ROW_209_4818 VSS VSS gf180mcu_fd_sc_mcu9t5v0__filltie
XTAP_TAPCELL_ROW_209_4807 VSS VSS gf180mcu_fd_sc_mcu9t5v0__filltie
XPHY_EDGE_ROW_39_Left_363 VSS VSS gf180mcu_fd_sc_mcu9t5v0__endcap
X_12336_ _18920_/Q _18921_/Q _12336_/A3 _12336_/B _12338_/A2 VSS VSS VSS VSS gf180mcu_fd_sc_mcu9t5v0__oai31_1
X_12267_ _18500_/Q _18484_/Q _12315_/S _12267_/Z VSS VSS VSS VSS gf180mcu_fd_sc_mcu9t5v0__mux2_1
XTAP_TAPCELL_ROW_209_4829 VSS VSS gf180mcu_fd_sc_mcu9t5v0__filltie
X_19932_ _19932_/D _20060_/RN clkload49/I _19932_/Q VSS VSS VSS VSS gf180mcu_fd_sc_mcu9t5v0__dffrnq_1
X_15055_ _15055_/A1 _15055_/A2 _15057_/A2 VSS _15056_/VNW VSS VSS gf180mcu_fd_sc_mcu9t5v0__xnor2_1
X_12198_ _12324_/B _12197_/Z _12199_/A2 VSS VSS VSS VSS gf180mcu_fd_sc_mcu9t5v0__nand2_1
X_19863_ _19863_/D _20055_/RN _20129_/CLK _19863_/Q VSS VSS VSS VSS gf180mcu_fd_sc_mcu9t5v0__dffrnq_1
X_11218_ _18273_/Q _11534_/S _11537_/S _11219_/A2 VSS _16425_/VNW VSS VSS gf180mcu_fd_sc_mcu9t5v0__oai21_1
X_14006_ _14006_/A1 _14006_/A2 _14071_/A1 _14006_/Z VSS VSS VSS VSS gf180mcu_fd_sc_mcu9t5v0__xor3_1
X_18814_ _18814_/D _20030_/RN clkload36/I _18814_/Q VSS VSS VSS VSS gf180mcu_fd_sc_mcu9t5v0__dffrnq_1
X_11149_ _18862_/Q _12689_/C _11151_/A2 VSS VSS VSS VSS gf180mcu_fd_sc_mcu9t5v0__nor2_1
X_19794_ _19794_/D _20050_/RN clkload29/I _19794_/Q VSS VSS VSS VSS gf180mcu_fd_sc_mcu9t5v0__dffrnq_1
X_15957_ _16198_/A2 _16297_/B2 _15957_/Z VSS VSS VSS VSS gf180mcu_fd_sc_mcu9t5v0__or2_2
X_18745_ _18745_/D clkload54/I _18745_/Q VSS VSS VSS VSS gf180mcu_fd_sc_mcu9t5v0__dffq_1
XTAP_TAPCELL_ROW_272_6554 VSS VSS gf180mcu_fd_sc_mcu9t5v0__filltie
X_15888_ _20097_/Q _19232_/Q _15920_/S _20097_/D VSS _15888_/VNW VSS VSS gf180mcu_fd_sc_mcu9t5v0__mux2_1
XTAP_TAPCELL_ROW_272_6543 VSS VSS gf180mcu_fd_sc_mcu9t5v0__filltie
X_18676_ _18676_/D _20144_/RN _20049_/CLK _18676_/Q VSS VSS VSS VSS gf180mcu_fd_sc_mcu9t5v0__dffrnq_1
X_14908_ _19418_/Q _19359_/Q _14932_/A1 VSS VSS VSS VSS gf180mcu_fd_sc_mcu9t5v0__nand2_1
X_17627_ _17627_/A1 _17627_/A2 _17702_/A3 VSS VSS VSS VSS gf180mcu_fd_sc_mcu9t5v0__nor2_1
XPHY_EDGE_ROW_48_Left_372 VSS VSS gf180mcu_fd_sc_mcu9t5v0__endcap
X_14839_ _19577_/Q _14839_/I1 _15163_/S _19577_/D VSS VSS VSS VSS gf180mcu_fd_sc_mcu9t5v0__mux2_1
X_17558_ input7/Z _17553_/Z _17561_/A1 VSS VSS VSS VSS gf180mcu_fd_sc_mcu9t5v0__nand2_1
X_17489_ _18594_/Q _19235_/Q _17513_/S _18594_/D VSS VSS VSS VSS gf180mcu_fd_sc_mcu9t5v0__mux2_1
XTAP_TAPCELL_ROW_285_6915 VSS VSS gf180mcu_fd_sc_mcu9t5v0__filltie
X_16509_ _19243_/Q _16099_/B _17025_/S _16509_/Z VSS VSS VSS VSS gf180mcu_fd_sc_mcu9t5v0__mux2_1
XTAP_TAPCELL_ROW_285_6904 VSS VSS gf180mcu_fd_sc_mcu9t5v0__filltie
XTAP_TAPCELL_ROW_41_2120 VSS VSS gf180mcu_fd_sc_mcu9t5v0__filltie
X_19228_ _19228_/D _20060_/RN clkload24/I _19228_/Q VSS VSS VSS VSS gf180mcu_fd_sc_mcu9t5v0__dffrnq_2
XTAP_TAPCELL_ROW_99_3698 VSS VSS gf180mcu_fd_sc_mcu9t5v0__filltie
X_19159_ _19159_/D _20055_/RN clkload28/I _19159_/Q VSS VSS VSS VSS gf180mcu_fd_sc_mcu9t5v0__dffrnq_1
XPHY_EDGE_ROW_57_Left_381 VSS VSS gf180mcu_fd_sc_mcu9t5v0__endcap
XTAP_TAPCELL_ROW_39_2060 VSS VSS gf180mcu_fd_sc_mcu9t5v0__filltie
X_20003_ _20003_/D _20067_/RN clkload49/I _20003_/Q VSS VSS VSS VSS gf180mcu_fd_sc_mcu9t5v0__dffrnq_1
X_09814_ _20026_/Q _18858_/Q _09814_/A3 _09815_/I VSS _09814_/VNW VSS VSS gf180mcu_fd_sc_mcu9t5v0__nand3_1
X_09745_ _09745_/I _10835_/A2 VSS VSS VSS VSS gf180mcu_fd_sc_mcu9t5v0__clkinv_1
XTAP_TAPCELL_ROW_48_2307 VSS VSS gf180mcu_fd_sc_mcu9t5v0__filltie
XTAP_TAPCELL_ROW_219_5103 VSS VSS gf180mcu_fd_sc_mcu9t5v0__filltie
X_09676_ _19913_/Q _20073_/Q _09676_/B _09677_/I VSS VSS VSS VSS gf180mcu_fd_sc_mcu9t5v0__aoi21_1
XPHY_EDGE_ROW_66_Left_390 VSS VSS gf180mcu_fd_sc_mcu9t5v0__endcap
X_10520_ _09261_/I _10520_/A2 _10520_/B _10543_/C _10521_/A4 VSS VSS VSS VSS gf180mcu_fd_sc_mcu9t5v0__oai211_1
XTAP_TAPCELL_ROW_24_1650 VSS VSS gf180mcu_fd_sc_mcu9t5v0__filltie
X_10451_ _19948_/Q wire216/Z _10655_/B _10452_/B2 VSS _10451_/VNW VSS VSS gf180mcu_fd_sc_mcu9t5v0__aoi21_1
XTAP_TAPCELL_ROW_20_1525 VSS VSS gf180mcu_fd_sc_mcu9t5v0__filltie
XTAP_TAPCELL_ROW_303_7410 VSS VSS gf180mcu_fd_sc_mcu9t5v0__filltie
XTAP_TAPCELL_ROW_178_3_8146 VSS VSS gf180mcu_fd_sc_mcu9t5v0__filltie
XTAP_TAPCELL_ROW_20_1536 VSS VSS gf180mcu_fd_sc_mcu9t5v0__filltie
X_10382_ _10516_/C _10382_/A2 _10382_/B1 _10353_/C _10382_/C1 _10543_/C _10383_/A2
+ VSS VSS VSS VSS gf180mcu_fd_sc_mcu9t5v0__aoi222_1
XTAP_TAPCELL_ROW_203_3_8233 VSS VSS gf180mcu_fd_sc_mcu9t5v0__filltie
X_13170_ _13170_/A1 _13170_/A2 _13170_/B _13186_/A2 VSS VSS VSS VSS gf180mcu_fd_sc_mcu9t5v0__aoi21_1
X_12121_ _12164_/B _12164_/A1 _12121_/B _12123_/A2 VSS VSS VSS VSS gf180mcu_fd_sc_mcu9t5v0__aoi21_1
X_12052_ _12686_/C _12052_/A2 _12052_/B _12053_/I1 VSS _12052_/VNW VSS VSS gf180mcu_fd_sc_mcu9t5v0__oai21_1
X_11003_ _18936_/Q _11003_/A2 _11003_/B _11006_/A2 VSS _11003_/VNW VSS VSS gf180mcu_fd_sc_mcu9t5v0__aoi21_1
XTAP_TAPCELL_ROW_18_1465 VSS VSS gf180mcu_fd_sc_mcu9t5v0__filltie
XTAP_TAPCELL_ROW_18_1476 VSS VSS gf180mcu_fd_sc_mcu9t5v0__filltie
X_16860_ _18422_/Q _16859_/Z _16864_/S _18422_/D VSS VSS VSS VSS gf180mcu_fd_sc_mcu9t5v0__mux2_1
XTAP_TAPCELL_ROW_158_3_8077 VSS VSS gf180mcu_fd_sc_mcu9t5v0__filltie
XTAP_TAPCELL_ROW_18_1487 VSS VSS gf180mcu_fd_sc_mcu9t5v0__filltie
X_16791_ _16791_/A1 _16933_/A1 _16792_/I1 VSS VSS VSS VSS gf180mcu_fd_sc_mcu9t5v0__nand2_1
X_15811_ input8/Z _19980_/Q _15811_/S _19980_/D VSS VSS VSS VSS gf180mcu_fd_sc_mcu9t5v0__mux2_1
X_18530_ _18530_/D _20132_/CLK _18530_/Q VSS VSS VSS VSS gf180mcu_fd_sc_mcu9t5v0__dffq_1
X_15742_ _15740_/Z _15742_/A2 _15743_/A2 VSS VSS VSS VSS gf180mcu_fd_sc_mcu9t5v0__nand2_1
X_12954_ _12735_/B _13503_/A2 _13500_/A1 VSS VSS VSS VSS gf180mcu_fd_sc_mcu9t5v0__nor2_1
XTAP_TAPCELL_ROW_289_7026 VSS VSS gf180mcu_fd_sc_mcu9t5v0__filltie
XTAP_TAPCELL_ROW_289_7015 VSS VSS gf180mcu_fd_sc_mcu9t5v0__filltie
X_18461_ _18461_/D clkload60/I _18461_/Q VSS VSS VSS VSS gf180mcu_fd_sc_mcu9t5v0__dffq_1
X_11905_ _18901_/Q _12336_/B _11907_/A3 VSS _11905_/VNW VSS VSS gf180mcu_fd_sc_mcu9t5v0__nand2_1
X_17412_ _17412_/A1 _17412_/A2 _17412_/B _17413_/A2 VSS VSS VSS VSS gf180mcu_fd_sc_mcu9t5v0__aoi21_1
X_15673_ _19911_/Q _15674_/A2 _15676_/A1 VSS VSS VSS VSS gf180mcu_fd_sc_mcu9t5v0__nand2_1
X_12885_ _12884_/Z _19217_/Q _13320_/B _19217_/D VSS _12885_/VNW VSS VSS gf180mcu_fd_sc_mcu9t5v0__mux2_1
X_18392_ _18392_/D clkload77/I _18392_/Q VSS VSS VSS VSS gf180mcu_fd_sc_mcu9t5v0__dffq_1
X_14624_ _19085_/Q _19502_/Q _14624_/S _19502_/D VSS VSS VSS VSS gf180mcu_fd_sc_mcu9t5v0__mux2_1
X_11836_ _12548_/A1 _11836_/A2 _11836_/B _11985_/B _11837_/B VSS _11836_/VNW VSS VSS
+ gf180mcu_fd_sc_mcu9t5v0__oai211_1
X_17343_ _18485_/Q _17380_/A2 _17380_/B1 _18501_/Q _17344_/B VSS _17345_/VNW VSS VSS
+ gf180mcu_fd_sc_mcu9t5v0__aoi22_1
X_14555_ _14555_/A1 _14555_/A2 _19468_/D VSS _14555_/VNW VSS VSS gf180mcu_fd_sc_mcu9t5v0__nand2_1
X_11767_ _13706_/A2 _11966_/B _11767_/B1 _11767_/B2 _19111_/D VSS VSS VSS VSS gf180mcu_fd_sc_mcu9t5v0__aoi22_1
X_17274_ _10514_/B _17273_/Z _17279_/A1 VSS VSS VSS VSS gf180mcu_fd_sc_mcu9t5v0__nand2_1
XPHY_EDGE_ROW_172_3_Left_830 VSS VSS gf180mcu_fd_sc_mcu9t5v0__endcap
X_10718_ _10693_/B _10716_/Z _10717_/Z _10659_/C _10718_/C _10719_/A2 VSS VSS VSS
+ VSS gf180mcu_fd_sc_mcu9t5v0__aoi221_1
X_13506_ _12962_/Z _13507_/A2 _13508_/A2 VSS _13506_/VNW VSS VSS gf180mcu_fd_sc_mcu9t5v0__nor2_1
X_16225_ _16224_/Z _18197_/Q _16782_/S _18197_/D VSS VSS VSS VSS gf180mcu_fd_sc_mcu9t5v0__mux2_1
X_11698_ _11698_/A1 _11697_/Z _11699_/B2 VSS _17546_/VNW VSS VSS gf180mcu_fd_sc_mcu9t5v0__xnor2_1
X_19013_ _19013_/D _20037_/RN clkload38/I _19013_/Q VSS VSS VSS VSS gf180mcu_fd_sc_mcu9t5v0__dffrnq_1
X_14486_ _14715_/S _14486_/A2 _14486_/A3 _14486_/B _19460_/D VSS _14486_/VNW VSS VSS
+ gf180mcu_fd_sc_mcu9t5v0__oai31_1
X_10649_ _10389_/C _10649_/A2 _10649_/A3 _17161_/C _10650_/B2 VSS _17409_/VNW VSS
+ VSS gf180mcu_fd_sc_mcu9t5v0__oai31_1
X_13437_ _13497_/A1 _13437_/A2 _13497_/B _13438_/B2 VSS VSS VSS VSS gf180mcu_fd_sc_mcu9t5v0__aoi21_1
XTAP_TAPCELL_ROW_94_3573 VSS VSS gf180mcu_fd_sc_mcu9t5v0__filltie
XTAP_TAPCELL_ROW_94_3562 VSS VSS gf180mcu_fd_sc_mcu9t5v0__filltie
X_16156_ _18177_/Q _16747_/A2 _16741_/A1 _16160_/B VSS VSS VSS VSS gf180mcu_fd_sc_mcu9t5v0__nand3_1
X_13368_ _19742_/Q _13403_/A2 _13366_/Z _13369_/I VSS _13368_/VNW VSS VSS gf180mcu_fd_sc_mcu9t5v0__nor3_1
XTAP_TAPCELL_ROW_90_3448 VSS VSS gf180mcu_fd_sc_mcu9t5v0__filltie
X_12319_ _12324_/B _12319_/A2 _12319_/A3 _12320_/B VSS VSS VSS VSS gf180mcu_fd_sc_mcu9t5v0__nand3_1
XTAP_TAPCELL_ROW_261_6255 VSS VSS gf180mcu_fd_sc_mcu9t5v0__filltie
X_16087_ _16750_/A1 _16674_/A2 _16182_/B _16090_/A2 VSS VSS VSS VSS gf180mcu_fd_sc_mcu9t5v0__aoi21_1
XTAP_TAPCELL_ROW_261_6244 VSS VSS gf180mcu_fd_sc_mcu9t5v0__filltie
XTAP_TAPCELL_ROW_90_3459 VSS VSS gf180mcu_fd_sc_mcu9t5v0__filltie
X_15107_ _19649_/Q _15106_/Z _20039_/Q _19649_/D VSS VSS VSS VSS gf180mcu_fd_sc_mcu9t5v0__mux2_1
X_19915_ _19915_/D _20043_/RN _20049_/CLK _19915_/Q VSS VSS VSS VSS gf180mcu_fd_sc_mcu9t5v0__dffrnq_1
X_13299_ _13299_/A1 _13299_/A2 _13305_/B1 VSS VSS VSS VSS gf180mcu_fd_sc_mcu9t5v0__nand2_1
X_15038_ _19303_/Q _19388_/Q _15041_/A2 VSS _15038_/VNW VSS VSS gf180mcu_fd_sc_mcu9t5v0__nor2_1
XTAP_TAPCELL_ROW_274_6605 VSS VSS gf180mcu_fd_sc_mcu9t5v0__filltie
X_19846_ _19846_/D _20038_/RN clkload51/I _19846_/Q VSS VSS VSS VSS gf180mcu_fd_sc_mcu9t5v0__dffrnq_1
XTAP_TAPCELL_ROW_274_6616 VSS VSS gf180mcu_fd_sc_mcu9t5v0__filltie
X_16989_ _19257_/Q _16660_/B _16993_/S _16989_/Z VSS VSS VSS VSS gf180mcu_fd_sc_mcu9t5v0__mux2_1
XTAP_TAPCELL_ROW_259_6184 VSS VSS gf180mcu_fd_sc_mcu9t5v0__filltie
X_19777_ _19777_/D _20033_/RN clkload41/I _19777_/Q VSS VSS VSS VSS gf180mcu_fd_sc_mcu9t5v0__dffrnq_1
XTAP_TAPCELL_ROW_88_3399 VSS VSS gf180mcu_fd_sc_mcu9t5v0__filltie
XTAP_TAPCELL_ROW_259_6195 VSS VSS gf180mcu_fd_sc_mcu9t5v0__filltie
X_09530_ _17423_/A1 _19841_/Q _19845_/Q _19846_/Q _09531_/A3 VSS VSS VSS VSS gf180mcu_fd_sc_mcu9t5v0__aoi211_1
X_18728_ _18728_/D clkload54/I _18728_/Q VSS VSS VSS VSS gf180mcu_fd_sc_mcu9t5v0__dffq_1
X_09461_ _12729_/A2 _14139_/S _09462_/I VSS VSS VSS VSS gf180mcu_fd_sc_mcu9t5v0__nand2_4
X_18659_ _18659_/D _20063_/RN clkload54/I _18659_/Q VSS VSS VSS VSS gf180mcu_fd_sc_mcu9t5v0__dffrnq_1
XTAP_TAPCELL_ROW_4_1085 VSS VSS gf180mcu_fd_sc_mcu9t5v0__filltie
Xwire79 wire79/I wire79/Z VSS VSS VSS VSS gf180mcu_fd_sc_mcu9t5v0__buf_4
X_09392_ _18566_/Q _18565_/Q _11548_/B VSS VSS VSS VSS gf180mcu_fd_sc_mcu9t5v0__nor2_1
XTAP_TAPCELL_ROW_184_3_8167 VSS VSS gf180mcu_fd_sc_mcu9t5v0__filltie
XTAP_TAPCELL_ROW_4_1096 VSS VSS gf180mcu_fd_sc_mcu9t5v0__filltie
XPHY_EDGE_ROW_278_Right_205 VSS VSS gf180mcu_fd_sc_mcu9t5v0__endcap
XTAP_TAPCELL_ROW_164_3_8098 VSS VSS gf180mcu_fd_sc_mcu9t5v0__filltie
XTAP_TAPCELL_ROW_37_2008 VSS VSS gf180mcu_fd_sc_mcu9t5v0__filltie
XTAP_TAPCELL_ROW_244_5774 VSS VSS gf180mcu_fd_sc_mcu9t5v0__filltie
XTAP_TAPCELL_ROW_73_2989 VSS VSS gf180mcu_fd_sc_mcu9t5v0__filltie
XTAP_TAPCELL_ROW_73_2978 VSS VSS gf180mcu_fd_sc_mcu9t5v0__filltie
XTAP_TAPCELL_ROW_244_5785 VSS VSS gf180mcu_fd_sc_mcu9t5v0__filltie
X_09728_ _20142_/Q _09758_/B _17577_/S VSS VSS VSS VSS gf180mcu_fd_sc_mcu9t5v0__nand2_1
XTAP_TAPCELL_ROW_13_1340 VSS VSS gf180mcu_fd_sc_mcu9t5v0__filltie
XTAP_TAPCELL_ROW_13_1351 VSS VSS gf180mcu_fd_sc_mcu9t5v0__filltie
XPHY_EDGE_ROW_29_Right_29 VSS VSS gf180mcu_fd_sc_mcu9t5v0__endcap
X_09659_ _15786_/S _09659_/A2 _20002_/D VSS VSS VSS VSS gf180mcu_fd_sc_mcu9t5v0__nand2_1
X_12670_ _12664_/C _12670_/A2 _12671_/B1 VSS VSS VSS VSS gf180mcu_fd_sc_mcu9t5v0__nand2_1
XTAP_TAPCELL_ROW_26_1701 VSS VSS gf180mcu_fd_sc_mcu9t5v0__filltie
X_11621_ _12649_/A2 _12643_/A1 _11621_/Z VSS _11621_/VNW VSS VSS gf180mcu_fd_sc_mcu9t5v0__and2_1
X_14340_ _14355_/I0 _19411_/Q _14352_/S _19411_/D VSS VSS VSS VSS gf180mcu_fd_sc_mcu9t5v0__mux2_1
X_11552_ wire175/I _17443_/B2 wire146/I VSS _17723_/VNW VSS VSS gf180mcu_fd_sc_mcu9t5v0__nand2_1
XPHY_EDGE_ROW_38_Right_38 VSS VSS gf180mcu_fd_sc_mcu9t5v0__endcap
X_11483_ _18484_/Q _11519_/A2 _11483_/B _11485_/A2 VSS VSS VSS VSS gf180mcu_fd_sc_mcu9t5v0__oai21_1
X_10503_ _10503_/A1 _10503_/A2 _10503_/B1 _10655_/B _10503_/ZN VSS VSS VSS VSS gf180mcu_fd_sc_mcu9t5v0__aoi22_4
X_14271_ _14357_/I0 _19345_/Q _14285_/S _19345_/D VSS VSS VSS VSS gf180mcu_fd_sc_mcu9t5v0__mux2_1
X_10434_ _17260_/S _18208_/Q _10436_/A3 VSS VSS VSS VSS gf180mcu_fd_sc_mcu9t5v0__nor2_1
X_16010_ _19229_/Q _16700_/A2 wire71/I _16011_/A3 VSS VSS VSS VSS gf180mcu_fd_sc_mcu9t5v0__nor3_1
X_13222_ _13206_/Z _13222_/A2 _13570_/B _13223_/A3 VSS _13222_/VNW VSS VSS gf180mcu_fd_sc_mcu9t5v0__oai21_1
X_10365_ _10654_/A2 _10365_/A2 _10365_/A3 _10366_/B VSS _10365_/VNW VSS VSS gf180mcu_fd_sc_mcu9t5v0__nand3_1
X_13153_ _13164_/A2 _19795_/Q _13170_/B VSS VSS VSS VSS gf180mcu_fd_sc_mcu9t5v0__nor2_1
X_12104_ _18911_/Q _12104_/A2 _12104_/B _12125_/B1 VSS _12104_/VNW VSS VSS gf180mcu_fd_sc_mcu9t5v0__oai21_1
X_10296_ _17195_/A1 _18315_/Q _10299_/A2 VSS VSS VSS VSS gf180mcu_fd_sc_mcu9t5v0__nor2_1
X_13084_ _13104_/A2 _13084_/A2 _13090_/B1 VSS VSS VSS VSS gf180mcu_fd_sc_mcu9t5v0__nand2_1
X_17961_ _12686_/C _17961_/A2 _17961_/A3 _17961_/A4 _17962_/A2 VSS VSS VSS VSS gf180mcu_fd_sc_mcu9t5v0__nand4_1
X_16912_ _16911_/Z _18448_/Q _16928_/S _18448_/D VSS VSS VSS VSS gf180mcu_fd_sc_mcu9t5v0__mux2_1
X_12035_ _11706_/B _12057_/A1 _12050_/A1 VSS VSS VSS VSS gf180mcu_fd_sc_mcu9t5v0__nor2_1
Xclkbuf_leaf_67_clk_regs clkload1/I clkload37/I VSS VSS VSS VSS gf180mcu_fd_sc_mcu9t5v0__clkbuf_8
X_17892_ _18060_/B _17909_/A1 _17922_/A2 VSS _17909_/VNW VSS VSS gf180mcu_fd_sc_mcu9t5v0__nor2_1
X_19700_ _19700_/D _20020_/RN clkload16/I _19700_/Q VSS VSS VSS VSS gf180mcu_fd_sc_mcu9t5v0__dffrnq_1
X_16843_ _19249_/Q _16606_/B _16861_/S _16843_/Z VSS VSS VSS VSS gf180mcu_fd_sc_mcu9t5v0__mux2_1
XPHY_EDGE_ROW_217_Left_540 VSS VSS gf180mcu_fd_sc_mcu9t5v0__endcap
XTAP_TAPCELL_ROW_190_3_8188 VSS VSS gf180mcu_fd_sc_mcu9t5v0__filltie
XPHY_EDGE_ROW_47_Right_47 VSS VSS gf180mcu_fd_sc_mcu9t5v0__endcap
X_19631_ _19631_/D _20143_/RN _19633_/CLK _19631_/Q VSS VSS VSS VSS gf180mcu_fd_sc_mcu9t5v0__dffrnq_1
X_19562_ _19562_/D _20138_/RN clkload7/I _19562_/Q VSS VSS VSS VSS gf180mcu_fd_sc_mcu9t5v0__dffrnq_1
X_18513_ _18513_/D _18513_/CLK _18513_/Q VSS VSS VSS VSS gf180mcu_fd_sc_mcu9t5v0__dffq_4
X_16774_ _16773_/Z _18386_/Q _16782_/S _18386_/D VSS VSS VSS VSS gf180mcu_fd_sc_mcu9t5v0__mux2_4
XTAP_TAPCELL_ROW_83_3263 VSS VSS gf180mcu_fd_sc_mcu9t5v0__filltie
X_13986_ _14027_/A1 _13986_/A2 _13986_/Z VSS VSS VSS VSS gf180mcu_fd_sc_mcu9t5v0__xor2_2
XTAP_TAPCELL_ROW_83_3252 VSS VSS gf180mcu_fd_sc_mcu9t5v0__filltie
X_15725_ _15747_/A2 _15725_/A2 _15725_/B1 _15725_/B2 _15726_/I0 VSS _15725_/VNW VSS
+ VSS gf180mcu_fd_sc_mcu9t5v0__aoi22_1
XTAP_TAPCELL_ROW_83_3274 VSS VSS gf180mcu_fd_sc_mcu9t5v0__filltie
X_12937_ _19779_/Q _12936_/Z _12944_/A2 VSS VSS VSS VSS gf180mcu_fd_sc_mcu9t5v0__nor2_1
X_19493_ _19493_/D _20069_/RN clkload24/I _19493_/Q VSS VSS VSS VSS gf180mcu_fd_sc_mcu9t5v0__dffrnq_1
X_18444_ _18444_/D clkload60/I _18444_/Q VSS VSS VSS VSS gf180mcu_fd_sc_mcu9t5v0__dffq_1
X_15656_ _19905_/Q _15671_/A4 _15657_/A2 VSS VSS VSS VSS gf180mcu_fd_sc_mcu9t5v0__xnor2_1
X_12868_ _13304_/B _12869_/B _12866_/Z _12868_/B _19215_/D VSS _13269_/VNW VSS VSS
+ gf180mcu_fd_sc_mcu9t5v0__oai31_1
X_11819_ _18288_/Q _12315_/S _11821_/A2 VSS _11819_/VNW VSS VSS gf180mcu_fd_sc_mcu9t5v0__nand2_1
X_18375_ _18375_/D clkload78/I _18375_/Q VSS VSS VSS VSS gf180mcu_fd_sc_mcu9t5v0__dffq_1
X_14607_ _19187_/Q _19485_/Q _14715_/S _19485_/D VSS VSS VSS VSS gf180mcu_fd_sc_mcu9t5v0__mux2_1
X_17326_ _17326_/A1 _17326_/A2 _17326_/B _17408_/B _17327_/B VSS VSS VSS VSS gf180mcu_fd_sc_mcu9t5v0__aoi211_1
XTAP_TAPCELL_ROW_267_6420 VSS VSS gf180mcu_fd_sc_mcu9t5v0__filltie
XTAP_TAPCELL_ROW_96_3635 VSS VSS gf180mcu_fd_sc_mcu9t5v0__filltie
X_12799_ _13497_/B _12799_/A2 _12799_/B _19204_/D VSS VSS VSS VSS gf180mcu_fd_sc_mcu9t5v0__oai21_1
X_15587_ _19880_/Q _15598_/S _15589_/B VSS _15587_/VNW VSS VSS gf180mcu_fd_sc_mcu9t5v0__nand2_1
XTAP_TAPCELL_ROW_96_3624 VSS VSS gf180mcu_fd_sc_mcu9t5v0__filltie
XPHY_EDGE_ROW_56_Right_56 VSS VSS gf180mcu_fd_sc_mcu9t5v0__endcap
XTAP_TAPCELL_ROW_96_3613 VSS VSS gf180mcu_fd_sc_mcu9t5v0__filltie
X_14538_ _14538_/A1 _14538_/A2 _19466_/D VSS VSS VSS VSS gf180mcu_fd_sc_mcu9t5v0__nand2_1
X_17257_ _18465_/Q _18449_/Q _17260_/S _17257_/Z VSS VSS VSS VSS gf180mcu_fd_sc_mcu9t5v0__mux2_1
XTAP_TAPCELL_ROW_263_6306 VSS VSS gf180mcu_fd_sc_mcu9t5v0__filltie
X_14469_ _14715_/S _14469_/A2 _14469_/A3 _14469_/B _19458_/D VSS _14469_/VNW VSS VSS
+ gf180mcu_fd_sc_mcu9t5v0__oai31_1
X_16208_ _16137_/C _19264_/Q _16783_/S _16208_/Z VSS VSS VSS VSS gf180mcu_fd_sc_mcu9t5v0__mux2_1
X_17188_ _17260_/S _18462_/Q _17190_/A3 VSS VSS VSS VSS gf180mcu_fd_sc_mcu9t5v0__nor2_1
XTAP_TAPCELL_ROW_77_3089 VSS VSS gf180mcu_fd_sc_mcu9t5v0__filltie
X_16139_ _16741_/B2 _16139_/A2 _16139_/B _16139_/C _16140_/I1 VSS VSS VSS VSS gf180mcu_fd_sc_mcu9t5v0__aoi211_4
XPHY_EDGE_ROW_65_Right_65 VSS VSS gf180mcu_fd_sc_mcu9t5v0__endcap
X_19829_ _19829_/D _20021_/RN clkload51/I _19829_/Q VSS VSS VSS VSS gf180mcu_fd_sc_mcu9t5v0__dffrnq_1
XTAP_TAPCELL_ROW_156_2_8068 VSS VSS gf180mcu_fd_sc_mcu9t5v0__filltie
XTAP_TAPCELL_ROW_6_1136 VSS VSS gf180mcu_fd_sc_mcu9t5v0__filltie
XTAP_TAPCELL_ROW_6_1147 VSS VSS gf180mcu_fd_sc_mcu9t5v0__filltie
XTAP_TAPCELL_ROW_6_1158 VSS VSS gf180mcu_fd_sc_mcu9t5v0__filltie
X_09513_ _18586_/Q _09513_/A2 _18578_/Q _17960_/A4 wire198/I _09515_/A3 VSS VSS VSS
+ VSS gf180mcu_fd_sc_mcu9t5v0__oai221_4
X_09444_ _09437_/Z _09445_/A3 _09445_/A4 _09614_/A2 VSS _09444_/VNW VSS VSS gf180mcu_fd_sc_mcu9t5v0__nand3_1
XTAP_TAPCELL_ROW_66_2793 VSS VSS gf180mcu_fd_sc_mcu9t5v0__filltie
XPHY_EDGE_ROW_74_Right_74 VSS VSS gf180mcu_fd_sc_mcu9t5v0__endcap
X_09375_ _18475_/Q _12061_/A1 VSS VSS VSS VSS gf180mcu_fd_sc_mcu9t5v0__clkinv_1
XTAP_TAPCELL_ROW_233_5486 VSS VSS gf180mcu_fd_sc_mcu9t5v0__filltie
XTAP_TAPCELL_ROW_233_5475 VSS VSS gf180mcu_fd_sc_mcu9t5v0__filltie
XTAP_TAPCELL_ROW_62_2679 VSS VSS gf180mcu_fd_sc_mcu9t5v0__filltie
XTAP_TAPCELL_ROW_246_5825 VSS VSS gf180mcu_fd_sc_mcu9t5v0__filltie
XTAP_TAPCELL_ROW_246_5847 VSS VSS gf180mcu_fd_sc_mcu9t5v0__filltie
XTAP_TAPCELL_ROW_246_5836 VSS VSS gf180mcu_fd_sc_mcu9t5v0__filltie
XPHY_EDGE_ROW_83_Right_83 VSS VSS gf180mcu_fd_sc_mcu9t5v0__endcap
X_10150_ _10659_/C _19234_/Q _19235_/Q _09998_/C _10151_/A4 VSS _10166_/VNW VSS VSS
+ gf180mcu_fd_sc_mcu9t5v0__nand4_1
X_10081_ _10106_/B _10081_/A2 _10081_/B _10081_/C _10082_/B VSS VSS VSS VSS gf180mcu_fd_sc_mcu9t5v0__aoi211_1
XTAP_TAPCELL_ROW_15_1402 VSS VSS gf180mcu_fd_sc_mcu9t5v0__filltie
XPHY_EDGE_ROW_210_Right_137 VSS VSS gf180mcu_fd_sc_mcu9t5v0__endcap
X_13840_ _19317_/Q _19298_/Q _13876_/A1 VSS _13887_/VNW VSS VSS gf180mcu_fd_sc_mcu9t5v0__nand2_1
X_10983_ _10984_/A1 _10984_/A2 _10986_/B VSS VSS VSS VSS gf180mcu_fd_sc_mcu9t5v0__nand2_1
X_13771_ _19292_/Q _19318_/Q _13785_/A1 _13771_/A4 _13785_/A2 VSS _13771_/VNW VSS
+ VSS gf180mcu_fd_sc_mcu9t5v0__nand4_1
X_16490_ _18302_/Q _16489_/Z _17020_/S _18302_/D VSS VSS VSS VSS gf180mcu_fd_sc_mcu9t5v0__mux2_4
X_15510_ _15512_/A1 _17422_/S _15512_/B _15511_/A2 VSS VSS VSS VSS gf180mcu_fd_sc_mcu9t5v0__aoi21_1
XPHY_EDGE_ROW_92_Right_92 VSS VSS gf180mcu_fd_sc_mcu9t5v0__endcap
X_12722_ _12722_/A1 _12722_/A2 _12722_/B _19190_/D VSS VSS VSS VSS gf180mcu_fd_sc_mcu9t5v0__oai21_1
X_15441_ _15472_/A2 _15441_/A2 _15444_/A2 VSS _15453_/VNW VSS VSS gf180mcu_fd_sc_mcu9t5v0__nand2_1
XTAP_TAPCELL_ROW_166_3_8106 VSS VSS gf180mcu_fd_sc_mcu9t5v0__filltie
XPHY_EDGE_ROW_133_Right_133 VSS VSS gf180mcu_fd_sc_mcu9t5v0__endcap
XPHY_EDGE_ROW_190_3_Right_305 VSS VSS gf180mcu_fd_sc_mcu9t5v0__endcap
X_12653_ _12671_/B2 _12653_/A2 _12653_/B1 _12664_/C _12707_/I1 VSS _12653_/VNW VSS
+ VSS gf180mcu_fd_sc_mcu9t5v0__oai22_1
X_12584_ _18500_/Q _12608_/A2 wire146/Z _12585_/B2 VSS VSS VSS VSS gf180mcu_fd_sc_mcu9t5v0__oai21_1
X_18160_ _18160_/D clkload76/I _18160_/Q VSS VSS VSS VSS gf180mcu_fd_sc_mcu9t5v0__dffq_1
X_15372_ _19657_/Q _19757_/Q _15430_/S _19757_/D VSS VSS VSS VSS gf180mcu_fd_sc_mcu9t5v0__mux2_1
XTAP_TAPCELL_ROW_134_4661 VSS VSS gf180mcu_fd_sc_mcu9t5v0__filltie
X_11604_ _18838_/Q _11600_/C _09782_/Z _11592_/Z _11604_/Z VSS _11604_/VNW VSS VSS
+ gf180mcu_fd_sc_mcu9t5v0__and4_1
X_11535_ _18536_/Q _18520_/Q _18504_/Q _18488_/Q _11534_/S wire136/Z _11535_/Z VSS
+ VSS VSS VSS gf180mcu_fd_sc_mcu9t5v0__mux4_1
X_17111_ _19826_/Q _17111_/A2 _17111_/A3 _17111_/B _17112_/A3 VSS VSS VSS VSS gf180mcu_fd_sc_mcu9t5v0__oai31_1
XTAP_TAPCELL_ROW_134_4672 VSS VSS gf180mcu_fd_sc_mcu9t5v0__filltie
X_18091_ _18935_/Q _11018_/B _18094_/B VSS _18097_/VNW VSS VSS gf180mcu_fd_sc_mcu9t5v0__nand2_1
X_14323_ _09458_/Z _14323_/A2 _14337_/S VSS _14817_/VNW VSS VSS gf180mcu_fd_sc_mcu9t5v0__nand2_1
X_17042_ _17041_/Z _18512_/Q _17042_/S _18512_/D VSS VSS VSS VSS gf180mcu_fd_sc_mcu9t5v0__mux2_1
XTAP_TAPCELL_ROW_130_4569 VSS VSS gf180mcu_fd_sc_mcu9t5v0__filltie
XTAP_TAPCELL_ROW_130_4558 VSS VSS gf180mcu_fd_sc_mcu9t5v0__filltie
XTAP_TAPCELL_ROW_130_4547 VSS VSS gf180mcu_fd_sc_mcu9t5v0__filltie
X_14254_ _14254_/A1 _14254_/A2 _14262_/A2 VSS VSS VSS VSS gf180mcu_fd_sc_mcu9t5v0__xnor2_1
X_11466_ _18451_/Q _11509_/A2 _11469_/A1 VSS VSS VSS VSS gf180mcu_fd_sc_mcu9t5v0__nor2_1
X_13205_ _13215_/A1 _13207_/A2 _13571_/A1 VSS VSS VSS VSS gf180mcu_fd_sc_mcu9t5v0__nand2_1
X_11397_ _18430_/Q _11176_/C _11401_/C VSS VSS VSS VSS gf180mcu_fd_sc_mcu9t5v0__nand2_1
X_10417_ _18543_/Q wire81/Z wire282/Z _10423_/A2 VSS VSS VSS VSS gf180mcu_fd_sc_mcu9t5v0__aoi21_4
XTAP_TAPCELL_ROW_162_2_8089 VSS VSS gf180mcu_fd_sc_mcu9t5v0__filltie
X_14185_ _14185_/A1 _14185_/A2 _14185_/B _14208_/A1 VSS _14185_/VNW VSS VSS gf180mcu_fd_sc_mcu9t5v0__oai21_1
X_10348_ _18157_/Q _17322_/A2 _17255_/B1 _18173_/Q _17406_/C _10349_/B VSS VSS VSS
+ VSS gf180mcu_fd_sc_mcu9t5v0__aoi221_1
X_18993_ _18993_/D _20145_/RN clkload71/I _18993_/Q VSS VSS VSS VSS gf180mcu_fd_sc_mcu9t5v0__dffrnq_1
X_13136_ _13136_/I _13159_/A1 VSS VSS VSS VSS gf180mcu_fd_sc_mcu9t5v0__clkinv_1
X_10279_ _19849_/Q _10724_/C _10416_/B _10279_/C _10286_/A1 VSS VSS VSS VSS gf180mcu_fd_sc_mcu9t5v0__oai211_4
X_17944_ _18852_/Q _11013_/B _17946_/B VSS VSS VSS VSS gf180mcu_fd_sc_mcu9t5v0__nand2_1
X_13067_ _13064_/Z _13067_/A2 _13067_/Z VSS _13067_/VNW VSS VSS gf180mcu_fd_sc_mcu9t5v0__xor2_1
X_12018_ _12492_/A1 _12018_/I1 _12046_/S _12018_/Z VSS VSS VSS VSS gf180mcu_fd_sc_mcu9t5v0__mux2_1
XTAP_TAPCELL_ROW_128_4498 VSS VSS gf180mcu_fd_sc_mcu9t5v0__filltie
XTAP_TAPCELL_ROW_85_3314 VSS VSS gf180mcu_fd_sc_mcu9t5v0__filltie
XTAP_TAPCELL_ROW_256_6121 VSS VSS gf180mcu_fd_sc_mcu9t5v0__filltie
XTAP_TAPCELL_ROW_256_6110 VSS VSS gf180mcu_fd_sc_mcu9t5v0__filltie
X_17875_ _18830_/Q _18831_/Q _17879_/A2 _17879_/B1 VSS _17876_/VNW VSS VSS gf180mcu_fd_sc_mcu9t5v0__nand3_1
XTAP_TAPCELL_ROW_85_3325 VSS VSS gf180mcu_fd_sc_mcu9t5v0__filltie
X_16826_ _16955_/S _16668_/B _16959_/B VSS VSS VSS VSS gf180mcu_fd_sc_mcu9t5v0__nand2_1
XTAP_TAPCELL_ROW_252_6007 VSS VSS gf180mcu_fd_sc_mcu9t5v0__filltie
X_19614_ _19614_/D _20062_/RN clkload22/I _19614_/Q VSS VSS VSS VSS gf180mcu_fd_sc_mcu9t5v0__dffrnq_1
X_16757_ _16576_/B _19277_/Q _16763_/S _16757_/Z VSS VSS VSS VSS gf180mcu_fd_sc_mcu9t5v0__mux2_1
X_13969_ _19295_/Q _19322_/Q _13973_/A2 VSS _13969_/VNW VSS VSS gf180mcu_fd_sc_mcu9t5v0__nand2_1
X_19545_ _19545_/D _20057_/RN clkload11/I _19545_/Q VSS VSS VSS VSS gf180mcu_fd_sc_mcu9t5v0__dffrnq_1
X_15708_ _19919_/Q _15704_/Z _15708_/Z VSS VSS VSS VSS gf180mcu_fd_sc_mcu9t5v0__or2_1
XTAP_TAPCELL_ROW_199_3_8220 VSS VSS gf180mcu_fd_sc_mcu9t5v0__filltie
XTAP_TAPCELL_ROW_1_1000 VSS VSS gf180mcu_fd_sc_mcu9t5v0__filltie
XTAP_TAPCELL_ROW_1_1011 VSS VSS gf180mcu_fd_sc_mcu9t5v0__filltie
XTAP_TAPCELL_ROW_1_1022 VSS VSS gf180mcu_fd_sc_mcu9t5v0__filltie
X_16688_ _16688_/A1 _16688_/A2 _16688_/B _16688_/C _16689_/I1 VSS VSS VSS VSS gf180mcu_fd_sc_mcu9t5v0__oai211_1
X_19476_ _19476_/D _20052_/RN clkload14/I _19476_/Q VSS VSS VSS VSS gf180mcu_fd_sc_mcu9t5v0__dffrnq_1
X_18427_ _18427_/D _18509_/CLK _18427_/Q VSS VSS VSS VSS gf180mcu_fd_sc_mcu9t5v0__dffq_4
XPHY_EDGE_ROW_100_Right_100 VSS VSS gf180mcu_fd_sc_mcu9t5v0__endcap
X_15639_ _15639_/A1 _10192_/I _15640_/B VSS _15639_/VNW VSS VSS gf180mcu_fd_sc_mcu9t5v0__nand2_1
X_18358_ _18358_/D clkload77/I _18358_/Q VSS VSS VSS VSS gf180mcu_fd_sc_mcu9t5v0__dffq_1
X_09160_ _19810_/Q _13402_/A2 VSS VSS VSS VSS gf180mcu_fd_sc_mcu9t5v0__clkinv_1
X_17309_ _17412_/A1 _17309_/A2 _17412_/B _17310_/A2 VSS _17330_/VNW VSS VSS gf180mcu_fd_sc_mcu9t5v0__aoi21_1
X_18289_ _18289_/D clkload68/I _18289_/Q VSS VSS VSS VSS gf180mcu_fd_sc_mcu9t5v0__dffq_1
X_09091_ _18682_/Q _17880_/A1 VSS _09584_/VNW VSS VSS gf180mcu_fd_sc_mcu9t5v0__clkinv_1
XTAP_TAPCELL_ROW_179_3_8151 VSS VSS gf180mcu_fd_sc_mcu9t5v0__filltie
XPHY_EDGE_ROW_312_Right_239 VSS VSS gf180mcu_fd_sc_mcu9t5v0__endcap
XTAP_TAPCELL_ROW_70_2904 VSS VSS gf180mcu_fd_sc_mcu9t5v0__filltie
XTAP_TAPCELL_ROW_241_5711 VSS VSS gf180mcu_fd_sc_mcu9t5v0__filltie
XTAP_TAPCELL_ROW_241_5700 VSS VSS gf180mcu_fd_sc_mcu9t5v0__filltie
X_09993_ _19269_/Q _10166_/A2 _09994_/A3 VSS _09994_/VNW VSS VSS gf180mcu_fd_sc_mcu9t5v0__nand2_1
XTAP_TAPCELL_ROW_70_2915 VSS VSS gf180mcu_fd_sc_mcu9t5v0__filltie
XTAP_TAPCELL_ROW_55_2483 VSS VSS gf180mcu_fd_sc_mcu9t5v0__filltie
XTAP_TAPCELL_ROW_226_5290 VSS VSS gf180mcu_fd_sc_mcu9t5v0__filltie
XTAP_TAPCELL_ROW_55_2494 VSS VSS gf180mcu_fd_sc_mcu9t5v0__filltie
XTAP_TAPCELL_ROW_222_5176 VSS VSS gf180mcu_fd_sc_mcu9t5v0__filltie
XTAP_TAPCELL_ROW_222_5165 VSS VSS gf180mcu_fd_sc_mcu9t5v0__filltie
XTAP_TAPCELL_ROW_172_3_8127 VSS VSS gf180mcu_fd_sc_mcu9t5v0__filltie
XTAP_TAPCELL_ROW_8_1209 VSS VSS gf180mcu_fd_sc_mcu9t5v0__filltie
XTAP_TAPCELL_ROW_222_5187 VSS VSS gf180mcu_fd_sc_mcu9t5v0__filltie
XTAP_TAPCELL_ROW_239_5640 VSS VSS gf180mcu_fd_sc_mcu9t5v0__filltie
XTAP_TAPCELL_ROW_162_1_4751 VSS VSS gf180mcu_fd_sc_mcu9t5v0__filltie
XTAP_TAPCELL_ROW_68_2855 VSS VSS gf180mcu_fd_sc_mcu9t5v0__filltie
XTAP_TAPCELL_ROW_68_2844 VSS VSS gf180mcu_fd_sc_mcu9t5v0__filltie
XTAP_TAPCELL_ROW_239_5651 VSS VSS gf180mcu_fd_sc_mcu9t5v0__filltie
XTAP_TAPCELL_ROW_68_2866 VSS VSS gf180mcu_fd_sc_mcu9t5v0__filltie
Xrst_tree_mid_6 rst_tree_root/Z rst_tree_mid_6/Z VSS VSS VSS VSS gf180mcu_fd_sc_mcu9t5v0__clkbuf_16
XTAP_TAPCELL_ROW_235_5537 VSS VSS gf180mcu_fd_sc_mcu9t5v0__filltie
XTAP_TAPCELL_ROW_235_5526 VSS VSS gf180mcu_fd_sc_mcu9t5v0__filltie
X_09427_ _18691_/Q _18692_/Q _09888_/B1 VSS _09434_/VNW VSS VSS gf180mcu_fd_sc_mcu9t5v0__xnor2_4
X_09358_ _18266_/Q _16409_/A1 VSS VSS VSS VSS gf180mcu_fd_sc_mcu9t5v0__clkinv_1
X_11320_ _18874_/Q _11878_/A1 _11320_/B1 _11320_/B2 _11320_/C _11322_/A1 VSS VSS VSS
+ VSS gf180mcu_fd_sc_mcu9t5v0__oai221_1
X_09289_ _19250_/Q _16943_/A1 VSS VSS VSS VSS gf180mcu_fd_sc_mcu9t5v0__clkinv_1
XTAP_TAPCELL_ROW_211_4880 VSS VSS gf180mcu_fd_sc_mcu9t5v0__filltie
XTAP_TAPCELL_ROW_323_7991 VSS VSS gf180mcu_fd_sc_mcu9t5v0__filltie
XTAP_TAPCELL_ROW_323_7980 VSS VSS gf180mcu_fd_sc_mcu9t5v0__filltie
X_11251_ _11251_/A1 _11524_/S _11252_/C VSS _11251_/VNW VSS VSS gf180mcu_fd_sc_mcu9t5v0__nand2_1
X_10202_ _17763_/A2 _17763_/A3 _17761_/A2 VSS VSS VSS VSS gf180mcu_fd_sc_mcu9t5v0__nor2_1
X_11182_ _18864_/Q _12548_/A1 _11185_/A2 VSS _13056_/VNW VSS VSS gf180mcu_fd_sc_mcu9t5v0__nor2_1
X_10133_ _18945_/Q _10133_/A2 _10133_/B1 _19016_/Q _10137_/A1 VSS VSS VSS VSS gf180mcu_fd_sc_mcu9t5v0__aoi22_1
X_15990_ _15939_/B _15988_/C _15990_/B _16107_/C VSS VSS VSS VSS gf180mcu_fd_sc_mcu9t5v0__aoi21_4
X_10064_ _16234_/A1 _15959_/A1 _10064_/S _10064_/Z VSS VSS VSS VSS gf180mcu_fd_sc_mcu9t5v0__mux2_1
X_14941_ _19605_/Q _19361_/Q _20039_/D _19605_/D VSS _14941_/VNW VSS VSS gf180mcu_fd_sc_mcu9t5v0__mux2_1
XTAP_TAPCELL_ROW_292_7099 VSS VSS gf180mcu_fd_sc_mcu9t5v0__filltie
XTAP_TAPCELL_ROW_292_7088 VSS VSS gf180mcu_fd_sc_mcu9t5v0__filltie
X_17660_ _18623_/Q _18699_/Q _17685_/S _18699_/D VSS VSS VSS VSS gf180mcu_fd_sc_mcu9t5v0__mux2_1
XTAP_TAPCELL_ROW_123_4373 VSS VSS gf180mcu_fd_sc_mcu9t5v0__filltie
XTAP_TAPCELL_ROW_123_4362 VSS VSS gf180mcu_fd_sc_mcu9t5v0__filltie
X_14872_ _14872_/A1 _14872_/A2 _14872_/B _14876_/A1 VSS VSS VSS VSS gf180mcu_fd_sc_mcu9t5v0__oai21_1
XTAP_TAPCELL_ROW_317_7795 VSS VSS gf180mcu_fd_sc_mcu9t5v0__filltie
X_16611_ input7/Z _18784_/Q _16619_/S _16611_/Z VSS VSS VSS VSS gf180mcu_fd_sc_mcu9t5v0__mux2_1
XTAP_TAPCELL_ROW_317_7784 VSS VSS gf180mcu_fd_sc_mcu9t5v0__filltie
X_17591_ wire301/Z _18656_/Q _17597_/S _18656_/D VSS VSS VSS VSS gf180mcu_fd_sc_mcu9t5v0__mux2_1
X_13823_ _13823_/A1 _13823_/A2 _13823_/B1 _13823_/B2 _13838_/A2 VSS VSS VSS VSS gf180mcu_fd_sc_mcu9t5v0__oai22_1
X_16542_ _16541_/Z _18327_/Q _17054_/S _18327_/D VSS _16542_/VNW VSS VSS gf180mcu_fd_sc_mcu9t5v0__mux2_4
X_19330_ _19330_/D _20034_/RN clkload19/I _19330_/Q VSS VSS VSS VSS gf180mcu_fd_sc_mcu9t5v0__dffrnq_1
XPHY_EDGE_ROW_11_Left_335 VSS VSS gf180mcu_fd_sc_mcu9t5v0__endcap
XTAP_TAPCELL_ROW_185_3_8172 VSS VSS gf180mcu_fd_sc_mcu9t5v0__filltie
X_10966_ _18924_/Q _10967_/A1 _18042_/A2 _10966_/Z VSS VSS VSS VSS gf180mcu_fd_sc_mcu9t5v0__and3_1
X_13754_ _14223_/A2 _14166_/B _13754_/B1 _14387_/A1 _19300_/D VSS _13754_/VNW VSS
+ VSS gf180mcu_fd_sc_mcu9t5v0__aoi22_1
X_10897_ _19245_/Q _19251_/Q _18151_/S _10897_/Z VSS VSS VSS VSS gf180mcu_fd_sc_mcu9t5v0__mux2_1
X_16473_ _19242_/Q _16187_/C _16993_/S _16473_/Z VSS VSS VSS VSS gf180mcu_fd_sc_mcu9t5v0__mux2_1
X_12705_ _19187_/Q _12724_/C _12709_/B VSS VSS VSS VSS gf180mcu_fd_sc_mcu9t5v0__nand2_1
X_13685_ _13686_/A1 _13686_/A2 _14656_/B _13698_/B VSS _14656_/VNW VSS VSS gf180mcu_fd_sc_mcu9t5v0__oai21_1
X_19261_ _19261_/D _20029_/RN clkload28/I _19261_/Q VSS VSS VSS VSS gf180mcu_fd_sc_mcu9t5v0__dffrnq_1
X_18212_ _18212_/D clkload82/I _18212_/Q VSS VSS VSS VSS gf180mcu_fd_sc_mcu9t5v0__dffq_1
X_15424_ _19709_/Q _19809_/Q _15430_/S _19809_/D VSS _15424_/VNW VSS VSS gf180mcu_fd_sc_mcu9t5v0__mux2_1
XTAP_TAPCELL_ROW_132_4609 VSS VSS gf180mcu_fd_sc_mcu9t5v0__filltie
X_19192_ _19192_/D _19960_/RN clkload14/I _19192_/Q VSS VSS VSS VSS gf180mcu_fd_sc_mcu9t5v0__dffrnq_1
X_12636_ _12665_/B _12636_/A2 _12636_/B _12645_/C _12637_/C VSS VSS VSS VSS gf180mcu_fd_sc_mcu9t5v0__aoi211_1
X_18143_ _19216_/Q _19222_/Q _18147_/S _18143_/Z VSS VSS VSS VSS gf180mcu_fd_sc_mcu9t5v0__mux2_1
XPHY_EDGE_ROW_191_3_Right_306 VSS VSS gf180mcu_fd_sc_mcu9t5v0__endcap
XTAP_TAPCELL_ROW_78_3140 VSS VSS gf180mcu_fd_sc_mcu9t5v0__filltie
XTAP_TAPCELL_ROW_117_4199 VSS VSS gf180mcu_fd_sc_mcu9t5v0__filltie
XTAP_TAPCELL_ROW_117_4188 VSS VSS gf180mcu_fd_sc_mcu9t5v0__filltie
X_15355_ _19647_/Q _19624_/Q _15357_/A2 _15355_/Z VSS VSS VSS VSS gf180mcu_fd_sc_mcu9t5v0__xor3_1
X_12567_ _18450_/Q _12615_/A2 _12569_/B1 VSS VSS VSS VSS gf180mcu_fd_sc_mcu9t5v0__nor2_1
XTAP_TAPCELL_ROW_74_3026 VSS VSS gf180mcu_fd_sc_mcu9t5v0__filltie
XTAP_TAPCELL_ROW_74_3015 VSS VSS gf180mcu_fd_sc_mcu9t5v0__filltie
XTAP_TAPCELL_ROW_74_3004 VSS VSS gf180mcu_fd_sc_mcu9t5v0__filltie
X_14306_ _14355_/I0 _19379_/Q _14322_/S _19379_/D VSS VSS VSS VSS gf180mcu_fd_sc_mcu9t5v0__mux2_1
X_11518_ _18439_/Q _11485_/C _11521_/C VSS _11521_/VNW VSS VSS gf180mcu_fd_sc_mcu9t5v0__nand2_1
X_12498_ _18346_/Q _12382_/S _12502_/A2 VSS _12498_/VNW VSS VSS gf180mcu_fd_sc_mcu9t5v0__nor2_1
Xwire172 wire172/I wire172/Z VSS VSS VSS VSS gf180mcu_fd_sc_mcu9t5v0__buf_4
X_18074_ _18040_/Z _18074_/A2 _18074_/Z VSS VSS VSS VSS gf180mcu_fd_sc_mcu9t5v0__or2_1
X_15286_ _19635_/Q _19612_/Q _15300_/A1 VSS _15286_/VNW VSS VSS gf180mcu_fd_sc_mcu9t5v0__nand2_1
XPHY_EDGE_ROW_20_Left_344 VSS VSS gf180mcu_fd_sc_mcu9t5v0__endcap
X_17025_ _19259_/Q _16750_/B _17025_/S _17025_/Z VSS VSS VSS VSS gf180mcu_fd_sc_mcu9t5v0__mux2_1
X_11449_ _19098_/Q _11541_/A2 _11450_/A2 VSS VSS VSS VSS gf180mcu_fd_sc_mcu9t5v0__nand2_1
X_14237_ _14237_/A1 _14238_/A3 _14240_/A2 VSS _14240_/VNW VSS VSS gf180mcu_fd_sc_mcu9t5v0__nand2_1
Xclkbuf_leaf_82_clk_regs clkbuf_3_0_0_clk_regs/Z clkload17/I VSS VSS VSS VSS gf180mcu_fd_sc_mcu9t5v0__clkbuf_8
XTAP_TAPCELL_ROW_281_6792 VSS VSS gf180mcu_fd_sc_mcu9t5v0__filltie
Xclkbuf_leaf_11_clk_regs clkload3/I clkload48/I VSS VSS VSS VSS gf180mcu_fd_sc_mcu9t5v0__clkbuf_8
X_14168_ _14323_/A2 _14267_/A2 _14266_/S VSS VSS VSS VSS gf180mcu_fd_sc_mcu9t5v0__nand2_2
X_13119_ _13145_/A1 _13544_/A2 _13121_/A2 VSS VSS VSS VSS gf180mcu_fd_sc_mcu9t5v0__nand2_1
Xload_slew111 _14900_/S _15148_/S VSS VSS VSS VSS gf180mcu_fd_sc_mcu9t5v0__clkbuf_16
Xload_slew144 _12116_/C _12320_/C VSS VSS VSS VSS gf180mcu_fd_sc_mcu9t5v0__buf_8
X_18976_ _18976_/D _20064_/RN clkload67/I _18976_/Q VSS VSS VSS VSS gf180mcu_fd_sc_mcu9t5v0__dffrnq_1
X_14099_ _14099_/A1 _14063_/I _14099_/B _14099_/C _14102_/B VSS VSS VSS VSS gf180mcu_fd_sc_mcu9t5v0__oai211_1
X_17927_ _18847_/Q _17958_/A2 _17930_/B VSS _17927_/VNW VSS VSS gf180mcu_fd_sc_mcu9t5v0__nand2_1
Xload_slew177 _12734_/Z _13184_/A1 VSS VSS VSS VSS gf180mcu_fd_sc_mcu9t5v0__clkbuf_8
Xeco14_skew_2 clkload75/I _18516_/CLK VSS VSS VSS VSS gf180mcu_fd_sc_mcu9t5v0__clkbuf_16
X_17858_ _18827_/Q _17856_/Z _17861_/A2 VSS _17858_/VNW VSS VSS gf180mcu_fd_sc_mcu9t5v0__nor2_1
X_16809_ _19285_/Q _16634_/B _16809_/S _16809_/Z VSS VSS VSS VSS gf180mcu_fd_sc_mcu9t5v0__mux2_1
X_17789_ _17789_/A1 _17789_/A2 _18767_/D VSS _17789_/VNW VSS VSS gf180mcu_fd_sc_mcu9t5v0__nor2_1
XTAP_TAPCELL_ROW_106_3892 VSS VSS gf180mcu_fd_sc_mcu9t5v0__filltie
XTAP_TAPCELL_ROW_102_3789 VSS VSS gf180mcu_fd_sc_mcu9t5v0__filltie
X_19528_ _19528_/D _20040_/RN clkload12/I _19528_/Q VSS VSS VSS VSS gf180mcu_fd_sc_mcu9t5v0__dffrnq_1
XTAP_TAPCELL_ROW_102_3778 VSS VSS gf180mcu_fd_sc_mcu9t5v0__filltie
XTAP_TAPCELL_ROW_230_5401 VSS VSS gf180mcu_fd_sc_mcu9t5v0__filltie
X_19459_ _19459_/D _20035_/RN clkload15/I _19459_/Q VSS VSS VSS VSS gf180mcu_fd_sc_mcu9t5v0__dffrnq_1
XTAP_TAPCELL_ROW_288_6979 VSS VSS gf180mcu_fd_sc_mcu9t5v0__filltie
XTAP_TAPCELL_ROW_44_2184 VSS VSS gf180mcu_fd_sc_mcu9t5v0__filltie
X_09212_ _19566_/Q _15193_/A2 VSS _15198_/VNW VSS VSS gf180mcu_fd_sc_mcu9t5v0__clkinv_1
XTAP_TAPCELL_ROW_44_2195 VSS VSS gf180mcu_fd_sc_mcu9t5v0__filltie
X_09143_ _19736_/Q _13280_/A1 VSS VSS VSS VSS gf180mcu_fd_sc_mcu9t5v0__clkinv_1
X_09074_ _20021_/Q _09726_/A1 VSS _09074_/VNW VSS VSS gf180mcu_fd_sc_mcu9t5v0__clkinv_1
XTAP_TAPCELL_ROW_228_5352 VSS VSS gf180mcu_fd_sc_mcu9t5v0__filltie
XTAP_TAPCELL_ROW_228_5341 VSS VSS gf180mcu_fd_sc_mcu9t5v0__filltie
XTAP_TAPCELL_ROW_228_5330 VSS VSS gf180mcu_fd_sc_mcu9t5v0__filltie
XTAP_TAPCELL_ROW_57_2545 VSS VSS gf180mcu_fd_sc_mcu9t5v0__filltie
XTAP_TAPCELL_ROW_57_2556 VSS VSS gf180mcu_fd_sc_mcu9t5v0__filltie
XTAP_TAPCELL_ROW_224_5227 VSS VSS gf180mcu_fd_sc_mcu9t5v0__filltie
XTAP_TAPCELL_ROW_224_5238 VSS VSS gf180mcu_fd_sc_mcu9t5v0__filltie
X_09976_ _19237_/Q _09981_/B _09978_/A2 VSS VSS VSS VSS gf180mcu_fd_sc_mcu9t5v0__nor2_1
X_20096_ _20096_/D clkload59/I _20096_/Q VSS VSS VSS VSS gf180mcu_fd_sc_mcu9t5v0__dffq_1
XTAP_TAPCELL_ROW_191_3_8193 VSS VSS gf180mcu_fd_sc_mcu9t5v0__filltie
X_10820_ _17231_/A3 _10821_/A2 _10819_/Z _09721_/B _10820_/B2 _20062_/D VSS VSS VSS
+ VSS gf180mcu_fd_sc_mcu9t5v0__oai32_1
X_10751_ _18838_/Q _11600_/C _10751_/A3 _10751_/B _10761_/A1 VSS _10751_/VNW VSS VSS
+ gf180mcu_fd_sc_mcu9t5v0__oai31_1
X_13470_ _13497_/A1 _13470_/A2 _13497_/B _13471_/B2 VSS VSS VSS VSS gf180mcu_fd_sc_mcu9t5v0__aoi21_1
XTAP_TAPCELL_ROW_213_4931 VSS VSS gf180mcu_fd_sc_mcu9t5v0__filltie
X_10682_ _10681_/Z _18824_/Q _20030_/Q _10682_/Z VSS VSS VSS VSS gf180mcu_fd_sc_mcu9t5v0__mux2_4
XTAP_TAPCELL_ROW_213_4920 VSS VSS gf180mcu_fd_sc_mcu9t5v0__filltie
X_12421_ _12355_/I _12485_/A2 _12421_/A3 _12421_/B _19148_/D VSS VSS VSS VSS gf180mcu_fd_sc_mcu9t5v0__oai31_1
XTAP_TAPCELL_ROW_321_7906 VSS VSS gf180mcu_fd_sc_mcu9t5v0__filltie
XTAP_TAPCELL_ROW_112_4063 VSS VSS gf180mcu_fd_sc_mcu9t5v0__filltie
XTAP_TAPCELL_ROW_112_4052 VSS VSS gf180mcu_fd_sc_mcu9t5v0__filltie
X_15140_ _19682_/Q _19522_/Q _15163_/S _19682_/D VSS _15140_/VNW VSS VSS gf180mcu_fd_sc_mcu9t5v0__mux2_1
X_12352_ _12311_/B _12352_/A2 _12352_/A3 _12352_/B _19139_/D VSS VSS VSS VSS gf180mcu_fd_sc_mcu9t5v0__oai31_4
XTAP_TAPCELL_ROW_306_7496 VSS VSS gf180mcu_fd_sc_mcu9t5v0__filltie
X_12283_ _18421_/Q _12315_/S _12322_/B _12286_/A2 VSS _12286_/VNW VSS VSS gf180mcu_fd_sc_mcu9t5v0__aoi21_1
XTAP_TAPCELL_ROW_306_7485 VSS VSS gf180mcu_fd_sc_mcu9t5v0__filltie
XTAP_TAPCELL_ROW_306_7474 VSS VSS gf180mcu_fd_sc_mcu9t5v0__filltie
X_11303_ _18215_/Q _18199_/Q _11534_/S _11303_/Z VSS VSS VSS VSS gf180mcu_fd_sc_mcu9t5v0__mux2_1
XTAP_TAPCELL_ROW_112_4074 VSS VSS gf180mcu_fd_sc_mcu9t5v0__filltie
X_15071_ _19309_/Q _19394_/Q _15073_/A1 _15072_/I1 VSS _15073_/VNW VSS VSS gf180mcu_fd_sc_mcu9t5v0__xnor3_1
X_11234_ _18338_/Q _18322_/Q _11524_/S _11234_/Z VSS VSS VSS VSS gf180mcu_fd_sc_mcu9t5v0__mux2_1
XTAP_TAPCELL_ROW_298_7253 VSS VSS gf180mcu_fd_sc_mcu9t5v0__filltie
X_14022_ _14022_/A1 _14020_/I _14023_/I VSS _14022_/VNW VSS VSS gf180mcu_fd_sc_mcu9t5v0__xor2_1
XTAP_TAPCELL_ROW_298_7275 VSS VSS gf180mcu_fd_sc_mcu9t5v0__filltie
XTAP_TAPCELL_ROW_298_7264 VSS VSS gf180mcu_fd_sc_mcu9t5v0__filltie
X_18830_ _18830_/D _20046_/RN clkload38/I _18830_/Q VSS VSS VSS VSS gf180mcu_fd_sc_mcu9t5v0__dffrnq_1
XTAP_TAPCELL_ROW_125_4424 VSS VSS gf180mcu_fd_sc_mcu9t5v0__filltie
XTAP_TAPCELL_ROW_125_4413 VSS VSS gf180mcu_fd_sc_mcu9t5v0__filltie
X_11165_ _18863_/Q _12548_/A1 _11167_/A3 VSS VSS VSS VSS gf180mcu_fd_sc_mcu9t5v0__nor2_1
XTAP_TAPCELL_ROW_319_7846 VSS VSS gf180mcu_fd_sc_mcu9t5v0__filltie
XTAP_TAPCELL_ROW_319_7835 VSS VSS gf180mcu_fd_sc_mcu9t5v0__filltie
X_11096_ _11566_/A1 _11403_/S _11099_/B VSS _11096_/VNW VSS VSS gf180mcu_fd_sc_mcu9t5v0__nand2_1
X_10116_ _19242_/Q _10169_/B1 _10168_/B1 _19210_/Q _10118_/A2 VSS _10116_/VNW VSS
+ VSS gf180mcu_fd_sc_mcu9t5v0__aoi22_1
X_15973_ _16234_/A2 _15971_/Z _15973_/B _15988_/C _16197_/A2 VSS VSS VSS VSS gf180mcu_fd_sc_mcu9t5v0__oai211_4
X_18761_ _18761_/D _20041_/RN _20049_/CLK _18761_/Q VSS VSS VSS VSS gf180mcu_fd_sc_mcu9t5v0__dffrnq_1
X_17712_ _18732_/Q _17673_/S _17743_/B _18656_/Q _17713_/I VSS VSS VSS VSS gf180mcu_fd_sc_mcu9t5v0__aoi22_1
X_14924_ _14924_/A1 _14923_/B _14925_/I1 VSS _14924_/VNW VSS VSS gf180mcu_fd_sc_mcu9t5v0__xnor2_1
X_10047_ _10180_/B1 _10047_/A2 _10047_/A3 _10052_/B VSS VSS VSS VSS gf180mcu_fd_sc_mcu9t5v0__nand3_1
X_18692_ _18692_/D _09246_/I clkload25/I _18692_/Q VSS VSS VSS VSS gf180mcu_fd_sc_mcu9t5v0__dffrnq_4
X_17643_ _18690_/Q _17745_/A3 _17643_/B _18689_/D VSS VSS VSS VSS gf180mcu_fd_sc_mcu9t5v0__oai21_1
X_14855_ _19581_/Q _19342_/Q _15148_/S _19581_/D VSS VSS VSS VSS gf180mcu_fd_sc_mcu9t5v0__mux2_1
X_11998_ _12299_/S _11998_/A2 _12001_/A2 VSS VSS VSS VSS gf180mcu_fd_sc_mcu9t5v0__nand2_1
X_17574_ _17574_/A1 _17576_/A1 _18643_/D VSS VSS VSS VSS gf180mcu_fd_sc_mcu9t5v0__nand2_1
X_13806_ _13807_/A1 _13805_/Z _13836_/A1 VSS VSS VSS VSS gf180mcu_fd_sc_mcu9t5v0__nand2_1
X_14786_ _14786_/A1 _14786_/A2 _14786_/B _14790_/A1 VSS VSS VSS VSS gf180mcu_fd_sc_mcu9t5v0__oai21_1
XTAP_TAPCELL_ROW_270_6493 VSS VSS gf180mcu_fd_sc_mcu9t5v0__filltie
X_16525_ _16147_/C _19234_/Q _17055_/S _16525_/Z VSS VSS VSS VSS gf180mcu_fd_sc_mcu9t5v0__mux2_1
XTAP_TAPCELL_ROW_270_6482 VSS VSS gf180mcu_fd_sc_mcu9t5v0__filltie
X_10949_ _18930_/Q _18937_/Q _10952_/A2 VSS _10994_/VNW VSS VSS gf180mcu_fd_sc_mcu9t5v0__xnor2_1
X_13737_ _13737_/A1 _19113_/Q _13738_/B VSS _14670_/VNW VSS VSS gf180mcu_fd_sc_mcu9t5v0__nand2_1
X_19313_ _19313_/D _20145_/RN clkload20/I _19313_/Q VSS VSS VSS VSS gf180mcu_fd_sc_mcu9t5v0__dffrnq_1
X_16456_ _18286_/Q _16455_/Z _16986_/S _18286_/D VSS VSS VSS VSS gf180mcu_fd_sc_mcu9t5v0__mux2_4
X_19244_ _19244_/D _20140_/RN clkload25/I _19244_/Q VSS VSS VSS VSS gf180mcu_fd_sc_mcu9t5v0__dffrnq_2
X_13668_ _19108_/Q _13668_/I1 _14475_/B _13668_/Z VSS _13668_/VNW VSS VSS gf180mcu_fd_sc_mcu9t5v0__mux2_1
X_15407_ _19692_/Q _19792_/Q _15430_/S _19792_/D VSS VSS VSS VSS gf180mcu_fd_sc_mcu9t5v0__mux2_1
X_16387_ _16058_/B _19236_/Q _16927_/S _16387_/Z VSS VSS VSS VSS gf180mcu_fd_sc_mcu9t5v0__mux2_1
XPHY_EDGE_ROW_192_3_Right_307 VSS VSS gf180mcu_fd_sc_mcu9t5v0__endcap
X_12619_ _19173_/Q _12620_/A1 _12620_/B VSS VSS VSS VSS gf180mcu_fd_sc_mcu9t5v0__nand2_1
X_19175_ _19175_/D _20071_/RN clkload12/I _19175_/Q VSS VSS VSS VSS gf180mcu_fd_sc_mcu9t5v0__dffrnq_1
X_13599_ _13599_/A1 _13599_/A2 _13599_/B _13603_/B VSS VSS VSS VSS gf180mcu_fd_sc_mcu9t5v0__oai21_1
XTAP_TAPCELL_ROW_283_6865 VSS VSS gf180mcu_fd_sc_mcu9t5v0__filltie
XTAP_TAPCELL_ROW_283_6854 VSS VSS gf180mcu_fd_sc_mcu9t5v0__filltie
XTAP_TAPCELL_ROW_283_6843 VSS VSS gf180mcu_fd_sc_mcu9t5v0__filltie
X_18126_ _18126_/A1 _18147_/S _18132_/B _18127_/I0 VSS VSS VSS VSS gf180mcu_fd_sc_mcu9t5v0__oai21_1
X_15338_ _19744_/Q _15338_/I1 _15364_/S _19744_/D VSS _15338_/VNW VSS VSS gf180mcu_fd_sc_mcu9t5v0__mux2_1
X_18057_ _18924_/Q _18923_/Q _18057_/A3 _18079_/A1 _18060_/A2 VSS VSS VSS VSS gf180mcu_fd_sc_mcu9t5v0__nand4_1
X_15269_ _19603_/Q _19580_/Q _15269_/A3 _15270_/I1 VSS VSS VSS VSS gf180mcu_fd_sc_mcu9t5v0__xnor3_1
X_17008_ _18495_/Q _17007_/Z _17020_/S _18495_/D VSS VSS VSS VSS gf180mcu_fd_sc_mcu9t5v0__mux2_4
XTAP_TAPCELL_ROW_52_2420 VSS VSS gf180mcu_fd_sc_mcu9t5v0__filltie
X_09830_ _09826_/C _09830_/A2 _20025_/Q _09831_/B VSS VSS VSS VSS gf180mcu_fd_sc_mcu9t5v0__oai21_1
X_18959_ _18959_/D _20047_/RN clkload70/I _18959_/Q VSS VSS VSS VSS gf180mcu_fd_sc_mcu9t5v0__dffrnq_1
X_09761_ _09761_/A1 _17627_/A1 _09761_/A3 _09761_/A4 _20013_/D VSS VSS VSS VSS gf180mcu_fd_sc_mcu9t5v0__nand4_1
XTAP_TAPCELL_ROW_108_3965 VSS VSS gf180mcu_fd_sc_mcu9t5v0__filltie
XTAP_TAPCELL_ROW_108_3954 VSS VSS gf180mcu_fd_sc_mcu9t5v0__filltie
XTAP_TAPCELL_ROW_108_3943 VSS VSS gf180mcu_fd_sc_mcu9t5v0__filltie
X_09692_ _09692_/I _17430_/B VSS VSS VSS VSS gf180mcu_fd_sc_mcu9t5v0__clkinv_1
XTAP_TAPCELL_ROW_104_3829 VSS VSS gf180mcu_fd_sc_mcu9t5v0__filltie
XTAP_TAPCELL_ROW_217_5042 VSS VSS gf180mcu_fd_sc_mcu9t5v0__filltie
XTAP_TAPCELL_ROW_217_5031 VSS VSS gf180mcu_fd_sc_mcu9t5v0__filltie
XTAP_TAPCELL_ROW_46_2235 VSS VSS gf180mcu_fd_sc_mcu9t5v0__filltie
XTAP_TAPCELL_ROW_46_2246 VSS VSS gf180mcu_fd_sc_mcu9t5v0__filltie
XTAP_TAPCELL_ROW_46_2257 VSS VSS gf180mcu_fd_sc_mcu9t5v0__filltie
XTAP_TAPCELL_ROW_59_2607 VSS VSS gf180mcu_fd_sc_mcu9t5v0__filltie
XTAP_TAPCELL_ROW_59_2618 VSS VSS gf180mcu_fd_sc_mcu9t5v0__filltie
X_09126_ _19791_/Q _13071_/A2 VSS _09126_/VNW VSS VSS gf180mcu_fd_sc_mcu9t5v0__clkinv_1
XTAP_TAPCELL_ROW_301_7360 VSS VSS gf180mcu_fd_sc_mcu9t5v0__filltie
XTAP_TAPCELL_ROW_35_1950 VSS VSS gf180mcu_fd_sc_mcu9t5v0__filltie
X_09959_ _18802_/Q _18799_/Q _18800_/Q _18798_/Q _09961_/A2 VSS VSS VSS VSS gf180mcu_fd_sc_mcu9t5v0__nor4_1
XTAP_TAPCELL_ROW_31_1825 VSS VSS gf180mcu_fd_sc_mcu9t5v0__filltie
XTAP_TAPCELL_ROW_31_1836 VSS VSS gf180mcu_fd_sc_mcu9t5v0__filltie
XTAP_TAPCELL_ROW_314_7710 VSS VSS gf180mcu_fd_sc_mcu9t5v0__filltie
X_20079_ _20079_/D clkload59/I _20079_/Q VSS VSS VSS VSS gf180mcu_fd_sc_mcu9t5v0__dffq_1
XTAP_TAPCELL_ROW_31_1847 VSS VSS gf180mcu_fd_sc_mcu9t5v0__filltie
X_12970_ _12735_/B _19750_/Q _12970_/B _12978_/A2 VSS _12973_/VNW VSS VSS gf180mcu_fd_sc_mcu9t5v0__oai21_1
X_11921_ _11921_/A1 _11921_/A2 _11921_/B1 _11921_/B2 _12320_/C _11922_/A3 VSS _12448_/VNW
+ VSS VSS gf180mcu_fd_sc_mcu9t5v0__aoi221_1
XTAP_TAPCELL_ROW_310_7607 VSS VSS gf180mcu_fd_sc_mcu9t5v0__filltie
X_11852_ _18719_/Q wire198/Z wire213/Z _11853_/B VSS VSS VSS VSS gf180mcu_fd_sc_mcu9t5v0__aoi21_1
X_14640_ _19102_/Q _19518_/Q _14730_/S _19518_/D VSS VSS VSS VSS gf180mcu_fd_sc_mcu9t5v0__mux2_1
X_10803_ _10798_/Z _10803_/A2 _10803_/B _10803_/C _10807_/A2 VSS VSS VSS VSS gf180mcu_fd_sc_mcu9t5v0__oai211_1
X_14571_ _14581_/A1 _14756_/A1 _14590_/B _14572_/B VSS VSS VSS VSS gf180mcu_fd_sc_mcu9t5v0__aoi21_1
X_11783_ _18270_/Q _12203_/A2 _12159_/B _11784_/B2 VSS _11783_/VNW VSS VSS gf180mcu_fd_sc_mcu9t5v0__aoi21_1
X_16310_ _18220_/Q _16309_/Z _16840_/S _18220_/D VSS VSS VSS VSS gf180mcu_fd_sc_mcu9t5v0__mux2_1
X_13522_ _13043_/I _13525_/A2 _13521_/Z _13522_/B _19265_/D VSS VSS VSS VSS gf180mcu_fd_sc_mcu9t5v0__oai31_1
XTAP_TAPCELL_ROW_29_1776 VSS VSS gf180mcu_fd_sc_mcu9t5v0__filltie
XTAP_TAPCELL_ROW_29_1787 VSS VSS gf180mcu_fd_sc_mcu9t5v0__filltie
X_17290_ _17412_/A1 _17290_/A2 _17412_/B _17291_/A2 VSS VSS VSS VSS gf180mcu_fd_sc_mcu9t5v0__aoi21_1
XTAP_TAPCELL_ROW_114_4114 VSS VSS gf180mcu_fd_sc_mcu9t5v0__filltie
X_10734_ _10709_/Z _10734_/A2 _10734_/B _10751_/B VSS VSS VSS VSS gf180mcu_fd_sc_mcu9t5v0__oai21_1
XTAP_TAPCELL_ROW_308_7547 VSS VSS gf180mcu_fd_sc_mcu9t5v0__filltie
XTAP_TAPCELL_ROW_308_7536 VSS VSS gf180mcu_fd_sc_mcu9t5v0__filltie
X_10665_ _19818_/Q _10389_/C _10665_/B1 _10821_/B _17412_/B _10667_/A2 VSS VSS VSS
+ VSS gf180mcu_fd_sc_mcu9t5v0__aoi221_4
X_16241_ _19261_/Q _16932_/A2 _16243_/A1 VSS VSS VSS VSS gf180mcu_fd_sc_mcu9t5v0__nand2_1
XTAP_TAPCELL_ROW_114_4125 VSS VSS gf180mcu_fd_sc_mcu9t5v0__filltie
X_13453_ _13453_/A1 _13453_/A2 _13453_/B _13466_/A2 VSS _13453_/VNW VSS VSS gf180mcu_fd_sc_mcu9t5v0__aoi21_1
X_16172_ _16751_/A2 _16751_/A3 _16751_/B _16172_/C _16174_/B VSS VSS VSS VSS gf180mcu_fd_sc_mcu9t5v0__oai211_1
X_12404_ _18159_/Q _12382_/S _12408_/A2 VSS _12404_/VNW VSS VSS gf180mcu_fd_sc_mcu9t5v0__nor2_1
X_13384_ _13403_/A1 _13403_/A2 _13388_/A3 VSS VSS VSS VSS gf180mcu_fd_sc_mcu9t5v0__nor2_1
X_10596_ _18600_/Q _17306_/C _10596_/B _10648_/C _10597_/A3 VSS VSS VSS VSS gf180mcu_fd_sc_mcu9t5v0__aoi211_1
X_15123_ _19665_/Q _19505_/Q wire108/Z _19665_/D VSS VSS VSS VSS gf180mcu_fd_sc_mcu9t5v0__mux2_1
X_12335_ _19139_/Q _12311_/B _12352_/B VSS VSS VSS VSS gf180mcu_fd_sc_mcu9t5v0__nand2_1
XTAP_TAPCELL_ROW_209_4819 VSS VSS gf180mcu_fd_sc_mcu9t5v0__filltie
XTAP_TAPCELL_ROW_209_4808 VSS VSS gf180mcu_fd_sc_mcu9t5v0__filltie
X_12266_ _12266_/A1 _12266_/A2 _12266_/B1 _12266_/B2 _12320_/C _12269_/B VSS _12266_/VNW
+ VSS VSS gf180mcu_fd_sc_mcu9t5v0__aoi221_1
X_19931_ _19931_/D _20059_/RN clkload49/I _19931_/Q VSS VSS VSS VSS gf180mcu_fd_sc_mcu9t5v0__dffrnq_1
X_15054_ _15055_/A1 _15055_/A2 _15058_/B VSS VSS VSS VSS gf180mcu_fd_sc_mcu9t5v0__nor2_1
X_12197_ _18369_/Q _18353_/Q _12315_/S _12197_/Z VSS VSS VSS VSS gf180mcu_fd_sc_mcu9t5v0__mux2_1
X_11217_ _18257_/Q _11509_/A2 _11219_/A1 VSS VSS VSS VSS gf180mcu_fd_sc_mcu9t5v0__nor2_1
X_19862_ _19862_/D _20054_/RN clkload59/I _19862_/Q VSS VSS VSS VSS gf180mcu_fd_sc_mcu9t5v0__dffrnq_1
X_14005_ _14006_/A2 _14036_/A2 _14004_/Z _14036_/A3 VSS VSS VSS VSS gf180mcu_fd_sc_mcu9t5v0__nor3_1
X_11148_ wire283/I _11148_/A2 _11148_/B1 _11148_/B2 _11150_/B2 VSS VSS VSS VSS gf180mcu_fd_sc_mcu9t5v0__aoi22_1
X_18813_ _18813_/D _20029_/RN clkload34/I _18813_/Q VSS VSS VSS VSS gf180mcu_fd_sc_mcu9t5v0__dffrnq_1
X_19793_ _19793_/D _20049_/RN clkload29/I _19793_/Q VSS VSS VSS VSS gf180mcu_fd_sc_mcu9t5v0__dffrnq_1
X_15956_ _16297_/B2 _16198_/A2 _15962_/B2 VSS VSS VSS VSS gf180mcu_fd_sc_mcu9t5v0__nor2_2
X_11079_ _18567_/Q wire175/I _20058_/D _11385_/A2 VSS VSS VSS VSS gf180mcu_fd_sc_mcu9t5v0__aoi21_2
X_18744_ _18744_/D clkload54/I _18744_/Q VSS VSS VSS VSS gf180mcu_fd_sc_mcu9t5v0__dffq_1
XTAP_TAPCELL_ROW_272_6555 VSS VSS gf180mcu_fd_sc_mcu9t5v0__filltie
XTAP_TAPCELL_ROW_272_6544 VSS VSS gf180mcu_fd_sc_mcu9t5v0__filltie
X_15887_ _20096_/Q _19231_/Q _15920_/S _20096_/D VSS VSS VSS VSS gf180mcu_fd_sc_mcu9t5v0__mux2_1
X_18675_ _18675_/D _20143_/RN clkload50/I _18675_/Q VSS VSS VSS VSS gf180mcu_fd_sc_mcu9t5v0__dffrnq_1
X_14907_ _14907_/A1 _14907_/A2 _14907_/B _14911_/A1 VSS VSS VSS VSS gf180mcu_fd_sc_mcu9t5v0__oai21_1
X_17626_ _18664_/Q _20142_/Q _17627_/A2 VSS VSS VSS VSS gf180mcu_fd_sc_mcu9t5v0__nor2_1
X_14838_ _14838_/A1 _14837_/B _14839_/I1 VSS VSS VSS VSS gf180mcu_fd_sc_mcu9t5v0__xnor2_1
XPHY_EDGE_ROW_144_3_Left_802 VSS VSS gf180mcu_fd_sc_mcu9t5v0__endcap
X_17557_ _17582_/I1 _18640_/Q _17571_/S _18640_/D VSS VSS VSS VSS gf180mcu_fd_sc_mcu9t5v0__mux2_1
XTAP_TAPCELL_ROW_41_2110 VSS VSS gf180mcu_fd_sc_mcu9t5v0__filltie
X_14769_ _19557_/Q _19439_/Q _15163_/S _19557_/D VSS VSS VSS VSS gf180mcu_fd_sc_mcu9t5v0__mux2_1
XTAP_TAPCELL_ROW_285_6916 VSS VSS gf180mcu_fd_sc_mcu9t5v0__filltie
XTAP_TAPCELL_ROW_285_6905 VSS VSS gf180mcu_fd_sc_mcu9t5v0__filltie
X_17488_ _18593_/Q _19234_/Q _17511_/S _18593_/D VSS VSS VSS VSS gf180mcu_fd_sc_mcu9t5v0__mux2_1
X_16508_ _18311_/Q _16507_/Z _17026_/S _18311_/D VSS VSS VSS VSS gf180mcu_fd_sc_mcu9t5v0__mux2_1
XTAP_TAPCELL_ROW_41_2121 VSS VSS gf180mcu_fd_sc_mcu9t5v0__filltie
X_16439_ _16439_/I0 _18280_/Q _16958_/S _18280_/D VSS VSS VSS VSS gf180mcu_fd_sc_mcu9t5v0__mux2_4
X_19227_ _19227_/D _20059_/RN clkload43/I _19227_/Q VSS VSS VSS VSS gf180mcu_fd_sc_mcu9t5v0__dffrnq_1
XTAP_TAPCELL_ROW_99_3699 VSS VSS gf180mcu_fd_sc_mcu9t5v0__filltie
XPHY_EDGE_ROW_206_3_Left_864 VSS VSS gf180mcu_fd_sc_mcu9t5v0__endcap
X_19158_ _19158_/D _20054_/RN clkload28/I _19158_/Q VSS VSS VSS VSS gf180mcu_fd_sc_mcu9t5v0__dffrnq_1
X_18109_ _19205_/Q _19199_/Q _18117_/S _18109_/Z VSS _18109_/VNW VSS VSS gf180mcu_fd_sc_mcu9t5v0__mux2_1
XPHY_EDGE_ROW_193_3_Right_308 VSS VSS gf180mcu_fd_sc_mcu9t5v0__endcap
XPHY_EDGE_ROW_140_1_Left_463 VSS VSS gf180mcu_fd_sc_mcu9t5v0__endcap
XTAP_TAPCELL_ROW_39_2050 VSS VSS gf180mcu_fd_sc_mcu9t5v0__filltie
XTAP_TAPCELL_ROW_39_2061 VSS VSS gf180mcu_fd_sc_mcu9t5v0__filltie
X_19089_ _19089_/D _20049_/RN clkload27/I _19089_/Q VSS VSS VSS VSS gf180mcu_fd_sc_mcu9t5v0__dffrnq_1
X_20002_ _20002_/D _20066_/RN _20054_/CLK _20002_/Q VSS VSS VSS VSS gf180mcu_fd_sc_mcu9t5v0__dffrnq_1
X_09813_ _17909_/A1 _17886_/A2 _09825_/A2 VSS _17891_/VNW VSS VSS gf180mcu_fd_sc_mcu9t5v0__nand2_1
XPHY_EDGE_ROW_139_3_Left_797 VSS VSS gf180mcu_fd_sc_mcu9t5v0__endcap
X_09744_ _20069_/Q _10834_/A2 _09745_/I VSS VSS VSS VSS gf180mcu_fd_sc_mcu9t5v0__nand2_1
XTAP_TAPCELL_ROW_219_5104 VSS VSS gf180mcu_fd_sc_mcu9t5v0__filltie
X_09675_ _09675_/A1 _09675_/A2 _09675_/B _19996_/Q _09680_/A2 VSS _09675_/VNW VSS
+ VSS gf180mcu_fd_sc_mcu9t5v0__oai211_1
XTAP_TAPCELL_ROW_48_2308 VSS VSS gf180mcu_fd_sc_mcu9t5v0__filltie
XTAP_TAPCELL_ROW_11_1290 VSS VSS gf180mcu_fd_sc_mcu9t5v0__filltie
XTAP_TAPCELL_ROW_198_3_8216 VSS VSS gf180mcu_fd_sc_mcu9t5v0__filltie
XTAP_TAPCELL_ROW_24_1640 VSS VSS gf180mcu_fd_sc_mcu9t5v0__filltie
XTAP_TAPCELL_ROW_24_1651 VSS VSS gf180mcu_fd_sc_mcu9t5v0__filltie
X_10450_ _18994_/Q _10654_/A2 _10450_/B wire160/Z _10452_/B1 VSS VSS VSS VSS gf180mcu_fd_sc_mcu9t5v0__oai211_1
XTAP_TAPCELL_ROW_303_7400 VSS VSS gf180mcu_fd_sc_mcu9t5v0__filltie
XTAP_TAPCELL_ROW_178_3_8147 VSS VSS gf180mcu_fd_sc_mcu9t5v0__filltie
XTAP_TAPCELL_ROW_20_1526 VSS VSS gf180mcu_fd_sc_mcu9t5v0__filltie
XTAP_TAPCELL_ROW_20_1537 VSS VSS gf180mcu_fd_sc_mcu9t5v0__filltie
X_09109_ _19436_/Q _15020_/A2 VSS VSS VSS VSS gf180mcu_fd_sc_mcu9t5v0__clkinv_1
XTAP_TAPCELL_ROW_303_7411 VSS VSS gf180mcu_fd_sc_mcu9t5v0__filltie
X_10381_ _17198_/A1 _10381_/A2 _10381_/A3 _10381_/B _10382_/B1 VSS VSS VSS VSS gf180mcu_fd_sc_mcu9t5v0__oai31_1
XTAP_TAPCELL_ROW_203_3_8234 VSS VSS gf180mcu_fd_sc_mcu9t5v0__filltie
X_12120_ _12120_/A1 _12120_/A2 _12120_/B1 _12120_/B2 _12121_/B VSS VSS VSS VSS gf180mcu_fd_sc_mcu9t5v0__aoi22_2
X_12051_ _18722_/Q _12527_/A2 wire208/Z _12051_/B2 _12052_/A2 VSS VSS VSS VSS gf180mcu_fd_sc_mcu9t5v0__aoi22_2
X_11002_ _18925_/Q _11002_/A2 _11003_/B VSS VSS VSS VSS gf180mcu_fd_sc_mcu9t5v0__nor2_1
XTAP_TAPCELL_ROW_18_1466 VSS VSS gf180mcu_fd_sc_mcu9t5v0__filltie
XTAP_TAPCELL_ROW_158_3_8078 VSS VSS gf180mcu_fd_sc_mcu9t5v0__filltie
XTAP_TAPCELL_ROW_18_1477 VSS VSS gf180mcu_fd_sc_mcu9t5v0__filltie
XTAP_TAPCELL_ROW_18_1488 VSS VSS gf180mcu_fd_sc_mcu9t5v0__filltie
X_16790_ _16787_/S _16576_/B _16933_/A1 VSS VSS VSS VSS gf180mcu_fd_sc_mcu9t5v0__nand2_1
X_15810_ input7/Z _19979_/Q _15811_/S _19979_/D VSS VSS VSS VSS gf180mcu_fd_sc_mcu9t5v0__mux2_1
X_15741_ _19924_/Q _19925_/Q _19926_/Q _19927_/Q _15742_/A2 VSS _15741_/VNW VSS VSS
+ gf180mcu_fd_sc_mcu9t5v0__oai31_1
X_12953_ _19784_/Q _19750_/Q _13503_/A2 VSS VSS VSS VSS gf180mcu_fd_sc_mcu9t5v0__xnor2_1
XTAP_TAPCELL_ROW_289_7016 VSS VSS gf180mcu_fd_sc_mcu9t5v0__filltie
X_18460_ _18460_/D clkload60/I _18460_/Q VSS VSS VSS VSS gf180mcu_fd_sc_mcu9t5v0__dffq_1
XTAP_TAPCELL_ROW_289_7005 VSS VSS gf180mcu_fd_sc_mcu9t5v0__filltie
X_15672_ _15672_/A1 _15674_/A2 _15672_/B _19910_/D VSS VSS VSS VSS gf180mcu_fd_sc_mcu9t5v0__aoi21_1
X_11904_ _11904_/A1 _11904_/A2 _19117_/D VSS VSS VSS VSS gf180mcu_fd_sc_mcu9t5v0__nand2_1
XTAP_TAPCELL_ROW_289_7027 VSS VSS gf180mcu_fd_sc_mcu9t5v0__filltie
X_17411_ _17411_/A1 _17411_/A2 _17411_/B _17411_/C _17412_/A2 VSS VSS VSS VSS gf180mcu_fd_sc_mcu9t5v0__oai211_1
X_14623_ _19084_/Q _19501_/Q _14730_/S _19501_/D VSS VSS VSS VSS gf180mcu_fd_sc_mcu9t5v0__mux2_1
X_12884_ _12884_/A1 _12884_/A2 _12884_/Z VSS VSS VSS VSS gf180mcu_fd_sc_mcu9t5v0__xor2_1
X_18391_ _18391_/D clkload78/I _18391_/Q VSS VSS VSS VSS gf180mcu_fd_sc_mcu9t5v0__dffq_1
X_11835_ _11835_/A1 _11835_/A2 _11835_/B _12028_/C _11836_/B VSS VSS VSS VSS gf180mcu_fd_sc_mcu9t5v0__oai211_4
X_17342_ _17260_/S _18533_/Q _17344_/A3 VSS VSS VSS VSS gf180mcu_fd_sc_mcu9t5v0__nor2_1
X_11766_ _12147_/S _11766_/A2 _11966_/B _11767_/B2 VSS VSS VSS VSS gf180mcu_fd_sc_mcu9t5v0__aoi21_1
X_14554_ _19135_/Q wire199/Z _14764_/B _14554_/C _14555_/A2 VSS VSS VSS VSS gf180mcu_fd_sc_mcu9t5v0__oai211_1
X_17273_ _18530_/Q _18514_/Q _17404_/S _17273_/Z VSS VSS VSS VSS gf180mcu_fd_sc_mcu9t5v0__mux2_1
X_10717_ _19936_/Q _19888_/Q _20043_/Q _10717_/Z VSS VSS VSS VSS gf180mcu_fd_sc_mcu9t5v0__mux2_1
X_14485_ _19460_/Q _14715_/S _14486_/B VSS VSS VSS VSS gf180mcu_fd_sc_mcu9t5v0__nand2_1
X_13505_ _19262_/Q _13304_/B _13509_/B VSS VSS VSS VSS gf180mcu_fd_sc_mcu9t5v0__nand2_1
X_16224_ _16177_/C _19272_/Q _16785_/S _16224_/Z VSS VSS VSS VSS gf180mcu_fd_sc_mcu9t5v0__mux2_1
X_11697_ _11697_/A1 _11697_/A2 _11697_/Z VSS VSS VSS VSS gf180mcu_fd_sc_mcu9t5v0__or2_1
X_19012_ _19012_/D _20036_/RN clkload38/I _19012_/Q VSS VSS VSS VSS gf180mcu_fd_sc_mcu9t5v0__dffrnq_1
X_13436_ _19745_/Q _19777_/Q _13453_/A1 _13437_/A2 VSS VSS VSS VSS gf180mcu_fd_sc_mcu9t5v0__xnor3_1
X_10648_ _18602_/Q _17306_/C _10648_/B1 _10648_/B2 _10648_/C _10649_/A3 VSS VSS VSS
+ VSS gf180mcu_fd_sc_mcu9t5v0__aoi221_1
XTAP_TAPCELL_ROW_94_3574 VSS VSS gf180mcu_fd_sc_mcu9t5v0__filltie
XTAP_TAPCELL_ROW_94_3563 VSS VSS gf180mcu_fd_sc_mcu9t5v0__filltie
X_16155_ _18176_/Q _16155_/I1 _16707_/S _18176_/D VSS VSS VSS VSS gf180mcu_fd_sc_mcu9t5v0__mux2_4
XTAP_TAPCELL_ROW_265_6370 VSS VSS gf180mcu_fd_sc_mcu9t5v0__filltie
X_10579_ _20091_/Q _17408_/B _10595_/A1 VSS VSS VSS VSS gf180mcu_fd_sc_mcu9t5v0__nand2_1
X_13367_ _13403_/A2 _13366_/Z _13373_/A2 VSS VSS VSS VSS gf180mcu_fd_sc_mcu9t5v0__nor2_1
XTAP_TAPCELL_ROW_90_3449 VSS VSS gf180mcu_fd_sc_mcu9t5v0__filltie
X_12318_ _18503_/Q _12345_/A2 _12319_/A3 VSS _16926_/VNW VSS VSS gf180mcu_fd_sc_mcu9t5v0__nand2_1
XTAP_TAPCELL_ROW_261_6256 VSS VSS gf180mcu_fd_sc_mcu9t5v0__filltie
XTAP_TAPCELL_ROW_261_6245 VSS VSS gf180mcu_fd_sc_mcu9t5v0__filltie
X_16086_ _18130_/A1 _16672_/A2 _16098_/B _16182_/B VSS VSS VSS VSS gf180mcu_fd_sc_mcu9t5v0__oai21_4
X_13298_ _12734_/Z _13313_/A2 _13299_/A2 VSS VSS VSS VSS gf180mcu_fd_sc_mcu9t5v0__nor2_1
X_15106_ _19395_/Q _19315_/Q _15106_/A3 _15106_/Z VSS VSS VSS VSS gf180mcu_fd_sc_mcu9t5v0__xor3_1
X_12249_ _12348_/C _12249_/A2 _12250_/B2 VSS VSS VSS VSS gf180mcu_fd_sc_mcu9t5v0__nand2_1
X_19914_ _19914_/D _20042_/RN clkload49/I _19914_/Q VSS VSS VSS VSS gf180mcu_fd_sc_mcu9t5v0__dffrnq_1
X_15037_ _19303_/Q _19388_/Q _15041_/B VSS VSS VSS VSS gf180mcu_fd_sc_mcu9t5v0__nand2_1
XTAP_TAPCELL_ROW_278_6720 VSS VSS gf180mcu_fd_sc_mcu9t5v0__filltie
XTAP_TAPCELL_ROW_274_6606 VSS VSS gf180mcu_fd_sc_mcu9t5v0__filltie
X_19845_ _19845_/D _20037_/RN clkload51/I _19845_/Q VSS VSS VSS VSS gf180mcu_fd_sc_mcu9t5v0__dffrnq_1
XTAP_TAPCELL_ROW_274_6617 VSS VSS gf180mcu_fd_sc_mcu9t5v0__filltie
X_16988_ _18485_/Q _16987_/Z wire28/Z _18485_/D VSS _16988_/VNW VSS VSS gf180mcu_fd_sc_mcu9t5v0__mux2_4
XPHY_EDGE_ROW_299_Left_622 VSS VSS gf180mcu_fd_sc_mcu9t5v0__endcap
XTAP_TAPCELL_ROW_259_6185 VSS VSS gf180mcu_fd_sc_mcu9t5v0__filltie
X_19776_ _19776_/D _09246_/I clkload43/I _19776_/Q VSS VSS VSS VSS gf180mcu_fd_sc_mcu9t5v0__dffrnq_1
XPHY_EDGE_ROW_3_Left_327 VSS VSS gf180mcu_fd_sc_mcu9t5v0__endcap
XTAP_TAPCELL_ROW_88_3389 VSS VSS gf180mcu_fd_sc_mcu9t5v0__filltie
XTAP_TAPCELL_ROW_259_6196 VSS VSS gf180mcu_fd_sc_mcu9t5v0__filltie
X_15939_ _15973_/B _15988_/C _15939_/B _15963_/A1 VSS VSS VSS VSS gf180mcu_fd_sc_mcu9t5v0__aoi21_4
X_18727_ _18727_/D clkload54/I _18727_/Q VSS VSS VSS VSS gf180mcu_fd_sc_mcu9t5v0__dffq_1
X_09460_ _13763_/S _14139_/S VSS VSS VSS VSS gf180mcu_fd_sc_mcu9t5v0__clkinv_8
X_18658_ _18658_/D _20062_/RN clkload47/I _18658_/Q VSS VSS VSS VSS gf180mcu_fd_sc_mcu9t5v0__dffrnq_1
X_18589_ _18589_/D clkload57/I _18589_/Q VSS VSS VSS VSS gf180mcu_fd_sc_mcu9t5v0__dffq_1
X_17609_ input8/Z _18672_/Q _17609_/S _18672_/D VSS VSS VSS VSS gf180mcu_fd_sc_mcu9t5v0__mux2_1
X_09391_ _18564_/Q _18565_/Q _12164_/B VSS _09391_/VNW VSS VSS gf180mcu_fd_sc_mcu9t5v0__or2_2
XTAP_TAPCELL_ROW_184_3_8168 VSS VSS gf180mcu_fd_sc_mcu9t5v0__filltie
XTAP_TAPCELL_ROW_4_1086 VSS VSS gf180mcu_fd_sc_mcu9t5v0__filltie
XTAP_TAPCELL_ROW_4_1097 VSS VSS gf180mcu_fd_sc_mcu9t5v0__filltie
XPHY_EDGE_ROW_194_3_Right_309 VSS VSS gf180mcu_fd_sc_mcu9t5v0__endcap
XTAP_TAPCELL_ROW_164_3_8099 VSS VSS gf180mcu_fd_sc_mcu9t5v0__filltie
XTAP_TAPCELL_ROW_37_2009 VSS VSS gf180mcu_fd_sc_mcu9t5v0__filltie
XTAP_TAPCELL_ROW_244_5775 VSS VSS gf180mcu_fd_sc_mcu9t5v0__filltie
XTAP_TAPCELL_ROW_73_2979 VSS VSS gf180mcu_fd_sc_mcu9t5v0__filltie
XTAP_TAPCELL_ROW_244_5786 VSS VSS gf180mcu_fd_sc_mcu9t5v0__filltie
XTAP_TAPCELL_ROW_13_1330 VSS VSS gf180mcu_fd_sc_mcu9t5v0__filltie
X_09727_ _15842_/A1 _15850_/A2 _17584_/S VSS _09727_/VNW VSS VSS gf180mcu_fd_sc_mcu9t5v0__nor2_2
XPHY_EDGE_ROW_114_Right_114 VSS VSS gf180mcu_fd_sc_mcu9t5v0__endcap
XTAP_TAPCELL_ROW_13_1341 VSS VSS gf180mcu_fd_sc_mcu9t5v0__filltie
XTAP_TAPCELL_ROW_13_1352 VSS VSS gf180mcu_fd_sc_mcu9t5v0__filltie
XPHY_EDGE_ROW_303_Left_626 VSS VSS gf180mcu_fd_sc_mcu9t5v0__endcap
X_09658_ _20002_/Q _09658_/A2 _09659_/A2 VSS VSS VSS VSS gf180mcu_fd_sc_mcu9t5v0__nand2_1
X_09589_ _17888_/B _18060_/B _11013_/B VSS _17945_/VNW VSS VSS gf180mcu_fd_sc_mcu9t5v0__nor2_1
XTAP_TAPCELL_ROW_26_1702 VSS VSS gf180mcu_fd_sc_mcu9t5v0__filltie
X_11620_ _11590_/Z _11620_/A2 _12643_/A1 VSS VSS VSS VSS gf180mcu_fd_sc_mcu9t5v0__nand2_1
X_11551_ _18568_/Q _18567_/Q _17443_/B2 VSS VSS VSS VSS gf180mcu_fd_sc_mcu9t5v0__xnor2_1
X_10502_ _18546_/Q wire80/Z _10650_/B1 _10502_/B2 _10503_/B1 VSS VSS VSS VSS gf180mcu_fd_sc_mcu9t5v0__aoi22_4
X_11482_ _18500_/Q _11524_/S _11485_/A1 VSS _11484_/VNW VSS VSS gf180mcu_fd_sc_mcu9t5v0__nor2_1
X_14270_ _13772_/Z _19344_/Q _14285_/S _19344_/D VSS VSS VSS VSS gf180mcu_fd_sc_mcu9t5v0__mux2_1
X_10433_ _17378_/A1 _18192_/Q _10436_/A2 VSS _10436_/VNW VSS VSS gf180mcu_fd_sc_mcu9t5v0__nor2_1
X_13221_ _13206_/Z _13222_/A2 _13570_/B _13221_/Z VSS _13222_/VNW VSS VSS gf180mcu_fd_sc_mcu9t5v0__or3_1
XPHY_EDGE_ROW_312_Left_635 VSS VSS gf180mcu_fd_sc_mcu9t5v0__endcap
X_10364_ _18943_/Q wire166/Z wire165/Z _18959_/Q _10365_/A3 VSS _18144_/VNW VSS VSS
+ gf180mcu_fd_sc_mcu9t5v0__aoi22_1
X_13152_ _13164_/A2 _19795_/Q _13170_/A2 VSS VSS VSS VSS gf180mcu_fd_sc_mcu9t5v0__nand2_1
X_12103_ _18911_/Q _12104_/A2 _12147_/S _12104_/B VSS _12103_/VNW VSS VSS gf180mcu_fd_sc_mcu9t5v0__aoi21_1
X_10295_ _17198_/A1 _10295_/A2 _10295_/A3 _10295_/B _10300_/A2 VSS _11712_/VNW VSS
+ VSS gf180mcu_fd_sc_mcu9t5v0__oai31_1
X_13083_ _13184_/A1 _13083_/A2 _13084_/A2 VSS VSS VSS VSS gf180mcu_fd_sc_mcu9t5v0__nor2_1
X_17960_ _17960_/A1 _17960_/A2 _17960_/A3 _17960_/A4 _17962_/A1 VSS VSS VSS VSS gf180mcu_fd_sc_mcu9t5v0__nand4_1
X_16911_ _16622_/B _19251_/Q _16925_/S _16911_/Z VSS VSS VSS VSS gf180mcu_fd_sc_mcu9t5v0__mux2_1
X_17891_ _17909_/A2 _17909_/A3 _18060_/B _17958_/A2 VSS _17891_/VNW VSS VSS gf180mcu_fd_sc_mcu9t5v0__aoi21_1
X_12034_ _12686_/C _12034_/A2 _12052_/B VSS _12034_/VNW VSS VSS gf180mcu_fd_sc_mcu9t5v0__nand2_1
X_16842_ _18413_/Q _16841_/Z _16850_/S _18413_/D VSS VSS VSS VSS gf180mcu_fd_sc_mcu9t5v0__mux2_4
XTAP_TAPCELL_ROW_190_3_8189 VSS VSS gf180mcu_fd_sc_mcu9t5v0__filltie
X_19630_ _19630_/D _20142_/RN _19633_/CLK _19630_/Q VSS VSS VSS VSS gf180mcu_fd_sc_mcu9t5v0__dffrnq_1
X_19561_ _19561_/D _20073_/RN clkload19/I _19561_/Q VSS VSS VSS VSS gf180mcu_fd_sc_mcu9t5v0__dffrnq_1
X_18512_ _18512_/D clkload72/I _18512_/Q VSS VSS VSS VSS gf180mcu_fd_sc_mcu9t5v0__dffq_1
XPHY_EDGE_ROW_321_Left_644 VSS VSS gf180mcu_fd_sc_mcu9t5v0__endcap
X_16773_ _16634_/B _19285_/Q _16785_/S _16773_/Z VSS VSS VSS VSS gf180mcu_fd_sc_mcu9t5v0__mux2_1
X_13985_ _14027_/A2 _13984_/Z _13986_/A2 VSS VSS VSS VSS gf180mcu_fd_sc_mcu9t5v0__nor2_1
XTAP_TAPCELL_ROW_83_3253 VSS VSS gf180mcu_fd_sc_mcu9t5v0__filltie
Xclkbuf_leaf_36_clk_regs clkload6/I clkload73/I VSS VSS VSS VSS gf180mcu_fd_sc_mcu9t5v0__clkbuf_8
XTAP_TAPCELL_ROW_254_6060 VSS VSS gf180mcu_fd_sc_mcu9t5v0__filltie
X_15724_ _15705_/B _15722_/I _15725_/B1 VSS _15724_/VNW VSS VSS gf180mcu_fd_sc_mcu9t5v0__nor2_1
XTAP_TAPCELL_ROW_83_3275 VSS VSS gf180mcu_fd_sc_mcu9t5v0__filltie
X_12936_ _19747_/Q _19812_/Q _12948_/S _12936_/Z VSS VSS VSS VSS gf180mcu_fd_sc_mcu9t5v0__mux2_1
XTAP_TAPCELL_ROW_83_3264 VSS VSS gf180mcu_fd_sc_mcu9t5v0__filltie
X_19492_ _19492_/D _20068_/RN clkload24/I _19492_/Q VSS VSS VSS VSS gf180mcu_fd_sc_mcu9t5v0__dffrnq_1
X_18443_ _18443_/D clkload61/I _18443_/Q VSS VSS VSS VSS gf180mcu_fd_sc_mcu9t5v0__dffq_1
X_15655_ _19904_/Q _15598_/S _15655_/B _19904_/D VSS _15655_/VNW VSS VSS gf180mcu_fd_sc_mcu9t5v0__oai21_1
X_12867_ _19215_/Q _13304_/B _12868_/B VSS _13269_/VNW VSS VSS gf180mcu_fd_sc_mcu9t5v0__nand2_1
X_11818_ _18192_/Q _11817_/Z _12324_/B _11818_/Z VSS VSS VSS VSS gf180mcu_fd_sc_mcu9t5v0__mux2_1
X_18374_ _18374_/D clkload77/I _18374_/Q VSS VSS VSS VSS gf180mcu_fd_sc_mcu9t5v0__dffq_4
X_15586_ _15597_/B1 _15586_/A2 _15586_/B _19879_/D VSS VSS VSS VSS gf180mcu_fd_sc_mcu9t5v0__oai21_1
X_14606_ _19186_/Q _19484_/Q _14715_/S _19484_/D VSS VSS VSS VSS gf180mcu_fd_sc_mcu9t5v0__mux2_1
X_17325_ _20134_/Q _17326_/A1 _17326_/B VSS _17328_/VNW VSS VSS gf180mcu_fd_sc_mcu9t5v0__nor2_1
XTAP_TAPCELL_ROW_267_6410 VSS VSS gf180mcu_fd_sc_mcu9t5v0__filltie
X_12798_ _19204_/Q _13497_/B _12799_/B VSS VSS VSS VSS gf180mcu_fd_sc_mcu9t5v0__nand2_1
XTAP_TAPCELL_ROW_96_3625 VSS VSS gf180mcu_fd_sc_mcu9t5v0__filltie
X_14537_ _19133_/Q wire199/I _14764_/B _14537_/C _14538_/A2 VSS VSS VSS VSS gf180mcu_fd_sc_mcu9t5v0__oai211_1
XTAP_TAPCELL_ROW_96_3614 VSS VSS gf180mcu_fd_sc_mcu9t5v0__filltie
XTAP_TAPCELL_ROW_267_6421 VSS VSS gf180mcu_fd_sc_mcu9t5v0__filltie
X_11749_ _11988_/B _11807_/A1 _11749_/Z VSS VSS VSS VSS gf180mcu_fd_sc_mcu9t5v0__or2_1
XTAP_TAPCELL_ROW_96_3636 VSS VSS gf180mcu_fd_sc_mcu9t5v0__filltie
X_17256_ _09261_/I _17256_/A2 _17256_/A3 _17256_/B _17264_/A2 VSS _17256_/VNW VSS
+ VSS gf180mcu_fd_sc_mcu9t5v0__oai31_1
XTAP_TAPCELL_ROW_263_6307 VSS VSS gf180mcu_fd_sc_mcu9t5v0__filltie
X_14468_ _19458_/Q _14715_/S _14469_/B VSS _14468_/VNW VSS VSS gf180mcu_fd_sc_mcu9t5v0__nand2_1
X_17187_ _17195_/A1 _18446_/Q _17190_/A2 VSS VSS VSS VSS gf180mcu_fd_sc_mcu9t5v0__nor2_1
X_16207_ _16206_/Z _18188_/Q _16764_/S _18188_/D VSS VSS VSS VSS gf180mcu_fd_sc_mcu9t5v0__mux2_1
X_13419_ _13497_/A1 _13419_/A2 _13419_/B _13420_/B2 VSS VSS VSS VSS gf180mcu_fd_sc_mcu9t5v0__aoi21_1
X_14399_ _14400_/B1 _19116_/Q _14408_/A2 VSS _14399_/VNW VSS VSS gf180mcu_fd_sc_mcu9t5v0__nor2_1
X_16138_ _19264_/Q _16695_/B _16139_/C VSS VSS VSS VSS gf180mcu_fd_sc_mcu9t5v0__nor2_4
XPHY_EDGE_ROW_265_Right_192 VSS VSS gf180mcu_fd_sc_mcu9t5v0__endcap
XTAP_TAPCELL_ROW_176_2_8138 VSS VSS gf180mcu_fd_sc_mcu9t5v0__filltie
X_16069_ _18124_/A1 _16672_/A2 _16098_/B _16167_/B VSS VSS VSS VSS gf180mcu_fd_sc_mcu9t5v0__oai21_2
X_19828_ _19828_/D _20020_/RN clkload57/I _19828_/Q VSS VSS VSS VSS gf180mcu_fd_sc_mcu9t5v0__dffrnq_1
XTAP_TAPCELL_ROW_6_1137 VSS VSS gf180mcu_fd_sc_mcu9t5v0__filltie
X_19759_ _19759_/D _20143_/RN clkload29/I _19759_/Q VSS VSS VSS VSS gf180mcu_fd_sc_mcu9t5v0__dffrnq_1
XTAP_TAPCELL_ROW_6_1148 VSS VSS gf180mcu_fd_sc_mcu9t5v0__filltie
XTAP_TAPCELL_ROW_6_1159 VSS VSS gf180mcu_fd_sc_mcu9t5v0__filltie
X_09512_ _19069_/Q _14730_/S _17960_/A4 VSS VSS VSS VSS gf180mcu_fd_sc_mcu9t5v0__nand2_4
X_09443_ _15834_/A1 _15829_/A1 _09445_/A4 VSS _09444_/VNW VSS VSS gf180mcu_fd_sc_mcu9t5v0__nor2_1
XTAP_TAPCELL_ROW_66_2794 VSS VSS gf180mcu_fd_sc_mcu9t5v0__filltie
X_09374_ _18491_/Q _12508_/A1 VSS _11361_/VNW VSS VSS gf180mcu_fd_sc_mcu9t5v0__clkinv_1
XTAP_TAPCELL_ROW_237_5590 VSS VSS gf180mcu_fd_sc_mcu9t5v0__filltie
XTAP_TAPCELL_ROW_233_5487 VSS VSS gf180mcu_fd_sc_mcu9t5v0__filltie
XTAP_TAPCELL_ROW_233_5476 VSS VSS gf180mcu_fd_sc_mcu9t5v0__filltie
XTAP_TAPCELL_ROW_233_5465 VSS VSS gf180mcu_fd_sc_mcu9t5v0__filltie
XTAP_TAPCELL_ROW_246_5826 VSS VSS gf180mcu_fd_sc_mcu9t5v0__filltie
XTAP_TAPCELL_ROW_246_5848 VSS VSS gf180mcu_fd_sc_mcu9t5v0__filltie
XTAP_TAPCELL_ROW_246_5837 VSS VSS gf180mcu_fd_sc_mcu9t5v0__filltie
X_10080_ _10659_/C _10080_/A2 _10080_/B1 _10028_/B _10081_/C VSS VSS VSS VSS gf180mcu_fd_sc_mcu9t5v0__oai22_1
XPHY_EDGE_ROW_169_2_Right_900 VSS VSS gf180mcu_fd_sc_mcu9t5v0__endcap
XTAP_TAPCELL_ROW_15_1403 VSS VSS gf180mcu_fd_sc_mcu9t5v0__filltie
X_10982_ _10986_/A1 _10981_/I _10984_/A2 VSS _10984_/VNW VSS VSS gf180mcu_fd_sc_mcu9t5v0__xnor2_1
X_13770_ _13785_/A1 _13771_/A4 _13772_/A2 VSS _13776_/VNW VSS VSS gf180mcu_fd_sc_mcu9t5v0__nand2_1
X_12721_ _12724_/A2 _12720_/Z _12722_/A2 VSS VSS VSS VSS gf180mcu_fd_sc_mcu9t5v0__xnor2_1
X_15440_ _19824_/Q _15465_/A2 _15441_/A2 VSS _16414_/VNW VSS VSS gf180mcu_fd_sc_mcu9t5v0__nor2_1
X_12652_ _12661_/A3 _12652_/A2 _12643_/Z _11654_/C _12653_/B1 VSS _12652_/VNW VSS
+ VSS gf180mcu_fd_sc_mcu9t5v0__aoi22_1
X_11603_ _11610_/B _11592_/Z _11665_/A2 VSS _11603_/VNW VSS VSS gf180mcu_fd_sc_mcu9t5v0__nand2_1
X_12583_ _18452_/Q _12607_/A2 _12585_/B1 VSS VSS VSS VSS gf180mcu_fd_sc_mcu9t5v0__nor2_1
XTAP_TAPCELL_ROW_182_2_8159 VSS VSS gf180mcu_fd_sc_mcu9t5v0__filltie
X_15371_ _19656_/Q _19756_/Q _15430_/S _19756_/D VSS VSS VSS VSS gf180mcu_fd_sc_mcu9t5v0__mux2_1
XTAP_TAPCELL_ROW_134_4662 VSS VSS gf180mcu_fd_sc_mcu9t5v0__filltie
X_11534_ _18472_/Q _18456_/Q _11534_/S _11534_/Z VSS VSS VSS VSS gf180mcu_fd_sc_mcu9t5v0__mux2_1
X_17110_ _18346_/Q _17322_/A2 _17255_/B1 _18362_/Q _17406_/C _17111_/B VSS _17221_/VNW
+ VSS VSS gf180mcu_fd_sc_mcu9t5v0__aoi221_1
XTAP_TAPCELL_ROW_134_4673 VSS VSS gf180mcu_fd_sc_mcu9t5v0__filltie
X_18090_ _18097_/A1 _18090_/A2 _18089_/Z _18090_/B _18934_/D VSS _18090_/VNW VSS VSS
+ gf180mcu_fd_sc_mcu9t5v0__oai31_1
X_14322_ _14322_/I0 _19395_/Q _14322_/S _19395_/D VSS _15322_/VNW VSS VSS gf180mcu_fd_sc_mcu9t5v0__mux2_1
X_17041_ _16622_/B _19251_/Q _17055_/S _17041_/Z VSS VSS VSS VSS gf180mcu_fd_sc_mcu9t5v0__mux2_1
X_11465_ _18435_/Q wire136/Z _11469_/C VSS VSS VSS VSS gf180mcu_fd_sc_mcu9t5v0__nand2_1
XTAP_TAPCELL_ROW_130_4559 VSS VSS gf180mcu_fd_sc_mcu9t5v0__filltie
XTAP_TAPCELL_ROW_130_4548 VSS VSS gf180mcu_fd_sc_mcu9t5v0__filltie
X_14253_ _14254_/A1 _14254_/A2 _14262_/B VSS _14253_/VNW VSS VSS gf180mcu_fd_sc_mcu9t5v0__nand2_1
X_10416_ _19854_/Q _10724_/C _10416_/B _10416_/C _10423_/A1 VSS VSS VSS VSS gf180mcu_fd_sc_mcu9t5v0__oai211_4
X_13204_ _19764_/Q _13204_/A2 _13218_/A2 _13207_/A2 VSS VSS VSS VSS gf180mcu_fd_sc_mcu9t5v0__xnor3_1
X_11396_ _19095_/Q _11423_/A1 _11409_/B VSS VSS VSS VSS gf180mcu_fd_sc_mcu9t5v0__nand2_1
X_14184_ _14184_/A1 _14184_/A2 _14213_/A1 VSS VSS VSS VSS gf180mcu_fd_sc_mcu9t5v0__nand2_1
XPHY_EDGE_ROW_84_Left_408 VSS VSS gf180mcu_fd_sc_mcu9t5v0__endcap
X_10347_ _17260_/S _18205_/Q _10349_/A3 VSS VSS VSS VSS gf180mcu_fd_sc_mcu9t5v0__nor2_1
X_18992_ _18992_/D _20144_/RN clkload67/I _18992_/Q VSS VSS VSS VSS gf180mcu_fd_sc_mcu9t5v0__dffrnq_1
XPHY_EDGE_ROW_153_3_Left_811 VSS VSS gf180mcu_fd_sc_mcu9t5v0__endcap
X_13135_ _19728_/Q _13138_/A2 _13136_/I VSS VSS VSS VSS gf180mcu_fd_sc_mcu9t5v0__nand2_1
X_10278_ _10724_/C _10278_/A2 _10278_/A3 _10279_/C VSS _10278_/VNW VSS VSS gf180mcu_fd_sc_mcu9t5v0__nand3_1
XTAP_TAPCELL_ROW_89_3440 VSS VSS gf180mcu_fd_sc_mcu9t5v0__filltie
X_17943_ _17889_/I _17941_/Z _17943_/A3 _17943_/B _18851_/D VSS _17943_/VNW VSS VSS
+ gf180mcu_fd_sc_mcu9t5v0__oai31_1
X_13066_ _13064_/Z _13067_/A2 _13085_/A2 VSS _13066_/VNW VSS VSS gf180mcu_fd_sc_mcu9t5v0__nor2_1
XTAP_TAPCELL_ROW_256_6100 VSS VSS gf180mcu_fd_sc_mcu9t5v0__filltie
X_12017_ _11736_/C _12017_/A2 _12026_/B2 VSS VSS VSS VSS gf180mcu_fd_sc_mcu9t5v0__nand2_1
XTAP_TAPCELL_ROW_128_4499 VSS VSS gf180mcu_fd_sc_mcu9t5v0__filltie
XTAP_TAPCELL_ROW_256_6122 VSS VSS gf180mcu_fd_sc_mcu9t5v0__filltie
XTAP_TAPCELL_ROW_256_6111 VSS VSS gf180mcu_fd_sc_mcu9t5v0__filltie
X_17874_ _17874_/I _18830_/D VSS VSS VSS VSS gf180mcu_fd_sc_mcu9t5v0__clkinv_1
XTAP_TAPCELL_ROW_85_3326 VSS VSS gf180mcu_fd_sc_mcu9t5v0__filltie
X_19613_ _19613_/D _20061_/RN clkload22/I _19613_/Q VSS VSS VSS VSS gf180mcu_fd_sc_mcu9t5v0__dffrnq_1
XTAP_TAPCELL_ROW_85_3315 VSS VSS gf180mcu_fd_sc_mcu9t5v0__filltie
X_16825_ _19290_/Q _16829_/A2 _16827_/A1 VSS VSS VSS VSS gf180mcu_fd_sc_mcu9t5v0__nand2_1
XTAP_TAPCELL_ROW_252_6008 VSS VSS gf180mcu_fd_sc_mcu9t5v0__filltie
X_16756_ _16756_/I0 _18377_/Q _16764_/S _18377_/D VSS VSS VSS VSS gf180mcu_fd_sc_mcu9t5v0__mux2_1
X_13968_ _19321_/Q _19296_/Q _14007_/A1 VSS VSS VSS VSS gf180mcu_fd_sc_mcu9t5v0__nand2_1
X_19544_ _19544_/D _19992_/RN clkload11/I _19544_/Q VSS VSS VSS VSS gf180mcu_fd_sc_mcu9t5v0__dffrnq_1
X_15707_ _15707_/I0 _19918_/Q _15726_/S _19918_/D VSS VSS VSS VSS gf180mcu_fd_sc_mcu9t5v0__mux2_1
X_12919_ _12919_/A1 _12920_/A2 _12930_/A2 VSS VSS VSS VSS gf180mcu_fd_sc_mcu9t5v0__nand2_1
X_19475_ _19475_/D _20051_/RN clkload14/I _19475_/Q VSS VSS VSS VSS gf180mcu_fd_sc_mcu9t5v0__dffrnq_1
XTAP_TAPCELL_ROW_1_1001 VSS VSS gf180mcu_fd_sc_mcu9t5v0__filltie
XTAP_TAPCELL_ROW_1_1012 VSS VSS gf180mcu_fd_sc_mcu9t5v0__filltie
XTAP_TAPCELL_ROW_1_1023 VSS VSS gf180mcu_fd_sc_mcu9t5v0__filltie
XPHY_EDGE_ROW_93_Left_417 VSS VSS gf180mcu_fd_sc_mcu9t5v0__endcap
X_16687_ _19278_/Q _16730_/C _16688_/C VSS VSS VSS VSS gf180mcu_fd_sc_mcu9t5v0__nand2_1
X_18426_ _18426_/D _20129_/CLK _18426_/Q VSS VSS VSS VSS gf180mcu_fd_sc_mcu9t5v0__dffq_1
XTAP_TAPCELL_ROW_199_3_8221 VSS VSS gf180mcu_fd_sc_mcu9t5v0__filltie
X_13899_ _13901_/A2 _13898_/Z _13907_/B VSS VSS VSS VSS gf180mcu_fd_sc_mcu9t5v0__and2_1
X_15638_ _19895_/Q _19896_/Q _19897_/Q _15649_/A2 _15640_/A2 VSS VSS VSS VSS gf180mcu_fd_sc_mcu9t5v0__nor4_1
X_18357_ _18357_/D clkload78/I _18357_/Q VSS VSS VSS VSS gf180mcu_fd_sc_mcu9t5v0__dffq_1
X_15569_ _17422_/S _15571_/A3 _15570_/A2 VSS _15569_/VNW VSS VSS gf180mcu_fd_sc_mcu9t5v0__nand2_1
X_18288_ _18288_/D clkload74/I _18288_/Q VSS VSS VSS VSS gf180mcu_fd_sc_mcu9t5v0__dffq_1
X_17308_ _17411_/C _17308_/A2 _17309_/A2 VSS VSS VSS VSS gf180mcu_fd_sc_mcu9t5v0__nand2_1
X_09090_ _20072_/Q _10063_/C VSS _09090_/VNW VSS VSS gf180mcu_fd_sc_mcu9t5v0__clkinv_1
X_17239_ _19826_/Q _17239_/A2 _17239_/A3 _17239_/B _17244_/B1 VSS VSS VSS VSS gf180mcu_fd_sc_mcu9t5v0__oai31_1
XTAP_TAPCELL_ROW_241_5701 VSS VSS gf180mcu_fd_sc_mcu9t5v0__filltie
X_09992_ _09916_/B _18964_/Q _09898_/C _09994_/A2 VSS _09992_/VNW VSS VSS gf180mcu_fd_sc_mcu9t5v0__nand3_1
XTAP_TAPCELL_ROW_70_2916 VSS VSS gf180mcu_fd_sc_mcu9t5v0__filltie
XTAP_TAPCELL_ROW_70_2905 VSS VSS gf180mcu_fd_sc_mcu9t5v0__filltie
XTAP_TAPCELL_ROW_226_5291 VSS VSS gf180mcu_fd_sc_mcu9t5v0__filltie
XTAP_TAPCELL_ROW_226_5280 VSS VSS gf180mcu_fd_sc_mcu9t5v0__filltie
XTAP_TAPCELL_ROW_55_2484 VSS VSS gf180mcu_fd_sc_mcu9t5v0__filltie
XTAP_TAPCELL_ROW_55_2495 VSS VSS gf180mcu_fd_sc_mcu9t5v0__filltie
XTAP_TAPCELL_ROW_222_5166 VSS VSS gf180mcu_fd_sc_mcu9t5v0__filltie
XTAP_TAPCELL_ROW_222_5188 VSS VSS gf180mcu_fd_sc_mcu9t5v0__filltie
XTAP_TAPCELL_ROW_222_5177 VSS VSS gf180mcu_fd_sc_mcu9t5v0__filltie
Xu_transform_scheduler_core.u_fft_scratch_sram.u_lo.g_pin_drive\[4\].u_addr_driver
+ _10743_/ZN u_transform_scheduler_core.u_fft_scratch_sram.u_lo.u_sram/A[4] VSS VSS
+ VSS VSS gf180mcu_fd_sc_mcu9t5v0__buf_8
XTAP_TAPCELL_ROW_239_5630 VSS VSS gf180mcu_fd_sc_mcu9t5v0__filltie
XTAP_TAPCELL_ROW_68_2845 VSS VSS gf180mcu_fd_sc_mcu9t5v0__filltie
XTAP_TAPCELL_ROW_239_5652 VSS VSS gf180mcu_fd_sc_mcu9t5v0__filltie
XTAP_TAPCELL_ROW_239_5641 VSS VSS gf180mcu_fd_sc_mcu9t5v0__filltie
XTAP_TAPCELL_ROW_68_2856 VSS VSS gf180mcu_fd_sc_mcu9t5v0__filltie
Xrst_tree_mid_7 rst_tree_root/Z rst_tree_mid_7/Z VSS VSS VSS VSS gf180mcu_fd_sc_mcu9t5v0__clkbuf_16
XTAP_TAPCELL_ROW_235_5538 VSS VSS gf180mcu_fd_sc_mcu9t5v0__filltie
XPHY_EDGE_ROW_236_Left_559 VSS VSS gf180mcu_fd_sc_mcu9t5v0__endcap
XTAP_TAPCELL_ROW_235_5527 VSS VSS gf180mcu_fd_sc_mcu9t5v0__filltie
X_09426_ _09887_/A1 _18692_/Q _17649_/I0 VSS VSS VSS VSS gf180mcu_fd_sc_mcu9t5v0__nor2_1
X_09357_ _18298_/Q _12368_/A1 VSS VSS VSS VSS gf180mcu_fd_sc_mcu9t5v0__clkinv_1
X_09288_ _19249_/Q _16700_/A1 VSS _13321_/VNW VSS VSS gf180mcu_fd_sc_mcu9t5v0__clkinv_1
XTAP_TAPCELL_ROW_211_4881 VSS VSS gf180mcu_fd_sc_mcu9t5v0__filltie
XTAP_TAPCELL_ROW_211_4870 VSS VSS gf180mcu_fd_sc_mcu9t5v0__filltie
XTAP_TAPCELL_ROW_323_7981 VSS VSS gf180mcu_fd_sc_mcu9t5v0__filltie
XTAP_TAPCELL_ROW_323_7970 VSS VSS gf180mcu_fd_sc_mcu9t5v0__filltie
X_11250_ _11521_/B _11248_/Z _11250_/B _11254_/A2 VSS VSS VSS VSS gf180mcu_fd_sc_mcu9t5v0__oai21_1
XPHY_EDGE_ROW_245_Left_568 VSS VSS gf180mcu_fd_sc_mcu9t5v0__endcap
XTAP_TAPCELL_ROW_323_7992 VSS VSS gf180mcu_fd_sc_mcu9t5v0__filltie
X_11181_ _11181_/A1 _11181_/A2 _11788_/B _11183_/B2 VSS VSS VSS VSS gf180mcu_fd_sc_mcu9t5v0__aoi21_1
X_10201_ _10201_/A1 _10201_/A2 _15672_/B _10201_/B _20048_/D VSS _10201_/VNW VSS VSS
+ gf180mcu_fd_sc_mcu9t5v0__oai31_1
X_10132_ _10063_/C _10132_/A2 _10132_/B1 _10132_/B2 output16/I VSS VSS VSS VSS gf180mcu_fd_sc_mcu9t5v0__aoi22_2
X_10063_ _19287_/Q _10166_/B1 _10063_/B1 _10138_/B1 _10063_/C _10067_/A2 VSS VSS VSS
+ VSS gf180mcu_fd_sc_mcu9t5v0__aoi221_1
X_14940_ _19604_/Q _19360_/Q _20039_/D _19604_/D VSS VSS VSS VSS gf180mcu_fd_sc_mcu9t5v0__mux2_1
XTAP_TAPCELL_ROW_292_7089 VSS VSS gf180mcu_fd_sc_mcu9t5v0__filltie
XTAP_TAPCELL_ROW_123_4374 VSS VSS gf180mcu_fd_sc_mcu9t5v0__filltie
XTAP_TAPCELL_ROW_123_4363 VSS VSS gf180mcu_fd_sc_mcu9t5v0__filltie
XTAP_TAPCELL_ROW_123_4352 VSS VSS gf180mcu_fd_sc_mcu9t5v0__filltie
X_14871_ _19592_/Q wire108/I _14877_/B VSS _14871_/VNW VSS VSS gf180mcu_fd_sc_mcu9t5v0__nor2_1
XTAP_TAPCELL_ROW_317_7796 VSS VSS gf180mcu_fd_sc_mcu9t5v0__filltie
XTAP_TAPCELL_ROW_317_7785 VSS VSS gf180mcu_fd_sc_mcu9t5v0__filltie
X_16610_ _19250_/Q _16744_/A2 wire71/Z _16616_/A2 VSS VSS VSS VSS gf180mcu_fd_sc_mcu9t5v0__nor3_1
XPHY_EDGE_ROW_254_Left_577 VSS VSS gf180mcu_fd_sc_mcu9t5v0__endcap
X_17590_ _09065_/I _18655_/Q _17597_/S _18655_/D VSS _17710_/VNW VSS VSS gf180mcu_fd_sc_mcu9t5v0__mux2_1
X_13822_ _13820_/I _13822_/A2 _13838_/A1 VSS _13928_/VNW VSS VSS gf180mcu_fd_sc_mcu9t5v0__nor2_1
X_16541_ _16187_/C _19242_/Q _17057_/S _16541_/Z VSS VSS VSS VSS gf180mcu_fd_sc_mcu9t5v0__mux2_1
X_13753_ _19115_/Q wire199/Z _14704_/S _13753_/C _14387_/A1 VSS _13753_/VNW VSS VSS
+ gf180mcu_fd_sc_mcu9t5v0__oai211_1
X_10965_ _18924_/Q _18042_/A2 _18070_/A2 VSS VSS VSS VSS gf180mcu_fd_sc_mcu9t5v0__nand2_1
X_12704_ _12722_/A1 _12703_/Z _12704_/B _19186_/D VSS _12704_/VNW VSS VSS gf180mcu_fd_sc_mcu9t5v0__oai21_1
X_16472_ _18294_/Q _16471_/Z _16990_/S _18294_/D VSS _16472_/VNW VSS VSS gf180mcu_fd_sc_mcu9t5v0__mux2_4
X_10896_ _10895_/Z _18987_/Q _18152_/S _18987_/D VSS VSS VSS VSS gf180mcu_fd_sc_mcu9t5v0__mux2_1
X_13684_ _19144_/Q _19110_/Q _14656_/B VSS _14660_/VNW VSS VSS gf180mcu_fd_sc_mcu9t5v0__xnor2_1
X_19260_ _19260_/D _20028_/RN clkload24/I _19260_/Q VSS VSS VSS VSS gf180mcu_fd_sc_mcu9t5v0__dffrnq_1
X_18211_ _18211_/D clkload79/I _18211_/Q VSS VSS VSS VSS gf180mcu_fd_sc_mcu9t5v0__dffq_4
X_15423_ _19708_/Q _19808_/Q _15430_/S _19808_/D VSS VSS VSS VSS gf180mcu_fd_sc_mcu9t5v0__mux2_1
X_19191_ _19191_/D _20023_/RN clkload14/I _19191_/Q VSS VSS VSS VSS gf180mcu_fd_sc_mcu9t5v0__dffrnq_1
X_12635_ _11649_/B _12648_/B _12635_/B _12636_/A2 VSS _12635_/VNW VSS VSS gf180mcu_fd_sc_mcu9t5v0__oai21_1
X_12566_ _18402_/Q wire163/Z _12569_/A3 VSS VSS VSS VSS gf180mcu_fd_sc_mcu9t5v0__nor2_1
X_18142_ _18141_/Z _18958_/Q _18152_/S _18958_/D VSS VSS VSS VSS gf180mcu_fd_sc_mcu9t5v0__mux2_1
XTAP_TAPCELL_ROW_78_3141 VSS VSS gf180mcu_fd_sc_mcu9t5v0__filltie
XTAP_TAPCELL_ROW_78_3130 VSS VSS gf180mcu_fd_sc_mcu9t5v0__filltie
XTAP_TAPCELL_ROW_117_4189 VSS VSS gf180mcu_fd_sc_mcu9t5v0__filltie
X_15354_ _15354_/A1 _15354_/A2 _15357_/A2 VSS VSS VSS VSS gf180mcu_fd_sc_mcu9t5v0__nand2_1
XTAP_TAPCELL_ROW_74_3027 VSS VSS gf180mcu_fd_sc_mcu9t5v0__filltie
X_11517_ _11517_/A1 _11517_/A2 _19103_/D VSS _11517_/VNW VSS VSS gf180mcu_fd_sc_mcu9t5v0__nand2_1
XTAP_TAPCELL_ROW_74_3016 VSS VSS gf180mcu_fd_sc_mcu9t5v0__filltie
XTAP_TAPCELL_ROW_74_3005 VSS VSS gf180mcu_fd_sc_mcu9t5v0__filltie
X_14305_ _13757_/Z _19378_/Q _14322_/S _19378_/D VSS VSS VSS VSS gf180mcu_fd_sc_mcu9t5v0__mux2_1
XPHY_EDGE_ROW_263_Left_586 VSS VSS gf180mcu_fd_sc_mcu9t5v0__endcap
X_18073_ _18929_/Q _18062_/I _18076_/A1 VSS _18073_/VNW VSS VSS gf180mcu_fd_sc_mcu9t5v0__nand2_1
X_15285_ _15285_/I0 _19734_/Q _15417_/S _19734_/D VSS VSS VSS VSS gf180mcu_fd_sc_mcu9t5v0__mux2_1
X_12497_ _12686_/C _12488_/I _12497_/A3 _12497_/B _19158_/D VSS _12497_/VNW VSS VSS
+ gf180mcu_fd_sc_mcu9t5v0__oai31_1
X_17024_ _18503_/Q _17023_/Z _17024_/S _18503_/D VSS VSS VSS VSS gf180mcu_fd_sc_mcu9t5v0__mux2_1
Xu_transform_scheduler_core.u_fft_scratch_sram.u_hi.g_pin_drive\[6\].u_addr_driver
+ _10792_/ZN u_transform_scheduler_core.u_fft_scratch_sram.u_hi.u_sram/A[6] VSS u_transform_scheduler_core.u_fft_scratch_sram.u_hi.g_pin_drive\[6\].u_addr_driver/VNW
+ VSS VSS gf180mcu_fd_sc_mcu9t5v0__buf_8
X_11448_ _18883_/Q _11878_/A1 _11488_/B _11448_/B2 _11540_/C _11450_/A1 VSS _17997_/VNW
+ VSS VSS gf180mcu_fd_sc_mcu9t5v0__oai221_1
X_14236_ _14237_/A1 _14238_/A3 _14240_/B VSS VSS VSS VSS gf180mcu_fd_sc_mcu9t5v0__nor2_1
X_11379_ wire283/I _11379_/A2 _11379_/B1 _11379_/B2 _11381_/B2 VSS _17109_/VNW VSS
+ VSS gf180mcu_fd_sc_mcu9t5v0__aoi22_1
XTAP_TAPCELL_ROW_281_6793 VSS VSS gf180mcu_fd_sc_mcu9t5v0__filltie
X_14167_ _14245_/A1 _14166_/B _14167_/B1 _14167_/B2 _19323_/D VSS VSS VSS VSS gf180mcu_fd_sc_mcu9t5v0__aoi22_1
Xload_slew112 _13419_/B _13497_/B VSS VSS VSS VSS gf180mcu_fd_sc_mcu9t5v0__clkbuf_12
X_13118_ _13145_/A1 _13544_/A2 _13118_/Z VSS _13118_/VNW VSS VSS gf180mcu_fd_sc_mcu9t5v0__or2_1
Xload_slew134 _11176_/C _11098_/B VSS VSS VSS VSS gf180mcu_fd_sc_mcu9t5v0__clkbuf_8
Xload_slew145 wire146/Z _12616_/B VSS VSS VSS VSS gf180mcu_fd_sc_mcu9t5v0__clkbuf_8
X_18975_ _18975_/D _20063_/RN clkload67/I _18975_/Q VSS VSS VSS VSS gf180mcu_fd_sc_mcu9t5v0__dffrnq_1
X_14098_ _14099_/A1 _14063_/I _14099_/B _14100_/A2 VSS VSS VSS VSS gf180mcu_fd_sc_mcu9t5v0__oai21_1
Xload_slew167 _17159_/B _17306_/C VSS VSS VSS VSS gf180mcu_fd_sc_mcu9t5v0__buf_8
Xclkbuf_leaf_51_clk_regs clkload2/I clkload39/I VSS VSS VSS VSS gf180mcu_fd_sc_mcu9t5v0__clkbuf_8
X_13049_ _13049_/A1 _13320_/B _13049_/B1 _13049_/B2 _19233_/D VSS _13049_/VNW VSS
+ VSS gf180mcu_fd_sc_mcu9t5v0__aoi22_1
X_17926_ _17926_/A1 _17925_/Z _18846_/D VSS _17926_/VNW VSS VSS gf180mcu_fd_sc_mcu9t5v0__nor2_1
XTAP_TAPCELL_ROW_50_2370 VSS VSS gf180mcu_fd_sc_mcu9t5v0__filltie
XPHY_EDGE_ROW_272_Left_595 VSS VSS gf180mcu_fd_sc_mcu9t5v0__endcap
Xeco14_skew_3 clkload70/I _18273_/CLK VSS VSS VSS VSS gf180mcu_fd_sc_mcu9t5v0__clkbuf_16
X_17857_ _17868_/A2 _17857_/A2 _17856_/Z _17864_/A1 _17857_/B2 _18826_/D VSS VSS VSS
+ VSS gf180mcu_fd_sc_mcu9t5v0__oai32_1
X_16808_ _18401_/Q _16807_/Z _16818_/S _18401_/D VSS _16808_/VNW VSS VSS gf180mcu_fd_sc_mcu9t5v0__mux2_4
X_17788_ _17758_/Z _17790_/A2 _17789_/A2 VSS _17788_/VNW VSS VSS gf180mcu_fd_sc_mcu9t5v0__nand2_1
X_19527_ _19527_/D _20039_/RN clkload10/I _19527_/Q VSS VSS VSS VSS gf180mcu_fd_sc_mcu9t5v0__dffrnq_1
XTAP_TAPCELL_ROW_106_3893 VSS VSS gf180mcu_fd_sc_mcu9t5v0__filltie
X_16739_ _19257_/Q _16725_/C _16741_/B1 VSS _16739_/VNW VSS VSS gf180mcu_fd_sc_mcu9t5v0__nor2_1
XTAP_TAPCELL_ROW_63_2720 VSS VSS gf180mcu_fd_sc_mcu9t5v0__filltie
XTAP_TAPCELL_ROW_102_3779 VSS VSS gf180mcu_fd_sc_mcu9t5v0__filltie
XTAP_TAPCELL_ROW_230_5402 VSS VSS gf180mcu_fd_sc_mcu9t5v0__filltie
X_19458_ _19458_/D _20034_/RN clkload16/I _19458_/Q VSS VSS VSS VSS gf180mcu_fd_sc_mcu9t5v0__dffrnq_1
X_18409_ _18409_/D clkload52/I _18409_/Q VSS VSS VSS VSS gf180mcu_fd_sc_mcu9t5v0__dffq_1
X_19389_ _19389_/D _20029_/RN clkload20/I _19389_/Q VSS VSS VSS VSS gf180mcu_fd_sc_mcu9t5v0__dffrnq_1
XTAP_TAPCELL_ROW_44_2185 VSS VSS gf180mcu_fd_sc_mcu9t5v0__filltie
X_09211_ _19558_/Q _15180_/C VSS VSS VSS VSS gf180mcu_fd_sc_mcu9t5v0__clkinv_1
XTAP_TAPCELL_ROW_44_2196 VSS VSS gf180mcu_fd_sc_mcu9t5v0__filltie
X_09142_ _19766_/Q _13229_/A2 VSS _12845_/VNW VSS VSS gf180mcu_fd_sc_mcu9t5v0__clkinv_1
X_09073_ _20054_/Q _17950_/A1 VSS VSS VSS VSS gf180mcu_fd_sc_mcu9t5v0__clkinv_1
XTAP_TAPCELL_ROW_228_5353 VSS VSS gf180mcu_fd_sc_mcu9t5v0__filltie
XTAP_TAPCELL_ROW_228_5342 VSS VSS gf180mcu_fd_sc_mcu9t5v0__filltie
XTAP_TAPCELL_ROW_228_5331 VSS VSS gf180mcu_fd_sc_mcu9t5v0__filltie
XTAP_TAPCELL_ROW_57_2546 VSS VSS gf180mcu_fd_sc_mcu9t5v0__filltie
XTAP_TAPCELL_ROW_57_2557 VSS VSS gf180mcu_fd_sc_mcu9t5v0__filltie
XTAP_TAPCELL_ROW_224_5217 VSS VSS gf180mcu_fd_sc_mcu9t5v0__filltie
XTAP_TAPCELL_ROW_224_5239 VSS VSS gf180mcu_fd_sc_mcu9t5v0__filltie
XTAP_TAPCELL_ROW_224_5228 VSS VSS gf180mcu_fd_sc_mcu9t5v0__filltie
XPHY_EDGE_ROW_177_2_Left_689 VSS VSS gf180mcu_fd_sc_mcu9t5v0__endcap
X_09975_ _10052_/A1 _19879_/Q _09975_/B _09975_/C _10006_/A2 VSS _09975_/VNW VSS VSS
+ gf180mcu_fd_sc_mcu9t5v0__oai211_1
X_20095_ _20095_/D clkload57/I _20095_/Q VSS VSS VSS VSS gf180mcu_fd_sc_mcu9t5v0__dffq_1
XTAP_TAPCELL_ROW_312_7660 VSS VSS gf180mcu_fd_sc_mcu9t5v0__filltie
X_10750_ _18557_/Q _10796_/A2 _17418_/I0 _17075_/A1 wire282/Z _10770_/B VSS VSS VSS
+ VSS gf180mcu_fd_sc_mcu9t5v0__aoi221_4
X_10681_ _19868_/Q _10681_/I1 _17161_/C _10681_/Z VSS VSS VSS VSS gf180mcu_fd_sc_mcu9t5v0__mux2_4
X_09409_ _19070_/Q _09465_/A3 _14475_/B VSS VSS VSS VSS gf180mcu_fd_sc_mcu9t5v0__nor2_1
XTAP_TAPCELL_ROW_213_4932 VSS VSS gf180mcu_fd_sc_mcu9t5v0__filltie
XTAP_TAPCELL_ROW_213_4921 VSS VSS gf180mcu_fd_sc_mcu9t5v0__filltie
X_12420_ wire175/Z wire125/Z _12618_/B _12421_/A3 VSS VSS VSS VSS gf180mcu_fd_sc_mcu9t5v0__aoi21_1
XTAP_TAPCELL_ROW_321_7907 VSS VSS gf180mcu_fd_sc_mcu9t5v0__filltie
X_12351_ wire208/Z _12351_/A2 _12351_/B _12352_/A3 VSS VSS VSS VSS gf180mcu_fd_sc_mcu9t5v0__aoi21_4
XTAP_TAPCELL_ROW_112_4053 VSS VSS gf180mcu_fd_sc_mcu9t5v0__filltie
X_12282_ _18437_/Q _12345_/A2 _12286_/A1 VSS _12282_/VNW VSS VSS gf180mcu_fd_sc_mcu9t5v0__nand2_1
XTAP_TAPCELL_ROW_306_7486 VSS VSS gf180mcu_fd_sc_mcu9t5v0__filltie
XTAP_TAPCELL_ROW_306_7475 VSS VSS gf180mcu_fd_sc_mcu9t5v0__filltie
X_11302_ _11469_/B _11300_/Z _11302_/B _11305_/A2 VSS _11305_/VNW VSS VSS gf180mcu_fd_sc_mcu9t5v0__oai21_1
XTAP_TAPCELL_ROW_112_4075 VSS VSS gf180mcu_fd_sc_mcu9t5v0__filltie
XTAP_TAPCELL_ROW_112_4064 VSS VSS gf180mcu_fd_sc_mcu9t5v0__filltie
X_15070_ _19309_/Q _19394_/Q _15073_/A2 VSS VSS VSS VSS gf180mcu_fd_sc_mcu9t5v0__nor2_1
XTAP_TAPCELL_ROW_306_7497 VSS VSS gf180mcu_fd_sc_mcu9t5v0__filltie
X_11233_ _18274_/Q _18258_/Q _11524_/S _11233_/Z VSS VSS VSS VSS gf180mcu_fd_sc_mcu9t5v0__mux2_1
X_14021_ _14022_/A1 _14021_/A2 _14064_/A1 VSS VSS VSS VSS gf180mcu_fd_sc_mcu9t5v0__nand2_1
XTAP_TAPCELL_ROW_298_7276 VSS VSS gf180mcu_fd_sc_mcu9t5v0__filltie
XTAP_TAPCELL_ROW_298_7265 VSS VSS gf180mcu_fd_sc_mcu9t5v0__filltie
XTAP_TAPCELL_ROW_298_7254 VSS VSS gf180mcu_fd_sc_mcu9t5v0__filltie
X_11164_ _18699_/Q wire198/Z _11164_/B1 _11164_/B2 wire213/Z _11167_/A2 VSS VSS VSS
+ VSS gf180mcu_fd_sc_mcu9t5v0__aoi221_4
XTAP_TAPCELL_ROW_125_4425 VSS VSS gf180mcu_fd_sc_mcu9t5v0__filltie
XTAP_TAPCELL_ROW_125_4414 VSS VSS gf180mcu_fd_sc_mcu9t5v0__filltie
XTAP_TAPCELL_ROW_319_7847 VSS VSS gf180mcu_fd_sc_mcu9t5v0__filltie
XTAP_TAPCELL_ROW_319_7836 VSS VSS gf180mcu_fd_sc_mcu9t5v0__filltie
X_10115_ _19226_/Q _09898_/C wire297/Z _19250_/Q _10118_/A1 VSS VSS VSS VSS gf180mcu_fd_sc_mcu9t5v0__aoi22_1
X_11095_ _09395_/I wire163/I _11095_/S _11429_/B VSS VSS VSS VSS gf180mcu_fd_sc_mcu9t5v0__mux2_2
X_15972_ _18568_/Q _15988_/B _16197_/A1 VSS VSS VSS VSS gf180mcu_fd_sc_mcu9t5v0__nor2_4
X_18760_ _18760_/D _20040_/RN _20049_/CLK _18760_/Q VSS VSS VSS VSS gf180mcu_fd_sc_mcu9t5v0__dffrnq_1
X_17711_ _17711_/I _18731_/D VSS _17711_/VNW VSS VSS gf180mcu_fd_sc_mcu9t5v0__clkinv_1
X_18691_ _18691_/D _20031_/RN clkload25/I _18691_/Q VSS VSS VSS VSS gf180mcu_fd_sc_mcu9t5v0__dffrnq_4
X_14923_ _14930_/A1 _14923_/A2 _14923_/B _14926_/A2 VSS _14924_/VNW VSS VSS gf180mcu_fd_sc_mcu9t5v0__oai21_1
X_10046_ _18794_/Q _10154_/A2 _10154_/B _10047_/A3 VSS _10046_/VNW VSS VSS gf180mcu_fd_sc_mcu9t5v0__oai21_1
X_17642_ _17749_/A3 _09517_/I _17745_/A3 VSS VSS VSS VSS gf180mcu_fd_sc_mcu9t5v0__nand2_1
X_14854_ _19580_/Q _14854_/I1 _15163_/S _19580_/D VSS VSS VSS VSS gf180mcu_fd_sc_mcu9t5v0__mux2_1
X_11997_ _11997_/A1 _11997_/A2 _11997_/B1 _11997_/B2 _11998_/A2 VSS VSS VSS VSS gf180mcu_fd_sc_mcu9t5v0__aoi22_1
X_17573_ _20139_/Q _09758_/B _17586_/A2 _17576_/A1 VSS VSS VSS VSS gf180mcu_fd_sc_mcu9t5v0__nand3_1
X_13805_ _13802_/Z _13805_/A2 _13805_/Z VSS VSS VSS VSS gf180mcu_fd_sc_mcu9t5v0__xor2_1
X_14785_ _19568_/Q _14785_/I1 _20039_/D _19568_/D VSS _14785_/VNW VSS VSS gf180mcu_fd_sc_mcu9t5v0__mux2_1
X_16524_ _16523_/Z _18318_/Q _17050_/S _18318_/D VSS VSS VSS VSS gf180mcu_fd_sc_mcu9t5v0__mux2_4
XTAP_TAPCELL_ROW_270_6494 VSS VSS gf180mcu_fd_sc_mcu9t5v0__filltie
XTAP_TAPCELL_ROW_270_6483 VSS VSS gf180mcu_fd_sc_mcu9t5v0__filltie
X_10948_ _18930_/Q _18937_/Q _10952_/B VSS VSS VSS VSS gf180mcu_fd_sc_mcu9t5v0__nand2_1
X_19312_ _19312_/D _20144_/RN clkload23/I _19312_/Q VSS VSS VSS VSS gf180mcu_fd_sc_mcu9t5v0__dffrnq_1
X_13736_ _13739_/A2 _14590_/B _13743_/A1 VSS VSS VSS VSS gf180mcu_fd_sc_mcu9t5v0__nand2_1
X_16455_ _19233_/Q _16142_/C _16991_/S _16455_/Z VSS VSS VSS VSS gf180mcu_fd_sc_mcu9t5v0__mux2_1
X_19243_ _19243_/D _20139_/RN clkload40/I _19243_/Q VSS VSS VSS VSS gf180mcu_fd_sc_mcu9t5v0__dffrnq_2
X_10879_ _19236_/Q _19242_/Q _18151_/S _10879_/Z VSS _10911_/VNW VSS VSS gf180mcu_fd_sc_mcu9t5v0__mux2_1
X_13667_ _13667_/A1 _13666_/B _13668_/I1 VSS _13668_/VNW VSS VSS gf180mcu_fd_sc_mcu9t5v0__xnor2_1
X_15406_ _19691_/Q _19791_/Q _15430_/S _19791_/D VSS _15406_/VNW VSS VSS gf180mcu_fd_sc_mcu9t5v0__mux2_1
X_16386_ _16385_/Z _18256_/Q _16926_/S _18256_/D VSS VSS VSS VSS gf180mcu_fd_sc_mcu9t5v0__mux2_4
X_12618_ wire175/Z _12618_/A2 _12618_/B _12620_/A3 VSS _12618_/VNW VSS VSS gf180mcu_fd_sc_mcu9t5v0__aoi21_1
X_19174_ _19174_/D _20070_/RN clkload26/I _19174_/Q VSS VSS VSS VSS gf180mcu_fd_sc_mcu9t5v0__dffrnq_1
X_13598_ _13599_/A1 _13599_/B _13599_/A2 _13601_/A1 VSS _13598_/VNW VSS VSS gf180mcu_fd_sc_mcu9t5v0__nor3_1
XTAP_TAPCELL_ROW_283_6866 VSS VSS gf180mcu_fd_sc_mcu9t5v0__filltie
XTAP_TAPCELL_ROW_283_6855 VSS VSS gf180mcu_fd_sc_mcu9t5v0__filltie
X_12549_ _18352_/Q _12382_/S _12553_/A2 VSS VSS VSS VSS gf180mcu_fd_sc_mcu9t5v0__nor2_1
XTAP_TAPCELL_ROW_283_6844 VSS VSS gf180mcu_fd_sc_mcu9t5v0__filltie
X_18125_ _18125_/I0 _18949_/Q _18148_/S _18949_/D VSS VSS VSS VSS gf180mcu_fd_sc_mcu9t5v0__mux2_1
X_15337_ _19644_/Q _19621_/Q _15337_/A3 _15338_/I1 VSS VSS VSS VSS gf180mcu_fd_sc_mcu9t5v0__xnor3_1
X_18056_ _18058_/A2 _18923_/Q _18056_/S _18923_/D VSS VSS VSS VSS gf180mcu_fd_sc_mcu9t5v0__mux2_1
XANTENNA_1 _16709_/A1 VSS _13361_/VNW VSS VSS gf180mcu_fd_sc_mcu9t5v0__antenna
X_15268_ _15268_/A1 _15268_/A2 _15268_/B _15269_/A3 VSS VSS VSS VSS gf180mcu_fd_sc_mcu9t5v0__oai21_1
X_17007_ _19250_/Q _16614_/B _17023_/S _17007_/Z VSS VSS VSS VSS gf180mcu_fd_sc_mcu9t5v0__mux2_1
X_14219_ _14252_/A1 _14219_/A2 _14219_/B _14241_/A1 VSS VSS VSS VSS gf180mcu_fd_sc_mcu9t5v0__oai21_1
X_15199_ _15204_/A1 _19567_/Q _15209_/A1 VSS VSS VSS VSS gf180mcu_fd_sc_mcu9t5v0__nor2_1
XTAP_TAPCELL_ROW_52_2410 VSS VSS gf180mcu_fd_sc_mcu9t5v0__filltie
XTAP_TAPCELL_ROW_52_2421 VSS VSS gf180mcu_fd_sc_mcu9t5v0__filltie
XPHY_EDGE_ROW_280_Left_603 VSS VSS gf180mcu_fd_sc_mcu9t5v0__endcap
X_18958_ _18958_/D _20046_/RN clkload67/I _18958_/Q VSS VSS VSS VSS gf180mcu_fd_sc_mcu9t5v0__dffrnq_1
X_09760_ _20017_/Q _20051_/Q _20014_/Q _20044_/Q _09760_/C1 _20019_/Q _09761_/A4 VSS
+ VSS VSS VSS gf180mcu_fd_sc_mcu9t5v0__aoi222_1
X_09691_ _09448_/B _09604_/I _10841_/A1 _09692_/I VSS VSS VSS VSS gf180mcu_fd_sc_mcu9t5v0__nor3_1
XTAP_TAPCELL_ROW_108_3966 VSS VSS gf180mcu_fd_sc_mcu9t5v0__filltie
XTAP_TAPCELL_ROW_108_3955 VSS VSS gf180mcu_fd_sc_mcu9t5v0__filltie
X_17909_ _17909_/A1 _17909_/A2 _17909_/A3 _17887_/I _17919_/B1 VSS _17909_/VNW VSS
+ VSS gf180mcu_fd_sc_mcu9t5v0__nand4_1
XTAP_TAPCELL_ROW_108_3944 VSS VSS gf180mcu_fd_sc_mcu9t5v0__filltie
XTAP_TAPCELL_ROW_178_1_4759 VSS VSS gf180mcu_fd_sc_mcu9t5v0__filltie
X_18889_ _18889_/D _20041_/RN _19680_/CLK _18889_/Q VSS VSS VSS VSS gf180mcu_fd_sc_mcu9t5v0__dffrnq_1
XTAP_TAPCELL_ROW_217_5032 VSS VSS gf180mcu_fd_sc_mcu9t5v0__filltie
XTAP_TAPCELL_ROW_46_2236 VSS VSS gf180mcu_fd_sc_mcu9t5v0__filltie
XTAP_TAPCELL_ROW_46_2247 VSS VSS gf180mcu_fd_sc_mcu9t5v0__filltie
XTAP_TAPCELL_ROW_217_5043 VSS VSS gf180mcu_fd_sc_mcu9t5v0__filltie
XTAP_TAPCELL_ROW_46_2258 VSS VSS gf180mcu_fd_sc_mcu9t5v0__filltie
XTAP_TAPCELL_ROW_59_2608 VSS VSS gf180mcu_fd_sc_mcu9t5v0__filltie
X_09125_ _19725_/Q _13088_/A1 VSS VSS VSS VSS gf180mcu_fd_sc_mcu9t5v0__clkinv_1
XTAP_TAPCELL_ROW_22_1590 VSS VSS gf180mcu_fd_sc_mcu9t5v0__filltie
XTAP_TAPCELL_ROW_301_7350 VSS VSS gf180mcu_fd_sc_mcu9t5v0__filltie
XTAP_TAPCELL_ROW_150_1_4745 VSS VSS gf180mcu_fd_sc_mcu9t5v0__filltie
XTAP_TAPCELL_ROW_301_7361 VSS VSS gf180mcu_fd_sc_mcu9t5v0__filltie
XTAP_TAPCELL_ROW_293_7140 VSS VSS gf180mcu_fd_sc_mcu9t5v0__filltie
XTAP_TAPCELL_ROW_35_1940 VSS VSS gf180mcu_fd_sc_mcu9t5v0__filltie
XTAP_TAPCELL_ROW_35_1951 VSS VSS gf180mcu_fd_sc_mcu9t5v0__filltie
X_09958_ _18791_/Q _18793_/Q _18794_/Q _09957_/Z _09961_/A1 VSS VSS VSS VSS gf180mcu_fd_sc_mcu9t5v0__nand4_1
XTAP_TAPCELL_ROW_31_1826 VSS VSS gf180mcu_fd_sc_mcu9t5v0__filltie
XTAP_TAPCELL_ROW_31_1837 VSS VSS gf180mcu_fd_sc_mcu9t5v0__filltie
XTAP_TAPCELL_ROW_314_7711 VSS VSS gf180mcu_fd_sc_mcu9t5v0__filltie
XTAP_TAPCELL_ROW_314_7700 VSS VSS gf180mcu_fd_sc_mcu9t5v0__filltie
X_20078_ _20078_/D clkload58/I _20078_/Q VSS VSS VSS VSS gf180mcu_fd_sc_mcu9t5v0__dffq_1
X_09889_ _20055_/Q _09889_/A2 _09889_/A3 _10164_/A1 VSS VSS VSS VSS gf180mcu_fd_sc_mcu9t5v0__nor3_2
XTAP_TAPCELL_ROW_31_1848 VSS VSS gf180mcu_fd_sc_mcu9t5v0__filltie
X_11920_ _18276_/Q _12345_/A2 _12299_/S _11921_/B2 VSS VSS VSS VSS gf180mcu_fd_sc_mcu9t5v0__aoi21_1
XTAP_TAPCELL_ROW_310_7608 VSS VSS gf180mcu_fd_sc_mcu9t5v0__filltie
X_11851_ _11851_/A1 _11850_/B _11851_/Z VSS VSS VSS VSS gf180mcu_fd_sc_mcu9t5v0__xor2_1
X_11782_ _18254_/Q _12315_/S _11784_/B1 VSS VSS VSS VSS gf180mcu_fd_sc_mcu9t5v0__nand2_1
X_10802_ _10798_/Z _10803_/A2 _10803_/B VSS VSS VSS VSS gf180mcu_fd_sc_mcu9t5v0__nand2_1
X_14570_ _19171_/Q _19137_/Q _14756_/A1 VSS VSS VSS VSS gf180mcu_fd_sc_mcu9t5v0__xnor2_1
XTAP_TAPCELL_ROW_118_4240 VSS VSS gf180mcu_fd_sc_mcu9t5v0__filltie
X_13521_ _13521_/A1 _13520_/B _13521_/A3 _13521_/Z VSS VSS VSS VSS gf180mcu_fd_sc_mcu9t5v0__and3_1
XTAP_TAPCELL_ROW_29_1777 VSS VSS gf180mcu_fd_sc_mcu9t5v0__filltie
X_10733_ _10709_/Z _10734_/A2 _10734_/B _10736_/B1 VSS _10736_/VNW VSS VSS gf180mcu_fd_sc_mcu9t5v0__nor3_1
XTAP_TAPCELL_ROW_29_1788 VSS VSS gf180mcu_fd_sc_mcu9t5v0__filltie
XPHY_EDGE_ROW_162_3_Left_820 VSS VSS gf180mcu_fd_sc_mcu9t5v0__endcap
XPHY_EDGE_ROW_169_1_Left_492 VSS VSS gf180mcu_fd_sc_mcu9t5v0__endcap
XTAP_TAPCELL_ROW_114_4104 VSS VSS gf180mcu_fd_sc_mcu9t5v0__filltie
XTAP_TAPCELL_ROW_308_7537 VSS VSS gf180mcu_fd_sc_mcu9t5v0__filltie
X_10664_ _19816_/Q _10825_/A1 _10665_/B1 VSS _10664_/VNW VSS VSS gf180mcu_fd_sc_mcu9t5v0__nor2_1
X_16240_ _18201_/Q _16240_/I1 _16798_/S _18201_/D VSS VSS VSS VSS gf180mcu_fd_sc_mcu9t5v0__mux2_1
XTAP_TAPCELL_ROW_114_4126 VSS VSS gf180mcu_fd_sc_mcu9t5v0__filltie
XTAP_TAPCELL_ROW_114_4115 VSS VSS gf180mcu_fd_sc_mcu9t5v0__filltie
X_13452_ _13454_/A1 _19778_/Q _13466_/A1 VSS _13452_/VNW VSS VSS gf180mcu_fd_sc_mcu9t5v0__nor2_1
XTAP_TAPCELL_ROW_308_7548 VSS VSS gf180mcu_fd_sc_mcu9t5v0__filltie
X_16171_ _19239_/Q _16751_/B _16174_/A2 VSS VSS VSS VSS gf180mcu_fd_sc_mcu9t5v0__nand2_1
X_10595_ _10595_/A1 _10595_/A2 _17306_/C _10596_/B VSS _17367_/VNW VSS VSS gf180mcu_fd_sc_mcu9t5v0__aoi21_1
X_13383_ _16714_/A1 _13419_/B _13376_/Z _13383_/B2 _19252_/D VSS _13609_/VNW VSS VSS
+ gf180mcu_fd_sc_mcu9t5v0__aoi22_1
X_12403_ _19147_/Q _12355_/I _12410_/B VSS VSS VSS VSS gf180mcu_fd_sc_mcu9t5v0__nand2_1
X_15122_ _19664_/Q _19504_/Q wire108/Z _19664_/D VSS VSS VSS VSS gf180mcu_fd_sc_mcu9t5v0__mux2_1
X_12334_ _14587_/A2 _12333_/B _12334_/B1 _12334_/B2 _19138_/D VSS VSS VSS VSS gf180mcu_fd_sc_mcu9t5v0__oai22_1
XTAP_TAPCELL_ROW_209_4809 VSS VSS gf180mcu_fd_sc_mcu9t5v0__filltie
X_19930_ _19930_/D _20058_/RN clkload49/I _19930_/Q VSS VSS VSS VSS gf180mcu_fd_sc_mcu9t5v0__dffrnq_1
X_15053_ _19306_/Q _19391_/Q _15055_/A2 VSS VSS VSS VSS gf180mcu_fd_sc_mcu9t5v0__xnor2_1
X_12265_ _18468_/Q _12345_/A2 _12324_/B _12266_/B2 VSS _12269_/VNW VSS VSS gf180mcu_fd_sc_mcu9t5v0__aoi21_1
XPHY_EDGE_ROW_128_Right_128 VSS VSS gf180mcu_fd_sc_mcu9t5v0__endcap
X_14004_ _14006_/A1 _14071_/A1 _14004_/Z VSS VSS VSS VSS gf180mcu_fd_sc_mcu9t5v0__and2_1
X_12196_ _18385_/Q _12322_/B _12199_/A1 VSS _12196_/VNW VSS VSS gf180mcu_fd_sc_mcu9t5v0__nand2_1
X_19861_ _19861_/D _20053_/RN clkload57/I _19861_/Q VSS VSS VSS VSS gf180mcu_fd_sc_mcu9t5v0__dffrnq_1
X_11216_ _18241_/Q wire136/Z _11219_/C VSS _16425_/VNW VSS VSS gf180mcu_fd_sc_mcu9t5v0__nand2_1
X_11147_ _11428_/B _11145_/Z wire283/I _11148_/B2 VSS VSS VSS VSS gf180mcu_fd_sc_mcu9t5v0__aoi21_1
X_18812_ _18812_/D _20028_/RN clkload34/I _18812_/Q VSS VSS VSS VSS gf180mcu_fd_sc_mcu9t5v0__dffrnq_1
X_19792_ _19792_/D _20048_/RN clkload29/I _19792_/Q VSS VSS VSS VSS gf180mcu_fd_sc_mcu9t5v0__dffrnq_1
X_18743_ _18743_/D clkload53/I _18743_/Q VSS VSS VSS VSS gf180mcu_fd_sc_mcu9t5v0__dffq_1
XTAP_TAPCELL_ROW_276_6670 VSS VSS gf180mcu_fd_sc_mcu9t5v0__filltie
X_11078_ _18567_/Q wire175/I _11094_/B VSS VSS VSS VSS gf180mcu_fd_sc_mcu9t5v0__nand2_1
X_15955_ _16234_/A2 _15952_/Z _15988_/C _15962_/B1 VSS VSS VSS VSS gf180mcu_fd_sc_mcu9t5v0__oai21_4
X_15886_ _20095_/Q _19230_/Q _15920_/S _20095_/D VSS VSS VSS VSS gf180mcu_fd_sc_mcu9t5v0__mux2_1
XTAP_TAPCELL_ROW_272_6545 VSS VSS gf180mcu_fd_sc_mcu9t5v0__filltie
X_10029_ _19230_/Q _09998_/C _10169_/B1 _19238_/Q _10030_/A2 VSS VSS VSS VSS gf180mcu_fd_sc_mcu9t5v0__aoi22_1
X_18674_ _18674_/D _20142_/RN clkload50/I _18674_/Q VSS VSS VSS VSS gf180mcu_fd_sc_mcu9t5v0__dffrnq_1
X_14906_ _19598_/Q _15148_/S _14912_/B VSS VSS VSS VSS gf180mcu_fd_sc_mcu9t5v0__nor2_1
XTAP_TAPCELL_ROW_272_6556 VSS VSS gf180mcu_fd_sc_mcu9t5v0__filltie
X_17625_ _17625_/A1 _17625_/A2 _18684_/D VSS _17625_/VNW VSS VSS gf180mcu_fd_sc_mcu9t5v0__nor2_1
X_14837_ _14831_/Z _14837_/A2 _14837_/B _14840_/A2 VSS VSS VSS VSS gf180mcu_fd_sc_mcu9t5v0__oai21_1
X_17556_ _18664_/Q _17696_/A2 _17556_/B _17582_/I1 VSS VSS VSS VSS gf180mcu_fd_sc_mcu9t5v0__oai21_1
X_16507_ _19242_/Q _16187_/C _17025_/S _16507_/Z VSS VSS VSS VSS gf180mcu_fd_sc_mcu9t5v0__mux2_1
XTAP_TAPCELL_ROW_41_2100 VSS VSS gf180mcu_fd_sc_mcu9t5v0__filltie
X_14768_ _19556_/Q _19438_/Q _15163_/S _19556_/D VSS _15141_/VNW VSS VSS gf180mcu_fd_sc_mcu9t5v0__mux2_1
XTAP_TAPCELL_ROW_285_6917 VSS VSS gf180mcu_fd_sc_mcu9t5v0__filltie
XTAP_TAPCELL_ROW_285_6906 VSS VSS gf180mcu_fd_sc_mcu9t5v0__filltie
X_17487_ _18592_/Q _19233_/Q _17504_/S _18592_/D VSS VSS VSS VSS gf180mcu_fd_sc_mcu9t5v0__mux2_1
XTAP_TAPCELL_ROW_41_2111 VSS VSS gf180mcu_fd_sc_mcu9t5v0__filltie
X_13719_ _19147_/Q _19113_/Q _13722_/A1 VSS VSS VSS VSS gf180mcu_fd_sc_mcu9t5v0__nor2_1
X_14699_ _14699_/A1 _14699_/A2 _14699_/B _14702_/A2 VSS VSS VSS VSS gf180mcu_fd_sc_mcu9t5v0__aoi21_1
XTAP_TAPCELL_ROW_41_2122 VSS VSS gf180mcu_fd_sc_mcu9t5v0__filltie
X_16438_ _16438_/A1 _16809_/S _16438_/B _16439_/I0 VSS VSS VSS VSS gf180mcu_fd_sc_mcu9t5v0__oai21_4
X_19226_ _19226_/D _20058_/RN clkload39/I _19226_/Q VSS VSS VSS VSS gf180mcu_fd_sc_mcu9t5v0__dffrnq_1
X_16369_ _16511_/A1 _16107_/B _16106_/C _16298_/Z _16897_/S VSS VSS VSS VSS gf180mcu_fd_sc_mcu9t5v0__and4_4
X_19157_ _19157_/D _20053_/RN clkload10/I _19157_/Q VSS VSS VSS VSS gf180mcu_fd_sc_mcu9t5v0__dffrnq_1
X_18108_ _18107_/Z _18941_/Q _18152_/S _18941_/D VSS _18108_/VNW VSS VSS gf180mcu_fd_sc_mcu9t5v0__mux2_1
X_19088_ _19088_/D _20048_/RN clkload41/I _19088_/Q VSS VSS VSS VSS gf180mcu_fd_sc_mcu9t5v0__dffrnq_1
XTAP_TAPCELL_ROW_39_2051 VSS VSS gf180mcu_fd_sc_mcu9t5v0__filltie
XTAP_TAPCELL_ROW_39_2062 VSS VSS gf180mcu_fd_sc_mcu9t5v0__filltie
X_18039_ _18929_/Q _18040_/A2 _18048_/A1 VSS VSS VSS VSS gf180mcu_fd_sc_mcu9t5v0__nand2_1
X_20001_ _20001_/D _20065_/RN _20049_/CLK _20001_/Q VSS VSS VSS VSS gf180mcu_fd_sc_mcu9t5v0__dffrnq_1
X_09812_ _17919_/A1 _10776_/A1 _09812_/B _09812_/C _17886_/A2 VSS VSS VSS VSS gf180mcu_fd_sc_mcu9t5v0__oai211_1
X_09743_ _10829_/A1 _10831_/B2 _10834_/A2 VSS _09743_/VNW VSS VSS gf180mcu_fd_sc_mcu9t5v0__nor2_1
XTAP_TAPCELL_ROW_219_5105 VSS VSS gf180mcu_fd_sc_mcu9t5v0__filltie
X_09674_ wire300/Z wire301/Z _09675_/A2 VSS VSS VSS VSS gf180mcu_fd_sc_mcu9t5v0__xnor2_1
XTAP_TAPCELL_ROW_48_2309 VSS VSS gf180mcu_fd_sc_mcu9t5v0__filltie
XTAP_TAPCELL_ROW_11_1280 VSS VSS gf180mcu_fd_sc_mcu9t5v0__filltie
XTAP_TAPCELL_ROW_11_1291 VSS VSS gf180mcu_fd_sc_mcu9t5v0__filltie
XTAP_TAPCELL_ROW_198_3_8217 VSS VSS gf180mcu_fd_sc_mcu9t5v0__filltie
XTAP_TAPCELL_ROW_24_1630 VSS VSS gf180mcu_fd_sc_mcu9t5v0__filltie
XTAP_TAPCELL_ROW_24_1641 VSS VSS gf180mcu_fd_sc_mcu9t5v0__filltie
XTAP_TAPCELL_ROW_24_1652 VSS VSS gf180mcu_fd_sc_mcu9t5v0__filltie
XTAP_TAPCELL_ROW_303_7401 VSS VSS gf180mcu_fd_sc_mcu9t5v0__filltie
XPHY_EDGE_ROW_207_2_Left_719 VSS VSS gf180mcu_fd_sc_mcu9t5v0__endcap
XTAP_TAPCELL_ROW_178_3_8148 VSS VSS gf180mcu_fd_sc_mcu9t5v0__filltie
XTAP_TAPCELL_ROW_20_1527 VSS VSS gf180mcu_fd_sc_mcu9t5v0__filltie
X_09108_ _19422_/Q _14935_/A2 VSS VSS VSS VSS gf180mcu_fd_sc_mcu9t5v0__clkinv_1
XTAP_TAPCELL_ROW_20_1538 VSS VSS gf180mcu_fd_sc_mcu9t5v0__filltie
XTAP_TAPCELL_ROW_303_7412 VSS VSS gf180mcu_fd_sc_mcu9t5v0__filltie
X_10380_ _18286_/Q _17380_/A2 _17380_/B1 _18302_/Q _10381_/B VSS _11776_/VNW VSS VSS
+ gf180mcu_fd_sc_mcu9t5v0__aoi22_1
XTAP_TAPCELL_ROW_203_3_8235 VSS VSS gf180mcu_fd_sc_mcu9t5v0__filltie
X_12050_ _12050_/A1 _12057_/A2 _12051_/B2 VSS VSS VSS VSS gf180mcu_fd_sc_mcu9t5v0__xnor2_1
X_11001_ _18933_/Q _11004_/A2 _11001_/B1 _18934_/Q _18935_/Q _11002_/A2 VSS _11001_/VNW
+ VSS VSS gf180mcu_fd_sc_mcu9t5v0__aoi221_1
XTAP_TAPCELL_ROW_18_1467 VSS VSS gf180mcu_fd_sc_mcu9t5v0__filltie
XTAP_TAPCELL_ROW_18_1478 VSS VSS gf180mcu_fd_sc_mcu9t5v0__filltie
XTAP_TAPCELL_ROW_18_1489 VSS VSS gf180mcu_fd_sc_mcu9t5v0__filltie
X_15740_ _19924_/Q _19925_/Q _19926_/Q _19927_/Q _15740_/Z VSS VSS VSS VSS gf180mcu_fd_sc_mcu9t5v0__or4_1
X_12952_ _19784_/Q _12952_/A2 _12961_/A1 VSS VSS VSS VSS gf180mcu_fd_sc_mcu9t5v0__nand2_1
XTAP_TAPCELL_ROW_289_7017 VSS VSS gf180mcu_fd_sc_mcu9t5v0__filltie
XTAP_TAPCELL_ROW_289_7006 VSS VSS gf180mcu_fd_sc_mcu9t5v0__filltie
X_15671_ _15671_/A1 _15671_/A2 _15671_/A3 _15671_/A4 _15674_/A2 VSS _15671_/VNW VSS
+ VSS gf180mcu_fd_sc_mcu9t5v0__nand4_1
X_11903_ _12548_/A1 _11903_/A2 _11903_/B1 _12004_/B _11985_/B _11904_/A2 VSS VSS VSS
+ VSS gf180mcu_fd_sc_mcu9t5v0__oai221_1
XTAP_TAPCELL_ROW_289_7028 VSS VSS gf180mcu_fd_sc_mcu9t5v0__filltie
X_17410_ _18618_/Q _17306_/C _17411_/B VSS _17410_/VNW VSS VSS gf180mcu_fd_sc_mcu9t5v0__nand2_1
X_14622_ _19083_/Q _19500_/Q _14670_/S _19500_/D VSS VSS VSS VSS gf180mcu_fd_sc_mcu9t5v0__mux2_1
X_12883_ _12891_/A1 _12889_/B _12884_/A2 VSS _15162_/VNW VSS VSS gf180mcu_fd_sc_mcu9t5v0__nor2_1
X_18390_ _18390_/D clkload77/I _18390_/Q VSS VSS VSS VSS gf180mcu_fd_sc_mcu9t5v0__dffq_1
X_11834_ _18718_/Q wire198/Z _11835_/B VSS VSS VSS VSS gf180mcu_fd_sc_mcu9t5v0__nand2_1
X_17341_ _17378_/A1 _18517_/Q _17344_/A2 VSS VSS VSS VSS gf180mcu_fd_sc_mcu9t5v0__nor2_1
XPHY_EDGE_ROW_246_Right_173 VSS VSS gf180mcu_fd_sc_mcu9t5v0__endcap
X_11765_ _12071_/B _11765_/A2 _11764_/Z _11765_/B _11766_/A2 VSS VSS VSS VSS gf180mcu_fd_sc_mcu9t5v0__oai31_4
X_14553_ wire199/Z _14553_/A2 _14554_/C VSS VSS VSS VSS gf180mcu_fd_sc_mcu9t5v0__nand2_1
X_17272_ _18546_/Q _17394_/A2 _17291_/B VSS VSS VSS VSS gf180mcu_fd_sc_mcu9t5v0__nand2_1
X_11696_ _12092_/B _11696_/A2 _11696_/B _11736_/C _11697_/A2 VSS VSS VSS VSS gf180mcu_fd_sc_mcu9t5v0__aoi211_1
X_10716_ _10713_/Z _10716_/I1 _10806_/B _10716_/Z VSS VSS VSS VSS gf180mcu_fd_sc_mcu9t5v0__mux2_1
X_14484_ _14487_/B _14483_/Z _14590_/B _14486_/A3 VSS _14484_/VNW VSS VSS gf180mcu_fd_sc_mcu9t5v0__aoi21_1
X_13504_ wire277/Z _13507_/A2 _13503_/Z _13504_/B _19261_/D VSS VSS VSS VSS gf180mcu_fd_sc_mcu9t5v0__oai31_1
X_10647_ _17306_/C _10647_/A2 _10648_/B2 VSS _15868_/VNW VSS VSS gf180mcu_fd_sc_mcu9t5v0__nor2_1
X_16223_ _16222_/Z _18196_/Q _16782_/S _18196_/D VSS _16223_/VNW VSS VSS gf180mcu_fd_sc_mcu9t5v0__mux2_1
X_19011_ _19011_/D _20035_/RN clkload38/I _19011_/Q VSS VSS VSS VSS gf180mcu_fd_sc_mcu9t5v0__dffrnq_1
X_13435_ _19745_/Q _13435_/A2 _13453_/B VSS VSS VSS VSS gf180mcu_fd_sc_mcu9t5v0__nor2_1
XTAP_TAPCELL_ROW_265_6360 VSS VSS gf180mcu_fd_sc_mcu9t5v0__filltie
XTAP_TAPCELL_ROW_94_3575 VSS VSS gf180mcu_fd_sc_mcu9t5v0__filltie
XTAP_TAPCELL_ROW_94_3564 VSS VSS gf180mcu_fd_sc_mcu9t5v0__filltie
X_16154_ _16154_/A1 _16154_/A2 _16154_/B _16155_/I1 VSS VSS VSS VSS gf180mcu_fd_sc_mcu9t5v0__oai21_1
XTAP_TAPCELL_ROW_265_6371 VSS VSS gf180mcu_fd_sc_mcu9t5v0__filltie
X_10578_ _10809_/B _10578_/A2 _10578_/B1 _10578_/B2 _10578_/ZN VSS VSS VSS VSS gf180mcu_fd_sc_mcu9t5v0__aoi22_4
XPHY_EDGE_ROW_191_2_Left_703 VSS VSS gf180mcu_fd_sc_mcu9t5v0__endcap
X_13366_ _13366_/A1 _13366_/A2 _13365_/B _13366_/Z VSS VSS VSS VSS gf180mcu_fd_sc_mcu9t5v0__and3_1
X_12317_ _18487_/Q _12315_/S _12319_/A2 VSS VSS VSS VSS gf180mcu_fd_sc_mcu9t5v0__nand2_1
XTAP_TAPCELL_ROW_261_6257 VSS VSS gf180mcu_fd_sc_mcu9t5v0__filltie
XTAP_TAPCELL_ROW_261_6246 VSS VSS gf180mcu_fd_sc_mcu9t5v0__filltie
X_16085_ _18165_/Q _16085_/I1 _16643_/S _18165_/D VSS VSS VSS VSS gf180mcu_fd_sc_mcu9t5v0__mux2_4
XTAP_TAPCELL_ROW_261_6235 VSS VSS gf180mcu_fd_sc_mcu9t5v0__filltie
X_13297_ _13297_/A1 _13297_/A2 _13590_/B _13313_/A2 VSS VSS VSS VSS gf180mcu_fd_sc_mcu9t5v0__aoi21_1
X_15105_ _15105_/A1 _15105_/A2 _15105_/B _15106_/A3 VSS VSS VSS VSS gf180mcu_fd_sc_mcu9t5v0__oai21_1
X_12248_ _18515_/Q _12299_/S _12248_/B _12320_/C _12249_/A2 VSS _12250_/VNW VSS VSS
+ gf180mcu_fd_sc_mcu9t5v0__oai211_1
X_19913_ _19913_/D _20041_/RN _20049_/CLK _19913_/Q VSS VSS VSS VSS gf180mcu_fd_sc_mcu9t5v0__dffrnq_1
X_15036_ _19636_/Q _15035_/Z _20039_/Q _19636_/D VSS VSS VSS VSS gf180mcu_fd_sc_mcu9t5v0__mux2_1
XTAP_TAPCELL_ROW_278_6721 VSS VSS gf180mcu_fd_sc_mcu9t5v0__filltie
XTAP_TAPCELL_ROW_278_6710 VSS VSS gf180mcu_fd_sc_mcu9t5v0__filltie
X_19844_ _19844_/D _20036_/RN clkload51/I _19844_/Q VSS VSS VSS VSS gf180mcu_fd_sc_mcu9t5v0__dffrnq_1
X_12179_ _18496_/Q _18480_/Q _18432_/Q _18416_/Q _12315_/S _12208_/C _12179_/Z VSS
+ VSS VSS VSS gf180mcu_fd_sc_mcu9t5v0__mux4_1
XTAP_TAPCELL_ROW_274_6618 VSS VSS gf180mcu_fd_sc_mcu9t5v0__filltie
X_16987_ _19256_/Q _16654_/B _16991_/S _16987_/Z VSS _16987_/VNW VSS VSS gf180mcu_fd_sc_mcu9t5v0__mux2_1
XTAP_TAPCELL_ROW_274_6607 VSS VSS gf180mcu_fd_sc_mcu9t5v0__filltie
X_19775_ _19775_/D _20031_/RN clkload37/I _19775_/Q VSS VSS VSS VSS gf180mcu_fd_sc_mcu9t5v0__dffrnq_1
XTAP_TAPCELL_ROW_259_6197 VSS VSS gf180mcu_fd_sc_mcu9t5v0__filltie
XTAP_TAPCELL_ROW_259_6186 VSS VSS gf180mcu_fd_sc_mcu9t5v0__filltie
X_15938_ _15973_/B _15986_/C _15938_/Z VSS VSS VSS VSS gf180mcu_fd_sc_mcu9t5v0__and2_4
X_18726_ _18726_/D clkload54/I _18726_/Q VSS VSS VSS VSS gf180mcu_fd_sc_mcu9t5v0__dffq_1
X_18657_ _18657_/D _20061_/RN clkload47/I _18657_/Q VSS VSS VSS VSS gf180mcu_fd_sc_mcu9t5v0__dffrnq_1
XTAP_TAPCELL_ROW_8_1190 VSS VSS gf180mcu_fd_sc_mcu9t5v0__filltie
Xwire37 wire37/I wire37/Z VSS VSS VSS VSS gf180mcu_fd_sc_mcu9t5v0__buf_4
X_15869_ _20078_/Q _19228_/Q _15905_/S _20078_/D VSS VSS VSS VSS gf180mcu_fd_sc_mcu9t5v0__mux2_1
X_17608_ input7/Z _18671_/Q _17609_/S _18671_/D VSS _17608_/VNW VSS VSS gf180mcu_fd_sc_mcu9t5v0__mux2_1
X_18588_ _18588_/D clkload59/I _18588_/Q VSS VSS VSS VSS gf180mcu_fd_sc_mcu9t5v0__dffq_1
X_09390_ _18564_/Q _18565_/Q _11706_/B VSS VSS VSS VSS gf180mcu_fd_sc_mcu9t5v0__nor2_4
XTAP_TAPCELL_ROW_184_3_8169 VSS VSS gf180mcu_fd_sc_mcu9t5v0__filltie
XTAP_TAPCELL_ROW_4_1087 VSS VSS gf180mcu_fd_sc_mcu9t5v0__filltie
XTAP_TAPCELL_ROW_4_1098 VSS VSS gf180mcu_fd_sc_mcu9t5v0__filltie
X_17539_ _17579_/I1 _18637_/Q _17571_/S _18637_/D VSS VSS VSS VSS gf180mcu_fd_sc_mcu9t5v0__mux2_1
XPHY_EDGE_ROW_186_2_Left_698 VSS VSS gf180mcu_fd_sc_mcu9t5v0__endcap
XPHY_EDGE_ROW_213_Right_140 VSS VSS gf180mcu_fd_sc_mcu9t5v0__endcap
XTAP_TAPCELL_ROW_250_5950 VSS VSS gf180mcu_fd_sc_mcu9t5v0__filltie
X_19209_ _19209_/D _20041_/RN clkload40/I _19209_/Q VSS VSS VSS VSS gf180mcu_fd_sc_mcu9t5v0__dffrnq_1
XPHY_EDGE_ROW_104_Left_428 VSS VSS gf180mcu_fd_sc_mcu9t5v0__endcap
XTAP_TAPCELL_ROW_248_5890 VSS VSS gf180mcu_fd_sc_mcu9t5v0__filltie
Xclkbuf_leaf_6_clk_regs clkload0/I clkload22/I VSS VSS VSS VSS gf180mcu_fd_sc_mcu9t5v0__clkbuf_8
XTAP_TAPCELL_ROW_244_5787 VSS VSS gf180mcu_fd_sc_mcu9t5v0__filltie
XTAP_TAPCELL_ROW_244_5776 VSS VSS gf180mcu_fd_sc_mcu9t5v0__filltie
XPHY_EDGE_ROW_113_Left_437 VSS VSS gf180mcu_fd_sc_mcu9t5v0__endcap
X_09726_ _09726_/A1 _20052_/Q _09726_/B _20021_/D VSS VSS VSS VSS gf180mcu_fd_sc_mcu9t5v0__oai21_1
XTAP_TAPCELL_ROW_13_1331 VSS VSS gf180mcu_fd_sc_mcu9t5v0__filltie
XTAP_TAPCELL_ROW_13_1342 VSS VSS gf180mcu_fd_sc_mcu9t5v0__filltie
XTAP_TAPCELL_ROW_13_1353 VSS VSS gf180mcu_fd_sc_mcu9t5v0__filltie
X_09657_ _20144_/Q input9/Z _15786_/S VSS VSS VSS VSS gf180mcu_fd_sc_mcu9t5v0__nand2_2
X_09588_ _10659_/C _19017_/Q _17869_/A2 VSS VSS VSS VSS gf180mcu_fd_sc_mcu9t5v0__nor2_2
XTAP_TAPCELL_ROW_26_1703 VSS VSS gf180mcu_fd_sc_mcu9t5v0__filltie
X_11550_ _18568_/Q _18567_/Q _11550_/Z VSS VSS VSS VSS gf180mcu_fd_sc_mcu9t5v0__xor2_1
X_10501_ _10389_/C _10649_/A2 _10501_/A3 _17161_/C _10502_/B2 VSS VSS VSS VSS gf180mcu_fd_sc_mcu9t5v0__oai31_1
XPHY_EDGE_ROW_122_Left_446 VSS VSS gf180mcu_fd_sc_mcu9t5v0__endcap
X_11481_ _18532_/Q _18516_/Q _18468_/Q _18452_/Q _11524_/S _11521_/B _11481_/Z VSS
+ VSS VSS VSS gf180mcu_fd_sc_mcu9t5v0__mux4_1
X_13220_ _19799_/Q _13220_/A2 _13225_/A1 _13570_/B VSS VSS VSS VSS gf180mcu_fd_sc_mcu9t5v0__xor3_1
X_10432_ _09261_/I _10432_/A2 _10432_/A3 _10432_/B _10437_/B1 VSS VSS VSS VSS gf180mcu_fd_sc_mcu9t5v0__oai31_1
X_10363_ _18975_/Q _10804_/A2 _10365_/A2 VSS _10365_/VNW VSS VSS gf180mcu_fd_sc_mcu9t5v0__nand2_1
X_13151_ _13151_/A1 _13151_/A2 _13151_/A3 _13151_/B _13170_/A1 VSS VSS VSS VSS gf180mcu_fd_sc_mcu9t5v0__oai31_1
X_13082_ _13082_/A1 _13082_/A2 _13081_/B _13083_/A2 VSS _13082_/VNW VSS VSS gf180mcu_fd_sc_mcu9t5v0__nor3_1
X_12102_ _12235_/B _12126_/A2 _12104_/A2 VSS VSS VSS VSS gf180mcu_fd_sc_mcu9t5v0__nor2_1
X_10294_ _18219_/Q _17380_/A2 _17380_/B1 _18235_/Q _10295_/B VSS _11712_/VNW VSS VSS
+ gf180mcu_fd_sc_mcu9t5v0__aoi22_1
X_16910_ _16909_/Z _18447_/Q _16910_/S _18447_/D VSS VSS VSS VSS gf180mcu_fd_sc_mcu9t5v0__mux2_1
X_12033_ _18908_/Q _12033_/A2 _12034_/A2 VSS _12033_/VNW VSS VSS gf180mcu_fd_sc_mcu9t5v0__xnor2_1
X_17890_ _11013_/B _17957_/A2 _17968_/A1 VSS VSS VSS VSS gf180mcu_fd_sc_mcu9t5v0__nor2_1
XPHY_EDGE_ROW_131_Left_455 VSS VSS gf180mcu_fd_sc_mcu9t5v0__endcap
X_16841_ _19248_/Q _16599_/B _16861_/S _16841_/Z VSS _16841_/VNW VSS VSS gf180mcu_fd_sc_mcu9t5v0__mux2_1
XPHY_EDGE_ROW_315_Right_242 VSS VSS gf180mcu_fd_sc_mcu9t5v0__endcap
X_16772_ _16771_/Z _18385_/Q _16784_/S _18385_/D VSS VSS VSS VSS gf180mcu_fd_sc_mcu9t5v0__mux2_1
X_19560_ _19560_/D _20072_/RN clkload19/I _19560_/Q VSS VSS VSS VSS gf180mcu_fd_sc_mcu9t5v0__dffrnq_1
X_18511_ _18511_/D _20099_/CLK _18511_/Q VSS VSS VSS VSS gf180mcu_fd_sc_mcu9t5v0__dffq_1
X_15723_ _09705_/Z _15723_/A2 _20003_/Q _15725_/A2 VSS VSS VSS VSS gf180mcu_fd_sc_mcu9t5v0__aoi21_1
X_13984_ _13941_/Z _13984_/A2 _13983_/B _13984_/Z VSS VSS VSS VSS gf180mcu_fd_sc_mcu9t5v0__and3_1
XTAP_TAPCELL_ROW_83_3254 VSS VSS gf180mcu_fd_sc_mcu9t5v0__filltie
XTAP_TAPCELL_ROW_254_6061 VSS VSS gf180mcu_fd_sc_mcu9t5v0__filltie
XTAP_TAPCELL_ROW_254_6050 VSS VSS gf180mcu_fd_sc_mcu9t5v0__filltie
XTAP_TAPCELL_ROW_83_3276 VSS VSS gf180mcu_fd_sc_mcu9t5v0__filltie
X_12935_ _19778_/Q _12928_/Z _12935_/B _12944_/A1 VSS VSS VSS VSS gf180mcu_fd_sc_mcu9t5v0__aoi21_1
XTAP_TAPCELL_ROW_83_3265 VSS VSS gf180mcu_fd_sc_mcu9t5v0__filltie
X_19491_ _19491_/D _20067_/RN clkload23/I _19491_/Q VSS VSS VSS VSS gf180mcu_fd_sc_mcu9t5v0__dffrnq_1
X_18442_ _18442_/D _20129_/CLK _18442_/Q VSS VSS VSS VSS gf180mcu_fd_sc_mcu9t5v0__dffq_1
X_15654_ _19904_/Q _15598_/S _15677_/B _15655_/B VSS _15655_/VNW VSS VSS gf180mcu_fd_sc_mcu9t5v0__nand3_1
X_12866_ _12870_/A1 _12870_/A2 _12866_/Z VSS VSS VSS VSS gf180mcu_fd_sc_mcu9t5v0__and2_1
X_11817_ _18176_/Q _18160_/Q _12315_/S _11817_/Z VSS VSS VSS VSS gf180mcu_fd_sc_mcu9t5v0__mux2_1
X_18373_ _18373_/D clkload78/I _18373_/Q VSS VSS VSS VSS gf180mcu_fd_sc_mcu9t5v0__dffq_1
X_15585_ _18023_/I0 _15596_/A2 _15586_/A2 VSS VSS VSS VSS gf180mcu_fd_sc_mcu9t5v0__nor2_1
X_14605_ _19185_/Q _19483_/Q _14715_/S _19483_/D VSS VSS VSS VSS gf180mcu_fd_sc_mcu9t5v0__mux2_1
Xclkbuf_leaf_76_clk_regs clkbuf_3_0_0_clk_regs/Z clkload11/I VSS VSS VSS VSS gf180mcu_fd_sc_mcu9t5v0__clkbuf_8
X_17324_ _10543_/C _17324_/A2 _17324_/B1 _10516_/C _17324_/C1 _10353_/C _17326_/A2
+ VSS VSS VSS VSS gf180mcu_fd_sc_mcu9t5v0__aoi222_1
XTAP_TAPCELL_ROW_267_6411 VSS VSS gf180mcu_fd_sc_mcu9t5v0__filltie
XTAP_TAPCELL_ROW_208_2_8250 VSS VSS gf180mcu_fd_sc_mcu9t5v0__filltie
XTAP_TAPCELL_ROW_267_6400 VSS VSS gf180mcu_fd_sc_mcu9t5v0__filltie
XTAP_TAPCELL_ROW_96_3626 VSS VSS gf180mcu_fd_sc_mcu9t5v0__filltie
X_12797_ _19758_/Q _12793_/Z _12794_/Z _12799_/A2 VSS VSS VSS VSS gf180mcu_fd_sc_mcu9t5v0__xnor3_1
X_14536_ wire199/I _14536_/A2 _14537_/C VSS _14545_/VNW VSS VSS gf180mcu_fd_sc_mcu9t5v0__nand2_1
XTAP_TAPCELL_ROW_96_3615 VSS VSS gf180mcu_fd_sc_mcu9t5v0__filltie
XTAP_TAPCELL_ROW_267_6422 VSS VSS gf180mcu_fd_sc_mcu9t5v0__filltie
X_11748_ _11748_/A1 _11748_/A2 _11748_/A3 _11807_/A1 VSS _12106_/VNW VSS VSS gf180mcu_fd_sc_mcu9t5v0__nor3_4
XTAP_TAPCELL_ROW_196_2_8208 VSS VSS gf180mcu_fd_sc_mcu9t5v0__filltie
X_17255_ _18353_/Q _17322_/A2 _17255_/B1 _18369_/Q _17406_/C _17256_/B VSS VSS VSS
+ VSS gf180mcu_fd_sc_mcu9t5v0__aoi221_1
XTAP_TAPCELL_ROW_263_6308 VSS VSS gf180mcu_fd_sc_mcu9t5v0__filltie
X_11679_ _17881_/A1 _12706_/A2 _12706_/A3 _11679_/B _12076_/B VSS VSS VSS VSS gf180mcu_fd_sc_mcu9t5v0__oai31_2
X_14467_ _14474_/A2 _14467_/A2 _14590_/B _14469_/A3 VSS VSS VSS VSS gf180mcu_fd_sc_mcu9t5v0__aoi21_1
X_17186_ _18608_/Q _17159_/B _17203_/B VSS _17186_/VNW VSS VSS gf180mcu_fd_sc_mcu9t5v0__nand2_1
X_16206_ _16131_/B _19263_/Q _16763_/S _16206_/Z VSS VSS VSS VSS gf180mcu_fd_sc_mcu9t5v0__mux2_1
X_13418_ _19744_/Q _19776_/Q _13418_/A3 _13419_/A2 VSS _13418_/VNW VSS VSS gf180mcu_fd_sc_mcu9t5v0__xnor3_1
X_14398_ _19151_/Q _19117_/Q _14688_/A2 VSS _14688_/VNW VSS VSS gf180mcu_fd_sc_mcu9t5v0__xnor2_1
X_16137_ _16668_/A1 _16686_/A3 _16730_/C _16137_/C _16139_/B VSS VSS VSS VSS gf180mcu_fd_sc_mcu9t5v0__aoi211_4
X_13349_ _19741_/Q _13352_/A2 _13375_/A1 VSS VSS VSS VSS gf180mcu_fd_sc_mcu9t5v0__nand2_1
X_16068_ _19238_/Q _16744_/A2 wire71/Z _16072_/A2 VSS _16073_/VNW VSS VSS gf180mcu_fd_sc_mcu9t5v0__nor3_1
X_15019_ _19377_/Q _15020_/A2 _15019_/Z VSS VSS VSS VSS gf180mcu_fd_sc_mcu9t5v0__or2_1
X_19827_ _19827_/D _20019_/RN _20129_/CLK _19827_/Q VSS VSS VSS VSS gf180mcu_fd_sc_mcu9t5v0__dffrnq_1
X_19758_ _19758_/D _20142_/RN clkload29/I _19758_/Q VSS VSS VSS VSS gf180mcu_fd_sc_mcu9t5v0__dffrnq_1
XTAP_TAPCELL_ROW_6_1138 VSS VSS gf180mcu_fd_sc_mcu9t5v0__filltie
XTAP_TAPCELL_ROW_6_1149 VSS VSS gf180mcu_fd_sc_mcu9t5v0__filltie
X_09511_ _14730_/S _19183_/Q _09511_/B _09513_/A2 VSS VSS VSS VSS gf180mcu_fd_sc_mcu9t5v0__aoi21_4
X_18709_ _18709_/D clkload47/I _18709_/Q VSS VSS VSS VSS gf180mcu_fd_sc_mcu9t5v0__dffq_1
X_19689_ _19689_/D _20073_/RN clkload11/I _19689_/Q VSS VSS VSS VSS gf180mcu_fd_sc_mcu9t5v0__dffrnq_1
XTAP_TAPCELL_ROW_237_5580 VSS VSS gf180mcu_fd_sc_mcu9t5v0__filltie
X_09442_ _09442_/I _15829_/A1 VSS _15827_/VNW VSS VSS gf180mcu_fd_sc_mcu9t5v0__clkinv_1
XTAP_TAPCELL_ROW_66_2784 VSS VSS gf180mcu_fd_sc_mcu9t5v0__filltie
XTAP_TAPCELL_ROW_66_2795 VSS VSS gf180mcu_fd_sc_mcu9t5v0__filltie
X_09373_ _18474_/Q _12046_/I1 VSS VSS VSS VSS gf180mcu_fd_sc_mcu9t5v0__clkinv_1
XTAP_TAPCELL_ROW_237_5591 VSS VSS gf180mcu_fd_sc_mcu9t5v0__filltie
XTAP_TAPCELL_ROW_233_5488 VSS VSS gf180mcu_fd_sc_mcu9t5v0__filltie
XTAP_TAPCELL_ROW_233_5477 VSS VSS gf180mcu_fd_sc_mcu9t5v0__filltie
XTAP_TAPCELL_ROW_233_5466 VSS VSS gf180mcu_fd_sc_mcu9t5v0__filltie
XTAP_TAPCELL_ROW_246_5849 VSS VSS gf180mcu_fd_sc_mcu9t5v0__filltie
XTAP_TAPCELL_ROW_246_5838 VSS VSS gf180mcu_fd_sc_mcu9t5v0__filltie
XTAP_TAPCELL_ROW_246_5827 VSS VSS gf180mcu_fd_sc_mcu9t5v0__filltie
XTAP_TAPCELL_ROW_15_1404 VSS VSS gf180mcu_fd_sc_mcu9t5v0__filltie
X_09709_ _17532_/A2 _17619_/A3 _09709_/Z VSS _17599_/VNW VSS VSS gf180mcu_fd_sc_mcu9t5v0__or2_1
X_10981_ _10981_/I _10998_/A3 VSS VSS VSS VSS gf180mcu_fd_sc_mcu9t5v0__clkinv_1
X_12720_ _12644_/B _12680_/Z _12720_/S _12720_/Z VSS VSS VSS VSS gf180mcu_fd_sc_mcu9t5v0__mux2_1
X_12651_ _12720_/S _12707_/I0 _12654_/B VSS _12651_/VNW VSS VSS gf180mcu_fd_sc_mcu9t5v0__nor2_1
X_11602_ _11602_/A1 _11620_/A2 _11632_/B VSS VSS VSS VSS gf180mcu_fd_sc_mcu9t5v0__or2_1
X_12582_ _18404_/Q _12582_/A2 _12585_/A3 VSS VSS VSS VSS gf180mcu_fd_sc_mcu9t5v0__nor2_1
X_15370_ _19655_/Q _19755_/Q _15430_/S _19755_/D VSS VSS VSS VSS gf180mcu_fd_sc_mcu9t5v0__mux2_1
X_11533_ _18376_/Q _11537_/S _11533_/B _11539_/A2 VSS VSS VSS VSS gf180mcu_fd_sc_mcu9t5v0__oai21_1
Xwire300 wire300/I wire300/Z VSS VSS VSS VSS gf180mcu_fd_sc_mcu9t5v0__clkbuf_8
XTAP_TAPCELL_ROW_134_4674 VSS VSS gf180mcu_fd_sc_mcu9t5v0__filltie
XTAP_TAPCELL_ROW_134_4663 VSS VSS gf180mcu_fd_sc_mcu9t5v0__filltie
X_14321_ _14259_/Z _19394_/Q _14322_/S _19394_/D VSS _14321_/VNW VSS VSS gf180mcu_fd_sc_mcu9t5v0__mux2_1
X_17040_ _17039_/Z _18511_/Q _17042_/S _18511_/D VSS VSS VSS VSS gf180mcu_fd_sc_mcu9t5v0__mux2_1
XPHY_EDGE_ROW_136_2_Right_867 VSS VSS gf180mcu_fd_sc_mcu9t5v0__endcap
X_11464_ _11464_/A1 _11464_/A2 _19099_/D VSS VSS VSS VSS gf180mcu_fd_sc_mcu9t5v0__nand2_1
XTAP_TAPCELL_ROW_130_4549 VSS VSS gf180mcu_fd_sc_mcu9t5v0__filltie
X_14252_ _14252_/A1 _14251_/Z _14254_/A2 VSS _14253_/VNW VSS VSS gf180mcu_fd_sc_mcu9t5v0__xnor2_1
X_10415_ _10724_/C _10415_/A2 _10415_/A3 _10416_/C VSS VSS VSS VSS gf180mcu_fd_sc_mcu9t5v0__nand3_1
X_13203_ _13203_/A1 _13203_/A2 _13203_/B _13218_/A2 VSS VSS VSS VSS gf180mcu_fd_sc_mcu9t5v0__aoi21_1
XTAP_TAPCELL_ROW_76_3080 VSS VSS gf180mcu_fd_sc_mcu9t5v0__filltie
X_11395_ _11423_/A1 _11395_/A2 _11395_/A3 _11395_/B _19094_/D VSS _11395_/VNW VSS
+ VSS gf180mcu_fd_sc_mcu9t5v0__oai31_1
X_14183_ _14183_/A1 _14183_/A2 _14183_/B _14216_/A1 VSS _14183_/VNW VSS VSS gf180mcu_fd_sc_mcu9t5v0__aoi21_1
X_10346_ _17195_/A1 _18189_/Q _10349_/A2 VSS VSS VSS VSS gf180mcu_fd_sc_mcu9t5v0__nor2_1
X_18991_ _18991_/D _20143_/RN clkload67/I _18991_/Q VSS VSS VSS VSS gf180mcu_fd_sc_mcu9t5v0__dffrnq_1
X_13134_ _19760_/Q _19794_/Q _13134_/A3 _13138_/A2 VSS VSS VSS VSS gf180mcu_fd_sc_mcu9t5v0__xnor3_1
X_10277_ _18588_/Q _17409_/B _17225_/B _10277_/C _10278_/A3 VSS VSS VSS VSS gf180mcu_fd_sc_mcu9t5v0__oai211_1
X_17942_ _10693_/B _10803_/C _18851_/Q _17943_/A3 VSS VSS VSS VSS gf180mcu_fd_sc_mcu9t5v0__aoi21_1
XTAP_TAPCELL_ROW_89_3430 VSS VSS gf180mcu_fd_sc_mcu9t5v0__filltie
X_13065_ _13044_/Z _13065_/A2 _13065_/B _13067_/A2 VSS _13065_/VNW VSS VSS gf180mcu_fd_sc_mcu9t5v0__aoi21_1
X_12016_ _18377_/Q _12090_/B _12017_/A2 VSS VSS VSS VSS gf180mcu_fd_sc_mcu9t5v0__nand2_1
XTAP_TAPCELL_ROW_89_3441 VSS VSS gf180mcu_fd_sc_mcu9t5v0__filltie
X_17873_ _17878_/A2 _17873_/A2 _17874_/I VSS _17873_/VNW VSS VSS gf180mcu_fd_sc_mcu9t5v0__nand2_1
XTAP_TAPCELL_ROW_128_4489 VSS VSS gf180mcu_fd_sc_mcu9t5v0__filltie
XTAP_TAPCELL_ROW_256_6123 VSS VSS gf180mcu_fd_sc_mcu9t5v0__filltie
XTAP_TAPCELL_ROW_256_6112 VSS VSS gf180mcu_fd_sc_mcu9t5v0__filltie
X_16824_ _18406_/Q _16824_/I1 _16824_/S _18406_/D VSS _16824_/VNW VSS VSS gf180mcu_fd_sc_mcu9t5v0__mux2_1
XTAP_TAPCELL_ROW_256_6101 VSS VSS gf180mcu_fd_sc_mcu9t5v0__filltie
XTAP_TAPCELL_ROW_85_3327 VSS VSS gf180mcu_fd_sc_mcu9t5v0__filltie
X_19612_ _19612_/D _20060_/RN clkload21/I _19612_/Q VSS VSS VSS VSS gf180mcu_fd_sc_mcu9t5v0__dffrnq_1
XTAP_TAPCELL_ROW_85_3316 VSS VSS gf180mcu_fd_sc_mcu9t5v0__filltie
Xclone234 _09700_/A1 _15855_/A1 _17763_/A3 _15936_/B _15989_/A3 VSS VSS VSS VSS gf180mcu_fd_sc_mcu9t5v0__oai31_4
XTAP_TAPCELL_ROW_252_6009 VSS VSS gf180mcu_fd_sc_mcu9t5v0__filltie
X_16755_ _16763_/S _16678_/B _16755_/B _16756_/I0 VSS VSS VSS VSS gf180mcu_fd_sc_mcu9t5v0__oai21_1
X_13967_ _13967_/A1 _13933_/Z _13967_/B _13976_/A2 VSS VSS VSS VSS gf180mcu_fd_sc_mcu9t5v0__oai21_1
X_19543_ _19543_/D _20055_/RN clkload10/I _19543_/Q VSS VSS VSS VSS gf180mcu_fd_sc_mcu9t5v0__dffrnq_1
X_16686_ _19246_/Q _16750_/A1 _16686_/A3 _16695_/B _16688_/B VSS _16686_/VNW VSS VSS
+ gf180mcu_fd_sc_mcu9t5v0__nand4_1
X_15706_ _15747_/A2 _15703_/Z _15704_/Z _15706_/B2 _15707_/I0 VSS VSS VSS VSS gf180mcu_fd_sc_mcu9t5v0__aoi22_1
X_12918_ _12918_/A1 _12918_/A2 _12918_/B _12920_/A2 VSS VSS VSS VSS gf180mcu_fd_sc_mcu9t5v0__oai21_1
X_19474_ _19474_/D _20050_/RN clkload14/I _19474_/Q VSS VSS VSS VSS gf180mcu_fd_sc_mcu9t5v0__dffrnq_1
XTAP_TAPCELL_ROW_1_1002 VSS VSS gf180mcu_fd_sc_mcu9t5v0__filltie
XTAP_TAPCELL_ROW_1_1013 VSS VSS gf180mcu_fd_sc_mcu9t5v0__filltie
X_18425_ _18425_/D clkload52/I _18425_/Q VSS VSS VSS VSS gf180mcu_fd_sc_mcu9t5v0__dffq_1
X_15637_ _15672_/B _15636_/Z _19897_/D VSS VSS VSS VSS gf180mcu_fd_sc_mcu9t5v0__nor2_1
X_13898_ _13881_/Z _13910_/A2 _13898_/Z VSS VSS VSS VSS gf180mcu_fd_sc_mcu9t5v0__xor2_1
X_12849_ _19767_/Q _12848_/Z _12853_/B VSS _13229_/VNW VSS VSS gf180mcu_fd_sc_mcu9t5v0__nand2_1
X_18356_ _18356_/D clkload75/I _18356_/Q VSS VSS VSS VSS gf180mcu_fd_sc_mcu9t5v0__dffq_1
X_15568_ _19876_/Q _15564_/Z _15571_/A3 VSS VSS VSS VSS gf180mcu_fd_sc_mcu9t5v0__nand2_1
XTAP_TAPCELL_ROW_61_2670 VSS VSS gf180mcu_fd_sc_mcu9t5v0__filltie
X_17307_ _18613_/Q _17306_/C _17307_/B _17308_/A2 VSS VSS VSS VSS gf180mcu_fd_sc_mcu9t5v0__aoi21_1
X_15499_ _17422_/S _15498_/Z _19836_/D VSS VSS VSS VSS gf180mcu_fd_sc_mcu9t5v0__and2_1
X_18287_ _18287_/D _20132_/CLK _18287_/Q VSS VSS VSS VSS gf180mcu_fd_sc_mcu9t5v0__dffq_1
X_14519_ _19131_/Q wire199/I _14519_/B _14521_/A2 VSS _14732_/VNW VSS VSS gf180mcu_fd_sc_mcu9t5v0__oai21_1
X_17238_ _18480_/Q _17282_/A2 _17282_/B1 _18496_/Q _17275_/C _17239_/B VSS VSS VSS
+ VSS gf180mcu_fd_sc_mcu9t5v0__aoi221_1
X_17169_ _17198_/A1 _17169_/A2 _17169_/A3 _17169_/B _17177_/A1 VSS VSS VSS VSS gf180mcu_fd_sc_mcu9t5v0__oai31_1
XTAP_TAPCELL_ROW_241_5702 VSS VSS gf180mcu_fd_sc_mcu9t5v0__filltie
X_09991_ _09991_/A1 _09991_/A2 _09991_/A3 _09995_/B VSS VSS VSS VSS gf180mcu_fd_sc_mcu9t5v0__nand3_1
XTAP_TAPCELL_ROW_70_2917 VSS VSS gf180mcu_fd_sc_mcu9t5v0__filltie
XTAP_TAPCELL_ROW_70_2906 VSS VSS gf180mcu_fd_sc_mcu9t5v0__filltie
XTAP_TAPCELL_ROW_226_5292 VSS VSS gf180mcu_fd_sc_mcu9t5v0__filltie
XTAP_TAPCELL_ROW_226_5281 VSS VSS gf180mcu_fd_sc_mcu9t5v0__filltie
XTAP_TAPCELL_ROW_55_2485 VSS VSS gf180mcu_fd_sc_mcu9t5v0__filltie
XTAP_TAPCELL_ROW_55_2496 VSS VSS gf180mcu_fd_sc_mcu9t5v0__filltie
XTAP_TAPCELL_ROW_222_5167 VSS VSS gf180mcu_fd_sc_mcu9t5v0__filltie
XTAP_TAPCELL_ROW_222_5189 VSS VSS gf180mcu_fd_sc_mcu9t5v0__filltie
XTAP_TAPCELL_ROW_222_5178 VSS VSS gf180mcu_fd_sc_mcu9t5v0__filltie
XTAP_TAPCELL_ROW_239_5631 VSS VSS gf180mcu_fd_sc_mcu9t5v0__filltie
XTAP_TAPCELL_ROW_68_2846 VSS VSS gf180mcu_fd_sc_mcu9t5v0__filltie
XTAP_TAPCELL_ROW_239_5653 VSS VSS gf180mcu_fd_sc_mcu9t5v0__filltie
XTAP_TAPCELL_ROW_239_5642 VSS VSS gf180mcu_fd_sc_mcu9t5v0__filltie
XTAP_TAPCELL_ROW_68_2857 VSS VSS gf180mcu_fd_sc_mcu9t5v0__filltie
XTAP_TAPCELL_ROW_235_5539 VSS VSS gf180mcu_fd_sc_mcu9t5v0__filltie
XTAP_TAPCELL_ROW_235_5528 VSS VSS gf180mcu_fd_sc_mcu9t5v0__filltie
X_09425_ _09448_/B _09615_/A1 _15941_/A3 VSS VSS VSS VSS gf180mcu_fd_sc_mcu9t5v0__nor2_4
X_09356_ _18281_/Q _11566_/A1 VSS _16625_/VNW VSS VSS gf180mcu_fd_sc_mcu9t5v0__clkinv_1
X_09287_ _19248_/Q _16695_/A1 VSS VSS VSS VSS gf180mcu_fd_sc_mcu9t5v0__clkinv_1
XTAP_TAPCELL_ROW_211_4882 VSS VSS gf180mcu_fd_sc_mcu9t5v0__filltie
XTAP_TAPCELL_ROW_211_4871 VSS VSS gf180mcu_fd_sc_mcu9t5v0__filltie
XTAP_TAPCELL_ROW_211_4860 VSS VSS gf180mcu_fd_sc_mcu9t5v0__filltie
XTAP_TAPCELL_ROW_323_7982 VSS VSS gf180mcu_fd_sc_mcu9t5v0__filltie
XTAP_TAPCELL_ROW_323_7971 VSS VSS gf180mcu_fd_sc_mcu9t5v0__filltie
XTAP_TAPCELL_ROW_323_7960 VSS VSS gf180mcu_fd_sc_mcu9t5v0__filltie
X_10200_ _10200_/A1 _10200_/A2 _15672_/B _20047_/D VSS VSS VSS VSS gf180mcu_fd_sc_mcu9t5v0__aoi21_1
XTAP_TAPCELL_ROW_323_7993 VSS VSS gf180mcu_fd_sc_mcu9t5v0__filltie
X_11180_ _11428_/B _11178_/Z _11526_/B _11181_/A2 VSS VSS VSS VSS gf180mcu_fd_sc_mcu9t5v0__aoi21_1
X_10131_ _10106_/B _10131_/A2 _10131_/B _10131_/C _10132_/B2 VSS VSS VSS VSS gf180mcu_fd_sc_mcu9t5v0__aoi211_1
X_10062_ _10062_/I _10063_/B1 VSS VSS VSS VSS gf180mcu_fd_sc_mcu9t5v0__clkinv_1
XTAP_TAPCELL_ROW_123_4364 VSS VSS gf180mcu_fd_sc_mcu9t5v0__filltie
XTAP_TAPCELL_ROW_123_4353 VSS VSS gf180mcu_fd_sc_mcu9t5v0__filltie
X_14870_ _19591_/Q _14870_/I1 _20039_/D _19591_/D VSS VSS VSS VSS gf180mcu_fd_sc_mcu9t5v0__mux2_1
XTAP_TAPCELL_ROW_317_7797 VSS VSS gf180mcu_fd_sc_mcu9t5v0__filltie
XTAP_TAPCELL_ROW_317_7786 VSS VSS gf180mcu_fd_sc_mcu9t5v0__filltie
XTAP_TAPCELL_ROW_317_7775 VSS VSS gf180mcu_fd_sc_mcu9t5v0__filltie
XTAP_TAPCELL_ROW_123_4375 VSS VSS gf180mcu_fd_sc_mcu9t5v0__filltie
X_13821_ _19317_/Q _19296_/Q _19297_/Q _19316_/Q _13822_/A2 VSS _13928_/VNW VSS VSS
+ gf180mcu_fd_sc_mcu9t5v0__aoi22_1
X_16540_ _16539_/Z _18326_/Q _17054_/S _18326_/D VSS VSS VSS VSS gf180mcu_fd_sc_mcu9t5v0__mux2_4
X_13752_ wire199/Z _13752_/A2 _13753_/C VSS _14677_/VNW VSS VSS gf180mcu_fd_sc_mcu9t5v0__nand2_1
X_10964_ _10964_/I0 _19011_/Q _18148_/S _19011_/D VSS VSS VSS VSS gf180mcu_fd_sc_mcu9t5v0__mux2_1
X_12703_ _12706_/A3 _12703_/A2 _12703_/Z VSS VSS VSS VSS gf180mcu_fd_sc_mcu9t5v0__xor2_1
X_18210_ _18210_/D clkload80/I _18210_/Q VSS VSS VSS VSS gf180mcu_fd_sc_mcu9t5v0__dffq_1
X_16471_ _19241_/Q _16182_/B _16993_/S _16471_/Z VSS _16472_/VNW VSS VSS gf180mcu_fd_sc_mcu9t5v0__mux2_1
X_10895_ _19244_/Q _19250_/Q _18151_/S _10895_/Z VSS VSS VSS VSS gf180mcu_fd_sc_mcu9t5v0__mux2_1
X_13683_ _19143_/Q _13683_/A2 _13686_/A2 VSS VSS VSS VSS gf180mcu_fd_sc_mcu9t5v0__nor2_1
X_15422_ _19707_/Q _19807_/Q _15430_/S _19807_/D VSS _15422_/VNW VSS VSS gf180mcu_fd_sc_mcu9t5v0__mux2_1
X_19190_ _19190_/D _20022_/RN clkload13/I _19190_/Q VSS VSS VSS VSS gf180mcu_fd_sc_mcu9t5v0__dffrnq_1
X_12634_ _11594_/Z _12634_/A2 _12648_/B VSS VSS VSS VSS gf180mcu_fd_sc_mcu9t5v0__nor2_1
XTAP_TAPCELL_ROW_78_3120 VSS VSS gf180mcu_fd_sc_mcu9t5v0__filltie
X_12565_ _18354_/Q _12613_/A2 _12569_/A2 VSS VSS VSS VSS gf180mcu_fd_sc_mcu9t5v0__nor2_1
X_18141_ _19215_/Q _19221_/Q _18151_/S _18141_/Z VSS VSS VSS VSS gf180mcu_fd_sc_mcu9t5v0__mux2_1
XTAP_TAPCELL_ROW_78_3131 VSS VSS gf180mcu_fd_sc_mcu9t5v0__filltie
X_15353_ _15353_/A1 _15347_/Z _15354_/A2 VSS VSS VSS VSS gf180mcu_fd_sc_mcu9t5v0__nand2_1
X_11516_ _19103_/Q _11541_/A2 _11517_/A2 VSS _11516_/VNW VSS VSS gf180mcu_fd_sc_mcu9t5v0__nand2_1
X_18072_ _18072_/A1 _18072_/A2 _18928_/D VSS VSS VSS VSS gf180mcu_fd_sc_mcu9t5v0__nand2_1
XTAP_TAPCELL_ROW_74_3017 VSS VSS gf180mcu_fd_sc_mcu9t5v0__filltie
XTAP_TAPCELL_ROW_74_3006 VSS VSS gf180mcu_fd_sc_mcu9t5v0__filltie
X_14304_ _14322_/I0 _19377_/Q _14304_/S _19377_/D VSS VSS VSS VSS gf180mcu_fd_sc_mcu9t5v0__mux2_1
X_17023_ _19258_/Q _16668_/B _17023_/S _17023_/Z VSS VSS VSS VSS gf180mcu_fd_sc_mcu9t5v0__mux2_1
Xwire163 wire163/I wire163/Z VSS VSS VSS VSS gf180mcu_fd_sc_mcu9t5v0__buf_4
XTAP_TAPCELL_ROW_74_3028 VSS VSS gf180mcu_fd_sc_mcu9t5v0__filltie
Xwire174 wire174/I wire174/Z VSS wire174/VNW VSS VSS gf180mcu_fd_sc_mcu9t5v0__buf_4
X_12496_ _19158_/Q _12488_/I _12497_/B VSS _12496_/VNW VSS VSS gf180mcu_fd_sc_mcu9t5v0__nand2_1
X_15284_ _15283_/B _15284_/A2 _15285_/I0 VSS VSS VSS VSS gf180mcu_fd_sc_mcu9t5v0__xnor2_1
X_11447_ _11526_/B _11447_/A2 _11447_/B1 _11447_/B2 _11788_/B _11448_/B2 VSS VSS VSS
+ VSS gf180mcu_fd_sc_mcu9t5v0__aoi221_4
XPHY_EDGE_ROW_137_2_Right_868 VSS VSS gf180mcu_fd_sc_mcu9t5v0__endcap
X_14235_ _14262_/A1 _14235_/A2 _14238_/A3 VSS VSS VSS VSS gf180mcu_fd_sc_mcu9t5v0__xnor2_1
X_11378_ _18364_/Q _11098_/B wire283/I _11379_/B2 VSS VSS VSS VSS gf180mcu_fd_sc_mcu9t5v0__aoi21_1
XTAP_TAPCELL_ROW_281_6794 VSS VSS gf180mcu_fd_sc_mcu9t5v0__filltie
X_14166_ _14715_/S _14165_/Z _14166_/B _14167_/B2 VSS _14166_/VNW VSS VSS gf180mcu_fd_sc_mcu9t5v0__aoi21_1
X_10329_ _20081_/Q _17408_/B _10330_/B VSS VSS VSS VSS gf180mcu_fd_sc_mcu9t5v0__nand2_1
X_13117_ _19759_/Q _19793_/Q _13117_/A3 _13544_/A2 VSS VSS VSS VSS gf180mcu_fd_sc_mcu9t5v0__xnor3_1
X_18974_ _18974_/D _20062_/RN clkload66/I _18974_/Q VSS VSS VSS VSS gf180mcu_fd_sc_mcu9t5v0__dffrnq_1
X_14097_ _14102_/A1 _14102_/A2 _14099_/C VSS VSS VSS VSS gf180mcu_fd_sc_mcu9t5v0__xor2_1
X_13048_ _13184_/A1 _13048_/A2 _13320_/B _13049_/B2 VSS VSS VSS VSS gf180mcu_fd_sc_mcu9t5v0__aoi21_1
X_17925_ _18846_/Q _17925_/A2 _17925_/Z VSS _17926_/VNW VSS VSS gf180mcu_fd_sc_mcu9t5v0__xor2_1
XTAP_TAPCELL_ROW_50_2360 VSS VSS gf180mcu_fd_sc_mcu9t5v0__filltie
Xeco14_skew_4 clkload61/I _18509_/CLK VSS VSS VSS VSS gf180mcu_fd_sc_mcu9t5v0__clkbuf_16
X_17856_ _18826_/Q _17853_/Z _17856_/Z VSS _17856_/VNW VSS VSS gf180mcu_fd_sc_mcu9t5v0__and2_1
XTAP_TAPCELL_ROW_50_2371 VSS VSS gf180mcu_fd_sc_mcu9t5v0__filltie
X_16807_ _19284_/Q _16628_/B _16955_/S _16807_/Z VSS _16807_/VNW VSS VSS gf180mcu_fd_sc_mcu9t5v0__mux2_1
X_17787_ _18767_/Q _17784_/Z _17790_/A2 VSS VSS VSS VSS gf180mcu_fd_sc_mcu9t5v0__nand2_1
X_16738_ _16114_/Z _16738_/A2 _16738_/B _18373_/D VSS VSS VSS VSS gf180mcu_fd_sc_mcu9t5v0__oai21_1
X_19526_ _19526_/D _20038_/RN clkload15/I _19526_/Q VSS VSS VSS VSS gf180mcu_fd_sc_mcu9t5v0__dffrnq_1
X_14999_ _19377_/Q _19433_/Q _15017_/A2 VSS _15334_/VNW VSS VSS gf180mcu_fd_sc_mcu9t5v0__nand2_1
XTAP_TAPCELL_ROW_106_3894 VSS VSS gf180mcu_fd_sc_mcu9t5v0__filltie
Xload_slew82 _16949_/S _16955_/S VSS VSS VSS VSS gf180mcu_fd_sc_mcu9t5v0__clkbuf_8
Xclkbuf_leaf_20_clk_regs clkload4/I clkload59/I VSS _17091_/VNW VSS VSS gf180mcu_fd_sc_mcu9t5v0__clkbuf_8
XTAP_TAPCELL_ROW_63_2710 VSS VSS gf180mcu_fd_sc_mcu9t5v0__filltie
XTAP_TAPCELL_ROW_63_2721 VSS VSS gf180mcu_fd_sc_mcu9t5v0__filltie
X_16669_ _15996_/B _16669_/A2 _16669_/A3 _16669_/B _16670_/I1 VSS VSS VSS VSS gf180mcu_fd_sc_mcu9t5v0__oai31_1
X_19457_ _19457_/D _20033_/RN clkload15/I _19457_/Q VSS VSS VSS VSS gf180mcu_fd_sc_mcu9t5v0__dffrnq_1
X_18408_ _18408_/D clkload82/I _18408_/Q VSS VSS VSS VSS gf180mcu_fd_sc_mcu9t5v0__dffq_1
XTAP_TAPCELL_ROW_230_5403 VSS VSS gf180mcu_fd_sc_mcu9t5v0__filltie
X_09210_ _19559_/Q _15181_/B2 VSS VSS VSS VSS gf180mcu_fd_sc_mcu9t5v0__clkinv_1
XTAP_TAPCELL_ROW_44_2186 VSS VSS gf180mcu_fd_sc_mcu9t5v0__filltie
X_19388_ _19388_/D _20028_/RN clkload21/I _19388_/Q VSS VSS VSS VSS gf180mcu_fd_sc_mcu9t5v0__dffrnq_1
X_18339_ _18339_/D clkload80/I _18339_/Q VSS VSS VSS VSS gf180mcu_fd_sc_mcu9t5v0__dffq_1
X_09141_ _19734_/Q _12843_/B VSS _09141_/VNW VSS VSS gf180mcu_fd_sc_mcu9t5v0__clkinv_1
XTAP_TAPCELL_ROW_44_2197 VSS VSS gf180mcu_fd_sc_mcu9t5v0__filltie
X_09072_ _19839_/Q _15505_/A1 VSS _15509_/VNW VSS VSS gf180mcu_fd_sc_mcu9t5v0__clkinv_1
XTAP_TAPCELL_ROW_228_5343 VSS VSS gf180mcu_fd_sc_mcu9t5v0__filltie
XTAP_TAPCELL_ROW_228_5332 VSS VSS gf180mcu_fd_sc_mcu9t5v0__filltie
XTAP_TAPCELL_ROW_57_2547 VSS VSS gf180mcu_fd_sc_mcu9t5v0__filltie
XTAP_TAPCELL_ROW_57_2558 VSS VSS gf180mcu_fd_sc_mcu9t5v0__filltie
XTAP_TAPCELL_ROW_228_5354 VSS VSS gf180mcu_fd_sc_mcu9t5v0__filltie
XTAP_TAPCELL_ROW_224_5218 VSS VSS gf180mcu_fd_sc_mcu9t5v0__filltie
XTAP_TAPCELL_ROW_224_5229 VSS VSS gf180mcu_fd_sc_mcu9t5v0__filltie
X_09974_ _19991_/Q _15825_/A1 _09974_/B _09974_/C _09975_/C VSS VSS VSS VSS gf180mcu_fd_sc_mcu9t5v0__oai211_1
X_20094_ _20094_/D clkload59/I _20094_/Q VSS VSS VSS VSS gf180mcu_fd_sc_mcu9t5v0__dffq_1
XTAP_TAPCELL_ROW_33_1890 VSS VSS gf180mcu_fd_sc_mcu9t5v0__filltie
XTAP_TAPCELL_ROW_312_7661 VSS VSS gf180mcu_fd_sc_mcu9t5v0__filltie
XTAP_TAPCELL_ROW_312_7650 VSS VSS gf180mcu_fd_sc_mcu9t5v0__filltie
XTAP_TAPCELL_ROW_1_997 VSS VSS gf180mcu_fd_sc_mcu9t5v0__filltie
X_10680_ _17411_/C _10822_/A1 _17231_/A3 _10680_/B _10681_/I1 VSS VSS VSS VSS gf180mcu_fd_sc_mcu9t5v0__oai31_4
X_09408_ _20140_/Q _20142_/Q _09408_/Z VSS _15847_/VNW VSS VSS gf180mcu_fd_sc_mcu9t5v0__or2_1
XTAP_TAPCELL_ROW_213_4933 VSS VSS gf180mcu_fd_sc_mcu9t5v0__filltie
XTAP_TAPCELL_ROW_213_4922 VSS VSS gf180mcu_fd_sc_mcu9t5v0__filltie
X_09339_ _19243_/Q _16438_/A1 VSS VSS VSS VSS gf180mcu_fd_sc_mcu9t5v0__clkinv_1
XPHY_EDGE_ROW_109_Right_109 VSS VSS gf180mcu_fd_sc_mcu9t5v0__endcap
X_12350_ _12350_/A1 _12350_/A2 _12351_/A2 VSS VSS VSS VSS gf180mcu_fd_sc_mcu9t5v0__xnor2_4
XTAP_TAPCELL_ROW_112_4054 VSS VSS gf180mcu_fd_sc_mcu9t5v0__filltie
XTAP_TAPCELL_ROW_321_7908 VSS VSS gf180mcu_fd_sc_mcu9t5v0__filltie
XTAP_TAPCELL_ROW_306_7487 VSS VSS gf180mcu_fd_sc_mcu9t5v0__filltie
X_12281_ _18389_/Q _12280_/Z _12324_/B _12281_/Z VSS _17339_/VNW VSS VSS gf180mcu_fd_sc_mcu9t5v0__mux2_1
XTAP_TAPCELL_ROW_306_7476 VSS VSS gf180mcu_fd_sc_mcu9t5v0__filltie
X_11301_ _11301_/A1 _11301_/A2 _11469_/B _11301_/C _11302_/B VSS VSS VSS VSS gf180mcu_fd_sc_mcu9t5v0__oai211_1
XTAP_TAPCELL_ROW_112_4076 VSS VSS gf180mcu_fd_sc_mcu9t5v0__filltie
XTAP_TAPCELL_ROW_112_4065 VSS VSS gf180mcu_fd_sc_mcu9t5v0__filltie
XTAP_TAPCELL_ROW_306_7498 VSS VSS gf180mcu_fd_sc_mcu9t5v0__filltie
X_11232_ _18178_/Q _11520_/B _11232_/B _11241_/A2 VSS VSS VSS VSS gf180mcu_fd_sc_mcu9t5v0__oai21_1
X_14020_ _14020_/I _14021_/A2 VSS VSS VSS VSS gf180mcu_fd_sc_mcu9t5v0__clkinv_1
XTAP_TAPCELL_ROW_298_7277 VSS VSS gf180mcu_fd_sc_mcu9t5v0__filltie
XTAP_TAPCELL_ROW_298_7266 VSS VSS gf180mcu_fd_sc_mcu9t5v0__filltie
XTAP_TAPCELL_ROW_298_7255 VSS VSS gf180mcu_fd_sc_mcu9t5v0__filltie
X_11163_ _11788_/B _11163_/A2 _11164_/B2 VSS VSS VSS VSS gf180mcu_fd_sc_mcu9t5v0__nor2_1
XPHY_EDGE_ROW_208_1_Left_531 VSS VSS gf180mcu_fd_sc_mcu9t5v0__endcap
XTAP_TAPCELL_ROW_129_4540 VSS VSS gf180mcu_fd_sc_mcu9t5v0__filltie
XTAP_TAPCELL_ROW_125_4426 VSS VSS gf180mcu_fd_sc_mcu9t5v0__filltie
X_10114_ _10114_/A1 _10114_/A2 _10132_/A2 VSS VSS VSS VSS gf180mcu_fd_sc_mcu9t5v0__nand2_1
XTAP_TAPCELL_ROW_125_4415 VSS VSS gf180mcu_fd_sc_mcu9t5v0__filltie
XTAP_TAPCELL_ROW_319_7848 VSS VSS gf180mcu_fd_sc_mcu9t5v0__filltie
XTAP_TAPCELL_ROW_319_7837 VSS VSS gf180mcu_fd_sc_mcu9t5v0__filltie
X_11094_ _18567_/Q wire163/I _11094_/B _11510_/B VSS VSS VSS VSS gf180mcu_fd_sc_mcu9t5v0__oai21_2
X_15971_ _20067_/Q _18787_/Q _16619_/S _15971_/Z VSS VSS VSS VSS gf180mcu_fd_sc_mcu9t5v0__mux2_4
X_17710_ _18731_/Q _17673_/S _17743_/B _18655_/Q _17711_/I VSS _17710_/VNW VSS VSS
+ gf180mcu_fd_sc_mcu9t5v0__aoi22_1
X_14922_ _19359_/Q _19420_/Q _14923_/B VSS _14922_/VNW VSS VSS gf180mcu_fd_sc_mcu9t5v0__xor2_1
X_10045_ _18810_/Q _10153_/A2 _10153_/B _10047_/A2 VSS VSS VSS VSS gf180mcu_fd_sc_mcu9t5v0__oai21_1
X_18690_ _18690_/D _20030_/RN clkload24/I _18690_/Q VSS VSS VSS VSS gf180mcu_fd_sc_mcu9t5v0__dffrnq_1
X_17641_ _18689_/Q _17747_/A4 _17643_/B VSS VSS VSS VSS gf180mcu_fd_sc_mcu9t5v0__nand2_1
X_14853_ _19409_/Q _14853_/A2 _14854_/I1 VSS VSS VSS VSS gf180mcu_fd_sc_mcu9t5v0__xnor2_1
X_13804_ _13802_/Z _13805_/A2 _13834_/A1 VSS VSS VSS VSS gf180mcu_fd_sc_mcu9t5v0__nand2_1
X_11996_ _18296_/Q _12340_/S _12345_/B _11997_/B1 VSS _11996_/VNW VSS VSS gf180mcu_fd_sc_mcu9t5v0__aoi21_1
X_17572_ _18643_/Q _17571_/S _17574_/A1 VSS _17572_/VNW VSS VSS gf180mcu_fd_sc_mcu9t5v0__nand2_1
X_14784_ _19397_/Q _19334_/Q _14786_/A1 _14785_/I1 VSS VSS VSS VSS gf180mcu_fd_sc_mcu9t5v0__xnor3_1
X_19311_ _19311_/D _20143_/RN clkload20/I _19311_/Q VSS VSS VSS VSS gf180mcu_fd_sc_mcu9t5v0__dffrnq_1
X_16523_ _16142_/C _19233_/Q _17055_/S _16523_/Z VSS VSS VSS VSS gf180mcu_fd_sc_mcu9t5v0__mux2_1
XTAP_TAPCELL_ROW_270_6484 VSS VSS gf180mcu_fd_sc_mcu9t5v0__filltie
X_10947_ _18929_/Q _18936_/Q _10947_/B _10952_/A1 VSS VSS VSS VSS gf180mcu_fd_sc_mcu9t5v0__aoi21_1
X_13735_ _19447_/Q _14286_/A2 _13745_/B1 _19464_/Q _13745_/C _13744_/B1 VSS VSS VSS
+ VSS gf180mcu_fd_sc_mcu9t5v0__aoi221_1
X_16454_ _18285_/Q _16453_/Z _16986_/S _18285_/D VSS VSS VSS VSS gf180mcu_fd_sc_mcu9t5v0__mux2_4
XTAP_TAPCELL_ROW_270_6495 VSS VSS gf180mcu_fd_sc_mcu9t5v0__filltie
X_19242_ _19242_/D _20138_/RN clkload69/I _19242_/Q VSS VSS VSS VSS gf180mcu_fd_sc_mcu9t5v0__dffrnq_1
X_13666_ _13666_/A1 _19107_/Q _13666_/B _13675_/A2 VSS _13666_/VNW VSS VSS gf180mcu_fd_sc_mcu9t5v0__oai21_1
X_12617_ _12616_/B _12617_/A2 _12617_/A3 _12617_/B1 _12617_/B2 _12618_/A2 VSS VSS
+ VSS VSS gf180mcu_fd_sc_mcu9t5v0__oai32_4
X_10878_ _10877_/Z _18978_/Q _18152_/S _18978_/D VSS VSS VSS VSS gf180mcu_fd_sc_mcu9t5v0__mux2_1
X_19173_ _19173_/D _20069_/RN clkload43/I _19173_/Q VSS VSS VSS VSS gf180mcu_fd_sc_mcu9t5v0__dffrnq_1
X_15405_ _19690_/Q _19790_/Q _15430_/S _19790_/D VSS VSS VSS VSS gf180mcu_fd_sc_mcu9t5v0__mux2_1
X_16385_ _16151_/B _19235_/Q _16925_/S _16385_/Z VSS VSS VSS VSS gf180mcu_fd_sc_mcu9t5v0__mux2_1
XTAP_TAPCELL_ROW_287_6970 VSS VSS gf180mcu_fd_sc_mcu9t5v0__filltie
X_18124_ _18124_/A1 _18147_/S _18132_/B _18125_/I0 VSS VSS VSS VSS gf180mcu_fd_sc_mcu9t5v0__oai21_1
X_13597_ _19282_/Q _13320_/B _13601_/B VSS VSS VSS VSS gf180mcu_fd_sc_mcu9t5v0__nand2_1
XTAP_TAPCELL_ROW_283_6856 VSS VSS gf180mcu_fd_sc_mcu9t5v0__filltie
XTAP_TAPCELL_ROW_283_6845 VSS VSS gf180mcu_fd_sc_mcu9t5v0__filltie
X_12548_ _12548_/A1 _12548_/A2 _12620_/A2 VSS _13063_/VNW VSS VSS gf180mcu_fd_sc_mcu9t5v0__nand2_1
X_15336_ _19644_/Q _19621_/Q _15345_/A1 VSS VSS VSS VSS gf180mcu_fd_sc_mcu9t5v0__nor2_1
X_12479_ _18216_/Q wire163/Z _12482_/A3 VSS VSS VSS VSS gf180mcu_fd_sc_mcu9t5v0__nor2_1
XANTENNA_2 _11515_/B2 VSS VSS VSS VSS gf180mcu_fd_sc_mcu9t5v0__antenna
X_18055_ _18923_/Q _18060_/B _18058_/A2 VSS VSS VSS VSS gf180mcu_fd_sc_mcu9t5v0__nor2_1
X_15267_ _19732_/Q _15267_/I1 _15364_/S _19732_/D VSS VSS VSS VSS gf180mcu_fd_sc_mcu9t5v0__mux2_1
X_17006_ _18494_/Q _17005_/Z _17006_/S _18494_/D VSS VSS VSS VSS gf180mcu_fd_sc_mcu9t5v0__mux2_1
XPHY_EDGE_ROW_138_2_Right_869 VSS VSS gf180mcu_fd_sc_mcu9t5v0__endcap
X_14218_ _14218_/I _14237_/A1 VSS _14240_/VNW VSS VSS gf180mcu_fd_sc_mcu9t5v0__clkinv_1
XTAP_TAPCELL_ROW_52_2400 VSS VSS gf180mcu_fd_sc_mcu9t5v0__filltie
X_15198_ _15204_/B1 _15204_/B2 _15204_/C _15200_/A3 VSS _15198_/VNW VSS VSS gf180mcu_fd_sc_mcu9t5v0__aoi21_1
XTAP_TAPCELL_ROW_52_2411 VSS VSS gf180mcu_fd_sc_mcu9t5v0__filltie
XTAP_TAPCELL_ROW_52_2422 VSS VSS gf180mcu_fd_sc_mcu9t5v0__filltie
X_14149_ _19476_/Q _19484_/Q _14165_/S _14149_/Z VSS _14610_/VNW VSS VSS gf180mcu_fd_sc_mcu9t5v0__mux2_1
X_18957_ _18957_/D _20045_/RN _20132_/CLK _18957_/Q VSS VSS VSS VSS gf180mcu_fd_sc_mcu9t5v0__dffrnq_1
X_09690_ _17426_/A1 _20011_/Q _09694_/A1 VSS VSS VSS VSS gf180mcu_fd_sc_mcu9t5v0__nand2_1
XTAP_TAPCELL_ROW_108_3956 VSS VSS gf180mcu_fd_sc_mcu9t5v0__filltie
X_17908_ _17912_/A3 _17908_/A2 _17910_/A1 VSS VSS VSS VSS gf180mcu_fd_sc_mcu9t5v0__nand2_1
XTAP_TAPCELL_ROW_108_3945 VSS VSS gf180mcu_fd_sc_mcu9t5v0__filltie
X_18888_ _18888_/D _20040_/RN _19680_/CLK _18888_/Q VSS VSS VSS VSS gf180mcu_fd_sc_mcu9t5v0__dffrnq_1
X_17839_ _19046_/Q _18816_/Q _17845_/S _18816_/D VSS _17839_/VNW VSS VSS gf180mcu_fd_sc_mcu9t5v0__mux2_1
XTAP_TAPCELL_ROW_217_5033 VSS VSS gf180mcu_fd_sc_mcu9t5v0__filltie
XTAP_TAPCELL_ROW_46_2237 VSS VSS gf180mcu_fd_sc_mcu9t5v0__filltie
XTAP_TAPCELL_ROW_217_5044 VSS VSS gf180mcu_fd_sc_mcu9t5v0__filltie
X_19509_ _19509_/D _20021_/RN clkload22/I _19509_/Q VSS VSS VSS VSS gf180mcu_fd_sc_mcu9t5v0__dffrnq_1
XTAP_TAPCELL_ROW_46_2248 VSS VSS gf180mcu_fd_sc_mcu9t5v0__filltie
XTAP_TAPCELL_ROW_46_2259 VSS VSS gf180mcu_fd_sc_mcu9t5v0__filltie
XTAP_TAPCELL_ROW_59_2609 VSS VSS gf180mcu_fd_sc_mcu9t5v0__filltie
X_09124_ _19756_/Q _13063_/A2 VSS VSS VSS VSS gf180mcu_fd_sc_mcu9t5v0__clkinv_1
XTAP_TAPCELL_ROW_22_1580 VSS VSS gf180mcu_fd_sc_mcu9t5v0__filltie
XTAP_TAPCELL_ROW_22_1591 VSS VSS gf180mcu_fd_sc_mcu9t5v0__filltie
XTAP_TAPCELL_ROW_301_7340 VSS VSS gf180mcu_fd_sc_mcu9t5v0__filltie
XTAP_TAPCELL_ROW_301_7351 VSS VSS gf180mcu_fd_sc_mcu9t5v0__filltie
XTAP_TAPCELL_ROW_293_7130 VSS VSS gf180mcu_fd_sc_mcu9t5v0__filltie
XTAP_TAPCELL_ROW_35_1941 VSS VSS gf180mcu_fd_sc_mcu9t5v0__filltie
XTAP_TAPCELL_ROW_35_1952 VSS VSS gf180mcu_fd_sc_mcu9t5v0__filltie
X_09957_ _18797_/Q _18795_/Q _18796_/Q _18792_/Q _09957_/Z VSS VSS VSS VSS gf180mcu_fd_sc_mcu9t5v0__and4_1
XTAP_TAPCELL_ROW_293_7141 VSS VSS gf180mcu_fd_sc_mcu9t5v0__filltie
X_20077_ _20077_/D clkload77/I _20077_/Q VSS VSS VSS VSS gf180mcu_fd_sc_mcu9t5v0__dffq_1
XTAP_TAPCELL_ROW_31_1827 VSS VSS gf180mcu_fd_sc_mcu9t5v0__filltie
XTAP_TAPCELL_ROW_314_7712 VSS VSS gf180mcu_fd_sc_mcu9t5v0__filltie
XTAP_TAPCELL_ROW_314_7701 VSS VSS gf180mcu_fd_sc_mcu9t5v0__filltie
X_09888_ _18750_/Q _17649_/I0 _09888_/B1 _18749_/Q _09888_/C _09889_/A3 VSS VSS VSS
+ VSS gf180mcu_fd_sc_mcu9t5v0__aoi221_1
XTAP_TAPCELL_ROW_31_1838 VSS VSS gf180mcu_fd_sc_mcu9t5v0__filltie
XPHY_EDGE_ROW_227_Right_154 VSS VSS gf180mcu_fd_sc_mcu9t5v0__endcap
XTAP_TAPCELL_ROW_310_7609 VSS VSS gf180mcu_fd_sc_mcu9t5v0__filltie
X_11850_ _12237_/B _11850_/A2 _11850_/B _11884_/A1 VSS VSS VSS VSS gf180mcu_fd_sc_mcu9t5v0__aoi21_4
X_11781_ _18222_/Q _12315_/S _12322_/B _11784_/A2 VSS VSS VSS VSS gf180mcu_fd_sc_mcu9t5v0__aoi21_1
X_10801_ _18852_/Q _10801_/A2 _10803_/A2 VSS VSS VSS VSS gf180mcu_fd_sc_mcu9t5v0__nand2_1
XTAP_TAPCELL_ROW_118_4230 VSS VSS gf180mcu_fd_sc_mcu9t5v0__filltie
X_13520_ _13521_/A1 _13521_/A3 _13520_/B _13525_/A2 VSS _13520_/VNW VSS VSS gf180mcu_fd_sc_mcu9t5v0__aoi21_1
XTAP_TAPCELL_ROW_29_1767 VSS VSS gf180mcu_fd_sc_mcu9t5v0__filltie
XTAP_TAPCELL_ROW_29_1778 VSS VSS gf180mcu_fd_sc_mcu9t5v0__filltie
X_10732_ _10732_/A1 _10751_/A3 _10734_/B VSS VSS VSS VSS gf180mcu_fd_sc_mcu9t5v0__xnor2_1
XPHY_EDGE_ROW_273_Right_200 VSS VSS gf180mcu_fd_sc_mcu9t5v0__endcap
XTAP_TAPCELL_ROW_118_4241 VSS VSS gf180mcu_fd_sc_mcu9t5v0__filltie
XTAP_TAPCELL_ROW_114_4105 VSS VSS gf180mcu_fd_sc_mcu9t5v0__filltie
XTAP_TAPCELL_ROW_29_1789 VSS VSS gf180mcu_fd_sc_mcu9t5v0__filltie
XTAP_TAPCELL_ROW_308_7538 VSS VSS gf180mcu_fd_sc_mcu9t5v0__filltie
XTAP_TAPCELL_ROW_308_7527 VSS VSS gf180mcu_fd_sc_mcu9t5v0__filltie
X_10663_ _18823_/Q _20030_/Q _10667_/B VSS VSS VSS VSS gf180mcu_fd_sc_mcu9t5v0__nand2_1
XTAP_TAPCELL_ROW_114_4127 VSS VSS gf180mcu_fd_sc_mcu9t5v0__filltie
XTAP_TAPCELL_ROW_114_4116 VSS VSS gf180mcu_fd_sc_mcu9t5v0__filltie
X_13451_ _13454_/A1 _19778_/Q _13466_/B VSS _13466_/VNW VSS VSS gf180mcu_fd_sc_mcu9t5v0__nand2_1
XTAP_TAPCELL_ROW_308_7549 VSS VSS gf180mcu_fd_sc_mcu9t5v0__filltie
X_16170_ _18179_/Q _16170_/I1 _16753_/S _18179_/D VSS VSS VSS VSS gf180mcu_fd_sc_mcu9t5v0__mux2_4
X_10594_ _20106_/Q _17304_/C wire168/Z _10594_/C _10595_/A2 VSS VSS VSS VSS gf180mcu_fd_sc_mcu9t5v0__oai211_1
X_13382_ _13497_/A1 _13382_/A2 _13419_/B _13383_/B2 VSS VSS VSS VSS gf180mcu_fd_sc_mcu9t5v0__aoi21_1
X_12402_ wire213/I _12355_/I _12402_/A3 _12402_/B _19146_/D VSS _15147_/VNW VSS VSS
+ gf180mcu_fd_sc_mcu9t5v0__oai31_1
X_15121_ _19663_/Q _19503_/Q wire108/Z _19663_/D VSS VSS VSS VSS gf180mcu_fd_sc_mcu9t5v0__mux2_1
X_12333_ _12548_/A1 _12333_/A2 _12333_/B _12334_/B2 VSS VSS VSS VSS gf180mcu_fd_sc_mcu9t5v0__oai21_1
X_15052_ _19305_/Q _19390_/Q _15052_/B _15055_/A1 VSS VSS VSS VSS gf180mcu_fd_sc_mcu9t5v0__aoi21_1
X_12264_ _18452_/Q _12315_/S _12266_/B1 VSS _16919_/VNW VSS VSS gf180mcu_fd_sc_mcu9t5v0__nand2_1
X_14003_ _14003_/A1 _14044_/A1 _14036_/A2 VSS VSS VSS VSS gf180mcu_fd_sc_mcu9t5v0__nor2_1
X_19860_ _19860_/D _20052_/RN clkload57/I _19860_/Q VSS VSS VSS VSS gf180mcu_fd_sc_mcu9t5v0__dffrnq_1
X_12195_ _12195_/A1 _12195_/A2 _12237_/B _12212_/A1 VSS VSS VSS VSS gf180mcu_fd_sc_mcu9t5v0__oai21_4
X_11215_ _11215_/A1 _11215_/A2 _19080_/D VSS VSS VSS VSS gf180mcu_fd_sc_mcu9t5v0__nand2_1
X_11146_ _18566_/Q _18172_/Q _11148_/B1 VSS VSS VSS VSS gf180mcu_fd_sc_mcu9t5v0__nand2_1
X_19791_ _19791_/D _20047_/RN clkload29/I _19791_/Q VSS VSS VSS VSS gf180mcu_fd_sc_mcu9t5v0__dffrnq_1
X_18811_ _18811_/D _19963_/RN clkload34/I _18811_/Q VSS VSS VSS VSS gf180mcu_fd_sc_mcu9t5v0__dffrnq_1
X_15954_ _15988_/B _15951_/Z _15954_/B _15963_/B1 VSS _15954_/VNW VSS VSS gf180mcu_fd_sc_mcu9t5v0__aoi21_4
X_18742_ _18742_/D clkload47/I _18742_/Q VSS VSS VSS VSS gf180mcu_fd_sc_mcu9t5v0__dffq_1
X_11077_ _18859_/Q _12689_/C _11108_/A2 VSS VSS VSS VSS gf180mcu_fd_sc_mcu9t5v0__nor2_1
XTAP_TAPCELL_ROW_276_6671 VSS VSS gf180mcu_fd_sc_mcu9t5v0__filltie
XTAP_TAPCELL_ROW_276_6660 VSS VSS gf180mcu_fd_sc_mcu9t5v0__filltie
X_10028_ _10028_/A1 _10028_/A2 _10028_/B _10042_/B VSS VSS VSS VSS gf180mcu_fd_sc_mcu9t5v0__aoi21_1
X_14905_ _19597_/Q _14905_/I1 wire108/I _19597_/D VSS VSS VSS VSS gf180mcu_fd_sc_mcu9t5v0__mux2_1
XTAP_TAPCELL_ROW_272_6546 VSS VSS gf180mcu_fd_sc_mcu9t5v0__filltie
X_15885_ _20094_/Q _19229_/Q _15920_/S _20094_/D VSS _16448_/VNW VSS VSS gf180mcu_fd_sc_mcu9t5v0__mux2_1
X_18673_ _18673_/D _20141_/RN clkload55/I _18673_/Q VSS VSS VSS VSS gf180mcu_fd_sc_mcu9t5v0__dffrnq_1
XTAP_TAPCELL_ROW_103_3820 VSS VSS gf180mcu_fd_sc_mcu9t5v0__filltie
XTAP_TAPCELL_ROW_272_6557 VSS VSS gf180mcu_fd_sc_mcu9t5v0__filltie
X_17624_ _18684_/Q _17421_/S _20050_/Q _17625_/A2 VSS VSS VSS VSS gf180mcu_fd_sc_mcu9t5v0__aoi21_1
X_14836_ _19341_/Q _19406_/Q _14837_/B VSS VSS VSS VSS gf180mcu_fd_sc_mcu9t5v0__xor2_1
X_17555_ _18664_/Q input6/Z _17556_/B VSS VSS VSS VSS gf180mcu_fd_sc_mcu9t5v0__nand2_1
X_14767_ _14767_/A1 _14767_/A2 _14767_/B _19555_/D VSS _14767_/VNW VSS VSS gf180mcu_fd_sc_mcu9t5v0__oai21_1
X_16506_ _18310_/Q _16505_/Z _17026_/S _18310_/D VSS VSS VSS VSS gf180mcu_fd_sc_mcu9t5v0__mux2_1
X_11979_ _18311_/Q _12345_/A2 _12347_/C _11979_/C _11981_/A2 VSS _11979_/VNW VSS VSS
+ gf180mcu_fd_sc_mcu9t5v0__aoi211_1
XTAP_TAPCELL_ROW_41_2101 VSS VSS gf180mcu_fd_sc_mcu9t5v0__filltie
X_13718_ _13720_/A2 _14590_/B _13728_/A1 VSS _13728_/VNW VSS VSS gf180mcu_fd_sc_mcu9t5v0__nand2_1
XTAP_TAPCELL_ROW_285_6918 VSS VSS gf180mcu_fd_sc_mcu9t5v0__filltie
XTAP_TAPCELL_ROW_285_6907 VSS VSS gf180mcu_fd_sc_mcu9t5v0__filltie
X_17486_ _18591_/Q _19232_/Q _17504_/S _18591_/D VSS VSS VSS VSS gf180mcu_fd_sc_mcu9t5v0__mux2_1
XPHY_EDGE_ROW_17_Left_341 VSS VSS gf180mcu_fd_sc_mcu9t5v0__endcap
XTAP_TAPCELL_ROW_41_2112 VSS VSS gf180mcu_fd_sc_mcu9t5v0__filltie
X_14698_ _19536_/Q _14697_/Z _14704_/S _19536_/D VSS VSS VSS VSS gf180mcu_fd_sc_mcu9t5v0__mux2_1
XTAP_TAPCELL_ROW_41_2123 VSS VSS gf180mcu_fd_sc_mcu9t5v0__filltie
X_16437_ _16437_/I0 _18279_/Q _16958_/S _18279_/D VSS VSS VSS VSS gf180mcu_fd_sc_mcu9t5v0__mux2_4
X_19225_ _19225_/D _20057_/RN clkload39/I _19225_/Q VSS VSS VSS VSS gf180mcu_fd_sc_mcu9t5v0__dffrnq_1
X_13649_ _14475_/B _14645_/A2 _13650_/C VSS _13649_/VNW VSS VSS gf180mcu_fd_sc_mcu9t5v0__nand2_1
X_16368_ _18248_/Q _16367_/Z _16892_/S _18248_/D VSS VSS VSS VSS gf180mcu_fd_sc_mcu9t5v0__mux2_4
X_19156_ _19156_/D _20052_/RN _19798_/CLK _19156_/Q VSS VSS VSS VSS gf180mcu_fd_sc_mcu9t5v0__dffrnq_1
X_18107_ _19204_/Q _19198_/Q _18117_/S _18107_/Z VSS VSS VSS VSS gf180mcu_fd_sc_mcu9t5v0__mux2_1
X_19087_ _19087_/D _20047_/RN clkload41/I _19087_/Q VSS VSS VSS VSS gf180mcu_fd_sc_mcu9t5v0__dffrnq_1
X_15319_ _19641_/Q _19618_/Q _15324_/A2 VSS VSS VSS VSS gf180mcu_fd_sc_mcu9t5v0__xnor2_1
X_16299_ _16299_/A1 _16298_/Z _16299_/ZN VSS VSS VSS VSS gf180mcu_fd_sc_mcu9t5v0__nand2_4
X_18038_ _18930_/Q _10981_/I _18078_/A1 VSS _18079_/VNW VSS VSS gf180mcu_fd_sc_mcu9t5v0__xnor2_1
XTAP_TAPCELL_ROW_39_2052 VSS VSS gf180mcu_fd_sc_mcu9t5v0__filltie
XTAP_TAPCELL_ROW_39_2063 VSS VSS gf180mcu_fd_sc_mcu9t5v0__filltie
X_20000_ _20004_/Q _20064_/RN clkload45/I _20000_/Q VSS VSS VSS VSS gf180mcu_fd_sc_mcu9t5v0__dffrnq_1
XPHY_EDGE_ROW_26_Left_350 VSS VSS gf180mcu_fd_sc_mcu9t5v0__endcap
X_09811_ _18838_/Q _11610_/B _18844_/Q _09812_/C VSS _09811_/VNW VSS VSS gf180mcu_fd_sc_mcu9t5v0__aoi21_1
X_09742_ _20138_/Q _15946_/A3 _15946_/A4 _09742_/ZN VSS VSS VSS VSS gf180mcu_fd_sc_mcu9t5v0__nand3_4
X_19989_ _19989_/D _20053_/RN _20054_/CLK _19989_/Q VSS VSS VSS VSS gf180mcu_fd_sc_mcu9t5v0__dffrnq_1
XPHY_EDGE_ROW_271_Right_198 VSS VSS gf180mcu_fd_sc_mcu9t5v0__endcap
XTAP_TAPCELL_ROW_219_5106 VSS VSS gf180mcu_fd_sc_mcu9t5v0__filltie
X_09673_ _09673_/A1 _09673_/A2 _19997_/D VSS VSS VSS VSS gf180mcu_fd_sc_mcu9t5v0__nand2_1
XTAP_TAPCELL_ROW_11_1281 VSS VSS gf180mcu_fd_sc_mcu9t5v0__filltie
XTAP_TAPCELL_ROW_11_1292 VSS VSS gf180mcu_fd_sc_mcu9t5v0__filltie
XTAP_TAPCELL_ROW_198_3_8218 VSS VSS gf180mcu_fd_sc_mcu9t5v0__filltie
Xu_transform_scheduler_core.u_fft_scratch_sram.u_lo.g_pin_drive\[4\].u_data_driver
+ _10368_/ZN u_transform_scheduler_core.u_fft_scratch_sram.u_lo.u_sram/D[4] VSS _09584_/VNW
+ VSS VSS gf180mcu_fd_sc_mcu9t5v0__buf_8
XTAP_TAPCELL_ROW_24_1631 VSS VSS gf180mcu_fd_sc_mcu9t5v0__filltie
XTAP_TAPCELL_ROW_24_1642 VSS VSS gf180mcu_fd_sc_mcu9t5v0__filltie
XTAP_TAPCELL_ROW_24_1653 VSS VSS gf180mcu_fd_sc_mcu9t5v0__filltie
XTAP_TAPCELL_ROW_20_1528 VSS VSS gf180mcu_fd_sc_mcu9t5v0__filltie
X_09107_ _19341_/Q _14849_/A1 VSS VSS VSS VSS gf180mcu_fd_sc_mcu9t5v0__clkinv_1
XTAP_TAPCELL_ROW_20_1539 VSS VSS gf180mcu_fd_sc_mcu9t5v0__filltie
XTAP_TAPCELL_ROW_303_7413 VSS VSS gf180mcu_fd_sc_mcu9t5v0__filltie
XTAP_TAPCELL_ROW_303_7402 VSS VSS gf180mcu_fd_sc_mcu9t5v0__filltie
X_11000_ _18925_/Q _18924_/Q _11000_/B _11006_/A1 VSS _11001_/VNW VSS VSS gf180mcu_fd_sc_mcu9t5v0__oai21_1
X_20129_ _20129_/D _20129_/CLK _20129_/Q VSS VSS VSS VSS gf180mcu_fd_sc_mcu9t5v0__dffq_1
XTAP_TAPCELL_ROW_18_1468 VSS VSS gf180mcu_fd_sc_mcu9t5v0__filltie
XTAP_TAPCELL_ROW_18_1479 VSS VSS gf180mcu_fd_sc_mcu9t5v0__filltie
X_12951_ _19784_/Q _12734_/Z _12956_/A2 VSS _12956_/VNW VSS VSS gf180mcu_fd_sc_mcu9t5v0__nand2_1
XTAP_TAPCELL_ROW_289_7007 VSS VSS gf180mcu_fd_sc_mcu9t5v0__filltie
X_11902_ _11902_/A1 _11902_/A2 _11903_/B1 VSS VSS VSS VSS gf180mcu_fd_sc_mcu9t5v0__nor2_2
X_15670_ _19910_/Q _15668_/Z _15672_/A1 VSS VSS VSS VSS gf180mcu_fd_sc_mcu9t5v0__nand2_1
X_12882_ _19771_/Q _12880_/Z _12889_/B VSS VSS VSS VSS gf180mcu_fd_sc_mcu9t5v0__and2_1
XTAP_TAPCELL_ROW_289_7029 VSS VSS gf180mcu_fd_sc_mcu9t5v0__filltie
XTAP_TAPCELL_ROW_289_7018 VSS VSS gf180mcu_fd_sc_mcu9t5v0__filltie
X_11833_ wire208/Z _11850_/A2 _11835_/A2 VSS VSS VSS VSS gf180mcu_fd_sc_mcu9t5v0__nand2_1
X_14621_ _19082_/Q _19499_/Q _14670_/S _19499_/D VSS VSS VSS VSS gf180mcu_fd_sc_mcu9t5v0__mux2_1
X_17340_ _09261_/I _17340_/A2 _17340_/A3 _17340_/B _17345_/C1 VSS _17340_/VNW VSS
+ VSS gf180mcu_fd_sc_mcu9t5v0__oai31_1
X_11764_ _11749_/Z _11807_/A2 _11764_/Z VSS VSS VSS VSS gf180mcu_fd_sc_mcu9t5v0__and2_1
X_14552_ _14560_/B _14748_/A1 _14553_/A2 VSS VSS VSS VSS gf180mcu_fd_sc_mcu9t5v0__xnor2_1
X_17271_ _17250_/Z _17271_/A2 _17271_/B _18545_/D VSS VSS VSS VSS gf180mcu_fd_sc_mcu9t5v0__oai21_4
X_11695_ _12208_/C _11688_/Z _11695_/B _12092_/B _11696_/B VSS _11695_/VNW VSS VSS
+ gf180mcu_fd_sc_mcu9t5v0__aoi211_1
X_10715_ _10715_/A1 _10804_/A2 _10715_/B _10715_/C _10716_/I1 VSS _10715_/VNW VSS
+ VSS gf180mcu_fd_sc_mcu9t5v0__aoi211_1
X_14483_ _14483_/A1 _14483_/A2 _14716_/B _14483_/Z VSS VSS VSS VSS gf180mcu_fd_sc_mcu9t5v0__or3_1
X_13503_ _19718_/Q _13503_/A2 _13502_/B _13503_/Z VSS VSS VSS VSS gf180mcu_fd_sc_mcu9t5v0__and3_1
X_16222_ _16172_/C _19271_/Q _16785_/S _16222_/Z VSS _16223_/VNW VSS VSS gf180mcu_fd_sc_mcu9t5v0__mux2_1
X_10646_ _20074_/Q wire168/Z _10647_/A2 VSS VSS VSS VSS gf180mcu_fd_sc_mcu9t5v0__nor2_1
XTAP_TAPCELL_ROW_98_3690 VSS VSS gf180mcu_fd_sc_mcu9t5v0__filltie
X_19010_ _19010_/D _20034_/RN clkload38/I _19010_/Q VSS VSS VSS VSS gf180mcu_fd_sc_mcu9t5v0__dffrnq_1
X_13434_ _19745_/Q _13435_/A2 _13453_/A2 VSS VSS VSS VSS gf180mcu_fd_sc_mcu9t5v0__nand2_1
X_16153_ _19267_/Q _16730_/C _16154_/B VSS VSS VSS VSS gf180mcu_fd_sc_mcu9t5v0__nand2_1
XTAP_TAPCELL_ROW_265_6350 VSS VSS gf180mcu_fd_sc_mcu9t5v0__filltie
XTAP_TAPCELL_ROW_94_3565 VSS VSS gf180mcu_fd_sc_mcu9t5v0__filltie
XTAP_TAPCELL_ROW_94_3554 VSS VSS gf180mcu_fd_sc_mcu9t5v0__filltie
XTAP_TAPCELL_ROW_265_6361 VSS VSS gf180mcu_fd_sc_mcu9t5v0__filltie
X_10577_ _19953_/Q wire216/Z _10655_/B _10578_/B2 VSS VSS VSS VSS gf180mcu_fd_sc_mcu9t5v0__aoi21_1
XTAP_TAPCELL_ROW_94_3576 VSS VSS gf180mcu_fd_sc_mcu9t5v0__filltie
X_13365_ _13366_/A1 _13366_/A2 _13365_/B _13403_/A2 VSS VSS VSS VSS gf180mcu_fd_sc_mcu9t5v0__aoi21_1
X_15104_ _19648_/Q _15104_/I1 _20039_/Q _19648_/D VSS VSS VSS VSS gf180mcu_fd_sc_mcu9t5v0__mux2_1
X_12316_ _18391_/Q _12315_/Z _12324_/B _12316_/Z VSS VSS VSS VSS gf180mcu_fd_sc_mcu9t5v0__mux2_1
XTAP_TAPCELL_ROW_261_6258 VSS VSS gf180mcu_fd_sc_mcu9t5v0__filltie
XTAP_TAPCELL_ROW_261_6247 VSS VSS gf180mcu_fd_sc_mcu9t5v0__filltie
X_16084_ _16675_/A1 _16084_/A2 _16084_/A3 _16084_/B _16085_/I1 VSS VSS VSS VSS gf180mcu_fd_sc_mcu9t5v0__oai31_1
XTAP_TAPCELL_ROW_261_6236 VSS VSS gf180mcu_fd_sc_mcu9t5v0__filltie
X_13296_ _13297_/A1 _13297_/A2 _13590_/B _13299_/A1 VSS VSS VSS VSS gf180mcu_fd_sc_mcu9t5v0__nand3_1
X_12247_ _12299_/S _12247_/A2 _12247_/A3 _12248_/B VSS VSS VSS VSS gf180mcu_fd_sc_mcu9t5v0__nand3_1
X_19912_ _19912_/D _20040_/RN clkload41/I _19912_/Q VSS VSS VSS VSS gf180mcu_fd_sc_mcu9t5v0__dffrnq_1
X_15035_ _19302_/Q _19387_/Q _15035_/Z VSS _15035_/VNW VSS VSS gf180mcu_fd_sc_mcu9t5v0__xor2_1
XTAP_TAPCELL_ROW_278_6722 VSS VSS gf180mcu_fd_sc_mcu9t5v0__filltie
XTAP_TAPCELL_ROW_278_6711 VSS VSS gf180mcu_fd_sc_mcu9t5v0__filltie
X_19843_ _19843_/D _20035_/RN clkload56/I _19843_/Q VSS VSS VSS VSS gf180mcu_fd_sc_mcu9t5v0__dffrnq_1
X_12178_ _12183_/C _12176_/Z _12178_/B _12342_/C _12185_/A1 VSS VSS VSS VSS gf180mcu_fd_sc_mcu9t5v0__oai211_1
XTAP_TAPCELL_ROW_274_6619 VSS VSS gf180mcu_fd_sc_mcu9t5v0__filltie
X_16986_ _18484_/Q _16985_/Z _16986_/S _18484_/D VSS VSS VSS VSS gf180mcu_fd_sc_mcu9t5v0__mux2_4
XTAP_TAPCELL_ROW_274_6608 VSS VSS gf180mcu_fd_sc_mcu9t5v0__filltie
X_11129_ _11129_/A1 _11129_/A2 _11429_/B _11129_/C _11130_/B VSS VSS VSS VSS gf180mcu_fd_sc_mcu9t5v0__oai211_1
X_19774_ _19774_/D _20030_/RN clkload44/I _19774_/Q VSS VSS VSS VSS gf180mcu_fd_sc_mcu9t5v0__dffrnq_1
Xu_transform_scheduler_core.u_fft_scratch_sram.u_hi.g_pin_drive\[6\].u_data_driver
+ _10630_/ZN u_transform_scheduler_core.u_fft_scratch_sram.u_hi.u_sram/D[6] VSS VSS
+ VSS VSS gf180mcu_fd_sc_mcu9t5v0__buf_8
XTAP_TAPCELL_ROW_259_6198 VSS VSS gf180mcu_fd_sc_mcu9t5v0__filltie
X_15937_ _15930_/I _15934_/I _15953_/B _15937_/ZN VSS VSS VSS VSS gf180mcu_fd_sc_mcu9t5v0__aoi21_4
XTAP_TAPCELL_ROW_259_6187 VSS VSS gf180mcu_fd_sc_mcu9t5v0__filltie
X_18725_ _18725_/D clkload53/I _18725_/Q VSS VSS VSS VSS gf180mcu_fd_sc_mcu9t5v0__dffq_1
X_15868_ _20077_/Q _19259_/Q _15927_/S _20077_/D VSS _15868_/VNW VSS VSS gf180mcu_fd_sc_mcu9t5v0__mux2_1
X_18656_ _18656_/D _20060_/RN clkload47/I _18656_/Q VSS VSS VSS VSS gf180mcu_fd_sc_mcu9t5v0__dffrnq_1
XTAP_TAPCELL_ROW_8_1191 VSS VSS gf180mcu_fd_sc_mcu9t5v0__filltie
Xwire38 wire38/I wire38/Z VSS VSS VSS VSS gf180mcu_fd_sc_mcu9t5v0__clkbuf_16
X_17607_ input6/Z _18670_/Q _17609_/S _18670_/D VSS VSS VSS VSS gf180mcu_fd_sc_mcu9t5v0__mux2_1
X_14819_ _19403_/Q _19340_/Q _14821_/A1 _14820_/I1 VSS _14819_/VNW VSS VSS gf180mcu_fd_sc_mcu9t5v0__xnor3_1
X_18587_ _18587_/D clkload59/I _18587_/Q VSS VSS VSS VSS gf180mcu_fd_sc_mcu9t5v0__dffq_1
X_15799_ _18034_/I0 _19969_/Q _15802_/S _19969_/D VSS _17996_/VNW VSS VSS gf180mcu_fd_sc_mcu9t5v0__mux2_1
XTAP_TAPCELL_ROW_4_1088 VSS VSS gf180mcu_fd_sc_mcu9t5v0__filltie
XTAP_TAPCELL_ROW_4_1099 VSS VSS gf180mcu_fd_sc_mcu9t5v0__filltie
XTAP_TAPCELL_ROW_250_5940 VSS VSS gf180mcu_fd_sc_mcu9t5v0__filltie
X_17538_ _17689_/A1 _17731_/A1 _17579_/I1 VSS _17579_/VNW VSS VSS gf180mcu_fd_sc_mcu9t5v0__nand2_1
XTAP_TAPCELL_ROW_250_5951 VSS VSS gf180mcu_fd_sc_mcu9t5v0__filltie
X_17469_ wire198/I _11985_/B _18581_/Q _17470_/A2 VSS _17469_/VNW VSS VSS gf180mcu_fd_sc_mcu9t5v0__aoi21_1
X_19208_ _19208_/D _20040_/RN clkload42/I _19208_/Q VSS VSS VSS VSS gf180mcu_fd_sc_mcu9t5v0__dffrnq_1
X_19139_ _19139_/D _20035_/RN clkload31/I _19139_/Q VSS VSS VSS VSS gf180mcu_fd_sc_mcu9t5v0__dffrnq_4
XTAP_TAPCELL_ROW_248_5891 VSS VSS gf180mcu_fd_sc_mcu9t5v0__filltie
XTAP_TAPCELL_ROW_248_5880 VSS VSS gf180mcu_fd_sc_mcu9t5v0__filltie
XTAP_TAPCELL_ROW_244_5788 VSS VSS gf180mcu_fd_sc_mcu9t5v0__filltie
XTAP_TAPCELL_ROW_244_5777 VSS VSS gf180mcu_fd_sc_mcu9t5v0__filltie
X_09725_ wire300/Z _09634_/Z _17601_/A3 VSS _09741_/VNW VSS VSS gf180mcu_fd_sc_mcu9t5v0__nand2_1
XTAP_TAPCELL_ROW_13_1332 VSS VSS gf180mcu_fd_sc_mcu9t5v0__filltie
XTAP_TAPCELL_ROW_13_1343 VSS VSS gf180mcu_fd_sc_mcu9t5v0__filltie
X_09656_ _09675_/B _15820_/B1 _09656_/B _20003_/D VSS _09656_/VNW VSS VSS gf180mcu_fd_sc_mcu9t5v0__oai21_1
X_09587_ _09582_/Z _09609_/A2 _09587_/A3 _17885_/S VSS VSS VSS VSS gf180mcu_fd_sc_mcu9t5v0__nand3_2
XTAP_TAPCELL_ROW_26_1704 VSS VSS gf180mcu_fd_sc_mcu9t5v0__filltie
X_10500_ _18596_/Q _17306_/C _10500_/B1 _10500_/B2 _10648_/C _10501_/A3 VSS VSS VSS
+ VSS gf180mcu_fd_sc_mcu9t5v0__aoi221_1
X_11480_ _18566_/Q _18372_/Q _11520_/B _11479_/Z _11487_/A2 VSS VSS VSS VSS gf180mcu_fd_sc_mcu9t5v0__aoi22_1
X_10431_ _18224_/Q _17322_/A2 _17255_/B1 _18240_/Q _10432_/B VSS VSS VSS VSS gf180mcu_fd_sc_mcu9t5v0__aoi22_1
X_10362_ _18541_/Q wire81/Z wire282/Z _10368_/A2 VSS VSS VSS VSS gf180mcu_fd_sc_mcu9t5v0__aoi21_1
X_13150_ _13159_/A1 _13159_/A2 _13160_/A1 VSS _13550_/VNW VSS VSS gf180mcu_fd_sc_mcu9t5v0__nor2_1
X_10293_ _17260_/S _18267_/Q _10295_/A3 VSS VSS VSS VSS gf180mcu_fd_sc_mcu9t5v0__nor2_1
XPHY_EDGE_ROW_143_3_Left_801 VSS VSS gf180mcu_fd_sc_mcu9t5v0__endcap
X_13081_ _13082_/A1 _13082_/A2 _13081_/B _13104_/A2 VSS _13082_/VNW VSS VSS gf180mcu_fd_sc_mcu9t5v0__oai21_1
X_12101_ _18907_/Q _18908_/Q _18909_/Q _18910_/Q _12126_/A2 VSS VSS VSS VSS gf180mcu_fd_sc_mcu9t5v0__nor4_1
X_12032_ _18907_/Q _12076_/B _12033_/A2 VSS _12033_/VNW VSS VSS gf180mcu_fd_sc_mcu9t5v0__nand2_1
X_16840_ _18412_/Q _16839_/Z _16840_/S _18412_/D VSS VSS VSS VSS gf180mcu_fd_sc_mcu9t5v0__mux2_1
XTAP_TAPCELL_ROW_180_1_4760 VSS VSS gf180mcu_fd_sc_mcu9t5v0__filltie
X_16771_ _16628_/B _19284_/Q _16783_/S _16771_/Z VSS VSS VSS VSS gf180mcu_fd_sc_mcu9t5v0__mux2_1
XPHY_EDGE_ROW_205_3_Left_863 VSS VSS gf180mcu_fd_sc_mcu9t5v0__endcap
XTAP_TAPCELL_ROW_87_3380 VSS VSS gf180mcu_fd_sc_mcu9t5v0__filltie
X_13983_ _13941_/Z _13984_/A2 _13983_/B _14027_/A2 VSS VSS VSS VSS gf180mcu_fd_sc_mcu9t5v0__aoi21_1
X_18510_ _18510_/D _18510_/CLK _18510_/Q VSS VSS VSS VSS gf180mcu_fd_sc_mcu9t5v0__dffq_1
X_15722_ _15722_/I _15727_/A2 VSS VSS VSS VSS gf180mcu_fd_sc_mcu9t5v0__clkinv_1
X_12934_ _13419_/B _12935_/B _12934_/A3 _12934_/B _19224_/D VSS VSS VSS VSS gf180mcu_fd_sc_mcu9t5v0__oai31_1
XTAP_TAPCELL_ROW_254_6062 VSS VSS gf180mcu_fd_sc_mcu9t5v0__filltie
XTAP_TAPCELL_ROW_254_6051 VSS VSS gf180mcu_fd_sc_mcu9t5v0__filltie
XTAP_TAPCELL_ROW_83_3277 VSS VSS gf180mcu_fd_sc_mcu9t5v0__filltie
XTAP_TAPCELL_ROW_83_3266 VSS VSS gf180mcu_fd_sc_mcu9t5v0__filltie
X_19490_ _19490_/D _20066_/RN clkload23/I _19490_/Q VSS VSS VSS VSS gf180mcu_fd_sc_mcu9t5v0__dffrnq_1
XPHY_EDGE_ROW_16_Right_16 VSS VSS gf180mcu_fd_sc_mcu9t5v0__endcap
XTAP_TAPCELL_ROW_83_3255 VSS VSS gf180mcu_fd_sc_mcu9t5v0__filltie
X_18441_ _18441_/D clkload52/I _18441_/Q VSS VSS VSS VSS gf180mcu_fd_sc_mcu9t5v0__dffq_1
X_15653_ _19904_/Q _15598_/S _15671_/A4 VSS VSS VSS VSS gf180mcu_fd_sc_mcu9t5v0__nor2_1
X_12865_ _12870_/A1 _12870_/A2 _12869_/B VSS VSS VSS VSS gf180mcu_fd_sc_mcu9t5v0__nor2_1
X_18372_ _18372_/D clkload75/I _18372_/Q VSS VSS VSS VSS gf180mcu_fd_sc_mcu9t5v0__dffq_1
X_15584_ _19879_/Q _15598_/S _15586_/B VSS VSS VSS VSS gf180mcu_fd_sc_mcu9t5v0__nand2_1
X_12796_ _19758_/Q _12794_/Z _12796_/Z VSS _12796_/VNW VSS VSS gf180mcu_fd_sc_mcu9t5v0__or2_1
X_14604_ _19184_/Q _19482_/Q _14715_/S _19482_/D VSS _14604_/VNW VSS VSS gf180mcu_fd_sc_mcu9t5v0__mux2_1
X_11816_ _11838_/A1 _11816_/A2 _11836_/A2 VSS _11836_/VNW VSS VSS gf180mcu_fd_sc_mcu9t5v0__xnor2_1
X_17323_ _09261_/I _17323_/A2 _17323_/A3 _17323_/B _17324_/C1 VSS VSS VSS VSS gf180mcu_fd_sc_mcu9t5v0__oai31_1
XTAP_TAPCELL_ROW_267_6401 VSS VSS gf180mcu_fd_sc_mcu9t5v0__filltie
X_11747_ _18715_/Q _12527_/A2 _11765_/B VSS VSS VSS VSS gf180mcu_fd_sc_mcu9t5v0__nand2_1
X_14535_ _14542_/B _14739_/A1 _14536_/A2 VSS _14535_/VNW VSS VSS gf180mcu_fd_sc_mcu9t5v0__xnor2_1
XTAP_TAPCELL_ROW_96_3616 VSS VSS gf180mcu_fd_sc_mcu9t5v0__filltie
X_17254_ _17260_/S _18401_/Q _17256_/A3 VSS VSS VSS VSS gf180mcu_fd_sc_mcu9t5v0__nor2_1
XTAP_TAPCELL_ROW_267_6423 VSS VSS gf180mcu_fd_sc_mcu9t5v0__filltie
XTAP_TAPCELL_ROW_267_6412 VSS VSS gf180mcu_fd_sc_mcu9t5v0__filltie
XPHY_EDGE_ROW_138_3_Left_796 VSS VSS gf180mcu_fd_sc_mcu9t5v0__endcap
XTAP_TAPCELL_ROW_96_3627 VSS VSS gf180mcu_fd_sc_mcu9t5v0__filltie
X_16205_ _16204_/Z _18187_/Q _16764_/S _18187_/D VSS VSS VSS VSS gf180mcu_fd_sc_mcu9t5v0__mux2_1
XTAP_TAPCELL_ROW_263_6309 VSS VSS gf180mcu_fd_sc_mcu9t5v0__filltie
X_11678_ _18833_/Q _11678_/A2 _11678_/B _12235_/B VSS _11678_/VNW VSS VSS gf180mcu_fd_sc_mcu9t5v0__aoi21_1
X_14466_ _14466_/A1 _14464_/Z _14467_/A2 VSS VSS VSS VSS gf180mcu_fd_sc_mcu9t5v0__nand2_1
X_17185_ _20030_/Q _17394_/A2 _17185_/A3 _17185_/B _18541_/D VSS VSS VSS VSS gf180mcu_fd_sc_mcu9t5v0__oai31_1
Xclkbuf_leaf_45_clk_regs clkload6/I clkload82/I VSS VSS VSS VSS gf180mcu_fd_sc_mcu9t5v0__clkbuf_8
X_10629_ _19955_/Q wire216/Z _10655_/B _10630_/B2 VSS _10629_/VNW VSS VSS gf180mcu_fd_sc_mcu9t5v0__aoi21_1
X_13417_ _13433_/A1 _13433_/A3 _13418_/A3 VSS _13417_/VNW VSS VSS gf180mcu_fd_sc_mcu9t5v0__nor2_1
X_14397_ _14397_/A1 _19117_/Q _14408_/A1 VSS _14403_/VNW VSS VSS gf180mcu_fd_sc_mcu9t5v0__nor2_1
XPHY_EDGE_ROW_25_Right_25 VSS VSS gf180mcu_fd_sc_mcu9t5v0__endcap
X_16136_ _19232_/Q _16730_/C _16139_/A2 VSS VSS VSS VSS gf180mcu_fd_sc_mcu9t5v0__nor2_1
X_13348_ _19741_/Q _13347_/Z _13608_/B VSS _13348_/VNW VSS VSS gf180mcu_fd_sc_mcu9t5v0__nor2_1
X_16067_ _18162_/Q _16067_/I1 _16670_/S _18162_/D VSS VSS VSS VSS gf180mcu_fd_sc_mcu9t5v0__mux2_4
X_13279_ _13244_/B _13297_/A2 _13278_/Z _13285_/A1 VSS _13300_/VNW VSS VSS gf180mcu_fd_sc_mcu9t5v0__nand3_1
X_15018_ _19377_/Q _15020_/A2 _15022_/I0 VSS _15018_/VNW VSS VSS gf180mcu_fd_sc_mcu9t5v0__nand2_1
XTAP_TAPCELL_ROW_72_2970 VSS VSS gf180mcu_fd_sc_mcu9t5v0__filltie
X_19826_ _19826_/D _20018_/RN _20129_/CLK _19826_/Q VSS VSS VSS VSS gf180mcu_fd_sc_mcu9t5v0__dffrnq_2
X_19757_ _19757_/D _20141_/RN clkload37/I _19757_/Q VSS VSS VSS VSS gf180mcu_fd_sc_mcu9t5v0__dffrnq_1
X_16969_ _19247_/Q _16592_/B _16971_/S _16969_/Z VSS VSS VSS VSS gf180mcu_fd_sc_mcu9t5v0__mux2_1
X_18708_ _18708_/D clkload63/I _18708_/Q VSS VSS VSS VSS gf180mcu_fd_sc_mcu9t5v0__dffq_1
XTAP_TAPCELL_ROW_6_1139 VSS VSS gf180mcu_fd_sc_mcu9t5v0__filltie
XPHY_EDGE_ROW_34_Right_34 VSS VSS gf180mcu_fd_sc_mcu9t5v0__endcap
X_09510_ _19183_/Q _14730_/S _12692_/A1 VSS VSS VSS VSS gf180mcu_fd_sc_mcu9t5v0__nand2_1
X_19688_ _19688_/D _20072_/RN clkload12/I _19688_/Q VSS VSS VSS VSS gf180mcu_fd_sc_mcu9t5v0__dffrnq_1
X_18639_ _18639_/D _20043_/RN clkload53/I _18639_/Q VSS VSS VSS VSS gf180mcu_fd_sc_mcu9t5v0__dffrnq_1
X_09441_ _19992_/Q _19993_/Q _09442_/I VSS VSS VSS VSS gf180mcu_fd_sc_mcu9t5v0__xor2_1
XTAP_TAPCELL_ROW_66_2785 VSS VSS gf180mcu_fd_sc_mcu9t5v0__filltie
X_09372_ _18490_/Q _12500_/A1 VSS VSS VSS VSS gf180mcu_fd_sc_mcu9t5v0__clkinv_1
XTAP_TAPCELL_ROW_237_5592 VSS VSS gf180mcu_fd_sc_mcu9t5v0__filltie
XTAP_TAPCELL_ROW_237_5581 VSS VSS gf180mcu_fd_sc_mcu9t5v0__filltie
XTAP_TAPCELL_ROW_66_2796 VSS VSS gf180mcu_fd_sc_mcu9t5v0__filltie
XTAP_TAPCELL_ROW_233_5478 VSS VSS gf180mcu_fd_sc_mcu9t5v0__filltie
XTAP_TAPCELL_ROW_233_5467 VSS VSS gf180mcu_fd_sc_mcu9t5v0__filltie
XTAP_TAPCELL_ROW_233_5489 VSS VSS gf180mcu_fd_sc_mcu9t5v0__filltie
XPHY_EDGE_ROW_43_Right_43 VSS VSS gf180mcu_fd_sc_mcu9t5v0__endcap
XTAP_TAPCELL_ROW_246_5839 VSS VSS gf180mcu_fd_sc_mcu9t5v0__filltie
XTAP_TAPCELL_ROW_246_5828 VSS VSS gf180mcu_fd_sc_mcu9t5v0__filltie
Xu_transform_scheduler_core.u_fft_scratch_sram.u_hi.g_pin_drive\[1\].u_addr_driver
+ _10676_/ZN u_transform_scheduler_core.u_fft_scratch_sram.u_hi.u_sram/A[1] VSS VSS
+ VSS VSS gf180mcu_fd_sc_mcu9t5v0__buf_8
Xeco9_buf_09481 _09481_/ZN _12028_/A1 VSS VSS VSS VSS gf180mcu_fd_sc_mcu9t5v0__clkbuf_16
XTAP_TAPCELL_ROW_15_1405 VSS VSS gf180mcu_fd_sc_mcu9t5v0__filltie
XPHY_EDGE_ROW_52_Right_52 VSS VSS gf180mcu_fd_sc_mcu9t5v0__endcap
X_09708_ _20013_/Q _09758_/B _15723_/A2 _17619_/A3 VSS VSS VSS VSS gf180mcu_fd_sc_mcu9t5v0__nand3_1
X_10980_ _18060_/A1 _18924_/Q _18923_/Q _10981_/I VSS _10980_/VNW VSS VSS gf180mcu_fd_sc_mcu9t5v0__nor3_1
X_09639_ _09662_/S _09639_/A2 _15691_/C _09639_/B _20007_/D VSS VSS VSS VSS gf180mcu_fd_sc_mcu9t5v0__oai31_1
X_12650_ _12664_/C _12650_/A2 _12650_/B _12707_/I0 VSS _12650_/VNW VSS VSS gf180mcu_fd_sc_mcu9t5v0__oai21_1
X_11601_ _11602_/A1 _11620_/A2 _11659_/A1 VSS VSS VSS VSS gf180mcu_fd_sc_mcu9t5v0__nor2_1
X_12581_ _18356_/Q _12613_/A2 _12585_/A2 VSS VSS VSS VSS gf180mcu_fd_sc_mcu9t5v0__nor2_1
XPHY_EDGE_ROW_61_Right_61 VSS VSS gf180mcu_fd_sc_mcu9t5v0__endcap
X_14320_ _14320_/I0 _19393_/Q _14322_/S _19393_/D VSS VSS VSS VSS gf180mcu_fd_sc_mcu9t5v0__mux2_1
X_11532_ _16832_/A1 _11534_/S _11537_/S _11532_/C _11533_/B VSS VSS VSS VSS gf180mcu_fd_sc_mcu9t5v0__oai211_1
XTAP_TAPCELL_ROW_216_4997 VSS VSS gf180mcu_fd_sc_mcu9t5v0__filltie
Xwire301 wire301/I wire301/Z VSS VSS VSS VSS gf180mcu_fd_sc_mcu9t5v0__clkbuf_8
XTAP_TAPCELL_ROW_134_4675 VSS VSS gf180mcu_fd_sc_mcu9t5v0__filltie
XTAP_TAPCELL_ROW_134_4664 VSS VSS gf180mcu_fd_sc_mcu9t5v0__filltie
X_11463_ _19099_/Q _11541_/A2 _11464_/A2 VSS VSS VSS VSS gf180mcu_fd_sc_mcu9t5v0__nand2_1
X_14251_ _14251_/A1 _14251_/A2 _14251_/Z VSS _14261_/VNW VSS VSS gf180mcu_fd_sc_mcu9t5v0__xor2_1
X_10414_ _18593_/Q _17409_/B _17225_/B _10414_/C _10415_/A3 VSS _17608_/VNW VSS VSS
+ gf180mcu_fd_sc_mcu9t5v0__oai211_1
XTAP_TAPCELL_ROW_76_3081 VSS VSS gf180mcu_fd_sc_mcu9t5v0__filltie
X_13202_ _19764_/Q _13204_/A2 _13218_/A1 VSS _13202_/VNW VSS VSS gf180mcu_fd_sc_mcu9t5v0__nor2_1
XTAP_TAPCELL_ROW_76_3070 VSS VSS gf180mcu_fd_sc_mcu9t5v0__filltie
X_14182_ _14367_/I0 _19337_/Q _14266_/S _19337_/D VSS VSS VSS VSS gf180mcu_fd_sc_mcu9t5v0__mux2_1
X_11394_ _18707_/Q wire198/Z wire208/Z _11394_/B2 wire213/Z _11395_/A3 VSS VSS VSS
+ VSS gf180mcu_fd_sc_mcu9t5v0__aoi221_2
X_13133_ _13151_/A1 _13151_/A3 _13134_/A3 VSS VSS VSS VSS gf180mcu_fd_sc_mcu9t5v0__nor2_1
X_10345_ _17198_/A1 _10345_/A2 _10345_/A3 _10345_/B _10354_/A2 VSS VSS VSS VSS gf180mcu_fd_sc_mcu9t5v0__oai31_1
X_18990_ _18990_/D _20142_/RN _20132_/CLK _18990_/Q VSS VSS VSS VSS gf180mcu_fd_sc_mcu9t5v0__dffrnq_1
X_10276_ _17409_/B _10276_/A2 _10276_/A3 _10277_/C VSS VSS VSS VSS gf180mcu_fd_sc_mcu9t5v0__nand3_1
XPHY_EDGE_ROW_70_Right_70 VSS VSS gf180mcu_fd_sc_mcu9t5v0__endcap
X_17941_ _18851_/Q _10693_/B _10803_/C _17941_/Z VSS VSS VSS VSS gf180mcu_fd_sc_mcu9t5v0__and3_1
XTAP_TAPCELL_ROW_89_3431 VSS VSS gf180mcu_fd_sc_mcu9t5v0__filltie
X_13064_ _19724_/Q _19756_/Q _13064_/Z VSS VSS VSS VSS gf180mcu_fd_sc_mcu9t5v0__xor2_1
XTAP_TAPCELL_ROW_89_3420 VSS VSS gf180mcu_fd_sc_mcu9t5v0__filltie
X_12015_ _12090_/B _12015_/A2 _12015_/A3 _12026_/B1 VSS VSS VSS VSS gf180mcu_fd_sc_mcu9t5v0__nor3_1
XTAP_TAPCELL_ROW_89_3442 VSS VSS gf180mcu_fd_sc_mcu9t5v0__filltie
X_17872_ _17872_/A1 _09416_/C _17873_/A2 VSS VSS VSS VSS gf180mcu_fd_sc_mcu9t5v0__nand2_1
XTAP_TAPCELL_ROW_256_6124 VSS VSS gf180mcu_fd_sc_mcu9t5v0__filltie
XTAP_TAPCELL_ROW_256_6113 VSS VSS gf180mcu_fd_sc_mcu9t5v0__filltie
X_16823_ _16823_/A1 _16957_/B _16824_/I1 VSS VSS VSS VSS gf180mcu_fd_sc_mcu9t5v0__nand2_1
XTAP_TAPCELL_ROW_256_6102 VSS VSS gf180mcu_fd_sc_mcu9t5v0__filltie
XTAP_TAPCELL_ROW_85_3328 VSS VSS gf180mcu_fd_sc_mcu9t5v0__filltie
XTAP_TAPCELL_ROW_85_3317 VSS VSS gf180mcu_fd_sc_mcu9t5v0__filltie
X_19611_ _19611_/D _20059_/RN _19633_/CLK _19611_/Q VSS VSS VSS VSS gf180mcu_fd_sc_mcu9t5v0__dffrnq_1
X_16754_ _19276_/Q _16763_/S _16755_/B VSS VSS VSS VSS gf180mcu_fd_sc_mcu9t5v0__nand2_1
X_13966_ _13966_/A1 _13964_/Z _13966_/Z VSS _13966_/VNW VSS VSS gf180mcu_fd_sc_mcu9t5v0__xor2_1
X_19542_ _19542_/D _20054_/RN clkload16/I _19542_/Q VSS VSS VSS VSS gf180mcu_fd_sc_mcu9t5v0__dffrnq_1
X_16685_ _18362_/Q _16685_/I1 _16707_/S _18362_/D VSS VSS VSS VSS gf180mcu_fd_sc_mcu9t5v0__mux2_4
X_15705_ _19918_/Q _15699_/Z _15705_/B _15706_/B2 VSS _15720_/VNW VSS VSS gf180mcu_fd_sc_mcu9t5v0__aoi21_1
X_12917_ _12917_/I _12919_/A1 VSS VSS VSS VSS gf180mcu_fd_sc_mcu9t5v0__clkinv_1
X_13897_ _13897_/A1 _13895_/Z _13910_/A2 VSS _13942_/VNW VSS VSS gf180mcu_fd_sc_mcu9t5v0__xnor2_1
XTAP_TAPCELL_ROW_1_1003 VSS VSS gf180mcu_fd_sc_mcu9t5v0__filltie
XTAP_TAPCELL_ROW_1_1014 VSS VSS gf180mcu_fd_sc_mcu9t5v0__filltie
X_19473_ _19473_/D _20049_/RN clkload31/I _19473_/Q VSS VSS VSS VSS gf180mcu_fd_sc_mcu9t5v0__dffrnq_1
X_18424_ _18424_/D clkload78/I _18424_/Q VSS VSS VSS VSS gf180mcu_fd_sc_mcu9t5v0__dffq_1
X_15636_ _19897_/Q _15636_/A2 _15636_/Z VSS VSS VSS VSS gf180mcu_fd_sc_mcu9t5v0__xor2_1
X_12848_ _19735_/Q _19800_/Q _13244_/B _12848_/Z VSS _12851_/VNW VSS VSS gf180mcu_fd_sc_mcu9t5v0__mux2_1
X_15567_ _19876_/Q _15564_/Z _15570_/A1 VSS _15569_/VNW VSS VSS gf180mcu_fd_sc_mcu9t5v0__nor2_1
X_18355_ _18355_/D clkload67/I _18355_/Q VSS VSS VSS VSS gf180mcu_fd_sc_mcu9t5v0__dffq_1
X_12779_ _19756_/Q _12778_/Z _12790_/A1 VSS VSS VSS VSS gf180mcu_fd_sc_mcu9t5v0__nand2_1
XTAP_TAPCELL_ROW_61_2660 VSS VSS gf180mcu_fd_sc_mcu9t5v0__filltie
XTAP_TAPCELL_ROW_61_2671 VSS VSS gf180mcu_fd_sc_mcu9t5v0__filltie
X_18286_ _18286_/D _18497_/CLK _18286_/Q VSS VSS VSS VSS gf180mcu_fd_sc_mcu9t5v0__dffq_1
X_17306_ _17306_/A1 _17408_/B _17306_/B1 _17306_/B2 _17306_/C _17307_/B VSS VSS VSS
+ VSS gf180mcu_fd_sc_mcu9t5v0__aoi221_1
X_15498_ _19836_/Q input6/Z _15502_/S _15498_/Z VSS VSS VSS VSS gf180mcu_fd_sc_mcu9t5v0__mux2_1
X_14518_ _14518_/A1 _14517_/Z wire199/I _14519_/B VSS VSS VSS VSS gf180mcu_fd_sc_mcu9t5v0__oai21_1
X_17237_ _17404_/S _18528_/Q _17239_/A3 VSS VSS VSS VSS gf180mcu_fd_sc_mcu9t5v0__nor2_1
X_14449_ _19156_/Q _19122_/Q _14707_/A2 VSS VSS VSS VSS gf180mcu_fd_sc_mcu9t5v0__nor2_1
X_17168_ _18349_/Q _17322_/A2 _17255_/B1 _18365_/Q _17406_/C _17169_/B VSS VSS VSS
+ VSS gf180mcu_fd_sc_mcu9t5v0__aoi221_1
X_16119_ _16730_/A1 _16119_/A2 _16119_/B _16119_/C _16120_/I1 VSS VSS VSS VSS gf180mcu_fd_sc_mcu9t5v0__oai211_1
XPHY_EDGE_ROW_167_2_Left_679 VSS VSS gf180mcu_fd_sc_mcu9t5v0__endcap
X_17099_ wire301/Z _10648_/C _17117_/A2 VSS VSS VSS VSS gf180mcu_fd_sc_mcu9t5v0__nand2_1
XTAP_TAPCELL_ROW_241_5703 VSS VSS gf180mcu_fd_sc_mcu9t5v0__filltie
X_09990_ _19277_/Q _10165_/B1 _10166_/B1 _19285_/Q _09991_/A3 VSS VSS VSS VSS gf180mcu_fd_sc_mcu9t5v0__aoi22_1
XTAP_TAPCELL_ROW_70_2918 VSS VSS gf180mcu_fd_sc_mcu9t5v0__filltie
XTAP_TAPCELL_ROW_70_2907 VSS VSS gf180mcu_fd_sc_mcu9t5v0__filltie
XTAP_TAPCELL_ROW_226_5293 VSS VSS gf180mcu_fd_sc_mcu9t5v0__filltie
XTAP_TAPCELL_ROW_226_5282 VSS VSS gf180mcu_fd_sc_mcu9t5v0__filltie
XTAP_TAPCELL_ROW_55_2486 VSS VSS gf180mcu_fd_sc_mcu9t5v0__filltie
XTAP_TAPCELL_ROW_55_2497 VSS VSS gf180mcu_fd_sc_mcu9t5v0__filltie
XTAP_TAPCELL_ROW_222_5179 VSS VSS gf180mcu_fd_sc_mcu9t5v0__filltie
XTAP_TAPCELL_ROW_222_5168 VSS VSS gf180mcu_fd_sc_mcu9t5v0__filltie
X_19809_ _19809_/D _20065_/RN clkload37/I _19809_/Q VSS VSS VSS VSS gf180mcu_fd_sc_mcu9t5v0__dffrnq_1
XTAP_TAPCELL_ROW_239_5654 VSS VSS gf180mcu_fd_sc_mcu9t5v0__filltie
XTAP_TAPCELL_ROW_239_5643 VSS VSS gf180mcu_fd_sc_mcu9t5v0__filltie
XTAP_TAPCELL_ROW_239_5632 VSS VSS gf180mcu_fd_sc_mcu9t5v0__filltie
XTAP_TAPCELL_ROW_68_2858 VSS VSS gf180mcu_fd_sc_mcu9t5v0__filltie
XTAP_TAPCELL_ROW_68_2847 VSS VSS gf180mcu_fd_sc_mcu9t5v0__filltie
XTAP_TAPCELL_ROW_235_5529 VSS VSS gf180mcu_fd_sc_mcu9t5v0__filltie
X_09424_ _09605_/A3 _17438_/A1 _18563_/Q _09615_/A1 VSS VSS VSS VSS gf180mcu_fd_sc_mcu9t5v0__aoi21_4
XPHY_EDGE_ROW_9_Left_333 VSS VSS gf180mcu_fd_sc_mcu9t5v0__endcap
X_09355_ _19864_/Q _10773_/A1 VSS _09355_/VNW VSS VSS gf180mcu_fd_sc_mcu9t5v0__clkinv_1
X_09286_ _19212_/Q _16565_/I0 VSS VSS VSS VSS gf180mcu_fd_sc_mcu9t5v0__clkinv_1
XTAP_TAPCELL_ROW_211_4872 VSS VSS gf180mcu_fd_sc_mcu9t5v0__filltie
XTAP_TAPCELL_ROW_211_4861 VSS VSS gf180mcu_fd_sc_mcu9t5v0__filltie
XTAP_TAPCELL_ROW_323_7972 VSS VSS gf180mcu_fd_sc_mcu9t5v0__filltie
XTAP_TAPCELL_ROW_323_7961 VSS VSS gf180mcu_fd_sc_mcu9t5v0__filltie
XTAP_TAPCELL_ROW_323_7950 VSS VSS gf180mcu_fd_sc_mcu9t5v0__filltie
XTAP_TAPCELL_ROW_211_4883 VSS VSS gf180mcu_fd_sc_mcu9t5v0__filltie
XTAP_TAPCELL_ROW_323_7994 VSS VSS gf180mcu_fd_sc_mcu9t5v0__filltie
XTAP_TAPCELL_ROW_323_7983 VSS VSS gf180mcu_fd_sc_mcu9t5v0__filltie
X_10130_ _20072_/Q _10130_/A2 _10130_/A3 _10131_/C VSS VSS VSS VSS gf180mcu_fd_sc_mcu9t5v0__nand3_1
X_10061_ _09916_/B _19006_/Q _10016_/B _18568_/Q _10062_/I VSS VSS VSS VSS gf180mcu_fd_sc_mcu9t5v0__aoi22_1
XTAP_TAPCELL_ROW_209_4790 VSS VSS gf180mcu_fd_sc_mcu9t5v0__filltie
XPHY_EDGE_ROW_190_1_Right_774 VSS VSS gf180mcu_fd_sc_mcu9t5v0__endcap
XTAP_TAPCELL_ROW_123_4365 VSS VSS gf180mcu_fd_sc_mcu9t5v0__filltie
XTAP_TAPCELL_ROW_123_4354 VSS VSS gf180mcu_fd_sc_mcu9t5v0__filltie
XTAP_TAPCELL_ROW_317_7798 VSS VSS gf180mcu_fd_sc_mcu9t5v0__filltie
XTAP_TAPCELL_ROW_317_7787 VSS VSS gf180mcu_fd_sc_mcu9t5v0__filltie
XTAP_TAPCELL_ROW_317_7776 VSS VSS gf180mcu_fd_sc_mcu9t5v0__filltie
XTAP_TAPCELL_ROW_123_4376 VSS VSS gf180mcu_fd_sc_mcu9t5v0__filltie
X_13820_ _13820_/I _13871_/A1 VSS _13856_/VNW VSS VSS gf180mcu_fd_sc_mcu9t5v0__clkinv_1
X_10963_ _10962_/B _10963_/A2 _10964_/I0 VSS VSS VSS VSS gf180mcu_fd_sc_mcu9t5v0__xnor2_1
X_13751_ _13751_/A1 _13749_/Z _13752_/A2 VSS _14677_/VNW VSS VSS gf180mcu_fd_sc_mcu9t5v0__xnor2_1
X_16470_ _18293_/Q _16469_/Z _16990_/S _18293_/D VSS VSS VSS VSS gf180mcu_fd_sc_mcu9t5v0__mux2_4
X_12702_ _18833_/Q _12706_/A2 _12703_/A2 VSS VSS VSS VSS gf180mcu_fd_sc_mcu9t5v0__nand2_1
X_10894_ _19243_/Q _18986_/Q _18152_/S _18986_/D VSS VSS VSS VSS gf180mcu_fd_sc_mcu9t5v0__mux2_1
X_15421_ _19706_/Q _19806_/Q _15430_/S _19806_/D VSS VSS VSS VSS gf180mcu_fd_sc_mcu9t5v0__mux2_1
X_13682_ _13970_/A1 _14166_/B _13681_/Z _14143_/B2 _13682_/C _19294_/D VSS VSS VSS
+ VSS gf180mcu_fd_sc_mcu9t5v0__aoi221_1
X_12633_ _12632_/C _12632_/B _12633_/B _12665_/B _12636_/B VSS VSS VSS VSS gf180mcu_fd_sc_mcu9t5v0__aoi211_1
XPHY_EDGE_ROW_309_Left_632 VSS VSS gf180mcu_fd_sc_mcu9t5v0__endcap
X_18140_ _18139_/Z _18957_/Q _18152_/S _18957_/D VSS VSS VSS VSS gf180mcu_fd_sc_mcu9t5v0__mux2_1
XTAP_TAPCELL_ROW_78_3132 VSS VSS gf180mcu_fd_sc_mcu9t5v0__filltie
X_12564_ _12620_/A1 _12620_/A2 _12564_/A3 _12564_/B _19166_/D VSS VSS VSS VSS gf180mcu_fd_sc_mcu9t5v0__oai31_1
XTAP_TAPCELL_ROW_78_3121 VSS VSS gf180mcu_fd_sc_mcu9t5v0__filltie
X_15352_ _19647_/Q _19624_/Q _15352_/Z VSS _15352_/VNW VSS VSS gf180mcu_fd_sc_mcu9t5v0__or2_1
Xwire120 wire120/I wire120/Z VSS VSS VSS VSS gf180mcu_fd_sc_mcu9t5v0__clkbuf_4
X_11515_ _18888_/Q _11878_/A1 _11488_/B _11515_/B2 _11540_/C _11517_/A1 VSS VSS VSS
+ VSS gf180mcu_fd_sc_mcu9t5v0__oai221_1
X_18071_ _18079_/A1 _18079_/A2 _18070_/Z _18072_/A2 VSS _18071_/VNW VSS VSS gf180mcu_fd_sc_mcu9t5v0__nand3_1
XTAP_TAPCELL_ROW_74_3018 VSS VSS gf180mcu_fd_sc_mcu9t5v0__filltie
X_14303_ _14259_/Z _19376_/Q _14304_/S _19376_/D VSS VSS VSS VSS gf180mcu_fd_sc_mcu9t5v0__mux2_1
XTAP_TAPCELL_ROW_74_3007 VSS VSS gf180mcu_fd_sc_mcu9t5v0__filltie
X_15283_ _15283_/A1 _15283_/A2 _15283_/B _15283_/C _15289_/A2 VSS VSS VSS VSS gf180mcu_fd_sc_mcu9t5v0__aoi211_1
X_17022_ _18502_/Q _17021_/Z _17026_/S _18502_/D VSS VSS VSS VSS gf180mcu_fd_sc_mcu9t5v0__mux2_1
X_12495_ _18739_/Q _12527_/A2 _12543_/B1 _12495_/B2 _12497_/A3 VSS VSS VSS VSS gf180mcu_fd_sc_mcu9t5v0__aoi22_4
Xwire175 wire175/I wire175/Z VSS VSS VSS VSS gf180mcu_fd_sc_mcu9t5v0__clkbuf_8
XTAP_TAPCELL_ROW_74_3029 VSS VSS gf180mcu_fd_sc_mcu9t5v0__filltie
X_14234_ _14262_/A1 _14235_/A2 _14241_/B VSS _14262_/VNW VSS VSS gf180mcu_fd_sc_mcu9t5v0__nor2_1
X_11446_ _18369_/Q _11485_/C _11526_/B _11447_/B2 VSS VSS VSS VSS gf180mcu_fd_sc_mcu9t5v0__aoi21_1
XTAP_TAPCELL_ROW_281_6795 VSS VSS gf180mcu_fd_sc_mcu9t5v0__filltie
X_11377_ _18380_/Q _11385_/A2 _11428_/B _11377_/C _11379_/B1 VSS VSS VSS VSS gf180mcu_fd_sc_mcu9t5v0__oai211_1
X_14165_ _19481_/Q _19489_/Q _14165_/S _14165_/Z VSS VSS VSS VSS gf180mcu_fd_sc_mcu9t5v0__mux2_1
X_10328_ _20096_/Q _17304_/C wire168/I _10330_/A2 VSS VSS VSS VSS gf180mcu_fd_sc_mcu9t5v0__oai21_1
X_18973_ _18973_/D _20061_/RN clkload67/I _18973_/Q VSS VSS VSS VSS gf180mcu_fd_sc_mcu9t5v0__dffrnq_1
X_13116_ _13116_/A1 _19793_/Q _13132_/A3 VSS VSS VSS VSS gf180mcu_fd_sc_mcu9t5v0__nor2_1
X_14096_ _14096_/A1 _14096_/A2 _14102_/A2 VSS VSS VSS VSS gf180mcu_fd_sc_mcu9t5v0__xnor2_1
XPHY_EDGE_ROW_318_Left_641 VSS VSS gf180mcu_fd_sc_mcu9t5v0__endcap
X_13047_ _19723_/Q _19755_/Q _13044_/Z _13048_/A2 VSS VSS VSS VSS gf180mcu_fd_sc_mcu9t5v0__xnor3_1
X_17924_ _17924_/I0 _17958_/A2 _18845_/Q _18845_/D VSS _17927_/VNW VSS VSS gf180mcu_fd_sc_mcu9t5v0__mux2_1
X_10259_ _18987_/Q _10654_/A2 _10259_/B wire160/Z _10261_/B1 VSS VSS VSS VSS gf180mcu_fd_sc_mcu9t5v0__oai211_1
Xload_slew158 _18147_/S _18151_/S VSS VSS VSS VSS gf180mcu_fd_sc_mcu9t5v0__buf_8
Xload_slew147 wire146/I _12541_/B VSS VSS VSS VSS gf180mcu_fd_sc_mcu9t5v0__clkbuf_8
XTAP_TAPCELL_ROW_50_2350 VSS VSS gf180mcu_fd_sc_mcu9t5v0__filltie
XTAP_TAPCELL_ROW_50_2361 VSS VSS gf180mcu_fd_sc_mcu9t5v0__filltie
Xeco14_skew_5 clkload80/I _18324_/CLK VSS VSS VSS VSS gf180mcu_fd_sc_mcu9t5v0__clkbuf_16
X_17855_ _18826_/Q _17853_/Z _17857_/A2 VSS VSS VSS VSS gf180mcu_fd_sc_mcu9t5v0__nor2_1
XPHY_EDGE_ROW_287_Right_214 VSS VSS gf180mcu_fd_sc_mcu9t5v0__endcap
X_16806_ _18400_/Q _16805_/Z _16818_/S _18400_/D VSS VSS VSS VSS gf180mcu_fd_sc_mcu9t5v0__mux2_4
X_17786_ _18767_/Q _17784_/Z _17789_/A1 VSS VSS VSS VSS gf180mcu_fd_sc_mcu9t5v0__nor2_1
X_16737_ _18373_/Q _16747_/A2 _16747_/A3 _16738_/B VSS _16737_/VNW VSS VSS gf180mcu_fd_sc_mcu9t5v0__nand3_1
XTAP_TAPCELL_ROW_106_3895 VSS VSS gf180mcu_fd_sc_mcu9t5v0__filltie
X_19525_ _19525_/D _20037_/RN clkload15/I _19525_/Q VSS VSS VSS VSS gf180mcu_fd_sc_mcu9t5v0__dffrnq_1
X_14998_ _15017_/A1 _15003_/A1 _15001_/A1 VSS _15003_/VNW VSS VSS gf180mcu_fd_sc_mcu9t5v0__nand2_1
XTAP_TAPCELL_ROW_106_3884 VSS VSS gf180mcu_fd_sc_mcu9t5v0__filltie
Xload_slew83 _16787_/S _16949_/S VSS VSS VSS VSS gf180mcu_fd_sc_mcu9t5v0__clkbuf_8
XTAP_TAPCELL_ROW_63_2711 VSS VSS gf180mcu_fd_sc_mcu9t5v0__filltie
XTAP_TAPCELL_ROW_63_2722 VSS VSS gf180mcu_fd_sc_mcu9t5v0__filltie
X_13949_ _19310_/Q _13948_/Z _14139_/S _19310_/D VSS _15077_/VNW VSS VSS gf180mcu_fd_sc_mcu9t5v0__mux2_1
X_16668_ _16668_/A1 _16668_/A2 _16668_/B _16669_/A3 VSS _16668_/VNW VSS VSS gf180mcu_fd_sc_mcu9t5v0__aoi21_1
Xload_slew94 _16700_/A2 _16744_/A2 VSS _16477_/VNW VSS VSS gf180mcu_fd_sc_mcu9t5v0__buf_4
XTAP_TAPCELL_ROW_48_2290 VSS VSS gf180mcu_fd_sc_mcu9t5v0__filltie
X_19456_ _19456_/D _09246_/I _19798_/CLK _19456_/Q VSS VSS VSS VSS gf180mcu_fd_sc_mcu9t5v0__dffrnq_1
X_18407_ _18407_/D clkload79/I _18407_/Q VSS VSS VSS VSS gf180mcu_fd_sc_mcu9t5v0__dffq_1
X_16599_ _16750_/A1 _16628_/A2 _16599_/B _16601_/A2 VSS VSS VSS VSS gf180mcu_fd_sc_mcu9t5v0__aoi21_1
XTAP_TAPCELL_ROW_230_5404 VSS VSS gf180mcu_fd_sc_mcu9t5v0__filltie
X_15619_ _19894_/Q _10192_/I _15625_/A3 _15623_/A2 VSS VSS VSS VSS gf180mcu_fd_sc_mcu9t5v0__nand3_1
XTAP_TAPCELL_ROW_44_2187 VSS VSS gf180mcu_fd_sc_mcu9t5v0__filltie
Xclkbuf_leaf_60_clk_regs clkload1/I clkload31/I VSS VSS VSS VSS gf180mcu_fd_sc_mcu9t5v0__clkbuf_8
X_19387_ _19387_/D _19963_/RN clkload22/I _19387_/Q VSS VSS VSS VSS gf180mcu_fd_sc_mcu9t5v0__dffrnq_1
X_18338_ _18338_/D clkload80/I _18338_/Q VSS VSS VSS VSS gf180mcu_fd_sc_mcu9t5v0__dffq_1
X_09140_ _19800_/Q _13237_/A1 VSS VSS VSS VSS gf180mcu_fd_sc_mcu9t5v0__clkinv_1
XTAP_TAPCELL_ROW_44_2198 VSS VSS gf180mcu_fd_sc_mcu9t5v0__filltie
X_09071_ _19841_/Q _15512_/C VSS _09071_/VNW VSS VSS gf180mcu_fd_sc_mcu9t5v0__clkinv_1
X_18269_ _18269_/D clkload62/I _18269_/Q VSS VSS VSS VSS gf180mcu_fd_sc_mcu9t5v0__dffq_1
XTAP_TAPCELL_ROW_228_5344 VSS VSS gf180mcu_fd_sc_mcu9t5v0__filltie
XTAP_TAPCELL_ROW_228_5333 VSS VSS gf180mcu_fd_sc_mcu9t5v0__filltie
XTAP_TAPCELL_ROW_57_2537 VSS VSS gf180mcu_fd_sc_mcu9t5v0__filltie
XTAP_TAPCELL_ROW_57_2548 VSS VSS gf180mcu_fd_sc_mcu9t5v0__filltie
XTAP_TAPCELL_ROW_57_2559 VSS VSS gf180mcu_fd_sc_mcu9t5v0__filltie
XTAP_TAPCELL_ROW_224_5219 VSS VSS gf180mcu_fd_sc_mcu9t5v0__filltie
X_09973_ _20005_/Q _15824_/B2 _15825_/A1 VSS _15824_/VNW VSS VSS gf180mcu_fd_sc_mcu9t5v0__nand2_1
X_20093_ _20093_/D clkload58/I _20093_/Q VSS VSS VSS VSS gf180mcu_fd_sc_mcu9t5v0__dffq_1
XTAP_TAPCELL_ROW_291_7080 VSS VSS gf180mcu_fd_sc_mcu9t5v0__filltie
XTAP_TAPCELL_ROW_33_1880 VSS VSS gf180mcu_fd_sc_mcu9t5v0__filltie
XTAP_TAPCELL_ROW_33_1891 VSS VSS gf180mcu_fd_sc_mcu9t5v0__filltie
XPHY_EDGE_ROW_2_Right_2 VSS VSS gf180mcu_fd_sc_mcu9t5v0__endcap
XTAP_TAPCELL_ROW_312_7651 VSS VSS gf180mcu_fd_sc_mcu9t5v0__filltie
XTAP_TAPCELL_ROW_312_7640 VSS VSS gf180mcu_fd_sc_mcu9t5v0__filltie
XPHY_EDGE_ROW_180_3_Right_295 VSS VSS gf180mcu_fd_sc_mcu9t5v0__endcap
XTAP_TAPCELL_ROW_312_7662 VSS VSS gf180mcu_fd_sc_mcu9t5v0__filltie
XPHY_EDGE_ROW_152_3_Left_810 VSS VSS gf180mcu_fd_sc_mcu9t5v0__endcap
XTAP_TAPCELL_ROW_1_998 VSS VSS gf180mcu_fd_sc_mcu9t5v0__filltie
X_09407_ _20140_/Q _20142_/Q _09542_/A1 VSS VSS VSS VSS gf180mcu_fd_sc_mcu9t5v0__nor2_1
XPHY_EDGE_ROW_159_1_Left_482 VSS VSS gf180mcu_fd_sc_mcu9t5v0__endcap
X_09338_ _19235_/Q _16422_/A1 VSS VSS VSS VSS gf180mcu_fd_sc_mcu9t5v0__clkinv_1
XTAP_TAPCELL_ROW_213_4934 VSS VSS gf180mcu_fd_sc_mcu9t5v0__filltie
XTAP_TAPCELL_ROW_213_4923 VSS VSS gf180mcu_fd_sc_mcu9t5v0__filltie
XTAP_TAPCELL_ROW_116_4180 VSS VSS gf180mcu_fd_sc_mcu9t5v0__filltie
X_11300_ _18343_/Q _18327_/Q _18311_/Q _18295_/Q _11534_/S wire136/Z _11300_/Z VSS
+ VSS VSS VSS gf180mcu_fd_sc_mcu9t5v0__mux4_1
Xeco12_buf_16106 _16106_/ZN _16477_/A2 VSS VSS VSS VSS gf180mcu_fd_sc_mcu9t5v0__clkbuf_16
X_09269_ _19925_/Q _09667_/A2 VSS VSS VSS VSS gf180mcu_fd_sc_mcu9t5v0__clkinv_1
XTAP_TAPCELL_ROW_321_7909 VSS VSS gf180mcu_fd_sc_mcu9t5v0__filltie
X_12280_ _18373_/Q _18357_/Q _12315_/S _12280_/Z VSS _12280_/VNW VSS VSS gf180mcu_fd_sc_mcu9t5v0__mux2_1
XTAP_TAPCELL_ROW_306_7477 VSS VSS gf180mcu_fd_sc_mcu9t5v0__filltie
XTAP_TAPCELL_ROW_112_4066 VSS VSS gf180mcu_fd_sc_mcu9t5v0__filltie
XTAP_TAPCELL_ROW_112_4055 VSS VSS gf180mcu_fd_sc_mcu9t5v0__filltie
XTAP_TAPCELL_ROW_306_7499 VSS VSS gf180mcu_fd_sc_mcu9t5v0__filltie
XTAP_TAPCELL_ROW_306_7488 VSS VSS gf180mcu_fd_sc_mcu9t5v0__filltie
X_11231_ _11520_/B _11231_/A2 _11231_/A3 _11232_/B VSS _16218_/VNW VSS VSS gf180mcu_fd_sc_mcu9t5v0__nand3_1
XTAP_TAPCELL_ROW_298_7267 VSS VSS gf180mcu_fd_sc_mcu9t5v0__filltie
X_11162_ _18566_/Q _18173_/Q _11428_/B _11161_/Z _11526_/B _11163_/A2 VSS VSS VSS
+ VSS gf180mcu_fd_sc_mcu9t5v0__aoi221_1
XTAP_TAPCELL_ROW_298_7256 VSS VSS gf180mcu_fd_sc_mcu9t5v0__filltie
XTAP_TAPCELL_ROW_129_4541 VSS VSS gf180mcu_fd_sc_mcu9t5v0__filltie
XTAP_TAPCELL_ROW_129_4530 VSS VSS gf180mcu_fd_sc_mcu9t5v0__filltie
XTAP_TAPCELL_ROW_298_7278 VSS VSS gf180mcu_fd_sc_mcu9t5v0__filltie
X_10113_ _20042_/Q _15595_/A1 _10178_/A1 _10113_/B2 _10114_/A2 VSS VSS VSS VSS gf180mcu_fd_sc_mcu9t5v0__aoi22_1
XTAP_TAPCELL_ROW_125_4416 VSS VSS gf180mcu_fd_sc_mcu9t5v0__filltie
XTAP_TAPCELL_ROW_319_7849 VSS VSS gf180mcu_fd_sc_mcu9t5v0__filltie
XTAP_TAPCELL_ROW_319_7838 VSS VSS gf180mcu_fd_sc_mcu9t5v0__filltie
X_11093_ _18249_/Q _11519_/A2 _11103_/A1 VSS VSS VSS VSS gf180mcu_fd_sc_mcu9t5v0__nor2_1
X_15970_ _15854_/Z _15973_/B _15988_/C _15988_/B _15970_/ZN VSS VSS VSS VSS gf180mcu_fd_sc_mcu9t5v0__nand4_4
XTAP_TAPCELL_ROW_125_4427 VSS VSS gf180mcu_fd_sc_mcu9t5v0__filltie
X_10044_ _10063_/C _10044_/A2 _10044_/B1 _10044_/B2 output13/I VSS _10108_/VNW VSS
+ VSS gf180mcu_fd_sc_mcu9t5v0__aoi22_1
X_14921_ _19359_/Q _19420_/Q _14926_/A1 VSS VSS VSS VSS gf180mcu_fd_sc_mcu9t5v0__nand2_1
XPHY_EDGE_ROW_191_1_Right_775 VSS VSS gf180mcu_fd_sc_mcu9t5v0__endcap
X_17640_ _18688_/Q _17640_/A2 _18688_/D VSS VSS VSS VSS gf180mcu_fd_sc_mcu9t5v0__xnor2_1
X_14852_ _14852_/A1 _14852_/A2 _14852_/B _14853_/A2 VSS VSS VSS VSS gf180mcu_fd_sc_mcu9t5v0__oai21_1
X_13803_ _13803_/A1 _13803_/A2 _13781_/B _13803_/B1 _13803_/B2 _13803_/B3 _13805_/A2
+ VSS VSS VSS VSS gf180mcu_fd_sc_mcu9t5v0__oai33_1
X_11995_ _18248_/Q _12345_/A2 _12320_/C _11997_/A2 VSS VSS VSS VSS gf180mcu_fd_sc_mcu9t5v0__aoi21_1
X_17571_ _17584_/I1 _18642_/Q _17571_/S _18642_/D VSS VSS VSS VSS gf180mcu_fd_sc_mcu9t5v0__mux2_1
X_14783_ _19397_/Q _19334_/Q _14786_/A2 VSS _14877_/VNW VSS VSS gf180mcu_fd_sc_mcu9t5v0__nor2_1
X_19310_ _19310_/D _20142_/RN clkload20/I _19310_/Q VSS VSS VSS VSS gf180mcu_fd_sc_mcu9t5v0__dffrnq_1
X_16522_ _16521_/Z _18317_/Q _17050_/S _18317_/D VSS VSS VSS VSS gf180mcu_fd_sc_mcu9t5v0__mux2_4
XTAP_TAPCELL_ROW_270_6485 VSS VSS gf180mcu_fd_sc_mcu9t5v0__filltie
X_10946_ _18148_/S _10986_/A1 _10946_/B _19007_/D VSS VSS VSS VSS gf180mcu_fd_sc_mcu9t5v0__oai21_1
X_13734_ _13734_/I _13745_/C VSS VSS VSS VSS gf180mcu_fd_sc_mcu9t5v0__clkinv_1
X_16453_ _19232_/Q _16137_/C _16991_/S _16453_/Z VSS VSS VSS VSS gf180mcu_fd_sc_mcu9t5v0__mux2_1
XTAP_TAPCELL_ROW_270_6496 VSS VSS gf180mcu_fd_sc_mcu9t5v0__filltie
X_10877_ _19241_/Q _19235_/Q _18117_/S _10877_/Z VSS VSS VSS VSS gf180mcu_fd_sc_mcu9t5v0__mux2_1
X_19241_ _19241_/D _20073_/RN clkload68/I _19241_/Q VSS VSS VSS VSS gf180mcu_fd_sc_mcu9t5v0__dffrnq_1
XTAP_TAPCELL_ROW_101_3770 VSS VSS gf180mcu_fd_sc_mcu9t5v0__filltie
X_13665_ _19142_/Q _19108_/Q _13666_/B VSS _14651_/VNW VSS VSS gf180mcu_fd_sc_mcu9t5v0__xnor2_1
X_12616_ _18504_/Q _12616_/A2 _12616_/B _12617_/B2 VSS VSS VSS VSS gf180mcu_fd_sc_mcu9t5v0__oai21_1
X_16384_ _16383_/Z _18255_/Q _16924_/S _18255_/D VSS VSS VSS VSS gf180mcu_fd_sc_mcu9t5v0__mux2_1
X_15404_ _19689_/Q _19789_/Q _15430_/S _19789_/D VSS VSS VSS VSS gf180mcu_fd_sc_mcu9t5v0__mux2_1
X_19172_ _19172_/D _20068_/RN clkload31/I _19172_/Q VSS VSS VSS VSS gf180mcu_fd_sc_mcu9t5v0__dffrnq_1
XTAP_TAPCELL_ROW_287_6971 VSS VSS gf180mcu_fd_sc_mcu9t5v0__filltie
XTAP_TAPCELL_ROW_287_6960 VSS VSS gf180mcu_fd_sc_mcu9t5v0__filltie
X_18123_ _18123_/I0 _18948_/Q _18148_/S _18948_/D VSS VSS VSS VSS gf180mcu_fd_sc_mcu9t5v0__mux2_1
X_13596_ wire277/Z _13599_/A2 _13595_/Z _13596_/B _19281_/D VSS VSS VSS VSS gf180mcu_fd_sc_mcu9t5v0__oai31_1
X_15335_ _19643_/Q _19620_/Q _15341_/C _15337_/A3 VSS VSS VSS VSS gf180mcu_fd_sc_mcu9t5v0__aoi21_1
XTAP_TAPCELL_ROW_283_6857 VSS VSS gf180mcu_fd_sc_mcu9t5v0__filltie
XTAP_TAPCELL_ROW_283_6846 VSS VSS gf180mcu_fd_sc_mcu9t5v0__filltie
X_12547_ _12618_/B _12547_/A2 _12548_/A2 VSS _13067_/VNW VSS VSS gf180mcu_fd_sc_mcu9t5v0__nand2_1
X_12478_ _18168_/Q _12613_/A2 _12482_/A2 VSS VSS VSS VSS gf180mcu_fd_sc_mcu9t5v0__nor2_1
Xeco5_buf_16236 _16236_/ZN _16824_/S VSS VSS VSS VSS gf180mcu_fd_sc_mcu9t5v0__clkbuf_16
X_18054_ _10996_/S _18054_/A2 _18060_/B _18056_/S VSS VSS VSS VSS gf180mcu_fd_sc_mcu9t5v0__aoi21_1
X_15266_ _15266_/A1 _19579_/Q _15268_/A1 _15267_/I1 VSS VSS VSS VSS gf180mcu_fd_sc_mcu9t5v0__xnor3_1
XANTENNA_3 _11836_/B VSS _11836_/VNW VSS VSS gf180mcu_fd_sc_mcu9t5v0__antenna
X_11429_ _11429_/A1 _11429_/A2 _11429_/B _11429_/C _11431_/B VSS VSS VSS VSS gf180mcu_fd_sc_mcu9t5v0__oai211_1
X_17005_ _19249_/Q _16606_/B _17023_/S _17005_/Z VSS VSS VSS VSS gf180mcu_fd_sc_mcu9t5v0__mux2_1
XPHY_EDGE_ROW_252_Right_179 VSS VSS gf180mcu_fd_sc_mcu9t5v0__endcap
X_14217_ _14217_/A1 _14217_/A2 _14218_/I VSS VSS VSS VSS gf180mcu_fd_sc_mcu9t5v0__nand2_1
X_15197_ _15417_/S _15197_/A2 _15197_/B _19719_/D VSS VSS VSS VSS gf180mcu_fd_sc_mcu9t5v0__oai21_1
X_14148_ _14148_/A1 _14166_/B _14148_/B1 _14148_/B2 _19317_/D VSS VSS VSS VSS gf180mcu_fd_sc_mcu9t5v0__aoi22_1
XTAP_TAPCELL_ROW_52_2401 VSS VSS gf180mcu_fd_sc_mcu9t5v0__filltie
XTAP_TAPCELL_ROW_52_2412 VSS VSS gf180mcu_fd_sc_mcu9t5v0__filltie
XTAP_TAPCELL_ROW_52_2423 VSS VSS gf180mcu_fd_sc_mcu9t5v0__filltie
X_18956_ _18956_/D _20044_/RN _20099_/CLK _18956_/Q VSS VSS VSS VSS gf180mcu_fd_sc_mcu9t5v0__dffrnq_1
X_14079_ _14115_/A1 _14079_/A2 _14111_/A1 _14090_/A1 VSS VSS VSS VSS gf180mcu_fd_sc_mcu9t5v0__xnor3_1
X_18887_ _18887_/D _20039_/RN clkload40/I _18887_/Q VSS VSS VSS VSS gf180mcu_fd_sc_mcu9t5v0__dffrnq_1
XTAP_TAPCELL_ROW_108_3957 VSS VSS gf180mcu_fd_sc_mcu9t5v0__filltie
X_17907_ _18838_/Q _17907_/A2 _17907_/B _17907_/C _17908_/A2 VSS VSS VSS VSS gf180mcu_fd_sc_mcu9t5v0__oai211_1
XTAP_TAPCELL_ROW_108_3946 VSS VSS gf180mcu_fd_sc_mcu9t5v0__filltie
X_17838_ _19045_/Q _18815_/Q _17845_/S _18815_/D VSS VSS VSS VSS gf180mcu_fd_sc_mcu9t5v0__mux2_1
X_17769_ _17769_/A1 _17779_/A2 _17769_/B _17779_/C _18759_/D VSS VSS VSS VSS gf180mcu_fd_sc_mcu9t5v0__aoi211_1
XTAP_TAPCELL_ROW_46_2238 VSS VSS gf180mcu_fd_sc_mcu9t5v0__filltie
XTAP_TAPCELL_ROW_217_5045 VSS VSS gf180mcu_fd_sc_mcu9t5v0__filltie
XTAP_TAPCELL_ROW_217_5034 VSS VSS gf180mcu_fd_sc_mcu9t5v0__filltie
X_19508_ _19508_/D _20020_/RN clkload23/I _19508_/Q VSS VSS VSS VSS gf180mcu_fd_sc_mcu9t5v0__dffrnq_1
XTAP_TAPCELL_ROW_46_2249 VSS VSS gf180mcu_fd_sc_mcu9t5v0__filltie
X_19439_ _19439_/D _20143_/RN clkload28/I _19439_/Q VSS VSS VSS VSS gf180mcu_fd_sc_mcu9t5v0__dffrnq_1
XPHY_EDGE_ROW_99_Left_423 VSS VSS gf180mcu_fd_sc_mcu9t5v0__endcap
X_09123_ _19789_/Q _13053_/A2 VSS _13053_/VNW VSS VSS gf180mcu_fd_sc_mcu9t5v0__clkinv_1
XTAP_TAPCELL_ROW_22_1581 VSS VSS gf180mcu_fd_sc_mcu9t5v0__filltie
XTAP_TAPCELL_ROW_22_1592 VSS VSS gf180mcu_fd_sc_mcu9t5v0__filltie
XTAP_TAPCELL_ROW_301_7341 VSS VSS gf180mcu_fd_sc_mcu9t5v0__filltie
XTAP_TAPCELL_ROW_301_7352 VSS VSS gf180mcu_fd_sc_mcu9t5v0__filltie
XTAP_TAPCELL_ROW_293_7131 VSS VSS gf180mcu_fd_sc_mcu9t5v0__filltie
XTAP_TAPCELL_ROW_293_7120 VSS VSS gf180mcu_fd_sc_mcu9t5v0__filltie
X_20145_ _20145_/D _20145_/RN clkload49/I _20145_/Q VSS VSS VSS VSS gf180mcu_fd_sc_mcu9t5v0__dffrnq_1
XTAP_TAPCELL_ROW_35_1942 VSS VSS gf180mcu_fd_sc_mcu9t5v0__filltie
X_09956_ _09956_/A1 _09956_/A2 _09956_/A3 _10179_/B _10154_/B VSS VSS VSS VSS gf180mcu_fd_sc_mcu9t5v0__oai31_1
XTAP_TAPCELL_ROW_35_1953 VSS VSS gf180mcu_fd_sc_mcu9t5v0__filltie
X_20076_ _20076_/D clkload76/I _20076_/Q VSS VSS VSS VSS gf180mcu_fd_sc_mcu9t5v0__dffq_1
X_09887_ _09887_/A1 _18692_/Q _18751_/Q _09888_/C VSS VSS VSS VSS gf180mcu_fd_sc_mcu9t5v0__and3_1
XTAP_TAPCELL_ROW_31_1828 VSS VSS gf180mcu_fd_sc_mcu9t5v0__filltie
XTAP_TAPCELL_ROW_314_7713 VSS VSS gf180mcu_fd_sc_mcu9t5v0__filltie
XTAP_TAPCELL_ROW_314_7702 VSS VSS gf180mcu_fd_sc_mcu9t5v0__filltie
XTAP_TAPCELL_ROW_31_1839 VSS VSS gf180mcu_fd_sc_mcu9t5v0__filltie
X_11780_ _18238_/Q _12203_/A2 _11784_/A1 VSS VSS VSS VSS gf180mcu_fd_sc_mcu9t5v0__nand2_1
XPHY_EDGE_ROW_181_3_Right_296 VSS VSS gf180mcu_fd_sc_mcu9t5v0__endcap
X_10800_ _10800_/A1 _10800_/A2 _10801_/A2 VSS VSS VSS VSS gf180mcu_fd_sc_mcu9t5v0__nand2_1
XTAP_TAPCELL_ROW_118_4231 VSS VSS gf180mcu_fd_sc_mcu9t5v0__filltie
XTAP_TAPCELL_ROW_118_4220 VSS VSS gf180mcu_fd_sc_mcu9t5v0__filltie
XTAP_TAPCELL_ROW_29_1768 VSS VSS gf180mcu_fd_sc_mcu9t5v0__filltie
X_10731_ _18841_/Q _18848_/Q _10753_/B _10751_/A3 VSS VSS VSS VSS gf180mcu_fd_sc_mcu9t5v0__xnor3_1
XTAP_TAPCELL_ROW_29_1779 VSS VSS gf180mcu_fd_sc_mcu9t5v0__filltie
X_13450_ _13450_/A1 _13450_/A2 _13456_/B1 VSS _13450_/VNW VSS VSS gf180mcu_fd_sc_mcu9t5v0__nand2_1
XTAP_TAPCELL_ROW_308_7528 VSS VSS gf180mcu_fd_sc_mcu9t5v0__filltie
X_12401_ _18736_/Q wire198/Z _12543_/B1 _12401_/B2 _12402_/A3 VSS VSS VSS VSS gf180mcu_fd_sc_mcu9t5v0__aoi22_2
XTAP_TAPCELL_ROW_114_4128 VSS VSS gf180mcu_fd_sc_mcu9t5v0__filltie
X_10662_ _10662_/I0 _10796_/A2 _10718_/C _10662_/Z VSS VSS VSS VSS gf180mcu_fd_sc_mcu9t5v0__mux2_4
XTAP_TAPCELL_ROW_114_4117 VSS VSS gf180mcu_fd_sc_mcu9t5v0__filltie
XTAP_TAPCELL_ROW_114_4106 VSS VSS gf180mcu_fd_sc_mcu9t5v0__filltie
XTAP_TAPCELL_ROW_308_7539 VSS VSS gf180mcu_fd_sc_mcu9t5v0__filltie
X_10593_ _17304_/C _10593_/A2 _10594_/C VSS VSS VSS VSS gf180mcu_fd_sc_mcu9t5v0__nand2_1
X_13381_ _13416_/B1 _13380_/I _13382_/A2 VSS _13381_/VNW VSS VSS gf180mcu_fd_sc_mcu9t5v0__xnor2_1
X_12332_ _12339_/A2 _12332_/A2 _12351_/B _12334_/B1 VSS _12332_/VNW VSS VSS gf180mcu_fd_sc_mcu9t5v0__aoi21_2
X_15120_ _19662_/Q _19502_/Q wire108/Z _19662_/D VSS VSS VSS VSS gf180mcu_fd_sc_mcu9t5v0__mux2_1
X_12263_ _18420_/Q _12315_/S _12322_/B _12266_/A2 VSS _12266_/VNW VSS VSS gf180mcu_fd_sc_mcu9t5v0__aoi21_1
X_15051_ _15090_/A2 _15052_/B _15050_/Z _15051_/B _19639_/D VSS VSS VSS VSS gf180mcu_fd_sc_mcu9t5v0__oai31_1
X_11214_ _19080_/Q _11321_/A2 _11215_/A2 VSS VSS VSS VSS gf180mcu_fd_sc_mcu9t5v0__nand2_1
X_14002_ _19319_/Q _19299_/Q _14071_/A1 VSS _14044_/VNW VSS VSS gf180mcu_fd_sc_mcu9t5v0__nand2_1
X_12194_ _12548_/A1 _12193_/Z _12216_/A2 VSS _12194_/VNW VSS VSS gf180mcu_fd_sc_mcu9t5v0__nor2_1
X_11145_ _18204_/Q _18188_/Q _11403_/S _11145_/Z VSS VSS VSS VSS gf180mcu_fd_sc_mcu9t5v0__mux2_1
X_18810_ _18810_/D _20026_/RN clkload34/I _18810_/Q VSS VSS VSS VSS gf180mcu_fd_sc_mcu9t5v0__dffrnq_1
X_19790_ _19790_/D _20046_/RN clkload32/I _19790_/Q VSS VSS VSS VSS gf180mcu_fd_sc_mcu9t5v0__dffrnq_1
X_15953_ _15930_/I _15934_/I _15953_/B _18567_/Q _15953_/ZN VSS VSS VSS VSS gf180mcu_fd_sc_mcu9t5v0__aoi211_4
X_18741_ _18741_/D clkload47/I _18741_/Q VSS VSS VSS VSS gf180mcu_fd_sc_mcu9t5v0__dffq_1
X_11076_ _17960_/A2 _11321_/A2 _19072_/D VSS _12012_/VNW VSS VSS gf180mcu_fd_sc_mcu9t5v0__nand2_1
XTAP_TAPCELL_ROW_276_6672 VSS VSS gf180mcu_fd_sc_mcu9t5v0__filltie
XTAP_TAPCELL_ROW_276_6661 VSS VSS gf180mcu_fd_sc_mcu9t5v0__filltie
XTAP_TAPCELL_ROW_276_6650 VSS VSS gf180mcu_fd_sc_mcu9t5v0__filltie
X_10027_ _19199_/Q _10133_/A2 _10169_/B1 _19239_/Q _10027_/C _10028_/A2 VSS VSS VSS
+ VSS gf180mcu_fd_sc_mcu9t5v0__aoi221_1
X_14904_ _19417_/Q _19358_/Q _14907_/A1 _14905_/I1 VSS _14904_/VNW VSS VSS gf180mcu_fd_sc_mcu9t5v0__xnor3_1
X_18672_ _18672_/D _20140_/RN _20129_/CLK _18672_/Q VSS VSS VSS VSS gf180mcu_fd_sc_mcu9t5v0__dffrnq_1
X_15884_ _20093_/Q _19228_/Q _15920_/S _20093_/D VSS VSS VSS VSS gf180mcu_fd_sc_mcu9t5v0__mux2_1
XPHY_EDGE_ROW_192_1_Right_776 VSS VSS gf180mcu_fd_sc_mcu9t5v0__endcap
XTAP_TAPCELL_ROW_103_3810 VSS VSS gf180mcu_fd_sc_mcu9t5v0__filltie
XTAP_TAPCELL_ROW_272_6558 VSS VSS gf180mcu_fd_sc_mcu9t5v0__filltie
XTAP_TAPCELL_ROW_272_6547 VSS VSS gf180mcu_fd_sc_mcu9t5v0__filltie
X_17623_ _15431_/Z _17623_/A2 _18683_/D VSS VSS VSS VSS gf180mcu_fd_sc_mcu9t5v0__nor2_1
XTAP_TAPCELL_ROW_103_3821 VSS VSS gf180mcu_fd_sc_mcu9t5v0__filltie
X_14835_ _19341_/Q _19406_/Q _14846_/A2 VSS VSS VSS VSS gf180mcu_fd_sc_mcu9t5v0__nand2_1
X_11978_ _11978_/A1 _11978_/A2 _11978_/B1 _11978_/B2 _12116_/C _11982_/B1 VSS _11978_/VNW
+ VSS VSS gf180mcu_fd_sc_mcu9t5v0__aoi221_1
X_17554_ _17554_/A1 _17553_/Z _17696_/A2 VSS VSS VSS VSS gf180mcu_fd_sc_mcu9t5v0__nand2_1
X_14766_ _19555_/Q _14766_/A2 _14767_/B VSS _14766_/VNW VSS VSS gf180mcu_fd_sc_mcu9t5v0__nand2_1
X_16505_ _19241_/Q _16182_/B _17025_/S _16505_/Z VSS _16505_/VNW VSS VSS gf180mcu_fd_sc_mcu9t5v0__mux2_1
XPHY_EDGE_ROW_176_2_Left_688 VSS VSS gf180mcu_fd_sc_mcu9t5v0__endcap
X_10929_ _18926_/Q _18933_/Q _10962_/B VSS _10962_/VNW VSS VSS gf180mcu_fd_sc_mcu9t5v0__xor2_1
X_13717_ _13756_/A1 _13717_/A2 _13717_/B _19297_/D VSS VSS VSS VSS gf180mcu_fd_sc_mcu9t5v0__oai21_1
XPHY_EDGE_ROW_321_Right_248 VSS VSS gf180mcu_fd_sc_mcu9t5v0__endcap
XTAP_TAPCELL_ROW_285_6908 VSS VSS gf180mcu_fd_sc_mcu9t5v0__filltie
X_17485_ _18590_/Q _19231_/Q _17504_/S _18590_/D VSS VSS VSS VSS gf180mcu_fd_sc_mcu9t5v0__mux2_1
X_19224_ _19224_/D _19992_/RN clkload39/I _19224_/Q VSS VSS VSS VSS gf180mcu_fd_sc_mcu9t5v0__dffrnq_1
XTAP_TAPCELL_ROW_41_2102 VSS VSS gf180mcu_fd_sc_mcu9t5v0__filltie
XTAP_TAPCELL_ROW_41_2113 VSS VSS gf180mcu_fd_sc_mcu9t5v0__filltie
X_14697_ _14697_/A1 _14699_/A2 _14697_/Z VSS VSS VSS VSS gf180mcu_fd_sc_mcu9t5v0__xor2_1
XTAP_TAPCELL_ROW_285_6919 VSS VSS gf180mcu_fd_sc_mcu9t5v0__filltie
X_16436_ _16436_/A1 _16809_/S _16436_/B _16437_/I0 VSS VSS VSS VSS gf180mcu_fd_sc_mcu9t5v0__oai21_4
X_13648_ _19141_/Q _19107_/Q _14645_/A2 VSS _13649_/VNW VSS VSS gf180mcu_fd_sc_mcu9t5v0__xnor2_1
X_16367_ _19243_/Q _16099_/B _16895_/S _16367_/Z VSS VSS VSS VSS gf180mcu_fd_sc_mcu9t5v0__mux2_1
X_19155_ _19155_/D _20051_/RN _19798_/CLK _19155_/Q VSS VSS VSS VSS gf180mcu_fd_sc_mcu9t5v0__dffrnq_1
X_13579_ _19278_/Q _13304_/B _13583_/B VSS _13579_/VNW VSS VSS gf180mcu_fd_sc_mcu9t5v0__nand2_1
X_18106_ _18105_/Z _18940_/Q _18152_/S _18940_/D VSS VSS VSS VSS gf180mcu_fd_sc_mcu9t5v0__mux2_1
X_16298_ _16298_/A1 _16440_/B _16298_/Z VSS VSS VSS VSS gf180mcu_fd_sc_mcu9t5v0__and2_4
X_19086_ _19086_/D _20046_/RN clkload42/I _19086_/Q VSS VSS VSS VSS gf180mcu_fd_sc_mcu9t5v0__dffrnq_1
X_15318_ _19641_/Q _19618_/Q _15324_/B VSS VSS VSS VSS gf180mcu_fd_sc_mcu9t5v0__nand2_1
XTAP_TAPCELL_ROW_39_2042 VSS VSS gf180mcu_fd_sc_mcu9t5v0__filltie
XTAP_TAPCELL_ROW_39_2053 VSS VSS gf180mcu_fd_sc_mcu9t5v0__filltie
X_18037_ _15581_/B _18922_/Q _18037_/S _18922_/D VSS VSS VSS VSS gf180mcu_fd_sc_mcu9t5v0__mux2_1
X_15249_ _15249_/A1 _15248_/B _15249_/A3 _15258_/C VSS VSS VSS VSS gf180mcu_fd_sc_mcu9t5v0__nand3_1
XTAP_TAPCELL_ROW_39_2064 VSS VSS gf180mcu_fd_sc_mcu9t5v0__filltie
XPHY_EDGE_ROW_269_Left_592 VSS VSS gf180mcu_fd_sc_mcu9t5v0__endcap
XPHY_EDGE_ROW_99_Right_99 VSS VSS gf180mcu_fd_sc_mcu9t5v0__endcap
X_19988_ _19988_/D _20052_/RN clkload46/I _19988_/Q VSS VSS VSS VSS gf180mcu_fd_sc_mcu9t5v0__dffrnq_1
X_09810_ _18837_/Q _18836_/Q _17900_/B2 VSS VSS VSS VSS gf180mcu_fd_sc_mcu9t5v0__xnor2_1
X_18939_ _18939_/D _19963_/RN clkload66/I _18939_/Q VSS VSS VSS VSS gf180mcu_fd_sc_mcu9t5v0__dffrnq_1
X_09741_ wire300/Z _09741_/A2 _09634_/Z _15703_/A3 VSS _09741_/VNW VSS VSS gf180mcu_fd_sc_mcu9t5v0__nand3_1
X_09672_ _17950_/A1 _09875_/A1 _19997_/Q _09673_/A2 VSS VSS VSS VSS gf180mcu_fd_sc_mcu9t5v0__oai21_1
XTAP_TAPCELL_ROW_11_1282 VSS VSS gf180mcu_fd_sc_mcu9t5v0__filltie
XTAP_TAPCELL_ROW_11_1293 VSS VSS gf180mcu_fd_sc_mcu9t5v0__filltie
XTAP_TAPCELL_ROW_24_1632 VSS VSS gf180mcu_fd_sc_mcu9t5v0__filltie
XTAP_TAPCELL_ROW_24_1643 VSS VSS gf180mcu_fd_sc_mcu9t5v0__filltie
XTAP_TAPCELL_ROW_24_1654 VSS VSS gf180mcu_fd_sc_mcu9t5v0__filltie
X_09106_ _18927_/Q _18068_/A1 VSS _18068_/VNW VSS VSS gf180mcu_fd_sc_mcu9t5v0__clkinv_1
XTAP_TAPCELL_ROW_20_1529 VSS VSS gf180mcu_fd_sc_mcu9t5v0__filltie
XTAP_TAPCELL_ROW_303_7414 VSS VSS gf180mcu_fd_sc_mcu9t5v0__filltie
XTAP_TAPCELL_ROW_303_7403 VSS VSS gf180mcu_fd_sc_mcu9t5v0__filltie
X_20128_ _20128_/D _20129_/CLK _20128_/Q VSS VSS VSS VSS gf180mcu_fd_sc_mcu9t5v0__dffq_1
XTAP_TAPCELL_ROW_18_1469 VSS VSS gf180mcu_fd_sc_mcu9t5v0__filltie
X_09939_ _09939_/A1 _09939_/A2 _09939_/B1 _09939_/B2 _09939_/C _09967_/A2 VSS VSS
+ VSS VSS gf180mcu_fd_sc_mcu9t5v0__oai221_2
X_20059_ _20059_/D _20059_/RN clkload58/I _20059_/Q VSS VSS VSS VSS gf180mcu_fd_sc_mcu9t5v0__dffrnq_1
X_12950_ _12950_/I0 _19227_/Q _13419_/B _19227_/D VSS VSS VSS VSS gf180mcu_fd_sc_mcu9t5v0__mux2_1
XTAP_TAPCELL_ROW_289_7008 VSS VSS gf180mcu_fd_sc_mcu9t5v0__filltie
X_11901_ wire208/Z _11901_/A2 _11902_/A2 VSS VSS VSS VSS gf180mcu_fd_sc_mcu9t5v0__nand2_1
X_12881_ _19771_/Q _12880_/Z _12891_/A1 VSS VSS VSS VSS gf180mcu_fd_sc_mcu9t5v0__nor2_1
XTAP_TAPCELL_ROW_289_7019 VSS VSS gf180mcu_fd_sc_mcu9t5v0__filltie
X_11832_ _11988_/B _11832_/A2 _11832_/B _11850_/A2 VSS VSS VSS VSS gf180mcu_fd_sc_mcu9t5v0__oai21_4
X_14620_ _19081_/Q _19498_/Q _14624_/S _19498_/D VSS VSS VSS VSS gf180mcu_fd_sc_mcu9t5v0__mux2_1
X_14551_ _19169_/Q _19135_/Q _14748_/A1 VSS _14748_/VNW VSS VSS gf180mcu_fd_sc_mcu9t5v0__xnor2_1
X_11763_ _11749_/Z _11807_/A2 _11765_/A2 VSS VSS VSS VSS gf180mcu_fd_sc_mcu9t5v0__nor2_1
XPHY_EDGE_ROW_182_3_Right_297 VSS VSS gf180mcu_fd_sc_mcu9t5v0__endcap
X_17270_ _17412_/A1 _17270_/A2 _17412_/B _17271_/A2 VSS VSS VSS VSS gf180mcu_fd_sc_mcu9t5v0__aoi21_1
X_11694_ _18314_/Q _12208_/C _11695_/B VSS VSS VSS VSS gf180mcu_fd_sc_mcu9t5v0__nor2_1
X_10714_ _19005_/Q _18831_/Q _10715_/B VSS _10715_/VNW VSS VSS gf180mcu_fd_sc_mcu9t5v0__nor2_1
X_14482_ _14483_/A1 _14483_/A2 _14716_/B _14487_/B VSS _14482_/VNW VSS VSS gf180mcu_fd_sc_mcu9t5v0__oai21_1
X_13502_ _19718_/Q _13503_/A2 _13502_/B _13507_/A2 VSS _13502_/VNW VSS VSS gf180mcu_fd_sc_mcu9t5v0__aoi21_1
X_16221_ _16220_/Z _18195_/Q _16784_/S _18195_/D VSS _16221_/VNW VSS VSS gf180mcu_fd_sc_mcu9t5v0__mux2_1
X_10645_ _17407_/C _10645_/A2 _10645_/B wire168/Z _10648_/B1 VSS VSS VSS VSS gf180mcu_fd_sc_mcu9t5v0__oai211_1
XTAP_TAPCELL_ROW_98_3691 VSS VSS gf180mcu_fd_sc_mcu9t5v0__filltie
XTAP_TAPCELL_ROW_98_3680 VSS VSS gf180mcu_fd_sc_mcu9t5v0__filltie
X_13433_ _13433_/A1 _13433_/A2 _13433_/A3 _13433_/B _13453_/A1 VSS VSS VSS VSS gf180mcu_fd_sc_mcu9t5v0__oai31_1
X_16152_ _19235_/Q _16744_/A2 _16714_/A3 _16695_/B _16154_/A2 VSS VSS VSS VSS gf180mcu_fd_sc_mcu9t5v0__oai31_1
XTAP_TAPCELL_ROW_265_6351 VSS VSS gf180mcu_fd_sc_mcu9t5v0__filltie
XTAP_TAPCELL_ROW_94_3566 VSS VSS gf180mcu_fd_sc_mcu9t5v0__filltie
X_13364_ _19774_/Q _19808_/Q _13365_/B VSS VSS VSS VSS gf180mcu_fd_sc_mcu9t5v0__xor2_1
XTAP_TAPCELL_ROW_94_3555 VSS VSS gf180mcu_fd_sc_mcu9t5v0__filltie
X_12315_ _18375_/Q _18359_/Q _12315_/S _12315_/Z VSS VSS VSS VSS gf180mcu_fd_sc_mcu9t5v0__mux2_1
XTAP_TAPCELL_ROW_265_6362 VSS VSS gf180mcu_fd_sc_mcu9t5v0__filltie
X_10576_ _18999_/Q _10654_/A2 _10576_/B wire160/Z _10578_/B1 VSS _10576_/VNW VSS VSS
+ gf180mcu_fd_sc_mcu9t5v0__oai211_1
XTAP_TAPCELL_ROW_94_3577 VSS VSS gf180mcu_fd_sc_mcu9t5v0__filltie
X_15103_ _19395_/Q _19314_/Q _15105_/A1 _15104_/I1 VSS VSS VSS VSS gf180mcu_fd_sc_mcu9t5v0__xnor3_1
XTAP_TAPCELL_ROW_261_6259 VSS VSS gf180mcu_fd_sc_mcu9t5v0__filltie
XTAP_TAPCELL_ROW_261_6248 VSS VSS gf180mcu_fd_sc_mcu9t5v0__filltie
X_16083_ _19240_/Q _16751_/A2 wire71/Z _16084_/A3 VSS VSS VSS VSS gf180mcu_fd_sc_mcu9t5v0__nor3_1
XTAP_TAPCELL_ROW_261_6237 VSS VSS gf180mcu_fd_sc_mcu9t5v0__filltie
X_13295_ _19738_/Q _13295_/A2 _13590_/B VSS VSS VSS VSS gf180mcu_fd_sc_mcu9t5v0__xnor2_1
X_12246_ _12246_/A1 _12246_/A2 _12246_/B1 _12246_/B2 _12320_/C _12250_/B1 VSS VSS
+ VSS VSS gf180mcu_fd_sc_mcu9t5v0__aoi221_1
X_19911_ _19911_/D _20039_/RN clkload41/I _19911_/Q VSS VSS VSS VSS gf180mcu_fd_sc_mcu9t5v0__dffrnq_1
X_15034_ _19302_/Q _19387_/Q _15041_/A1 VSS VSS VSS VSS gf180mcu_fd_sc_mcu9t5v0__nand2_1
X_12177_ _18384_/Q _12159_/B _12178_/B VSS VSS VSS VSS gf180mcu_fd_sc_mcu9t5v0__or2_1
XTAP_TAPCELL_ROW_278_6723 VSS VSS gf180mcu_fd_sc_mcu9t5v0__filltie
XTAP_TAPCELL_ROW_278_6712 VSS VSS gf180mcu_fd_sc_mcu9t5v0__filltie
X_19842_ _19842_/D _20034_/RN clkload56/I _19842_/Q VSS VSS VSS VSS gf180mcu_fd_sc_mcu9t5v0__dffrnq_1
X_11128_ _18331_/Q _18315_/Q _18299_/Q _18283_/Q _11403_/S _11098_/B _11128_/Z VSS
+ VSS VSS VSS gf180mcu_fd_sc_mcu9t5v0__mux4_1
X_16985_ _19255_/Q _16647_/B _16991_/S _16985_/Z VSS _17346_/VNW VSS VSS gf180mcu_fd_sc_mcu9t5v0__mux2_1
XTAP_TAPCELL_ROW_274_6609 VSS VSS gf180mcu_fd_sc_mcu9t5v0__filltie
X_19773_ _19773_/D _20029_/RN clkload45/I _19773_/Q VSS VSS VSS VSS gf180mcu_fd_sc_mcu9t5v0__dffrnq_1
XTAP_TAPCELL_ROW_259_6199 VSS VSS gf180mcu_fd_sc_mcu9t5v0__filltie
XTAP_TAPCELL_ROW_259_6188 VSS VSS gf180mcu_fd_sc_mcu9t5v0__filltie
X_15936_ _15936_/A1 _15985_/B1 _15936_/B _15936_/C _15936_/ZN VSS VSS VSS VSS gf180mcu_fd_sc_mcu9t5v0__oai211_4
X_18724_ _18724_/D clkload52/I _18724_/Q VSS VSS VSS VSS gf180mcu_fd_sc_mcu9t5v0__dffq_1
X_11059_ _18029_/I0 _19060_/Q _11067_/S _19060_/D VSS VSS VSS VSS gf180mcu_fd_sc_mcu9t5v0__mux2_1
X_15867_ _20076_/Q _19259_/Q _15912_/S _20076_/D VSS _17409_/VNW VSS VSS gf180mcu_fd_sc_mcu9t5v0__mux2_1
X_18655_ _18655_/D _20059_/RN clkload47/I _18655_/Q VSS VSS VSS VSS gf180mcu_fd_sc_mcu9t5v0__dffrnq_1
XTAP_TAPCELL_ROW_8_1192 VSS VSS gf180mcu_fd_sc_mcu9t5v0__filltie
X_17606_ input5/Z _18669_/Q _17609_/S _18669_/D VSS VSS VSS VSS gf180mcu_fd_sc_mcu9t5v0__mux2_1
Xwire28 wire28/I wire28/Z VSS wire28/VNW VSS VSS gf180mcu_fd_sc_mcu9t5v0__buf_4
XPHY_EDGE_ROW_193_1_Right_777 VSS VSS gf180mcu_fd_sc_mcu9t5v0__endcap
X_14818_ _19403_/Q _19340_/Q _14821_/A2 VSS _14819_/VNW VSS VSS gf180mcu_fd_sc_mcu9t5v0__nor2_1
X_15798_ _18033_/I0 _19968_/Q _15802_/S _19968_/D VSS VSS VSS VSS gf180mcu_fd_sc_mcu9t5v0__mux2_1
XTAP_TAPCELL_ROW_4_1089 VSS VSS gf180mcu_fd_sc_mcu9t5v0__filltie
X_18586_ _18586_/D _20022_/RN clkload11/I _18586_/Q VSS VSS VSS VSS gf180mcu_fd_sc_mcu9t5v0__dffrnq_1
X_17537_ _18664_/Q wire300/Z _17731_/A1 VSS _17579_/VNW VSS VSS gf180mcu_fd_sc_mcu9t5v0__nand2_1
X_14749_ _14764_/B _14749_/A2 _14749_/B _19550_/D VSS _14749_/VNW VSS VSS gf180mcu_fd_sc_mcu9t5v0__aoi21_1
XTAP_TAPCELL_ROW_250_5952 VSS VSS gf180mcu_fd_sc_mcu9t5v0__filltie
XTAP_TAPCELL_ROW_250_5941 VSS VSS gf180mcu_fd_sc_mcu9t5v0__filltie
X_17468_ _09517_/I _17468_/A2 _18580_/D VSS VSS VSS VSS gf180mcu_fd_sc_mcu9t5v0__nor2_1
X_16419_ _16418_/Z _18270_/Q _16960_/S _18270_/D VSS VSS VSS VSS gf180mcu_fd_sc_mcu9t5v0__mux2_1
X_19207_ _19207_/D _20039_/RN clkload40/I _19207_/Q VSS VSS VSS VSS gf180mcu_fd_sc_mcu9t5v0__dffrnq_1
X_17399_ _17399_/A1 _18456_/Q _17402_/A2 VSS _17400_/VNW VSS VSS gf180mcu_fd_sc_mcu9t5v0__nor2_1
X_19138_ _19138_/D _20034_/RN clkload31/I _19138_/Q VSS VSS VSS VSS gf180mcu_fd_sc_mcu9t5v0__dffrnq_1
XPHY_EDGE_ROW_277_Left_600 VSS VSS gf180mcu_fd_sc_mcu9t5v0__endcap
XTAP_TAPCELL_ROW_248_5892 VSS VSS gf180mcu_fd_sc_mcu9t5v0__filltie
XTAP_TAPCELL_ROW_248_5881 VSS VSS gf180mcu_fd_sc_mcu9t5v0__filltie
X_19069_ _19069_/D _20029_/RN clkload11/I _19069_/Q VSS VSS VSS VSS gf180mcu_fd_sc_mcu9t5v0__dffrnq_1
XTAP_TAPCELL_ROW_244_5789 VSS VSS gf180mcu_fd_sc_mcu9t5v0__filltie
XTAP_TAPCELL_ROW_244_5778 VSS VSS gf180mcu_fd_sc_mcu9t5v0__filltie
XTAP_TAPCELL_ROW_244_5767 VSS VSS gf180mcu_fd_sc_mcu9t5v0__filltie
XPHY_EDGE_ROW_168_1_Left_491 VSS VSS gf180mcu_fd_sc_mcu9t5v0__endcap
X_09724_ _17601_/A2 _15747_/A2 _09726_/B VSS _17778_/VNW VSS VSS gf180mcu_fd_sc_mcu9t5v0__or2_1
XTAP_TAPCELL_ROW_13_1333 VSS VSS gf180mcu_fd_sc_mcu9t5v0__filltie
XTAP_TAPCELL_ROW_13_1344 VSS VSS gf180mcu_fd_sc_mcu9t5v0__filltie
X_09655_ _20003_/Q _09670_/A2 _09656_/B VSS _09656_/VNW VSS VSS gf180mcu_fd_sc_mcu9t5v0__nand2_1
X_09586_ _09582_/Z _09609_/A2 _09587_/A3 _18060_/B VSS VSS VSS VSS gf180mcu_fd_sc_mcu9t5v0__and3_2
XTAP_TAPCELL_ROW_26_1705 VSS VSS gf180mcu_fd_sc_mcu9t5v0__filltie
X_10430_ _17260_/S _18272_/Q _10432_/A3 VSS VSS VSS VSS gf180mcu_fd_sc_mcu9t5v0__nor2_1
X_10361_ _19852_/Q _17161_/C _10416_/B _10361_/C _10368_/A1 VSS VSS VSS VSS gf180mcu_fd_sc_mcu9t5v0__oai211_4
X_10292_ _17195_/A1 _18251_/Q _10295_/A2 VSS _11712_/VNW VSS VSS gf180mcu_fd_sc_mcu9t5v0__nor2_1
X_13080_ _13088_/A1 _13080_/A2 _13081_/B VSS VSS VSS VSS gf180mcu_fd_sc_mcu9t5v0__xnor2_1
X_12100_ _14487_/A2 _12311_/B _12100_/B _19127_/D VSS _14484_/VNW VSS VSS gf180mcu_fd_sc_mcu9t5v0__aoi21_1
X_12031_ _12031_/A1 _12031_/A2 _19124_/D VSS VSS VSS VSS gf180mcu_fd_sc_mcu9t5v0__nand2_1
X_16770_ _16769_/Z _18384_/Q _16770_/S _18384_/D VSS VSS VSS VSS gf180mcu_fd_sc_mcu9t5v0__mux2_1
X_13982_ _13988_/A1 _13982_/A2 _13979_/Z _13983_/B VSS VSS VSS VSS gf180mcu_fd_sc_mcu9t5v0__xnor3_1
XTAP_TAPCELL_ROW_87_3370 VSS VSS gf180mcu_fd_sc_mcu9t5v0__filltie
X_15721_ _19915_/Q _19916_/Q _15721_/A3 _15722_/I VSS VSS VSS VSS gf180mcu_fd_sc_mcu9t5v0__nor3_1
X_12933_ _19224_/Q _13419_/B _12934_/B VSS _12933_/VNW VSS VSS gf180mcu_fd_sc_mcu9t5v0__nand2_1
XTAP_TAPCELL_ROW_87_3381 VSS VSS gf180mcu_fd_sc_mcu9t5v0__filltie
XPHY_EDGE_ROW_45_Left_369 VSS VSS gf180mcu_fd_sc_mcu9t5v0__endcap
X_18440_ _18440_/D clkload77/I _18440_/Q VSS VSS VSS VSS gf180mcu_fd_sc_mcu9t5v0__dffq_1
XTAP_TAPCELL_ROW_254_6063 VSS VSS gf180mcu_fd_sc_mcu9t5v0__filltie
XTAP_TAPCELL_ROW_254_6052 VSS VSS gf180mcu_fd_sc_mcu9t5v0__filltie
XTAP_TAPCELL_ROW_83_3278 VSS VSS gf180mcu_fd_sc_mcu9t5v0__filltie
XTAP_TAPCELL_ROW_83_3267 VSS VSS gf180mcu_fd_sc_mcu9t5v0__filltie
XTAP_TAPCELL_ROW_83_3256 VSS VSS gf180mcu_fd_sc_mcu9t5v0__filltie
X_15652_ _19903_/Q _15652_/A2 _19903_/D VSS _15652_/VNW VSS VSS gf180mcu_fd_sc_mcu9t5v0__and2_1
X_12864_ _19769_/Q _12862_/Z _12870_/A2 VSS VSS VSS VSS gf180mcu_fd_sc_mcu9t5v0__xnor2_1
X_18371_ _18371_/D clkload77/I _18371_/Q VSS VSS VSS VSS gf180mcu_fd_sc_mcu9t5v0__dffq_1
X_15583_ _15583_/A1 _20042_/D _15583_/B1 _15597_/B1 _19878_/D VSS VSS VSS VSS gf180mcu_fd_sc_mcu9t5v0__oai22_1
X_12795_ _19758_/Q _12794_/Z _12800_/B VSS _12796_/VNW VSS VSS gf180mcu_fd_sc_mcu9t5v0__and2_1
X_14603_ _19182_/Q _19481_/Q _14715_/S _19481_/D VSS _14603_/VNW VSS VSS gf180mcu_fd_sc_mcu9t5v0__mux2_1
X_11815_ _12235_/B _11838_/A2 _11816_/A2 VSS VSS VSS VSS gf180mcu_fd_sc_mcu9t5v0__nor2_1
X_17322_ _18484_/Q _17322_/A2 _17380_/B1 _18500_/Q _17323_/B VSS VSS VSS VSS gf180mcu_fd_sc_mcu9t5v0__aoi22_1
XTAP_TAPCELL_ROW_267_6402 VSS VSS gf180mcu_fd_sc_mcu9t5v0__filltie
XPHY_EDGE_ROW_183_3_Right_298 VSS VSS gf180mcu_fd_sc_mcu9t5v0__endcap
X_11746_ _18895_/Q _11746_/A2 _11746_/B _11767_/B1 VSS _11746_/VNW VSS VSS gf180mcu_fd_sc_mcu9t5v0__oai21_1
X_14534_ _19167_/Q _19133_/Q _14739_/A1 VSS VSS VSS VSS gf180mcu_fd_sc_mcu9t5v0__xnor2_1
XTAP_TAPCELL_ROW_96_3617 VSS VSS gf180mcu_fd_sc_mcu9t5v0__filltie
X_17253_ _17378_/A1 _18385_/Q _17256_/A2 VSS _17256_/VNW VSS VSS gf180mcu_fd_sc_mcu9t5v0__nor2_1
XTAP_TAPCELL_ROW_267_6424 VSS VSS gf180mcu_fd_sc_mcu9t5v0__filltie
XTAP_TAPCELL_ROW_267_6413 VSS VSS gf180mcu_fd_sc_mcu9t5v0__filltie
XTAP_TAPCELL_ROW_96_3628 VSS VSS gf180mcu_fd_sc_mcu9t5v0__filltie
X_16204_ _16016_/B _19262_/Q _16763_/S _16204_/Z VSS VSS VSS VSS gf180mcu_fd_sc_mcu9t5v0__mux2_1
X_11677_ _12706_/A2 _12706_/A3 _11678_/A2 VSS _11678_/VNW VSS VSS gf180mcu_fd_sc_mcu9t5v0__nor2_1
XPHY_EDGE_ROW_54_Left_378 VSS VSS gf180mcu_fd_sc_mcu9t5v0__endcap
X_14465_ _14465_/A1 _19124_/Q _14465_/B _14474_/A2 VSS VSS VSS VSS gf180mcu_fd_sc_mcu9t5v0__oai21_1
X_17184_ _18541_/Q _17394_/A2 _17185_/B VSS VSS VSS VSS gf180mcu_fd_sc_mcu9t5v0__nand2_1
X_10628_ _19001_/Q _10654_/A2 _10628_/B wire160/Z _10630_/B1 VSS _10628_/VNW VSS VSS
+ gf180mcu_fd_sc_mcu9t5v0__oai211_1
X_13416_ _13416_/A1 _19775_/Q _13416_/B1 _13416_/B2 _13416_/C _13433_/A3 VSS VSS VSS
+ VSS gf180mcu_fd_sc_mcu9t5v0__aoi221_1
X_14396_ _14397_/A1 _19117_/Q _14408_/B VSS VSS VSS VSS gf180mcu_fd_sc_mcu9t5v0__nand2_1
X_10559_ _18229_/Q _17406_/A2 _17405_/A2 _18245_/Q _10560_/B VSS _10559_/VNW VSS VSS
+ gf180mcu_fd_sc_mcu9t5v0__aoi22_1
X_16135_ _18172_/Q _16135_/I1 _16707_/S _18172_/D VSS VSS VSS VSS gf180mcu_fd_sc_mcu9t5v0__mux2_4
X_13347_ _13347_/A1 _13345_/B _13347_/Z VSS VSS VSS VSS gf180mcu_fd_sc_mcu9t5v0__xor2_1
X_16066_ _15996_/B _16066_/A2 _16066_/A3 _16066_/B _16067_/I1 VSS VSS VSS VSS gf180mcu_fd_sc_mcu9t5v0__oai31_4
X_13278_ _13257_/Z _13278_/A2 _13585_/B _13278_/Z VSS _13278_/VNW VSS VSS gf180mcu_fd_sc_mcu9t5v0__or3_1
X_12229_ _18730_/Q wire198/Z _12307_/B VSS _12229_/VNW VSS VSS gf180mcu_fd_sc_mcu9t5v0__nand2_1
XTAP_TAPCELL_ROW_72_2960 VSS VSS gf180mcu_fd_sc_mcu9t5v0__filltie
X_15017_ _15017_/A1 _15017_/A2 _15017_/A3 _15017_/A4 _15022_/S VSS _15017_/VNW VSS
+ VSS gf180mcu_fd_sc_mcu9t5v0__nand4_1
Xclkbuf_leaf_14_clk_regs clkload3/I clkload50/I VSS _09710_/VNW VSS VSS gf180mcu_fd_sc_mcu9t5v0__clkbuf_8
XTAP_TAPCELL_ROW_72_2971 VSS VSS gf180mcu_fd_sc_mcu9t5v0__filltie
X_19825_ _19825_/D _20145_/RN clkload57/I _19825_/Q VSS VSS VSS VSS gf180mcu_fd_sc_mcu9t5v0__dffrnq_2
X_16968_ _18475_/Q _16967_/Z _16986_/S _18475_/D VSS VSS VSS VSS gf180mcu_fd_sc_mcu9t5v0__mux2_4
XPHY_EDGE_ROW_63_Left_387 VSS VSS gf180mcu_fd_sc_mcu9t5v0__endcap
X_19756_ _19756_/D _20140_/RN clkload35/I _19756_/Q VSS VSS VSS VSS gf180mcu_fd_sc_mcu9t5v0__dffrnq_1
X_15919_ _20128_/Q _19249_/Q _15920_/S _20128_/D VSS VSS VSS VSS gf180mcu_fd_sc_mcu9t5v0__mux2_1
XPHY_EDGE_ROW_206_2_Left_718 VSS VSS gf180mcu_fd_sc_mcu9t5v0__endcap
X_18707_ _18707_/D clkload64/I _18707_/Q VSS VSS VSS VSS gf180mcu_fd_sc_mcu9t5v0__dffq_1
X_16899_ _16576_/B _19245_/Q _16925_/S _16899_/Z VSS VSS VSS VSS gf180mcu_fd_sc_mcu9t5v0__mux2_1
X_09440_ _15827_/B _19993_/Q _09926_/A1 VSS VSS VSS VSS gf180mcu_fd_sc_mcu9t5v0__nand2_1
X_19687_ _19687_/D _20071_/RN clkload12/I _19687_/Q VSS VSS VSS VSS gf180mcu_fd_sc_mcu9t5v0__dffrnq_1
X_18638_ _18638_/D _20042_/RN clkload52/I _18638_/Q VSS VSS VSS VSS gf180mcu_fd_sc_mcu9t5v0__dffrnq_1
XPHY_EDGE_ROW_194_1_Right_778 VSS VSS gf180mcu_fd_sc_mcu9t5v0__endcap
XTAP_TAPCELL_ROW_66_2786 VSS VSS gf180mcu_fd_sc_mcu9t5v0__filltie
XTAP_TAPCELL_ROW_237_5593 VSS VSS gf180mcu_fd_sc_mcu9t5v0__filltie
XTAP_TAPCELL_ROW_237_5582 VSS VSS gf180mcu_fd_sc_mcu9t5v0__filltie
X_09371_ _18473_/Q _12018_/I1 VSS _17514_/VNW VSS VSS gf180mcu_fd_sc_mcu9t5v0__clkinv_1
XTAP_TAPCELL_ROW_66_2797 VSS VSS gf180mcu_fd_sc_mcu9t5v0__filltie
X_18569_ _18569_/D _20069_/RN clkload11/I _18569_/Q VSS VSS VSS VSS gf180mcu_fd_sc_mcu9t5v0__dffrnq_1
XTAP_TAPCELL_ROW_233_5479 VSS VSS gf180mcu_fd_sc_mcu9t5v0__filltie
XTAP_TAPCELL_ROW_233_5468 VSS VSS gf180mcu_fd_sc_mcu9t5v0__filltie
XPHY_EDGE_ROW_72_Left_396 VSS VSS gf180mcu_fd_sc_mcu9t5v0__endcap
XTAP_TAPCELL_ROW_246_5829 VSS VSS gf180mcu_fd_sc_mcu9t5v0__filltie
XPHY_EDGE_ROW_145_3_Right_260 VSS VSS gf180mcu_fd_sc_mcu9t5v0__endcap
XTAP_TAPCELL_ROW_15_1406 VSS VSS gf180mcu_fd_sc_mcu9t5v0__filltie
X_09707_ wire300/Z _09735_/B _15723_/A2 VSS _09736_/VNW VSS VSS gf180mcu_fd_sc_mcu9t5v0__nor2_1
XPHY_EDGE_ROW_190_2_Left_702 VSS VSS gf180mcu_fd_sc_mcu9t5v0__endcap
X_09638_ _19996_/Q _09675_/B _15691_/C VSS _09638_/VNW VSS VSS gf180mcu_fd_sc_mcu9t5v0__nand2_1
X_09569_ _18938_/Q _18832_/Q _09569_/A3 _10715_/C VSS VSS VSS VSS gf180mcu_fd_sc_mcu9t5v0__nand3_1
X_12580_ _12620_/A1 _12620_/A2 _12580_/A3 _12580_/B _19168_/D VSS _12580_/VNW VSS
+ VSS gf180mcu_fd_sc_mcu9t5v0__oai31_1
X_11600_ _17900_/B2 _11581_/Z _18838_/Q _11600_/C _11620_/A2 VSS _11604_/VNW VSS VSS
+ gf180mcu_fd_sc_mcu9t5v0__oai211_1
X_11531_ _18392_/Q _11534_/S _11532_/C VSS VSS VSS VSS gf180mcu_fd_sc_mcu9t5v0__nand2_1
XTAP_TAPCELL_ROW_216_4998 VSS VSS gf180mcu_fd_sc_mcu9t5v0__filltie
XTAP_TAPCELL_ROW_134_4676 VSS VSS gf180mcu_fd_sc_mcu9t5v0__filltie
XTAP_TAPCELL_ROW_134_4665 VSS VSS gf180mcu_fd_sc_mcu9t5v0__filltie
XTAP_TAPCELL_ROW_134_4654 VSS VSS gf180mcu_fd_sc_mcu9t5v0__filltie
X_11462_ _18884_/Q _12028_/C _11488_/B _11462_/B2 _11540_/C _11464_/A1 VSS VSS VSS
+ VSS gf180mcu_fd_sc_mcu9t5v0__oai221_1
X_14250_ _14251_/A1 _14251_/A2 _14261_/B VSS _14263_/VNW VSS VSS gf180mcu_fd_sc_mcu9t5v0__nor2_1
X_10413_ _17409_/B _10413_/A2 _10413_/A3 _10414_/C VSS VSS VSS VSS gf180mcu_fd_sc_mcu9t5v0__nand3_1
XPHY_EDGE_ROW_156_1_Right_740 VSS VSS gf180mcu_fd_sc_mcu9t5v0__endcap
XTAP_TAPCELL_ROW_76_3082 VSS VSS gf180mcu_fd_sc_mcu9t5v0__filltie
X_13201_ _19764_/Q _13204_/A2 _13218_/B VSS VSS VSS VSS gf180mcu_fd_sc_mcu9t5v0__nand2_1
XTAP_TAPCELL_ROW_76_3071 VSS VSS gf180mcu_fd_sc_mcu9t5v0__filltie
X_11393_ _18879_/Q _12689_/C _11395_/A2 VSS VSS VSS VSS gf180mcu_fd_sc_mcu9t5v0__nor2_1
X_14181_ _14366_/I0 _19336_/Q _14266_/S _19336_/D VSS VSS VSS VSS gf180mcu_fd_sc_mcu9t5v0__mux2_1
XTAP_TAPCELL_ROW_76_3060 VSS VSS gf180mcu_fd_sc_mcu9t5v0__filltie
X_10344_ _18221_/Q _17380_/A2 _17380_/B1 _18237_/Q _10345_/B VSS VSS VSS VSS gf180mcu_fd_sc_mcu9t5v0__aoi22_1
X_13132_ _13132_/A1 _13132_/A2 _13132_/A3 _13151_/A3 VSS VSS VSS VSS gf180mcu_fd_sc_mcu9t5v0__nor3_1
X_10275_ _20079_/Q _17408_/B _10276_/A3 VSS VSS VSS VSS gf180mcu_fd_sc_mcu9t5v0__nand2_1
XPHY_EDGE_ROW_185_2_Left_697 VSS VSS gf180mcu_fd_sc_mcu9t5v0__endcap
X_17940_ _18851_/Q _11013_/B _17943_/B VSS VSS VSS VSS gf180mcu_fd_sc_mcu9t5v0__nand2_1
X_13063_ _19724_/Q _13063_/A2 _13085_/A1 VSS _13063_/VNW VSS VSS gf180mcu_fd_sc_mcu9t5v0__nor2_1
XTAP_TAPCELL_ROW_89_3421 VSS VSS gf180mcu_fd_sc_mcu9t5v0__filltie
X_12014_ _18345_/Q _12181_/A2 _12015_/A3 VSS VSS VSS VSS gf180mcu_fd_sc_mcu9t5v0__nor2_1
XTAP_TAPCELL_ROW_89_3443 VSS VSS gf180mcu_fd_sc_mcu9t5v0__filltie
X_17871_ _18830_/Q _17879_/A2 _17878_/A2 VSS VSS VSS VSS gf180mcu_fd_sc_mcu9t5v0__nand2_1
XTAP_TAPCELL_ROW_89_3432 VSS VSS gf180mcu_fd_sc_mcu9t5v0__filltie
XTAP_TAPCELL_ROW_256_6114 VSS VSS gf180mcu_fd_sc_mcu9t5v0__filltie
X_16822_ _16809_/S _16660_/B _16957_/B VSS _16822_/VNW VSS VSS gf180mcu_fd_sc_mcu9t5v0__nand2_1
XTAP_TAPCELL_ROW_256_6103 VSS VSS gf180mcu_fd_sc_mcu9t5v0__filltie
XTAP_TAPCELL_ROW_85_3329 VSS VSS gf180mcu_fd_sc_mcu9t5v0__filltie
XTAP_TAPCELL_ROW_85_3318 VSS VSS gf180mcu_fd_sc_mcu9t5v0__filltie
X_19610_ _19610_/D _20058_/RN _19633_/CLK _19610_/Q VSS VSS VSS VSS gf180mcu_fd_sc_mcu9t5v0__dffrnq_1
XTAP_TAPCELL_ROW_85_3307 VSS VSS gf180mcu_fd_sc_mcu9t5v0__filltie
X_19541_ _19541_/D _20053_/RN clkload16/I _19541_/Q VSS VSS VSS VSS gf180mcu_fd_sc_mcu9t5v0__dffrnq_1
X_16753_ _18376_/Q _16753_/I1 _16753_/S _18376_/D VSS VSS VSS VSS gf180mcu_fd_sc_mcu9t5v0__mux2_4
X_13965_ _19318_/Q _19299_/Q _13964_/Z _13995_/B VSS _13965_/VNW VSS VSS gf180mcu_fd_sc_mcu9t5v0__nand3_1
X_16684_ _16747_/A3 _16684_/A2 _16684_/B1 _16741_/B2 _16684_/C _16685_/I1 VSS _16684_/VNW
+ VSS VSS gf180mcu_fd_sc_mcu9t5v0__aoi221_1
X_15704_ _19918_/Q _15699_/Z _15704_/Z VSS _15704_/VNW VSS VSS gf180mcu_fd_sc_mcu9t5v0__or2_1
X_12916_ _19776_/Q _12914_/Z _12917_/I VSS VSS VSS VSS gf180mcu_fd_sc_mcu9t5v0__xnor2_1
X_13896_ _13896_/A1 _13896_/A2 _13895_/Z _13910_/B VSS _13950_/VNW VSS VSS gf180mcu_fd_sc_mcu9t5v0__and3_1
XTAP_TAPCELL_ROW_1_1004 VSS VSS gf180mcu_fd_sc_mcu9t5v0__filltie
XTAP_TAPCELL_ROW_1_1015 VSS VSS gf180mcu_fd_sc_mcu9t5v0__filltie
X_19472_ _19472_/D _20048_/RN clkload31/I _19472_/Q VSS VSS VSS VSS gf180mcu_fd_sc_mcu9t5v0__dffrnq_1
X_18423_ _18423_/D clkload79/I _18423_/Q VSS VSS VSS VSS gf180mcu_fd_sc_mcu9t5v0__dffq_1
X_15635_ _15672_/B _15634_/Z _15657_/B _19896_/D VSS VSS VSS VSS gf180mcu_fd_sc_mcu9t5v0__oai21_1
X_12847_ _12847_/I0 _19212_/Q _13304_/B _19212_/D VSS _12847_/VNW VSS VSS gf180mcu_fd_sc_mcu9t5v0__mux2_1
X_18354_ _18354_/D _20132_/CLK _18354_/Q VSS VSS VSS VSS gf180mcu_fd_sc_mcu9t5v0__dffq_1
X_17305_ _20133_/Q _17407_/C _17408_/B _17306_/B2 VSS _17305_/VNW VSS VSS gf180mcu_fd_sc_mcu9t5v0__aoi21_1
X_15566_ _15566_/A1 _15564_/Z _15566_/A3 _19875_/D VSS _15566_/VNW VSS VSS gf180mcu_fd_sc_mcu9t5v0__nor3_1
XPHY_EDGE_ROW_184_3_Right_299 VSS VSS gf180mcu_fd_sc_mcu9t5v0__endcap
X_12778_ _19724_/Q _19789_/Q _12948_/S _12778_/Z VSS VSS VSS VSS gf180mcu_fd_sc_mcu9t5v0__mux2_1
XTAP_TAPCELL_ROW_61_2650 VSS VSS gf180mcu_fd_sc_mcu9t5v0__filltie
XTAP_TAPCELL_ROW_61_2661 VSS VSS gf180mcu_fd_sc_mcu9t5v0__filltie
XTAP_TAPCELL_ROW_61_2672 VSS VSS gf180mcu_fd_sc_mcu9t5v0__filltie
X_18285_ _18285_/D clkload73/I _18285_/Q VSS VSS VSS VSS gf180mcu_fd_sc_mcu9t5v0__dffq_1
X_15497_ _17422_/S _15496_/Z _19835_/D VSS _15497_/VNW VSS VSS gf180mcu_fd_sc_mcu9t5v0__and2_1
X_11729_ _18172_/Q _18156_/Q _12046_/S _11729_/Z VSS VSS VSS VSS gf180mcu_fd_sc_mcu9t5v0__mux2_1
X_14517_ _14517_/A1 _14735_/A1 _14517_/Z VSS _14732_/VNW VSS VSS gf180mcu_fd_sc_mcu9t5v0__and2_1
X_17236_ _17378_/A1 _18512_/Q _17239_/A2 VSS _17236_/VNW VSS VSS gf180mcu_fd_sc_mcu9t5v0__nor2_1
X_14448_ _19155_/Q _14448_/A2 _14448_/B _14452_/A1 VSS VSS VSS VSS gf180mcu_fd_sc_mcu9t5v0__oai21_1
X_17167_ _17260_/S _18397_/Q _17169_/A3 VSS _17167_/VNW VSS VSS gf180mcu_fd_sc_mcu9t5v0__nor2_1
X_16118_ _19260_/Q _16730_/C _16119_/C VSS VSS VSS VSS gf180mcu_fd_sc_mcu9t5v0__nand2_1
X_14379_ _19444_/Q _14715_/S _14380_/A2 VSS _14379_/VNW VSS VSS gf180mcu_fd_sc_mcu9t5v0__nand2_1
XTAP_TAPCELL_ROW_241_5704 VSS VSS gf180mcu_fd_sc_mcu9t5v0__filltie
X_17098_ _20030_/Q _17420_/S _17098_/A3 _17098_/B _18537_/D VSS _17098_/VNW VSS VSS
+ gf180mcu_fd_sc_mcu9t5v0__oai31_1
XTAP_TAPCELL_ROW_70_2919 VSS VSS gf180mcu_fd_sc_mcu9t5v0__filltie
XTAP_TAPCELL_ROW_70_2908 VSS VSS gf180mcu_fd_sc_mcu9t5v0__filltie
XTAP_TAPCELL_ROW_226_5283 VSS VSS gf180mcu_fd_sc_mcu9t5v0__filltie
X_16049_ _18680_/Q _18777_/Q _16619_/S _16049_/Z VSS VSS VSS VSS gf180mcu_fd_sc_mcu9t5v0__mux2_4
XTAP_TAPCELL_ROW_226_5272 VSS VSS gf180mcu_fd_sc_mcu9t5v0__filltie
XTAP_TAPCELL_ROW_55_2487 VSS VSS gf180mcu_fd_sc_mcu9t5v0__filltie
XTAP_TAPCELL_ROW_55_2498 VSS VSS gf180mcu_fd_sc_mcu9t5v0__filltie
XTAP_TAPCELL_ROW_226_5294 VSS VSS gf180mcu_fd_sc_mcu9t5v0__filltie
XTAP_TAPCELL_ROW_222_5169 VSS VSS gf180mcu_fd_sc_mcu9t5v0__filltie
X_19808_ _19808_/D _20064_/RN clkload36/I _19808_/Q VSS VSS VSS VSS gf180mcu_fd_sc_mcu9t5v0__dffrnq_1
XTAP_TAPCELL_ROW_239_5655 VSS VSS gf180mcu_fd_sc_mcu9t5v0__filltie
XTAP_TAPCELL_ROW_239_5644 VSS VSS gf180mcu_fd_sc_mcu9t5v0__filltie
XTAP_TAPCELL_ROW_239_5633 VSS VSS gf180mcu_fd_sc_mcu9t5v0__filltie
XTAP_TAPCELL_ROW_68_2859 VSS VSS gf180mcu_fd_sc_mcu9t5v0__filltie
X_19739_ _19739_/D _20059_/RN clkload23/I _19739_/Q VSS VSS VSS VSS gf180mcu_fd_sc_mcu9t5v0__dffrnq_1
XTAP_TAPCELL_ROW_68_2848 VSS VSS gf180mcu_fd_sc_mcu9t5v0__filltie
X_09423_ _11558_/C _18564_/Q _18565_/Q _17438_/A1 VSS VSS VSS VSS gf180mcu_fd_sc_mcu9t5v0__nand3_4
X_09354_ _19892_/Q _15626_/A1 VSS VSS VSS VSS gf180mcu_fd_sc_mcu9t5v0__clkinv_1
XPHY_EDGE_ROW_195_1_Right_779 VSS VSS gf180mcu_fd_sc_mcu9t5v0__endcap
XPHY_EDGE_ROW_80_Left_404 VSS VSS gf180mcu_fd_sc_mcu9t5v0__endcap
XTAP_TAPCELL_ROW_310_7590 VSS VSS gf180mcu_fd_sc_mcu9t5v0__filltie
X_09285_ _18778_/Q _16563_/I1 VSS _16041_/VNW VSS VSS gf180mcu_fd_sc_mcu9t5v0__clkinv_1
XTAP_TAPCELL_ROW_211_4873 VSS VSS gf180mcu_fd_sc_mcu9t5v0__filltie
XTAP_TAPCELL_ROW_211_4862 VSS VSS gf180mcu_fd_sc_mcu9t5v0__filltie
XTAP_TAPCELL_ROW_323_7973 VSS VSS gf180mcu_fd_sc_mcu9t5v0__filltie
XTAP_TAPCELL_ROW_323_7962 VSS VSS gf180mcu_fd_sc_mcu9t5v0__filltie
XTAP_TAPCELL_ROW_323_7951 VSS VSS gf180mcu_fd_sc_mcu9t5v0__filltie
XTAP_TAPCELL_ROW_323_7940 VSS VSS gf180mcu_fd_sc_mcu9t5v0__filltie
XTAP_TAPCELL_ROW_211_4884 VSS VSS gf180mcu_fd_sc_mcu9t5v0__filltie
XTAP_TAPCELL_ROW_323_7995 VSS VSS gf180mcu_fd_sc_mcu9t5v0__filltie
XTAP_TAPCELL_ROW_323_7984 VSS VSS gf180mcu_fd_sc_mcu9t5v0__filltie
XPHY_EDGE_ROW_146_3_Right_261 VSS VSS gf180mcu_fd_sc_mcu9t5v0__endcap
X_10060_ _09916_/B _18966_/Q _09898_/C _10067_/A1 VSS _10073_/VNW VSS VSS gf180mcu_fd_sc_mcu9t5v0__nand3_1
XPHY_EDGE_ROW_214_Left_537 VSS VSS gf180mcu_fd_sc_mcu9t5v0__endcap
XTAP_TAPCELL_ROW_209_4791 VSS VSS gf180mcu_fd_sc_mcu9t5v0__filltie
XTAP_TAPCELL_ROW_209_4780 VSS VSS gf180mcu_fd_sc_mcu9t5v0__filltie
XTAP_TAPCELL_ROW_196_1_4768 VSS VSS gf180mcu_fd_sc_mcu9t5v0__filltie
XTAP_TAPCELL_ROW_127_4480 VSS VSS gf180mcu_fd_sc_mcu9t5v0__filltie
XTAP_TAPCELL_ROW_123_4355 VSS VSS gf180mcu_fd_sc_mcu9t5v0__filltie
XTAP_TAPCELL_ROW_317_7799 VSS VSS gf180mcu_fd_sc_mcu9t5v0__filltie
XTAP_TAPCELL_ROW_317_7788 VSS VSS gf180mcu_fd_sc_mcu9t5v0__filltie
XTAP_TAPCELL_ROW_317_7777 VSS VSS gf180mcu_fd_sc_mcu9t5v0__filltie
XTAP_TAPCELL_ROW_123_4377 VSS VSS gf180mcu_fd_sc_mcu9t5v0__filltie
XTAP_TAPCELL_ROW_123_4366 VSS VSS gf180mcu_fd_sc_mcu9t5v0__filltie
X_10962_ _18923_/Q _18932_/Q _10962_/B _18044_/B _10969_/A2 VSS _10962_/VNW VSS VSS
+ gf180mcu_fd_sc_mcu9t5v0__oai211_1
X_13750_ _13751_/A1 _13749_/Z _14400_/C VSS _14677_/VNW VSS VSS gf180mcu_fd_sc_mcu9t5v0__nor2_1
XPHY_EDGE_ROW_119_Left_443 VSS VSS gf180mcu_fd_sc_mcu9t5v0__endcap
X_12701_ _19186_/Q _12724_/C _12704_/B VSS VSS VSS VSS gf180mcu_fd_sc_mcu9t5v0__nand2_1
X_10893_ _10893_/I0 _18985_/Q _18148_/S _18985_/D VSS VSS VSS VSS gf180mcu_fd_sc_mcu9t5v0__mux2_1
X_13681_ _13681_/A1 _13681_/A2 _13681_/Z VSS VSS VSS VSS gf180mcu_fd_sc_mcu9t5v0__and2_1
X_15420_ _19705_/Q _19805_/Q _15420_/S _19805_/D VSS VSS VSS VSS gf180mcu_fd_sc_mcu9t5v0__mux2_1
XPHY_EDGE_ROW_223_Left_546 VSS VSS gf180mcu_fd_sc_mcu9t5v0__endcap
X_12632_ _12632_/A1 _12649_/A3 _12632_/B _12632_/C _12633_/B VSS VSS VSS VSS gf180mcu_fd_sc_mcu9t5v0__aoi211_1
XTAP_TAPCELL_ROW_78_3133 VSS VSS gf180mcu_fd_sc_mcu9t5v0__filltie
X_12563_ _19166_/Q _12620_/A1 _12564_/B VSS _17959_/VNW VSS VSS gf180mcu_fd_sc_mcu9t5v0__nand2_1
XTAP_TAPCELL_ROW_78_3122 VSS VSS gf180mcu_fd_sc_mcu9t5v0__filltie
X_15351_ _19647_/Q _19624_/Q _15357_/B VSS VSS VSS VSS gf180mcu_fd_sc_mcu9t5v0__and2_1
Xwire121 wire121/I wire121/Z VSS VSS VSS VSS gf180mcu_fd_sc_mcu9t5v0__clkbuf_4
X_11514_ _11514_/A1 _11514_/A2 _11788_/B _11515_/B2 VSS VSS VSS VSS gf180mcu_fd_sc_mcu9t5v0__aoi21_2
X_12494_ _12541_/B _12494_/A2 _12494_/A3 _12494_/B _12495_/B2 VSS VSS VSS VSS gf180mcu_fd_sc_mcu9t5v0__oai31_1
X_18070_ _18928_/Q _18070_/A2 _18045_/Z _18070_/Z VSS VSS VSS VSS gf180mcu_fd_sc_mcu9t5v0__xor3_1
X_15282_ _15283_/A1 _15283_/A2 _15283_/C _15284_/A2 VSS _15282_/VNW VSS VSS gf180mcu_fd_sc_mcu9t5v0__aoi21_1
X_14302_ _14320_/I0 _19375_/Q _14304_/S _19375_/D VSS _15273_/VNW VSS VSS gf180mcu_fd_sc_mcu9t5v0__mux2_1
XTAP_TAPCELL_ROW_74_3008 VSS VSS gf180mcu_fd_sc_mcu9t5v0__filltie
X_11445_ _18385_/Q _11519_/A2 _11520_/B _11445_/C _11447_/B1 VSS _16628_/VNW VSS VSS
+ gf180mcu_fd_sc_mcu9t5v0__oai211_1
X_17021_ _19257_/Q _16660_/B _17025_/S _17021_/Z VSS VSS VSS VSS gf180mcu_fd_sc_mcu9t5v0__mux2_1
Xwire165 wire165/I wire165/Z VSS VSS VSS VSS gf180mcu_fd_sc_mcu9t5v0__buf_4
XTAP_TAPCELL_ROW_74_3019 VSS VSS gf180mcu_fd_sc_mcu9t5v0__filltie
X_14233_ _14241_/A1 _14241_/A2 _14235_/A2 VSS _14262_/VNW VSS VSS gf180mcu_fd_sc_mcu9t5v0__xnor2_1
Xwire198 wire198/I wire198/Z VSS VSS VSS VSS gf180mcu_fd_sc_mcu9t5v0__buf_8
XPHY_EDGE_ROW_157_1_Right_741 VSS VSS gf180mcu_fd_sc_mcu9t5v0__endcap
XPHY_EDGE_ROW_128_Left_452 VSS VSS gf180mcu_fd_sc_mcu9t5v0__endcap
XTAP_TAPCELL_ROW_281_6796 VSS VSS gf180mcu_fd_sc_mcu9t5v0__filltie
X_11376_ _18396_/Q _11403_/S _11377_/C VSS VSS VSS VSS gf180mcu_fd_sc_mcu9t5v0__or2_1
XTAP_TAPCELL_ROW_281_6785 VSS VSS gf180mcu_fd_sc_mcu9t5v0__filltie
X_14164_ _19182_/Q _14546_/S _14167_/B1 VSS VSS VSS VSS gf180mcu_fd_sc_mcu9t5v0__nand2_1
X_10327_ _10327_/A1 _10327_/A2 _17177_/B _10330_/A1 VSS VSS VSS VSS gf180mcu_fd_sc_mcu9t5v0__aoi21_1
X_18972_ _18972_/D _20060_/RN _20099_/CLK _18972_/Q VSS VSS VSS VSS gf180mcu_fd_sc_mcu9t5v0__dffrnq_1
XPHY_EDGE_ROW_232_Left_555 VSS VSS gf180mcu_fd_sc_mcu9t5v0__endcap
X_13115_ _13115_/I _13151_/A1 VSS _13115_/VNW VSS VSS gf180mcu_fd_sc_mcu9t5v0__clkinv_1
X_14095_ _14096_/A1 _14096_/A2 _14103_/B VSS VSS VSS VSS gf180mcu_fd_sc_mcu9t5v0__and2_1
Xload_slew137 wire136/I _11176_/C VSS VSS VSS VSS gf180mcu_fd_sc_mcu9t5v0__clkbuf_8
X_10258_ _10258_/A1 _10654_/A2 _10258_/A3 _10259_/B VSS VSS VSS VSS gf180mcu_fd_sc_mcu9t5v0__nand3_1
X_13046_ _19723_/Q _13046_/A2 _13065_/B VSS VSS VSS VSS gf180mcu_fd_sc_mcu9t5v0__nor2_1
X_17923_ _17923_/I _17924_/I0 VSS _17930_/VNW VSS VSS gf180mcu_fd_sc_mcu9t5v0__clkinv_1
Xload_slew148 _11429_/B _11521_/B VSS VSS VSS VSS gf180mcu_fd_sc_mcu9t5v0__clkbuf_8
Xload_slew159 _18145_/S _18147_/S VSS VSS VSS VSS gf180mcu_fd_sc_mcu9t5v0__buf_8
XTAP_TAPCELL_ROW_50_2351 VSS VSS gf180mcu_fd_sc_mcu9t5v0__filltie
Xeco14_skew_6 clkload72/I _18496_/CLK VSS VSS VSS VSS gf180mcu_fd_sc_mcu9t5v0__clkbuf_16
X_17854_ _17868_/A2 _17854_/A2 _17853_/Z _17864_/A1 _17854_/B2 _18825_/D VSS VSS VSS
+ VSS gf180mcu_fd_sc_mcu9t5v0__oai32_1
X_10189_ _09458_/Z _14267_/A2 _10189_/S _20038_/D VSS VSS VSS VSS gf180mcu_fd_sc_mcu9t5v0__mux2_1
XTAP_TAPCELL_ROW_50_2362 VSS VSS gf180mcu_fd_sc_mcu9t5v0__filltie
X_16805_ _19283_/Q _16622_/B _16949_/S _16805_/Z VSS VSS VSS VSS gf180mcu_fd_sc_mcu9t5v0__mux2_1
X_17785_ _17779_/C _17785_/A2 _17784_/Z _18766_/D VSS VSS VSS VSS gf180mcu_fd_sc_mcu9t5v0__nor3_1
X_14997_ _15163_/S _14997_/A2 _14997_/B _19621_/D VSS _15003_/VNW VSS VSS gf180mcu_fd_sc_mcu9t5v0__aoi21_1
X_16736_ _16725_/C _16736_/A2 _16736_/A3 _16736_/B _16738_/A2 VSS VSS VSS VSS gf180mcu_fd_sc_mcu9t5v0__oai31_1
XTAP_TAPCELL_ROW_106_3896 VSS VSS gf180mcu_fd_sc_mcu9t5v0__filltie
X_13948_ _13948_/A1 _13948_/A2 _13948_/Z VSS VSS VSS VSS gf180mcu_fd_sc_mcu9t5v0__xor2_2
X_19524_ _19524_/D _20036_/RN clkload16/I _19524_/Q VSS VSS VSS VSS gf180mcu_fd_sc_mcu9t5v0__dffrnq_1
XTAP_TAPCELL_ROW_106_3885 VSS VSS gf180mcu_fd_sc_mcu9t5v0__filltie
Xload_slew84 _16787_/S _16809_/S VSS _12404_/VNW VSS VSS gf180mcu_fd_sc_mcu9t5v0__clkbuf_8
XPHY_EDGE_ROW_241_Left_564 VSS VSS gf180mcu_fd_sc_mcu9t5v0__endcap
Xload_slew62 _17742_/S _17681_/S VSS VSS VSS VSS gf180mcu_fd_sc_mcu9t5v0__clkbuf_8
X_19455_ _19455_/D _20031_/RN _19798_/CLK _19455_/Q VSS VSS VSS VSS gf180mcu_fd_sc_mcu9t5v0__dffrnq_1
XTAP_TAPCELL_ROW_63_2712 VSS VSS gf180mcu_fd_sc_mcu9t5v0__filltie
XTAP_TAPCELL_ROW_63_2723 VSS VSS gf180mcu_fd_sc_mcu9t5v0__filltie
X_16667_ _19258_/Q _16744_/A2 wire71/Z _16669_/A2 VSS _16668_/VNW VSS VSS gf180mcu_fd_sc_mcu9t5v0__nor3_1
X_18406_ _18406_/D clkload68/I _18406_/Q VSS VSS VSS VSS gf180mcu_fd_sc_mcu9t5v0__dffq_1
X_13879_ _13879_/A1 _13879_/A2 _13879_/Z VSS _13952_/VNW VSS VSS gf180mcu_fd_sc_mcu9t5v0__xor2_1
XTAP_TAPCELL_ROW_48_2291 VSS VSS gf180mcu_fd_sc_mcu9t5v0__filltie
XTAP_TAPCELL_ROW_230_5405 VSS VSS gf180mcu_fd_sc_mcu9t5v0__filltie
X_16598_ _19216_/Q _16597_/Z _16598_/S _16599_/B VSS _17428_/VNW VSS VSS gf180mcu_fd_sc_mcu9t5v0__mux2_1
X_15618_ _15618_/A1 _15620_/B _15618_/A3 _15620_/A2 _15625_/A3 VSS VSS VSS VSS gf180mcu_fd_sc_mcu9t5v0__nor4_1
X_19386_ _19386_/D _20026_/RN clkload21/I _19386_/Q VSS VSS VSS VSS gf180mcu_fd_sc_mcu9t5v0__dffrnq_1
X_15549_ _19867_/Q _19874_/Q _15551_/S _19867_/D VSS VSS VSS VSS gf180mcu_fd_sc_mcu9t5v0__mux2_1
X_18337_ _18337_/D clkload68/I _18337_/Q VSS VSS VSS VSS gf180mcu_fd_sc_mcu9t5v0__dffq_1
XTAP_TAPCELL_ROW_44_2188 VSS VSS gf180mcu_fd_sc_mcu9t5v0__filltie
XTAP_TAPCELL_ROW_44_2199 VSS VSS gf180mcu_fd_sc_mcu9t5v0__filltie
X_18268_ _18268_/D clkload64/I _18268_/Q VSS VSS VSS VSS gf180mcu_fd_sc_mcu9t5v0__dffq_1
X_09070_ _18562_/Q _17423_/A1 VSS VSS VSS VSS gf180mcu_fd_sc_mcu9t5v0__clkinv_1
XTAP_TAPCELL_ROW_138_1_4739 VSS VSS gf180mcu_fd_sc_mcu9t5v0__filltie
X_17219_ _18367_/Q _17282_/B1 _17216_/Z _10514_/B _17219_/C _17220_/C VSS VSS VSS
+ VSS gf180mcu_fd_sc_mcu9t5v0__aoi221_1
X_18199_ _18199_/D clkload68/I _18199_/Q VSS VSS VSS VSS gf180mcu_fd_sc_mcu9t5v0__dffq_1
XTAP_TAPCELL_ROW_228_5334 VSS VSS gf180mcu_fd_sc_mcu9t5v0__filltie
XTAP_TAPCELL_ROW_57_2538 VSS VSS gf180mcu_fd_sc_mcu9t5v0__filltie
XTAP_TAPCELL_ROW_57_2549 VSS VSS gf180mcu_fd_sc_mcu9t5v0__filltie
XTAP_TAPCELL_ROW_228_5345 VSS VSS gf180mcu_fd_sc_mcu9t5v0__filltie
XPHY_EDGE_ROW_250_Left_573 VSS VSS gf180mcu_fd_sc_mcu9t5v0__endcap
XPHY_EDGE_ROW_159_2_Right_890 VSS VSS gf180mcu_fd_sc_mcu9t5v0__endcap
XPHY_EDGE_ROW_123_Right_123 VSS VSS gf180mcu_fd_sc_mcu9t5v0__endcap
X_09972_ _20000_/Q _19958_/Q _19966_/Q _20004_/Q _19982_/Q _19998_/Q _09974_/B VSS
+ VSS VSS VSS gf180mcu_fd_sc_mcu9t5v0__aoi222_1
X_20092_ _20092_/D clkload76/I _20092_/Q VSS VSS VSS VSS gf180mcu_fd_sc_mcu9t5v0__dffq_1
XPHY_EDGE_ROW_196_1_Left_519 VSS VSS gf180mcu_fd_sc_mcu9t5v0__endcap
XTAP_TAPCELL_ROW_291_7070 VSS VSS gf180mcu_fd_sc_mcu9t5v0__filltie
XTAP_TAPCELL_ROW_33_1881 VSS VSS gf180mcu_fd_sc_mcu9t5v0__filltie
XTAP_TAPCELL_ROW_33_1892 VSS VSS gf180mcu_fd_sc_mcu9t5v0__filltie
XTAP_TAPCELL_ROW_291_7081 VSS VSS gf180mcu_fd_sc_mcu9t5v0__filltie
XTAP_TAPCELL_ROW_312_7652 VSS VSS gf180mcu_fd_sc_mcu9t5v0__filltie
XTAP_TAPCELL_ROW_312_7641 VSS VSS gf180mcu_fd_sc_mcu9t5v0__filltie
XTAP_TAPCELL_ROW_312_7663 VSS VSS gf180mcu_fd_sc_mcu9t5v0__filltie
XTAP_TAPCELL_ROW_1_999 VSS VSS gf180mcu_fd_sc_mcu9t5v0__filltie
X_09406_ _15802_/S _20004_/D VSS VSS VSS VSS gf180mcu_fd_sc_mcu9t5v0__clkinv_1
XTAP_TAPCELL_ROW_213_4924 VSS VSS gf180mcu_fd_sc_mcu9t5v0__filltie
X_09337_ _19884_/Q _15597_/A1 VSS _15588_/VNW VSS VSS gf180mcu_fd_sc_mcu9t5v0__clkinv_1
XTAP_TAPCELL_ROW_213_4935 VSS VSS gf180mcu_fd_sc_mcu9t5v0__filltie
X_09268_ _19999_/Q _15686_/A1 VSS _09268_/VNW VSS VSS gf180mcu_fd_sc_mcu9t5v0__clkinv_1
XTAP_TAPCELL_ROW_116_4170 VSS VSS gf180mcu_fd_sc_mcu9t5v0__filltie
XTAP_TAPCELL_ROW_116_4181 VSS VSS gf180mcu_fd_sc_mcu9t5v0__filltie
XTAP_TAPCELL_ROW_306_7478 VSS VSS gf180mcu_fd_sc_mcu9t5v0__filltie
XTAP_TAPCELL_ROW_112_4067 VSS VSS gf180mcu_fd_sc_mcu9t5v0__filltie
XTAP_TAPCELL_ROW_112_4056 VSS VSS gf180mcu_fd_sc_mcu9t5v0__filltie
X_09199_ _19171_/Q _14580_/A1 VSS _14568_/VNW VSS VSS gf180mcu_fd_sc_mcu9t5v0__clkinv_1
XTAP_TAPCELL_ROW_306_7489 VSS VSS gf180mcu_fd_sc_mcu9t5v0__filltie
X_11230_ _18210_/Q _11509_/A2 _11231_/A3 VSS VSS VSS VSS gf180mcu_fd_sc_mcu9t5v0__nand2_1
XTAP_TAPCELL_ROW_298_7268 VSS VSS gf180mcu_fd_sc_mcu9t5v0__filltie
X_11161_ _18205_/Q _18189_/Q _11524_/S _11161_/Z VSS VSS VSS VSS gf180mcu_fd_sc_mcu9t5v0__mux2_1
XTAP_TAPCELL_ROW_298_7257 VSS VSS gf180mcu_fd_sc_mcu9t5v0__filltie
XTAP_TAPCELL_ROW_129_4542 VSS VSS gf180mcu_fd_sc_mcu9t5v0__filltie
XTAP_TAPCELL_ROW_129_4531 VSS VSS gf180mcu_fd_sc_mcu9t5v0__filltie
XTAP_TAPCELL_ROW_129_4520 VSS VSS gf180mcu_fd_sc_mcu9t5v0__filltie
XTAP_TAPCELL_ROW_298_7279 VSS VSS gf180mcu_fd_sc_mcu9t5v0__filltie
XTAP_TAPCELL_ROW_142_3_8020 VSS VSS gf180mcu_fd_sc_mcu9t5v0__filltie
XTAP_TAPCELL_ROW_125_4417 VSS VSS gf180mcu_fd_sc_mcu9t5v0__filltie
X_10112_ _20000_/Q _19962_/Q _19970_/Q _20004_/Q _19986_/Q _19998_/Q _10113_/B2 VSS
+ VSS VSS VSS gf180mcu_fd_sc_mcu9t5v0__aoi222_1
XTAP_TAPCELL_ROW_319_7839 VSS VSS gf180mcu_fd_sc_mcu9t5v0__filltie
X_11092_ _11558_/C _18169_/Q _11092_/B _11359_/B _11105_/B VSS _16582_/VNW VSS VSS
+ gf180mcu_fd_sc_mcu9t5v0__oai211_1
XPHY_EDGE_ROW_147_3_Right_262 VSS VSS gf180mcu_fd_sc_mcu9t5v0__endcap
XTAP_TAPCELL_ROW_125_4428 VSS VSS gf180mcu_fd_sc_mcu9t5v0__filltie
X_10043_ _09916_/B _10043_/A2 _10043_/B1 _10106_/B _10044_/B2 VSS VSS VSS VSS gf180mcu_fd_sc_mcu9t5v0__aoi22_1
X_14920_ _14930_/A1 _14923_/A2 _14924_/A1 VSS _14922_/VNW VSS VSS gf180mcu_fd_sc_mcu9t5v0__nor2_1
X_14851_ _14852_/A1 _14851_/A2 _14852_/B VSS VSS VSS VSS gf180mcu_fd_sc_mcu9t5v0__nand2_1
XPHY_EDGE_ROW_302_Right_229 VSS VSS gf180mcu_fd_sc_mcu9t5v0__endcap
X_17570_ _18664_/Q _17703_/A2 _17570_/B _17584_/I1 VSS VSS VSS VSS gf180mcu_fd_sc_mcu9t5v0__oai21_1
X_13802_ _13795_/Z _13829_/A2 _13802_/Z VSS _13831_/VNW VSS VSS gf180mcu_fd_sc_mcu9t5v0__xor2_1
X_16521_ _16137_/C _19232_/Q _17055_/S _16521_/Z VSS VSS VSS VSS gf180mcu_fd_sc_mcu9t5v0__mux2_1
X_11994_ _18312_/Q _12345_/A2 _11997_/B2 VSS VSS VSS VSS gf180mcu_fd_sc_mcu9t5v0__nand2_1
X_14782_ _19397_/Q _19334_/Q _14786_/B VSS VSS VSS VSS gf180mcu_fd_sc_mcu9t5v0__nand2_1
X_10945_ _19007_/Q _18148_/S _10946_/B VSS VSS VSS VSS gf180mcu_fd_sc_mcu9t5v0__nand2_1
XTAP_TAPCELL_ROW_101_3760 VSS VSS gf180mcu_fd_sc_mcu9t5v0__filltie
X_13733_ _19456_/Q _13733_/A2 _13656_/Z _19473_/Q _13734_/I VSS _13733_/VNW VSS VSS
+ gf180mcu_fd_sc_mcu9t5v0__aoi22_1
XTAP_TAPCELL_ROW_270_6497 VSS VSS gf180mcu_fd_sc_mcu9t5v0__filltie
X_19240_ _19240_/D _20072_/RN clkload69/I _19240_/Q VSS VSS VSS VSS gf180mcu_fd_sc_mcu9t5v0__dffrnq_1
X_10876_ _10875_/Z _18977_/Q _18152_/S _18977_/D VSS VSS VSS VSS gf180mcu_fd_sc_mcu9t5v0__mux2_1
X_16452_ _18284_/Q _16451_/Z _16972_/S _18284_/D VSS VSS VSS VSS gf180mcu_fd_sc_mcu9t5v0__mux2_1
XTAP_TAPCELL_ROW_270_6486 VSS VSS gf180mcu_fd_sc_mcu9t5v0__filltie
XTAP_TAPCELL_ROW_101_3771 VSS VSS gf180mcu_fd_sc_mcu9t5v0__filltie
X_13664_ _13664_/A1 _19108_/Q _13675_/A1 VSS _13672_/VNW VSS VSS gf180mcu_fd_sc_mcu9t5v0__nand2_1
X_12615_ _18456_/Q _12615_/A2 _12617_/B1 VSS VSS VSS VSS gf180mcu_fd_sc_mcu9t5v0__nor2_1
XTAP_TAPCELL_ROW_287_6950 VSS VSS gf180mcu_fd_sc_mcu9t5v0__filltie
X_16383_ _16147_/C _19234_/Q _16927_/S _16383_/Z VSS VSS VSS VSS gf180mcu_fd_sc_mcu9t5v0__mux2_1
X_19171_ _19171_/D _20067_/RN clkload31/I _19171_/Q VSS VSS VSS VSS gf180mcu_fd_sc_mcu9t5v0__dffrnq_1
X_15403_ _19688_/Q _19788_/Q _15430_/S _19788_/D VSS VSS VSS VSS gf180mcu_fd_sc_mcu9t5v0__mux2_1
XTAP_TAPCELL_ROW_287_6972 VSS VSS gf180mcu_fd_sc_mcu9t5v0__filltie
XTAP_TAPCELL_ROW_287_6961 VSS VSS gf180mcu_fd_sc_mcu9t5v0__filltie
X_18122_ _18122_/A1 _18147_/S _18132_/B _18123_/I0 VSS VSS VSS VSS gf180mcu_fd_sc_mcu9t5v0__oai21_1
X_13595_ _13595_/A1 _13594_/B _13595_/A3 _13595_/Z VSS _13595_/VNW VSS VSS gf180mcu_fd_sc_mcu9t5v0__and3_1
X_15334_ _15417_/S _15331_/Z _15341_/C _15334_/B _19743_/D VSS _15334_/VNW VSS VSS
+ gf180mcu_fd_sc_mcu9t5v0__oai31_1
XTAP_TAPCELL_ROW_283_6847 VSS VSS gf180mcu_fd_sc_mcu9t5v0__filltie
X_12546_ _18746_/Q wire198/I _12547_/A2 VSS VSS VSS VSS gf180mcu_fd_sc_mcu9t5v0__nand2_1
XTAP_TAPCELL_ROW_283_6858 VSS VSS gf180mcu_fd_sc_mcu9t5v0__filltie
X_18053_ _18053_/A1 _18053_/A2 _18079_/A2 _18054_/A2 VSS _18053_/VNW VSS VSS gf180mcu_fd_sc_mcu9t5v0__nor3_1
X_12477_ _12355_/I _12485_/A2 _12477_/A3 _12477_/B _19155_/D VSS _12477_/VNW VSS VSS
+ gf180mcu_fd_sc_mcu9t5v0__oai31_1
X_15265_ _15266_/A1 _19579_/Q _15268_/A2 VSS VSS VSS VSS gf180mcu_fd_sc_mcu9t5v0__nor2_1
X_17004_ _18493_/Q _17003_/Z _17006_/S _18493_/D VSS _17004_/VNW VSS VSS gf180mcu_fd_sc_mcu9t5v0__mux2_1
X_11428_ _18464_/Q _11524_/S _11428_/B _11429_/A2 VSS VSS VSS VSS gf180mcu_fd_sc_mcu9t5v0__oai21_1
X_14216_ _14216_/A1 _14216_/A2 _14216_/B _14240_/A1 VSS VSS VSS VSS gf180mcu_fd_sc_mcu9t5v0__oai21_1
XANTENNA_4 _12308_/A2 VSS VSS VSS VSS gf180mcu_fd_sc_mcu9t5v0__antenna
X_15196_ _19719_/Q _15417_/S _15197_/B VSS VSS VSS VSS gf180mcu_fd_sc_mcu9t5v0__nand2_1
X_11359_ _18363_/Q _11428_/B _11359_/B _11359_/C _11365_/B VSS _11365_/VNW VSS VSS
+ gf180mcu_fd_sc_mcu9t5v0__oai211_1
XPHY_EDGE_ROW_158_1_Right_742 VSS VSS gf180mcu_fd_sc_mcu9t5v0__endcap
X_14147_ _14715_/S _14146_/Z _14166_/B _14148_/B2 VSS VSS VSS VSS gf180mcu_fd_sc_mcu9t5v0__aoi21_1
XTAP_TAPCELL_ROW_52_2402 VSS VSS gf180mcu_fd_sc_mcu9t5v0__filltie
XTAP_TAPCELL_ROW_52_2413 VSS VSS gf180mcu_fd_sc_mcu9t5v0__filltie
XTAP_TAPCELL_ROW_52_2424 VSS VSS gf180mcu_fd_sc_mcu9t5v0__filltie
X_18955_ _18955_/D _20043_/RN clkload66/I _18955_/Q VSS VSS VSS VSS gf180mcu_fd_sc_mcu9t5v0__dffrnq_1
X_14078_ _19320_/Q _19301_/Q _14111_/A2 VSS VSS VSS VSS gf180mcu_fd_sc_mcu9t5v0__nand2_1
Xeco6_buf_11983 _11983_/ZN _11984_/A2 VSS VSS VSS VSS gf180mcu_fd_sc_mcu9t5v0__clkbuf_16
X_18886_ _18886_/D _20038_/RN _19680_/CLK _18886_/Q VSS VSS VSS VSS gf180mcu_fd_sc_mcu9t5v0__dffrnq_1
XTAP_TAPCELL_ROW_108_3958 VSS VSS gf180mcu_fd_sc_mcu9t5v0__filltie
X_17906_ _18840_/Q _17894_/I _17910_/B VSS _17906_/VNW VSS VSS gf180mcu_fd_sc_mcu9t5v0__nand2_1
X_13029_ _12948_/S _13044_/A2 _13030_/A2 VSS VSS VSS VSS gf180mcu_fd_sc_mcu9t5v0__nor2_1
XTAP_TAPCELL_ROW_108_3947 VSS VSS gf180mcu_fd_sc_mcu9t5v0__filltie
X_17837_ _19044_/Q _18814_/Q _17845_/S _18814_/D VSS VSS VSS VSS gf180mcu_fd_sc_mcu9t5v0__mux2_1
X_17768_ _18759_/Q _17779_/A2 _17769_/B VSS VSS VSS VSS gf180mcu_fd_sc_mcu9t5v0__nor2_1
XTAP_TAPCELL_ROW_217_5046 VSS VSS gf180mcu_fd_sc_mcu9t5v0__filltie
X_16719_ _16719_/A1 _16751_/A2 _16751_/A3 _16720_/B VSS VSS VSS VSS gf180mcu_fd_sc_mcu9t5v0__nor3_1
XTAP_TAPCELL_ROW_217_5035 VSS VSS gf180mcu_fd_sc_mcu9t5v0__filltie
X_17699_ _18651_/Q _17743_/B _17701_/B VSS VSS VSS VSS gf180mcu_fd_sc_mcu9t5v0__nand2_1
X_19507_ _19507_/D _20019_/RN clkload23/I _19507_/Q VSS VSS VSS VSS gf180mcu_fd_sc_mcu9t5v0__dffrnq_1
XTAP_TAPCELL_ROW_46_2239 VSS VSS gf180mcu_fd_sc_mcu9t5v0__filltie
X_19438_ _19438_/D _20142_/RN clkload16/I _19438_/Q VSS VSS VSS VSS gf180mcu_fd_sc_mcu9t5v0__dffrnq_1
X_19369_ _19369_/D _20073_/RN clkload21/I _19369_/Q VSS VSS VSS VSS gf180mcu_fd_sc_mcu9t5v0__dffrnq_1
X_09122_ _19755_/Q _13046_/A2 VSS VSS VSS VSS gf180mcu_fd_sc_mcu9t5v0__clkinv_1
XTAP_TAPCELL_ROW_22_1582 VSS VSS gf180mcu_fd_sc_mcu9t5v0__filltie
XTAP_TAPCELL_ROW_22_1593 VSS VSS gf180mcu_fd_sc_mcu9t5v0__filltie
XTAP_TAPCELL_ROW_301_7353 VSS VSS gf180mcu_fd_sc_mcu9t5v0__filltie
XTAP_TAPCELL_ROW_301_7342 VSS VSS gf180mcu_fd_sc_mcu9t5v0__filltie
XTAP_TAPCELL_ROW_293_7121 VSS VSS gf180mcu_fd_sc_mcu9t5v0__filltie
X_20144_ _20144_/D _20144_/RN clkload49/I _20144_/Q VSS VSS VSS VSS gf180mcu_fd_sc_mcu9t5v0__dffrnq_1
XTAP_TAPCELL_ROW_35_1932 VSS VSS gf180mcu_fd_sc_mcu9t5v0__filltie
XTAP_TAPCELL_ROW_35_1943 VSS VSS gf180mcu_fd_sc_mcu9t5v0__filltie
X_09955_ _18803_/Q _18804_/Q _18801_/Q _18802_/Q _09956_/A3 VSS VSS VSS VSS gf180mcu_fd_sc_mcu9t5v0__nand4_1
XTAP_TAPCELL_ROW_35_1954 VSS VSS gf180mcu_fd_sc_mcu9t5v0__filltie
XTAP_TAPCELL_ROW_293_7132 VSS VSS gf180mcu_fd_sc_mcu9t5v0__filltie
X_20075_ _20075_/D clkload77/I _20075_/Q VSS VSS VSS VSS gf180mcu_fd_sc_mcu9t5v0__dffq_1
X_09886_ _09886_/A1 _09885_/I _20054_/D VSS VSS VSS VSS gf180mcu_fd_sc_mcu9t5v0__nor2_1
XTAP_TAPCELL_ROW_314_7703 VSS VSS gf180mcu_fd_sc_mcu9t5v0__filltie
Xu_transform_scheduler_core.u_fft_scratch_sram.u_hi.g_pin_drive\[1\].u_data_driver
+ _10503_/ZN u_transform_scheduler_core.u_fft_scratch_sram.u_hi.u_sram/D[1] VSS VSS
+ VSS VSS gf180mcu_fd_sc_mcu9t5v0__buf_8
XTAP_TAPCELL_ROW_31_1829 VSS VSS gf180mcu_fd_sc_mcu9t5v0__filltie
XTAP_TAPCELL_ROW_314_7714 VSS VSS gf180mcu_fd_sc_mcu9t5v0__filltie
XTAP_TAPCELL_ROW_118_4221 VSS VSS gf180mcu_fd_sc_mcu9t5v0__filltie
XTAP_TAPCELL_ROW_29_1769 VSS VSS gf180mcu_fd_sc_mcu9t5v0__filltie
X_10730_ _10730_/A1 _10730_/A2 _10753_/B VSS VSS VSS VSS gf180mcu_fd_sc_mcu9t5v0__nand2_1
XTAP_TAPCELL_ROW_118_4232 VSS VSS gf180mcu_fd_sc_mcu9t5v0__filltie
X_10661_ _17075_/A1 _10661_/A2 _10796_/A2 VSS VSS VSS VSS gf180mcu_fd_sc_mcu9t5v0__nor2_4
X_12400_ wire146/Z _12400_/A2 _12400_/A3 _12400_/B1 _12400_/B2 _12401_/B2 VSS VSS
+ VSS VSS gf180mcu_fd_sc_mcu9t5v0__oai32_2
XTAP_TAPCELL_ROW_308_7529 VSS VSS gf180mcu_fd_sc_mcu9t5v0__filltie
XTAP_TAPCELL_ROW_114_4129 VSS VSS gf180mcu_fd_sc_mcu9t5v0__filltie
XTAP_TAPCELL_ROW_114_4118 VSS VSS gf180mcu_fd_sc_mcu9t5v0__filltie
XTAP_TAPCELL_ROW_114_4107 VSS VSS gf180mcu_fd_sc_mcu9t5v0__filltie
X_10592_ _10543_/C _10592_/A2 _10592_/B1 _10643_/B2 _10592_/C1 _10643_/A1 _10593_/A2
+ VSS VSS VSS VSS gf180mcu_fd_sc_mcu9t5v0__aoi222_1
X_13380_ _13380_/I _13416_/B2 VSS VSS VSS VSS gf180mcu_fd_sc_mcu9t5v0__clkinv_1
X_12331_ _12071_/B _12331_/A2 _12332_/A2 VSS VSS VSS VSS gf180mcu_fd_sc_mcu9t5v0__nor2_1
X_12262_ _18436_/Q _12345_/A2 _12266_/A1 VSS VSS VSS VSS gf180mcu_fd_sc_mcu9t5v0__nand2_1
X_15050_ _15050_/A1 _15050_/A2 _15050_/Z VSS _15050_/VNW VSS VSS gf180mcu_fd_sc_mcu9t5v0__and2_1
XTAP_TAPCELL_ROW_263_6290 VSS VSS gf180mcu_fd_sc_mcu9t5v0__filltie
X_11213_ _18866_/Q _11878_/A1 _11320_/B1 _11213_/B2 _11320_/C _11215_/A1 VSS VSS VSS
+ VSS gf180mcu_fd_sc_mcu9t5v0__oai221_1
X_14001_ _19320_/Q _19299_/Q _14044_/A1 VSS _14127_/VNW VSS VSS gf180mcu_fd_sc_mcu9t5v0__nand2_1
X_12193_ _18915_/Q _12217_/A2 _12193_/Z VSS _12194_/VNW VSS VSS gf180mcu_fd_sc_mcu9t5v0__xor2_1
X_11144_ _11429_/B _11143_/Z _11144_/B _11148_/A2 VSS VSS VSS VSS gf180mcu_fd_sc_mcu9t5v0__oai21_1
X_15952_ _15952_/I0 _15952_/I1 _16619_/S _15952_/Z VSS _15952_/VNW VSS VSS gf180mcu_fd_sc_mcu9t5v0__mux2_4
X_18740_ _18740_/D clkload48/I _18740_/Q VSS VSS VSS VSS gf180mcu_fd_sc_mcu9t5v0__dffq_1
XPHY_EDGE_ROW_148_3_Right_263 VSS VSS gf180mcu_fd_sc_mcu9t5v0__endcap
X_11075_ _11075_/A1 _11075_/A2 _11321_/A2 VSS VSS VSS VSS gf180mcu_fd_sc_mcu9t5v0__nand2_2
XTAP_TAPCELL_ROW_276_6662 VSS VSS gf180mcu_fd_sc_mcu9t5v0__filltie
XTAP_TAPCELL_ROW_276_6651 VSS VSS gf180mcu_fd_sc_mcu9t5v0__filltie
X_10026_ _19231_/Q _10138_/A2 _10026_/B1 _19207_/Q _10028_/A1 VSS VSS VSS VSS gf180mcu_fd_sc_mcu9t5v0__aoi22_1
X_18671_ _18671_/D _20139_/RN clkload59/I _18671_/Q VSS VSS VSS VSS gf180mcu_fd_sc_mcu9t5v0__dffrnq_1
X_14903_ _19417_/Q _19358_/Q _14907_/A2 VSS _14904_/VNW VSS VSS gf180mcu_fd_sc_mcu9t5v0__nor2_1
XTAP_TAPCELL_ROW_276_6673 VSS VSS gf180mcu_fd_sc_mcu9t5v0__filltie
XTAP_TAPCELL_ROW_272_6537 VSS VSS gf180mcu_fd_sc_mcu9t5v0__filltie
X_15883_ _20092_/Q _19242_/Q _15912_/S _20092_/D VSS VSS VSS VSS gf180mcu_fd_sc_mcu9t5v0__mux2_1
X_17622_ _18683_/Q _17421_/S _20049_/Q _17623_/A2 VSS VSS VSS VSS gf180mcu_fd_sc_mcu9t5v0__aoi21_1
XTAP_TAPCELL_ROW_103_3811 VSS VSS gf180mcu_fd_sc_mcu9t5v0__filltie
XTAP_TAPCELL_ROW_272_6559 VSS VSS gf180mcu_fd_sc_mcu9t5v0__filltie
XTAP_TAPCELL_ROW_272_6548 VSS VSS gf180mcu_fd_sc_mcu9t5v0__filltie
XTAP_TAPCELL_ROW_103_3822 VSS VSS gf180mcu_fd_sc_mcu9t5v0__filltie
X_14834_ _14831_/Z _14837_/A2 _14838_/A1 VSS _14834_/VNW VSS VSS gf180mcu_fd_sc_mcu9t5v0__nor2_1
X_11977_ _18279_/Q _12345_/A2 _12299_/S _11978_/B2 VSS VSS VSS VSS gf180mcu_fd_sc_mcu9t5v0__aoi21_1
X_17553_ input6/Z _17546_/Z _17553_/Z VSS VSS VSS VSS gf180mcu_fd_sc_mcu9t5v0__or2_1
X_14765_ _14763_/Z _14767_/A2 _14765_/B _19554_/D VSS _14765_/VNW VSS VSS gf180mcu_fd_sc_mcu9t5v0__oai21_1
Xclkbuf_leaf_39_clk_regs clkload6/I clkload76/I VSS _17410_/VNW VSS VSS gf180mcu_fd_sc_mcu9t5v0__clkbuf_8
X_17484_ _18589_/Q _19230_/Q _17504_/S _18589_/D VSS VSS VSS VSS gf180mcu_fd_sc_mcu9t5v0__mux2_1
X_16504_ _18309_/Q _16503_/Z _17026_/S _18309_/D VSS VSS VSS VSS gf180mcu_fd_sc_mcu9t5v0__mux2_1
X_10928_ _18926_/Q _18933_/Q _10936_/A1 VSS VSS VSS VSS gf180mcu_fd_sc_mcu9t5v0__nand2_1
X_13716_ _19297_/Q _14166_/B _13712_/Z _14546_/S _13717_/B VSS VSS VSS VSS gf180mcu_fd_sc_mcu9t5v0__aoi22_1
XTAP_TAPCELL_ROW_285_6909 VSS VSS gf180mcu_fd_sc_mcu9t5v0__filltie
X_16435_ _16435_/I0 _18278_/Q _16958_/S _18278_/D VSS VSS VSS VSS gf180mcu_fd_sc_mcu9t5v0__mux2_4
X_19223_ _19223_/D _20055_/RN clkload39/I _19223_/Q VSS VSS VSS VSS gf180mcu_fd_sc_mcu9t5v0__dffrnq_1
XTAP_TAPCELL_ROW_41_2103 VSS VSS gf180mcu_fd_sc_mcu9t5v0__filltie
XTAP_TAPCELL_ROW_41_2114 VSS VSS gf180mcu_fd_sc_mcu9t5v0__filltie
X_14696_ _14696_/A1 _14696_/A2 _14696_/B _14699_/A2 VSS VSS VSS VSS gf180mcu_fd_sc_mcu9t5v0__aoi21_1
X_10859_ _10859_/I0 _18968_/Q _18148_/S _18968_/D VSS _10859_/VNW VSS VSS gf180mcu_fd_sc_mcu9t5v0__mux2_1
X_13647_ _13666_/A1 _19107_/Q _13667_/A1 VSS _13666_/VNW VSS VSS gf180mcu_fd_sc_mcu9t5v0__nor2_1
X_16366_ _18247_/Q _16365_/Z _16892_/S _18247_/D VSS VSS VSS VSS gf180mcu_fd_sc_mcu9t5v0__mux2_4
X_19154_ _19154_/D _20050_/RN _19798_/CLK _19154_/Q VSS VSS VSS VSS gf180mcu_fd_sc_mcu9t5v0__dffrnq_1
X_13578_ wire277/Z _13581_/A3 _13577_/Z _13578_/B _19277_/D VSS _13581_/VNW VSS VSS
+ gf180mcu_fd_sc_mcu9t5v0__oai31_1
X_18105_ _19197_/Q _19203_/Q _18151_/S _18105_/Z VSS VSS VSS VSS gf180mcu_fd_sc_mcu9t5v0__mux2_1
X_16297_ _15939_/B _10064_/S _15973_/B _15985_/C _16297_/B2 _16440_/B VSS VSS VSS
+ VSS gf180mcu_fd_sc_mcu9t5v0__oai32_4
X_19085_ _19085_/D _20045_/RN clkload41/I _19085_/Q VSS VSS VSS VSS gf180mcu_fd_sc_mcu9t5v0__dffrnq_1
X_12529_ _12686_/C _12620_/A1 _12529_/A3 _12529_/B _19162_/D VSS _14724_/VNW VSS VSS
+ gf180mcu_fd_sc_mcu9t5v0__oai31_1
X_15317_ _15316_/Z _19740_/Q _15417_/S _19740_/D VSS _15317_/VNW VSS VSS gf180mcu_fd_sc_mcu9t5v0__mux2_1
XTAP_TAPCELL_ROW_39_2043 VSS VSS gf180mcu_fd_sc_mcu9t5v0__filltie
X_15248_ _15249_/A1 _15249_/A3 _15248_/B _15252_/A1 VSS VSS VSS VSS gf180mcu_fd_sc_mcu9t5v0__aoi21_1
X_18036_ _18036_/I0 _18921_/Q _18037_/S _18921_/D VSS VSS VSS VSS gf180mcu_fd_sc_mcu9t5v0__mux2_1
XTAP_TAPCELL_ROW_39_2054 VSS VSS gf180mcu_fd_sc_mcu9t5v0__filltie
XTAP_TAPCELL_ROW_39_2065 VSS VSS gf180mcu_fd_sc_mcu9t5v0__filltie
XPHY_EDGE_ROW_159_1_Right_743 VSS VSS gf180mcu_fd_sc_mcu9t5v0__endcap
X_15179_ _15179_/A1 _19565_/Q _15192_/A1 VSS VSS VSS VSS gf180mcu_fd_sc_mcu9t5v0__nor2_1
X_19987_ _19987_/D _20051_/RN clkload26/I _19987_/Q VSS VSS VSS VSS gf180mcu_fd_sc_mcu9t5v0__dffrnq_1
X_09740_ _09740_/A1 _20051_/Q _09740_/B _20017_/D VSS VSS VSS VSS gf180mcu_fd_sc_mcu9t5v0__oai21_1
X_18938_ _18938_/D _20026_/RN clkload46/I _18938_/Q VSS VSS VSS VSS gf180mcu_fd_sc_mcu9t5v0__dffrnq_1
.ends
