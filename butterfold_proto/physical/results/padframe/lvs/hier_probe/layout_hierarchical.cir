* Extracted by KLayout with GF180MCU LVS runset on : 11/08/2026 22:56

.SUBCKT gf180mcu_fd_io__dvss
.ENDS gf180mcu_fd_io__dvss

.SUBCKT gf180mcu_fd_io__cor
.ENDS gf180mcu_fd_io__cor

.SUBCKT butterfold_padframe_top pad_din_valid_i pad_dout[0] pad_din[0]
+ pad_dout[1] pad_din[1] pad_dout[2] pad_din[2] pad_dout[3] pad_din[3]
+ pad_dout[4] pad_din[4] pad_dout[5] pad_din[5] pad_dout[6] pad_din[6]
+ pad_dout[7] pad_din[7] pad_dout_valid_o pad_din_ready_o pad_clk pad_rst_n
X$1 \$3 \$17530 \$29840 \$22887 \$23180 \$17354 \$29840 \$29840 \$19591 \$22279
+ \$21366 \$29840 \$16120 \$29943 \$29841 \$29842 \$29946 \$I71768 \$29266
+ \$29840 \$29118 \$29119 \$29288 \$29120 \$25915 \$17363 \$29840 \$20517
+ \$I71770 \$24221 \$20045 \$29840 \$29840 \$18252 \$23021 \$I71769 \$20400
+ \$29840 \$16129 \$I71762 \$I71763 \$I71764 \$I71765 \$I71766 \$I71752
+ \$I71759 \$I71747 \$I71767 \$I71742 \$I71750 \$I71757 \$I71761 \$I71745
+ \$I71749 \$I71755 \$I71756 \$I71758 \$I71760 \$I71743 \$I71744 \$I71746
+ \$I71748 \$I71751 \$3 \$I71753 \$I71754 \$I71741 \$1
+ gf180mcu_fd_ip_sram__sram256x8m8wm1
X$2 \$3 \$18704 \$29422 \$22833 \$23446 \$15808 \$29422 \$29422 \$17368 \$23314
+ \$20226 \$29422 \$16916 \$29448 \$29841 \$29842 \$29946 \$1 \$29266 \$29422
+ \$29289 \$29119 \$29288 \$29120 \$25915 \$17370 \$29422 \$23315 \$1 \$23445
+ \$19152 \$29422 \$29422 \$17822 \$23317 \$1 \$23922 \$29422 \$16917 \$1 \$1
+ \$1 \$1 \$1 \$1 \$1 \$1 \$1 \$1 \$1 \$1 \$1 \$1 \$1 \$1 \$1 \$1 \$1 \$1 \$1
+ \$1 \$1 \$1 \$3 \$1 \$1 \$1 \$I71739 gf180mcu_fd_ip_sram__sram256x8m8wm1
X$3 \$2 \$4 gf180mcu_fd_sc_mcu9t5v0__filltie
X$4 \$2 \$4 gf180mcu_fd_sc_mcu9t5v0__filltie
X$5 \$2 \$4 gf180mcu_fd_sc_mcu9t5v0__filltie
X$6 \$2 \$4 gf180mcu_fd_sc_mcu9t5v0__filltie
X$7 \$2 \$4 gf180mcu_fd_sc_mcu9t5v0__filltie
X$8 \$2 \$4 gf180mcu_fd_sc_mcu9t5v0__filltie
X$9 \$2 \$4 gf180mcu_fd_sc_mcu9t5v0__filltie
X$10 \$2 \$4 gf180mcu_fd_sc_mcu9t5v0__filltie
X$11 \$2 \$4 gf180mcu_fd_sc_mcu9t5v0__filltie
X$12 \$2 \$4 gf180mcu_fd_sc_mcu9t5v0__filltie
X$13 \$2 \$4 gf180mcu_fd_sc_mcu9t5v0__filltie
X$14 \$2 \$4 gf180mcu_fd_sc_mcu9t5v0__filltie
X$15 \$2 \$4 gf180mcu_fd_sc_mcu9t5v0__endcap
X$16 \$2 \$4 gf180mcu_fd_sc_mcu9t5v0__endcap
X$17 \$90 \$4 gf180mcu_fd_sc_mcu9t5v0__filltie
X$18 \$90 \$4 gf180mcu_fd_sc_mcu9t5v0__filltie
X$19 \$90 \$4 gf180mcu_fd_sc_mcu9t5v0__filltie
X$20 \$90 \$4 gf180mcu_fd_sc_mcu9t5v0__filltie
X$21 \$90 \$4 gf180mcu_fd_sc_mcu9t5v0__filltie
X$22 \$90 \$4 gf180mcu_fd_sc_mcu9t5v0__filltie
X$23 \$90 \$4 gf180mcu_fd_sc_mcu9t5v0__endcap
X$24 \$90 \$4 gf180mcu_fd_sc_mcu9t5v0__endcap
X$25 \$260 \$89 gf180mcu_fd_sc_mcu9t5v0__filltie
X$26 \$260 \$89 gf180mcu_fd_sc_mcu9t5v0__filltie
X$27 \$260 \$89 gf180mcu_fd_sc_mcu9t5v0__filltie
X$28 \$260 \$89 gf180mcu_fd_sc_mcu9t5v0__filltie
X$29 \$260 \$89 gf180mcu_fd_sc_mcu9t5v0__filltie
X$30 \$260 \$89 gf180mcu_fd_sc_mcu9t5v0__filltie
X$31 \$90 \$89 gf180mcu_fd_sc_mcu9t5v0__filltie
X$32 \$90 \$89 gf180mcu_fd_sc_mcu9t5v0__filltie
X$33 \$90 \$89 gf180mcu_fd_sc_mcu9t5v0__filltie
X$34 \$90 \$89 gf180mcu_fd_sc_mcu9t5v0__filltie
X$35 \$90 \$89 gf180mcu_fd_sc_mcu9t5v0__filltie
X$36 \$90 \$89 gf180mcu_fd_sc_mcu9t5v0__filltie
X$37 \$90 \$89 gf180mcu_fd_sc_mcu9t5v0__endcap
X$38 \$260 \$89 gf180mcu_fd_sc_mcu9t5v0__endcap
X$39 \$260 \$89 gf180mcu_fd_sc_mcu9t5v0__endcap
X$40 \$90 \$89 gf180mcu_fd_sc_mcu9t5v0__endcap
X$41 \$430 \$259 gf180mcu_fd_sc_mcu9t5v0__filltie
X$42 \$430 \$259 gf180mcu_fd_sc_mcu9t5v0__filltie
X$43 \$430 \$259 gf180mcu_fd_sc_mcu9t5v0__filltie
X$44 \$430 \$259 gf180mcu_fd_sc_mcu9t5v0__filltie
X$45 \$430 \$259 gf180mcu_fd_sc_mcu9t5v0__filltie
X$46 \$430 \$259 gf180mcu_fd_sc_mcu9t5v0__filltie
X$47 \$260 \$259 gf180mcu_fd_sc_mcu9t5v0__filltie
X$48 \$260 \$259 gf180mcu_fd_sc_mcu9t5v0__filltie
X$49 \$260 \$259 gf180mcu_fd_sc_mcu9t5v0__filltie
X$50 \$260 \$259 gf180mcu_fd_sc_mcu9t5v0__filltie
X$51 \$260 \$259 gf180mcu_fd_sc_mcu9t5v0__filltie
X$52 \$260 \$259 gf180mcu_fd_sc_mcu9t5v0__filltie
X$53 \$260 \$259 gf180mcu_fd_sc_mcu9t5v0__endcap
X$54 \$430 \$259 gf180mcu_fd_sc_mcu9t5v0__endcap
X$55 \$430 \$259 gf180mcu_fd_sc_mcu9t5v0__endcap
X$56 \$260 \$259 gf180mcu_fd_sc_mcu9t5v0__endcap
X$57 \$600 \$429 gf180mcu_fd_sc_mcu9t5v0__filltie
X$58 \$600 \$429 gf180mcu_fd_sc_mcu9t5v0__filltie
X$59 \$600 \$429 gf180mcu_fd_sc_mcu9t5v0__filltie
X$60 \$600 \$429 gf180mcu_fd_sc_mcu9t5v0__filltie
X$61 \$600 \$429 gf180mcu_fd_sc_mcu9t5v0__filltie
X$62 \$600 \$429 gf180mcu_fd_sc_mcu9t5v0__filltie
X$63 \$430 \$429 gf180mcu_fd_sc_mcu9t5v0__filltie
X$64 \$430 \$429 gf180mcu_fd_sc_mcu9t5v0__filltie
X$65 \$430 \$429 gf180mcu_fd_sc_mcu9t5v0__filltie
X$66 \$430 \$429 gf180mcu_fd_sc_mcu9t5v0__filltie
X$67 \$430 \$429 gf180mcu_fd_sc_mcu9t5v0__filltie
X$68 \$430 \$429 gf180mcu_fd_sc_mcu9t5v0__filltie
X$69 \$430 \$429 gf180mcu_fd_sc_mcu9t5v0__endcap
X$70 \$600 \$429 gf180mcu_fd_sc_mcu9t5v0__endcap
X$71 \$600 \$429 gf180mcu_fd_sc_mcu9t5v0__endcap
X$72 \$430 \$429 gf180mcu_fd_sc_mcu9t5v0__endcap
X$73 \$770 \$599 gf180mcu_fd_sc_mcu9t5v0__filltie
X$74 \$770 \$599 gf180mcu_fd_sc_mcu9t5v0__filltie
X$75 \$770 \$599 gf180mcu_fd_sc_mcu9t5v0__filltie
X$76 \$770 \$599 gf180mcu_fd_sc_mcu9t5v0__filltie
X$77 \$770 \$599 gf180mcu_fd_sc_mcu9t5v0__filltie
X$78 \$770 \$599 gf180mcu_fd_sc_mcu9t5v0__filltie
X$79 \$600 \$599 gf180mcu_fd_sc_mcu9t5v0__filltie
X$80 \$600 \$599 gf180mcu_fd_sc_mcu9t5v0__filltie
X$81 \$600 \$599 gf180mcu_fd_sc_mcu9t5v0__filltie
X$82 \$600 \$599 gf180mcu_fd_sc_mcu9t5v0__filltie
X$83 \$600 \$599 gf180mcu_fd_sc_mcu9t5v0__filltie
X$84 \$600 \$599 gf180mcu_fd_sc_mcu9t5v0__filltie
X$85 \$600 \$599 gf180mcu_fd_sc_mcu9t5v0__endcap
X$86 \$770 \$599 gf180mcu_fd_sc_mcu9t5v0__endcap
X$87 \$770 \$599 gf180mcu_fd_sc_mcu9t5v0__endcap
X$88 \$600 \$599 gf180mcu_fd_sc_mcu9t5v0__endcap
X$89 \$940 \$769 gf180mcu_fd_sc_mcu9t5v0__filltie
X$90 \$940 \$769 gf180mcu_fd_sc_mcu9t5v0__filltie
X$91 \$940 \$769 gf180mcu_fd_sc_mcu9t5v0__filltie
X$92 \$940 \$769 gf180mcu_fd_sc_mcu9t5v0__filltie
X$93 \$940 \$769 gf180mcu_fd_sc_mcu9t5v0__filltie
X$94 \$940 \$769 gf180mcu_fd_sc_mcu9t5v0__filltie
X$95 \$770 \$769 gf180mcu_fd_sc_mcu9t5v0__filltie
X$96 \$770 \$769 gf180mcu_fd_sc_mcu9t5v0__filltie
X$97 \$770 \$769 gf180mcu_fd_sc_mcu9t5v0__filltie
X$98 \$770 \$769 gf180mcu_fd_sc_mcu9t5v0__filltie
X$99 \$770 \$769 gf180mcu_fd_sc_mcu9t5v0__filltie
X$100 \$770 \$769 gf180mcu_fd_sc_mcu9t5v0__filltie
X$101 \$770 \$769 gf180mcu_fd_sc_mcu9t5v0__endcap
X$102 \$940 \$769 gf180mcu_fd_sc_mcu9t5v0__endcap
X$103 \$940 \$769 gf180mcu_fd_sc_mcu9t5v0__endcap
X$104 \$770 \$769 gf180mcu_fd_sc_mcu9t5v0__endcap
X$105 \$1110 \$939 gf180mcu_fd_sc_mcu9t5v0__filltie
X$106 \$1110 \$939 gf180mcu_fd_sc_mcu9t5v0__filltie
X$107 \$1110 \$939 gf180mcu_fd_sc_mcu9t5v0__filltie
X$108 \$1110 \$939 gf180mcu_fd_sc_mcu9t5v0__filltie
X$109 \$1110 \$939 gf180mcu_fd_sc_mcu9t5v0__filltie
X$110 \$1110 \$939 gf180mcu_fd_sc_mcu9t5v0__filltie
X$111 \$940 \$939 gf180mcu_fd_sc_mcu9t5v0__filltie
X$112 \$940 \$939 gf180mcu_fd_sc_mcu9t5v0__filltie
X$113 \$940 \$939 gf180mcu_fd_sc_mcu9t5v0__filltie
X$114 \$940 \$939 gf180mcu_fd_sc_mcu9t5v0__filltie
X$115 \$940 \$939 gf180mcu_fd_sc_mcu9t5v0__filltie
X$116 \$940 \$939 gf180mcu_fd_sc_mcu9t5v0__filltie
X$117 \$940 \$939 gf180mcu_fd_sc_mcu9t5v0__endcap
X$118 \$1110 \$939 gf180mcu_fd_sc_mcu9t5v0__endcap
X$119 \$1110 \$939 gf180mcu_fd_sc_mcu9t5v0__endcap
X$120 \$940 \$939 gf180mcu_fd_sc_mcu9t5v0__endcap
X$121 \$1280 \$1109 gf180mcu_fd_sc_mcu9t5v0__filltie
X$122 \$1280 \$1109 gf180mcu_fd_sc_mcu9t5v0__filltie
X$123 \$1280 \$1109 gf180mcu_fd_sc_mcu9t5v0__filltie
X$124 \$1280 \$1109 gf180mcu_fd_sc_mcu9t5v0__filltie
X$125 \$1280 \$1109 gf180mcu_fd_sc_mcu9t5v0__filltie
X$126 \$1280 \$1109 gf180mcu_fd_sc_mcu9t5v0__filltie
X$127 \$1110 \$1109 gf180mcu_fd_sc_mcu9t5v0__filltie
X$128 \$1110 \$1109 gf180mcu_fd_sc_mcu9t5v0__filltie
X$129 \$1110 \$1109 gf180mcu_fd_sc_mcu9t5v0__filltie
X$130 \$1110 \$1109 gf180mcu_fd_sc_mcu9t5v0__filltie
X$131 \$1110 \$1109 gf180mcu_fd_sc_mcu9t5v0__filltie
X$132 \$1110 \$1109 gf180mcu_fd_sc_mcu9t5v0__filltie
X$133 \$1110 \$1109 gf180mcu_fd_sc_mcu9t5v0__endcap
X$134 \$1280 \$1109 gf180mcu_fd_sc_mcu9t5v0__endcap
X$135 \$1280 \$1109 gf180mcu_fd_sc_mcu9t5v0__endcap
X$136 \$1110 \$1109 gf180mcu_fd_sc_mcu9t5v0__endcap
X$137 \$1450 \$1279 gf180mcu_fd_sc_mcu9t5v0__filltie
X$138 \$1450 \$1279 gf180mcu_fd_sc_mcu9t5v0__filltie
X$139 \$1450 \$1279 gf180mcu_fd_sc_mcu9t5v0__filltie
X$140 \$1450 \$1279 gf180mcu_fd_sc_mcu9t5v0__filltie
X$141 \$1450 \$1279 gf180mcu_fd_sc_mcu9t5v0__filltie
X$142 \$1450 \$1279 gf180mcu_fd_sc_mcu9t5v0__filltie
X$143 \$1280 \$1279 gf180mcu_fd_sc_mcu9t5v0__filltie
X$144 \$1280 \$1279 gf180mcu_fd_sc_mcu9t5v0__filltie
X$145 \$1280 \$1279 gf180mcu_fd_sc_mcu9t5v0__filltie
X$146 \$1280 \$1279 gf180mcu_fd_sc_mcu9t5v0__filltie
X$147 \$1280 \$1279 gf180mcu_fd_sc_mcu9t5v0__filltie
X$148 \$1280 \$1279 gf180mcu_fd_sc_mcu9t5v0__filltie
X$149 \$1280 \$1279 gf180mcu_fd_sc_mcu9t5v0__endcap
X$150 \$1450 \$1279 gf180mcu_fd_sc_mcu9t5v0__endcap
X$151 \$1450 \$1279 gf180mcu_fd_sc_mcu9t5v0__endcap
X$152 \$1280 \$1279 gf180mcu_fd_sc_mcu9t5v0__endcap
X$153 \$1620 \$1449 gf180mcu_fd_sc_mcu9t5v0__filltie
X$154 \$1620 \$1449 gf180mcu_fd_sc_mcu9t5v0__filltie
X$155 \$1620 \$1449 gf180mcu_fd_sc_mcu9t5v0__filltie
X$156 \$1620 \$1449 gf180mcu_fd_sc_mcu9t5v0__filltie
X$157 \$1620 \$1449 gf180mcu_fd_sc_mcu9t5v0__filltie
X$158 \$1620 \$1449 gf180mcu_fd_sc_mcu9t5v0__filltie
X$159 \$1450 \$1449 gf180mcu_fd_sc_mcu9t5v0__filltie
X$160 \$1450 \$1449 gf180mcu_fd_sc_mcu9t5v0__filltie
X$161 \$1450 \$1449 gf180mcu_fd_sc_mcu9t5v0__filltie
X$162 \$1450 \$1449 gf180mcu_fd_sc_mcu9t5v0__filltie
X$163 \$1450 \$1449 gf180mcu_fd_sc_mcu9t5v0__filltie
X$164 \$1450 \$1449 gf180mcu_fd_sc_mcu9t5v0__filltie
X$165 \$1450 \$1449 gf180mcu_fd_sc_mcu9t5v0__endcap
X$166 \$1620 \$1449 gf180mcu_fd_sc_mcu9t5v0__endcap
X$167 \$1620 \$1449 gf180mcu_fd_sc_mcu9t5v0__endcap
X$168 \$1450 \$1449 gf180mcu_fd_sc_mcu9t5v0__endcap
X$169 \$1790 \$1619 gf180mcu_fd_sc_mcu9t5v0__filltie
X$170 \$1790 \$1619 gf180mcu_fd_sc_mcu9t5v0__filltie
X$171 \$1790 \$1619 gf180mcu_fd_sc_mcu9t5v0__filltie
X$172 \$1790 \$1619 gf180mcu_fd_sc_mcu9t5v0__filltie
X$173 \$1790 \$1619 gf180mcu_fd_sc_mcu9t5v0__filltie
X$174 \$1790 \$1619 gf180mcu_fd_sc_mcu9t5v0__filltie
X$175 \$1620 \$1619 gf180mcu_fd_sc_mcu9t5v0__filltie
X$176 \$1620 \$1619 gf180mcu_fd_sc_mcu9t5v0__filltie
X$177 \$1620 \$1619 gf180mcu_fd_sc_mcu9t5v0__filltie
X$178 \$1620 \$1619 gf180mcu_fd_sc_mcu9t5v0__filltie
X$179 \$1620 \$1619 gf180mcu_fd_sc_mcu9t5v0__filltie
X$180 \$1620 \$1619 gf180mcu_fd_sc_mcu9t5v0__filltie
X$181 \$1620 \$1619 gf180mcu_fd_sc_mcu9t5v0__endcap
X$182 \$1790 \$1619 gf180mcu_fd_sc_mcu9t5v0__endcap
X$183 \$1790 \$1619 gf180mcu_fd_sc_mcu9t5v0__endcap
X$184 \$1620 \$1619 gf180mcu_fd_sc_mcu9t5v0__endcap
X$185 \$2141 \$2799 \$1962 \$1789 \$1960 \$1961 gf180mcu_fd_sc_mcu9t5v0__mux2_1
X$186 \$1960 \$1789 gf180mcu_fd_sc_mcu9t5v0__filltie
X$187 \$1960 \$1789 gf180mcu_fd_sc_mcu9t5v0__filltie
X$188 \$1960 \$1789 gf180mcu_fd_sc_mcu9t5v0__filltie
X$189 \$1960 \$1789 gf180mcu_fd_sc_mcu9t5v0__filltie
X$190 \$1960 \$1789 gf180mcu_fd_sc_mcu9t5v0__filltie
X$191 \$1960 \$1789 gf180mcu_fd_sc_mcu9t5v0__filltie
X$192 \$1790 \$1789 gf180mcu_fd_sc_mcu9t5v0__filltie
X$193 \$1790 \$1789 gf180mcu_fd_sc_mcu9t5v0__filltie
X$194 \$1790 \$1789 gf180mcu_fd_sc_mcu9t5v0__filltie
X$195 \$1790 \$1789 gf180mcu_fd_sc_mcu9t5v0__filltie
X$196 \$1790 \$1789 gf180mcu_fd_sc_mcu9t5v0__filltie
X$197 \$1790 \$1789 gf180mcu_fd_sc_mcu9t5v0__filltie
X$198 \$1790 \$1789 gf180mcu_fd_sc_mcu9t5v0__endcap
X$199 \$1960 \$1789 gf180mcu_fd_sc_mcu9t5v0__endcap
X$200 \$1960 \$1789 gf180mcu_fd_sc_mcu9t5v0__endcap
X$201 \$1790 \$1789 gf180mcu_fd_sc_mcu9t5v0__endcap
X$202 \$1959 \$2139 \$20553 gf180mcu_fd_sc_mcu9t5v0__tieh
X$203 \$1959 \$2139 \$2246 gf180mcu_fd_sc_mcu9t5v0__tiel
X$204 \$1959 \$2139 \$20506 gf180mcu_fd_sc_mcu9t5v0__tiel
X$205 \$2654 \$2139 \$1959 \$2137 gf180mcu_fd_sc_mcu9t5v0__buf_1
X$206 \$2137 \$2139 \$1959 \$2138 gf180mcu_fd_sc_mcu9t5v0__buf_8
X$207 \$2155 \$2264 \$1966 \$1959 \$2139 \$2154 gf180mcu_fd_sc_mcu9t5v0__mux2_2
X$208 \$2249 \$2148 \$2899 \$1959 \$2139 gf180mcu_fd_sc_mcu9t5v0__dffq_2
X$209 \$2256 \$2147 \$1962 \$1959 \$2139 \$2146 gf180mcu_fd_sc_mcu9t5v0__mux2_1
X$210 \$2153 \$2152 \$2142 \$1959 \$2139 \$2151 gf180mcu_fd_sc_mcu9t5v0__mux2_1
X$211 \$2153 \$2158 \$1962 \$1959 \$2139 \$2157 gf180mcu_fd_sc_mcu9t5v0__mux2_1
X$212 \$2259 \$2260 \$2142 \$1959 \$2139 \$2150 gf180mcu_fd_sc_mcu9t5v0__mux2_1
X$213 \$2370 \$2144 \$1962 \$1959 \$2139 \$2143 gf180mcu_fd_sc_mcu9t5v0__mux2_1
X$214 \$2275 \$2160 \$2255 \$1959 \$2139 \$2161 gf180mcu_fd_sc_mcu9t5v0__mux2_1
X$215 \$2141 \$2248 \$2142 \$1959 \$2139 \$2140 gf180mcu_fd_sc_mcu9t5v0__mux2_1
X$216 \$2266 \$2267 \$2255 \$1959 \$2139 \$2159 gf180mcu_fd_sc_mcu9t5v0__mux2_1
X$217 \$1965 \$1964 \$1966 \$1959 \$1960 \$1963 gf180mcu_fd_sc_mcu9t5v0__mux2_1
X$218 \$2259 \$2149 \$1962 \$1959 \$1960 \$1967 gf180mcu_fd_sc_mcu9t5v0__mux2_1
X$219 \$2249 \$1963 \$1964 \$1959 \$2139 gf180mcu_fd_sc_mcu9t5v0__dffq_2
X$220 \$2249 \$1967 \$2149 \$1959 \$2139 gf180mcu_fd_sc_mcu9t5v0__dffq_2
X$221 \$2249 \$1961 \$2799 \$1959 \$1960 gf180mcu_fd_sc_mcu9t5v0__dffq_2
X$222 \$2139 \$1959 gf180mcu_fd_sc_mcu9t5v0__filltie
X$223 \$2139 \$1959 gf180mcu_fd_sc_mcu9t5v0__filltie
X$224 \$2139 \$1959 gf180mcu_fd_sc_mcu9t5v0__filltie
X$225 \$2139 \$1959 gf180mcu_fd_sc_mcu9t5v0__filltie
X$226 \$2139 \$1959 gf180mcu_fd_sc_mcu9t5v0__filltie
X$227 \$2139 \$1959 gf180mcu_fd_sc_mcu9t5v0__filltie
X$228 \$1960 \$1959 gf180mcu_fd_sc_mcu9t5v0__filltie
X$229 \$1960 \$1959 gf180mcu_fd_sc_mcu9t5v0__filltie
X$230 \$1960 \$1959 gf180mcu_fd_sc_mcu9t5v0__filltie
X$231 \$1960 \$1959 gf180mcu_fd_sc_mcu9t5v0__filltie
X$232 \$1960 \$1959 gf180mcu_fd_sc_mcu9t5v0__filltie
X$233 \$1960 \$1959 gf180mcu_fd_sc_mcu9t5v0__filltie
X$234 \$1960 \$1959 gf180mcu_fd_sc_mcu9t5v0__endcap
X$235 \$2139 \$1959 gf180mcu_fd_sc_mcu9t5v0__endcap
X$236 \$2139 \$1959 gf180mcu_fd_sc_mcu9t5v0__endcap
X$237 \$1960 \$1959 gf180mcu_fd_sc_mcu9t5v0__endcap
X$238 \$10918 \$10630 \$10782 \$1962 gf180mcu_fd_sc_mcu9t5v0__buf_8
X$239 \$6374 \$6682 \$1962 \$6770 \$6890 \$6912 gf180mcu_fd_sc_mcu9t5v0__mux2_1
X$240 \$12494 \$11970 \$1962 \$12486 \$12526 \$12544
+ gf180mcu_fd_sc_mcu9t5v0__mux2_1
X$241 \$3490 \$4719 \$1962 \$3931 \$4041 \$4049 gf180mcu_fd_sc_mcu9t5v0__mux2_1
X$242 \$8697 \$8981 \$1962 \$8834 \$8963 \$8982 gf180mcu_fd_sc_mcu9t5v0__mux2_1
X$243 \$5256 \$5374 \$1962 \$5207 \$5240 \$5257 gf180mcu_fd_sc_mcu9t5v0__mux2_1
X$244 \$6113 \$5853 \$1962 \$5735 \$5833 \$5852 gf180mcu_fd_sc_mcu9t5v0__mux2_1
X$245 \$7592 \$8693 \$1962 \$9102 \$8963 \$9090 gf180mcu_fd_sc_mcu9t5v0__mux2_1
X$246 \$2160 \$2278 \$1962 \$2247 \$2139 \$2277 gf180mcu_fd_sc_mcu9t5v0__mux2_1
X$247 \$9735 \$10051 \$1962 \$10022 \$9900 \$10052
+ gf180mcu_fd_sc_mcu9t5v0__mux2_1
X$248 \$2267 \$2272 \$1962 \$2247 \$2139 \$2271 gf180mcu_fd_sc_mcu9t5v0__mux2_1
X$249 \$2703 \$3376 \$1962 \$2891 \$2791 \$2910 gf180mcu_fd_sc_mcu9t5v0__mux2_1
X$250 \$8853 \$8856 \$1962 \$8834 \$8717 \$8855 gf180mcu_fd_sc_mcu9t5v0__mux2_1
X$251 \$5632 \$6524 \$1962 \$6497 \$6387 \$6525 gf180mcu_fd_sc_mcu9t5v0__mux2_1
X$252 \$7557 \$7706 \$1962 \$7797 \$7688 \$7819 gf180mcu_fd_sc_mcu9t5v0__mux2_1
X$253 \$5115 \$5644 \$1962 \$5735 \$5473 \$5645 gf180mcu_fd_sc_mcu9t5v0__mux2_1
X$254 \$9235 \$12392 \$1962 \$12486 \$12376 \$12562
+ gf180mcu_fd_sc_mcu9t5v0__mux2_1
X$255 \$9917 \$12508 \$1962 \$12786 \$12526 \$12797
+ gf180mcu_fd_sc_mcu9t5v0__mux2_1
X$256 \$1964 \$2376 \$3207 \$3476 \$3354 \$3221 \$3351 \$3463 \$3477
+ gf180mcu_fd_sc_mcu9t5v0__mux4_1
X$257 \$3207 \$3476 \$1964 \$2376 \$3468 \$3203 \$3581 \$3463 \$3712
+ gf180mcu_fd_sc_mcu9t5v0__mux4_1
X$258 \$4320 \$4212 \$4199 \$1964 \$4173 \$4314 \$4180
+ gf180mcu_fd_sc_mcu9t5v0__aoi22_1
X$259 \$1964 \$2802 \$2803 \$3000 \$5356 \$2679 \$2791 \$2903
+ gf180mcu_fd_sc_mcu9t5v0__aoi221_1
X$260 \$2260 \$2259 \$2258 \$2247 \$2139 \$1965 gf180mcu_fd_sc_mcu9t5v0__mux2_1
X$261 \$10528 \$10630 \$10514 \$1966 gf180mcu_fd_sc_mcu9t5v0__buf_20
X$262 \$7285 \$7174 \$1966 \$7047 \$7160 \$7284 gf180mcu_fd_sc_mcu9t5v0__mux2_2
X$263 \$6395 \$6011 \$1966 \$6497 \$6387 \$6509 gf180mcu_fd_sc_mcu9t5v0__mux2_2
X$264 \$7701 \$7700 \$1966 \$7797 \$7947 \$7699 gf180mcu_fd_sc_mcu9t5v0__mux2_1
X$265 \$3489 \$3726 \$1966 \$3581 \$3812 \$3613 gf180mcu_fd_sc_mcu9t5v0__mux2_1
X$266 \$6373 \$6401 \$1966 \$6136 \$6387 \$6400 gf180mcu_fd_sc_mcu9t5v0__mux2_1
X$267 \$2161 \$3242 \$1966 \$2247 \$2365 \$2276 gf180mcu_fd_sc_mcu9t5v0__mux2_1
X$268 \$2257 \$2899 \$1966 \$2247 \$2365 \$2148 gf180mcu_fd_sc_mcu9t5v0__mux2_1
X$269 \$8969 \$9359 \$1966 \$9102 \$9221 \$9082 gf180mcu_fd_sc_mcu9t5v0__mux2_1
X$270 \$10681 \$10680 \$1966 \$10630 \$10782 \$10810
+ gf180mcu_fd_sc_mcu9t5v0__mux2_1
X$271 \$10670 \$10669 \$1966 \$10630 \$10782 \$10796
+ gf180mcu_fd_sc_mcu9t5v0__mux2_1
X$272 \$3704 \$4535 \$1966 \$3931 \$4041 \$3915 gf180mcu_fd_sc_mcu9t5v0__mux2_1
X$273 \$2159 \$2380 \$1966 \$2247 \$2365 \$2270 gf180mcu_fd_sc_mcu9t5v0__mux2_1
X$274 \$9920 \$10268 \$1966 \$10022 \$10282 \$10050
+ gf180mcu_fd_sc_mcu9t5v0__mux2_1
X$275 \$8698 \$8978 \$1966 \$8834 \$8963 \$8735 gf180mcu_fd_sc_mcu9t5v0__mux2_1
X$276 \$10809 \$10679 \$1966 \$10630 \$10782 \$10808
+ gf180mcu_fd_sc_mcu9t5v0__mux2_1
X$277 \$5381 \$5382 \$1966 \$5358 \$5240 \$5263 gf180mcu_fd_sc_mcu9t5v0__mux2_1
X$278 \$3199 \$3212 \$1966 \$3238 \$3112 \$3239 gf180mcu_fd_sc_mcu9t5v0__mux2_1
X$279 \$2253 \$2252 \$1966 \$2247 \$2139 \$2251 gf180mcu_fd_sc_mcu9t5v0__mux2_1
X$280 \$2687 \$2800 \$1966 \$2679 \$2670 \$2686 gf180mcu_fd_sc_mcu9t5v0__mux2_1
X$281 \$6157 \$6120 \$1966 \$6136 \$6105 \$6156 gf180mcu_fd_sc_mcu9t5v0__mux2_1
X$282 \$2702 \$2806 \$1966 \$2679 \$2670 \$2701 gf180mcu_fd_sc_mcu9t5v0__mux2_1
X$283 \$8086 \$7968 \$1966 \$8301 \$8183 \$8209 gf180mcu_fd_sc_mcu9t5v0__mux2_1
X$284 \$18858 \$20508 \$2138 \$19927 \$20087 \$20036
+ gf180mcu_fd_sc_mcu9t5v0__oai21_1
X$285 \$2138 \$20209 \$20383 \$20372 gf180mcu_fd_sc_mcu9t5v0__buf_1
X$286 \$2139 \$2247 gf180mcu_fd_sc_mcu9t5v0__filltie
X$287 \$2139 \$2247 gf180mcu_fd_sc_mcu9t5v0__filltie
X$288 \$2139 \$2247 gf180mcu_fd_sc_mcu9t5v0__filltie
X$289 \$2139 \$2247 gf180mcu_fd_sc_mcu9t5v0__filltie
X$290 \$2139 \$2247 gf180mcu_fd_sc_mcu9t5v0__filltie
X$291 \$2139 \$2247 gf180mcu_fd_sc_mcu9t5v0__filltie
X$292 \$2261 \$2378 \$2263 \$2247 \$2139 gf180mcu_fd_sc_mcu9t5v0__dffq_2
X$293 \$2249 \$2250 \$2894 \$2247 \$2139 gf180mcu_fd_sc_mcu9t5v0__dffq_2
X$294 \$2261 \$2154 \$2264 \$2247 \$2139 gf180mcu_fd_sc_mcu9t5v0__dffq_2
X$295 \$2269 \$2276 \$3242 \$2247 \$2139 gf180mcu_fd_sc_mcu9t5v0__dffq_2
X$296 \$2249 \$2143 \$2144 \$2247 \$2139 gf180mcu_fd_sc_mcu9t5v0__dffq_2
X$297 \$2261 \$2262 \$2376 \$2247 \$2139 gf180mcu_fd_sc_mcu9t5v0__dffq_2
X$298 \$2249 \$2146 \$2147 \$2247 \$2139 gf180mcu_fd_sc_mcu9t5v0__dffq_2
X$299 \$2269 \$2270 \$2380 \$2247 \$2139 gf180mcu_fd_sc_mcu9t5v0__dffq_2
X$300 \$2269 \$2157 \$2158 \$2247 \$2139 gf180mcu_fd_sc_mcu9t5v0__dffq_2
X$301 \$2280 \$2384 \$2377 \$2247 \$2139 \$2279 gf180mcu_fd_sc_mcu9t5v0__mux2_1
X$302 \$2248 \$2141 \$2255 \$2247 \$2139 \$2253 gf180mcu_fd_sc_mcu9t5v0__mux2_1
X$303 \$2160 \$2275 \$2268 \$2247 \$2139 \$2274 gf180mcu_fd_sc_mcu9t5v0__mux2_1
X$304 \$2267 \$2266 \$2268 \$2247 \$2139 \$2265 gf180mcu_fd_sc_mcu9t5v0__mux2_1
X$305 \$2374 \$2256 \$2258 \$2247 \$2139 \$2257 gf180mcu_fd_sc_mcu9t5v0__mux2_1
X$306 \$2139 \$I1134 gf180mcu_fd_sc_mcu9t5v0__endcap
X$307 \$2139 \$2247 gf180mcu_fd_sc_mcu9t5v0__endcap
X$308 \$2140 \$2894 \$2367 \$2247 \$2365 \$2250 gf180mcu_fd_sc_mcu9t5v0__mux2_1
X$309 \$5736 \$5840 \$2141 \$5735 \$5833 \$5487 gf180mcu_fd_sc_mcu9t5v0__aoi21_1
X$310 \$2141 \$4043 \$4434 \$4314 \$4146 gf180mcu_fd_sc_mcu9t5v0__nand2_1
X$311 \$2141 \$2248 \$2793 \$2247 \$2365 \$2366 gf180mcu_fd_sc_mcu9t5v0__mux2_2
X$312 \$2248 \$2141 \$3003 \$2891 \$3112 \$2796 gf180mcu_fd_sc_mcu9t5v0__mux2_1
X$313 \$2248 \$2141 \$4142 \$4173 \$4041 \$4177 gf180mcu_fd_sc_mcu9t5v0__mux2_1
X$314 \$14498 \$14340 \$8581 \$14454 \$14635 \$2141
+ gf180mcu_fd_sc_mcu9t5v0__mux2_1
X$315 \$2141 \$4962 \$4991 \$4951 \$5106 \$4996 gf180mcu_fd_sc_mcu9t5v0__mux2_1
X$316 \$6623 \$9608 \$9457 \$2142 gf180mcu_fd_sc_mcu9t5v0__buf_8
X$317 \$2370 \$2369 \$2142 \$2247 \$2365 \$2368 gf180mcu_fd_sc_mcu9t5v0__mux2_1
X$318 \$8302 \$8186 \$2142 \$8301 \$8335 \$8334 gf180mcu_fd_sc_mcu9t5v0__mux2_1
X$319 \$5115 \$5018 \$2142 \$4951 \$5106 \$5019 gf180mcu_fd_sc_mcu9t5v0__mux2_1
X$320 \$7557 \$7908 \$2142 \$7304 \$7417 \$7322 gf180mcu_fd_sc_mcu9t5v0__mux2_1
X$321 \$8853 \$8968 \$2142 \$9337 \$9457 \$9358 gf180mcu_fd_sc_mcu9t5v0__mux2_1
X$322 \$3490 \$3491 \$2142 \$3351 \$3463 \$3495 gf180mcu_fd_sc_mcu9t5v0__mux2_1
X$323 \$9917 \$9795 \$2142 \$11136 \$11182 \$11212
+ gf180mcu_fd_sc_mcu9t5v0__mux2_1
X$324 \$7272 \$7273 \$2142 \$7526 \$7688 \$7686 gf180mcu_fd_sc_mcu9t5v0__mux2_1
X$325 \$9735 \$9736 \$2142 \$10901 \$10782 \$10812
+ gf180mcu_fd_sc_mcu9t5v0__mux2_1
X$326 \$9235 \$9239 \$2142 \$11306 \$11182 \$11332
+ gf180mcu_fd_sc_mcu9t5v0__mux2_1
X$327 \$8697 \$8695 \$2142 \$8572 \$8335 \$8568 gf180mcu_fd_sc_mcu9t5v0__mux2_1
X$328 \$6113 \$6380 \$2142 \$6497 \$6387 \$6365 gf180mcu_fd_sc_mcu9t5v0__mux2_1
X$329 \$6374 \$6375 \$2142 \$6136 \$6105 \$6165 gf180mcu_fd_sc_mcu9t5v0__mux2_1
X$330 \$2144 \$2801 \$3333 \$3220 \$3354 \$3221 \$3238 \$3112 \$3241
+ gf180mcu_fd_sc_mcu9t5v0__mux4_1
X$331 \$3333 \$3220 \$2144 \$2801 \$3468 \$3203 \$3238 \$3338 \$3340
+ gf180mcu_fd_sc_mcu9t5v0__mux4_1
X$332 \$2144 \$2801 \$2906 \$2891 \$3112 \$3009 gf180mcu_fd_sc_mcu9t5v0__mux2_1
X$333 \$2147 \$2672 \$3016 \$3015 \$3354 \$3221 \$3238 \$3112 \$3222
+ gf180mcu_fd_sc_mcu9t5v0__mux4_1
X$334 \$3016 \$3015 \$2147 \$2672 \$3468 \$3203 \$2891 \$3112 \$3012
+ gf180mcu_fd_sc_mcu9t5v0__mux4_1
X$335 \$2147 \$2672 \$2906 \$2679 \$2670 \$2692 gf180mcu_fd_sc_mcu9t5v0__mux2_1
X$336 \$2149 \$2693 \$3363 \$3342 \$3354 \$3221 \$3351 \$3338 \$3362
+ gf180mcu_fd_sc_mcu9t5v0__mux4_1
X$337 \$3363 \$3342 \$2149 \$2693 \$3468 \$3203 \$3351 \$3463 \$3479
+ gf180mcu_fd_sc_mcu9t5v0__mux4_1
X$338 \$2149 \$2693 \$2906 \$2472 \$2670 \$2803 gf180mcu_fd_sc_mcu9t5v0__mux2_1
X$339 \$2150 \$2376 \$2377 \$2247 \$2365 \$2262 gf180mcu_fd_sc_mcu9t5v0__mux2_1
X$340 \$2151 \$2263 \$2367 \$2247 \$2365 \$2378 gf180mcu_fd_sc_mcu9t5v0__mux2_1
X$341 \$2152 \$5736 \$5840 \$8572 \$8335 \$8552 gf180mcu_fd_sc_mcu9t5v0__and3_1
X$342 \$8968 \$13515 \$13892 \$2152 \$13734 \$13897 \$13881 \$13729 \$13858
+ gf180mcu_fd_sc_mcu9t5v0__aoi222_1
X$343 \$2153 \$2152 \$2665 \$2472 \$2670 \$2677 gf180mcu_fd_sc_mcu9t5v0__mux2_2
X$344 \$6641 \$2152 \$6343 \$6770 \$6616 \$6769 gf180mcu_fd_sc_mcu9t5v0__mux2_1
X$345 \$13461 \$14007 \$13226 \$13881 \$13729 \$2152
+ gf180mcu_fd_sc_mcu9t5v0__mux2_1
X$346 \$2152 \$2153 \$2804 \$2679 \$2791 \$2664 gf180mcu_fd_sc_mcu9t5v0__mux2_1
X$347 \$2152 \$2153 \$2255 \$2247 \$2365 \$2155 gf180mcu_fd_sc_mcu9t5v0__mux2_1
X$348 \$2152 \$5201 \$4972 \$5207 \$5106 \$5200 gf180mcu_fd_sc_mcu9t5v0__mux2_1
X$349 \$2152 \$4695 \$4134 \$4702 \$4567 \$4694 gf180mcu_fd_sc_mcu9t5v0__mux2_1
X$350 \$2152 \$2153 \$3599 \$3581 \$3463 \$3598 gf180mcu_fd_sc_mcu9t5v0__mux2_1
X$351 \$4156 \$2153 \$4173 \$4041 \$4182 gf180mcu_fd_sc_mcu9t5v0__nor2_1
X$352 \$4158 \$2153 \$4173 \$4314 \$4159 gf180mcu_fd_sc_mcu9t5v0__nand2_1
X$353 \$7062 \$7047 \$7160 \$2153 gf180mcu_fd_sc_mcu9t5v0__buf_8
X$354 \$2153 \$5253 \$4991 \$5207 \$5240 \$5489 gf180mcu_fd_sc_mcu9t5v0__mux2_1
X$355 \$2158 \$2264 \$3226 \$2663 \$3334 \$3221 \$3238 \$3112 \$3225
+ gf180mcu_fd_sc_mcu9t5v0__mux4_1
X$356 \$3226 \$3343 \$2158 \$2805 \$3468 \$3203 \$3238 \$3338 \$3344
+ gf180mcu_fd_sc_mcu9t5v0__mux4_1
X$357 \$2158 \$2805 \$2906 \$2891 \$2791 \$2905 gf180mcu_fd_sc_mcu9t5v0__mux2_1
X$358 \$4156 \$2160 \$3931 \$4041 \$4045 gf180mcu_fd_sc_mcu9t5v0__nor2_1
X$359 \$4158 \$2160 \$4434 \$4314 \$4225 gf180mcu_fd_sc_mcu9t5v0__nand2_1
X$360 \$2160 \$2275 \$2665 \$2472 \$2670 \$2669 gf180mcu_fd_sc_mcu9t5v0__mux2_2
X$361 \$5370 \$5358 \$5240 \$2160 gf180mcu_fd_sc_mcu9t5v0__buf_8
X$362 \$2275 \$2160 \$3599 \$3581 \$3812 \$3718 gf180mcu_fd_sc_mcu9t5v0__mux2_1
X$363 \$2275 \$2160 \$2804 \$2679 \$2670 \$2700 gf180mcu_fd_sc_mcu9t5v0__mux2_1
X$364 \$2160 \$5259 \$4991 \$5207 \$5240 \$5222 gf180mcu_fd_sc_mcu9t5v0__mux2_1
X$365 \$3377 pad_din_valid_i \$I20747 \$I20765 \$I20756 \$I20774 \$I20783
+ \$I20801 \$I20792 \$I20810 \$I20819 \$I20837 \$I20828 \$I20846 \$I20855
+ \$I20864 \$I20873 \$I20882 \$I20891 \$I20900 \$I20909 \$I20918 \$I20927
+ \$I20936 \$I20945 \$I20954 \$I20963 \$I20981 \$I20972 \$I20990 \$I20999
+ \$I21017 \$I21008 \$I21026 \$I21044 \$I21035 \$I21053 \$I21062 \$I21071
+ \$I21089 \$I21080 \$I21098 \$I21107 \$I21116 \$I21125 \$I21134 \$I21143
+ \$I21161 \$I21152 \$I21170 \$I21179 \$I21197 \$I21188 \$I21206 \$I21215
+ \$I21233 \$I21224 \$I21242 \$I21251 \$I21269 \$I21260 \$I21278 \$I21287
+ \$I21296 \$I21305 \$I21314 \$I21323 \$I21332 \$I21341 \$I21350 \$I21368
+ \$I21377 \$I21404 \$I21413 \$I21359 \$I21395 \$I21386 \$I21431 \$I21422
+ \$I21458 \$I21449 \$I21467 \$I21440 \$I21485 \$I21476 \$I21494 \$I21512
+ \$I21539 \$I21548 \$I21557 \$I21503 \$I21530 \$I21521 \$I21575 \$I21566
+ \$I21584 \$I21593 \$I21602 \$I21611 \$I21620 \$I21629 \$I21638 \$2246
+ \$I21647 \$I21665 \$I21656 \$I21674 \$2246 \$2996 gf180mcu_fd_io__in_c
X$366 \$2373 \$2371 \$2367 \$2247 \$2365 \$2372 gf180mcu_fd_sc_mcu9t5v0__mux2_1
X$367 \$2256 \$2374 \$2268 \$2247 \$2365 \$2373 gf180mcu_fd_sc_mcu9t5v0__mux2_1
X$368 \$2249 \$2251 \$2252 \$2247 \$2365 gf180mcu_fd_sc_mcu9t5v0__dffq_2
X$369 \$2269 \$2271 \$2272 \$2247 \$2365 gf180mcu_fd_sc_mcu9t5v0__dffq_2
X$370 \$2269 \$2379 \$2476 \$2247 \$2365 gf180mcu_fd_sc_mcu9t5v0__dffq_2
X$371 \$2269 \$2382 \$2477 \$2247 \$2365 gf180mcu_fd_sc_mcu9t5v0__dffq_2
X$372 \$2269 \$2277 \$2278 \$2247 \$2365 gf180mcu_fd_sc_mcu9t5v0__dffq_2
X$373 \$2383 \$2279 \$2384 \$2247 \$2365 gf180mcu_fd_sc_mcu9t5v0__dffq_2
X$374 \$2365 \$2247 gf180mcu_fd_sc_mcu9t5v0__filltie
X$375 \$2365 \$2247 gf180mcu_fd_sc_mcu9t5v0__filltie
X$376 \$2365 \$2247 gf180mcu_fd_sc_mcu9t5v0__filltie
X$377 \$2365 \$2247 gf180mcu_fd_sc_mcu9t5v0__filltie
X$378 \$2365 \$2247 gf180mcu_fd_sc_mcu9t5v0__filltie
X$379 \$2365 \$2247 gf180mcu_fd_sc_mcu9t5v0__filltie
X$380 \$2365 \$2247 gf180mcu_fd_sc_mcu9t5v0__endcap
X$381 \$2248 \$6932 \$7576 \$7304 \$7417 \$7282 gf180mcu_fd_sc_mcu9t5v0__nand3_1
X$382 \$2248 \$4173 \$4314 \$4145 gf180mcu_fd_sc_mcu9t5v0__clkinv_1
X$383 \$14216 \$2248 \$14217 \$14151 \$14337 \$14215
+ gf180mcu_fd_sc_mcu9t5v0__mux2_1
X$384 \$6496 \$2248 \$6343 \$6497 \$6387 \$6344 gf180mcu_fd_sc_mcu9t5v0__mux2_1
X$385 \$14208 \$14006 \$13226 \$14151 \$14034 \$2248
+ gf180mcu_fd_sc_mcu9t5v0__mux2_1
X$386 \$2248 \$5599 \$4972 \$5735 \$5473 \$5598 gf180mcu_fd_sc_mcu9t5v0__mux2_1
X$387 \$2248 \$5211 \$4134 \$5207 \$5106 \$5212 gf180mcu_fd_sc_mcu9t5v0__mux2_1
X$388 \$2249 \$2679 \$2791 \$I54761 gf180mcu_fd_sc_mcu9t5v0__clkinv_1
X$389 \$5890 \$2679 \$2791 \$2249 gf180mcu_fd_sc_mcu9t5v0__clkbuf_8
X$390 \$2249 \$4179 \$4209 \$4173 \$4314 gf180mcu_fd_sc_mcu9t5v0__dffq_2
X$391 \$2249 \$2686 \$2800 \$2679 \$2791 gf180mcu_fd_sc_mcu9t5v0__dffq_2
X$392 \$2249 \$2682 \$2683 \$2679 \$2791 gf180mcu_fd_sc_mcu9t5v0__dffq_2
X$393 \$2249 \$3591 \$3333 \$3581 \$3812 gf180mcu_fd_sc_mcu9t5v0__dffq_2
X$394 \$2249 \$3816 \$3016 \$3931 \$3812 gf180mcu_fd_sc_mcu9t5v0__dffq_2
X$395 \$2249 \$5110 \$5109 \$5207 \$5106 gf180mcu_fd_sc_mcu9t5v0__dffq_2
X$396 \$2249 \$2689 \$2801 \$2679 \$2670 gf180mcu_fd_sc_mcu9t5v0__dffq_2
X$397 \$2249 \$2475 \$2656 \$2472 \$2365 gf180mcu_fd_sc_mcu9t5v0__dffq_2
X$398 \$2249 \$2674 \$2693 \$2679 \$2670 gf180mcu_fd_sc_mcu9t5v0__dffq_2
X$399 \$2249 \$2673 \$2672 \$2679 \$2670 gf180mcu_fd_sc_mcu9t5v0__dffq_2
X$400 \$2249 \$2372 \$2371 \$2472 \$2365 gf180mcu_fd_sc_mcu9t5v0__dffq_2
X$401 \$2252 \$2802 \$2898 \$2894 \$5356 \$2891 \$2791 \$2895
+ gf180mcu_fd_sc_mcu9t5v0__aoi221_1
X$402 \$2795 \$3005 \$2252 \$2894 \$3468 \$3203 \$2891 \$3112 \$3004
+ gf180mcu_fd_sc_mcu9t5v0__mux4_1
X$403 \$2252 \$2894 \$2795 \$3005 \$3354 \$3221 \$2891 \$3112 \$3006
+ gf180mcu_fd_sc_mcu9t5v0__mux4_1
X$404 \$4203 \$4212 \$4199 \$2252 \$4434 \$4314 \$4420
+ gf180mcu_fd_sc_mcu9t5v0__aoi22_1
X$405 \$10919 \$5735 \$5833 \$2255 gf180mcu_fd_sc_mcu9t5v0__buf_8
X$406 \$10227 \$7592 \$2255 \$7526 \$7688 \$7701 gf180mcu_fd_sc_mcu9t5v0__mux2_1
X$407 \$8968 \$8853 \$2255 \$8834 \$8963 \$8969 gf180mcu_fd_sc_mcu9t5v0__mux2_1
X$408 \$9775 \$10667 \$2255 \$10630 \$10782 \$10670
+ gf180mcu_fd_sc_mcu9t5v0__mux2_1
X$409 \$5594 \$5256 \$2255 \$6497 \$6387 \$6395 gf180mcu_fd_sc_mcu9t5v0__mux2_1
X$410 \$6132 \$5632 \$2255 \$6136 \$6105 \$6157 gf180mcu_fd_sc_mcu9t5v0__mux2_1
X$411 \$2704 \$2703 \$2255 \$2679 \$2670 \$2702 gf180mcu_fd_sc_mcu9t5v0__mux2_1
X$412 \$6380 \$6113 \$2255 \$7304 \$7160 \$7285 gf180mcu_fd_sc_mcu9t5v0__mux2_1
X$413 \$5736 \$5840 \$2256 \$5735 \$5833 \$5624 gf180mcu_fd_sc_mcu9t5v0__aoi21_1
X$414 \$2256 \$4043 \$4173 \$4314 \$4151 gf180mcu_fd_sc_mcu9t5v0__nand2_1
X$415 \$2256 \$2374 \$2658 \$2472 \$2670 \$2657 gf180mcu_fd_sc_mcu9t5v0__mux2_2
X$416 \$2374 \$2256 \$2804 \$2679 \$2791 \$2661 gf180mcu_fd_sc_mcu9t5v0__mux2_1
X$417 \$2374 \$2256 \$4213 \$4434 \$4314 \$4154 gf180mcu_fd_sc_mcu9t5v0__mux2_1
X$418 \$14209 \$14163 \$8581 \$14151 \$14337 \$2256
+ gf180mcu_fd_sc_mcu9t5v0__mux2_1
X$419 \$2256 \$4999 \$4991 \$5207 \$5240 \$5250 gf180mcu_fd_sc_mcu9t5v0__mux2_1
X$420 \$10919 \$10901 \$10782 \$2258 gf180mcu_fd_sc_mcu9t5v0__buf_8
X$421 \$3491 \$3490 \$2258 \$3351 \$3463 \$3489 gf180mcu_fd_sc_mcu9t5v0__mux2_1
X$422 \$6375 \$6374 \$2258 \$6136 \$6387 \$6373 gf180mcu_fd_sc_mcu9t5v0__mux2_1
X$423 \$9795 \$9917 \$2258 \$10630 \$10782 \$10681
+ gf180mcu_fd_sc_mcu9t5v0__mux2_1
X$424 \$8695 \$8697 \$2258 \$8572 \$8717 \$8698 gf180mcu_fd_sc_mcu9t5v0__mux2_1
X$425 \$9736 \$9735 \$2258 \$9748 \$9900 \$9920 gf180mcu_fd_sc_mcu9t5v0__mux2_1
X$426 \$2369 \$2370 \$2258 \$2679 \$2670 \$2687 gf180mcu_fd_sc_mcu9t5v0__mux2_1
X$427 \$9239 \$9235 \$2258 \$10901 \$10782 \$10809
+ gf180mcu_fd_sc_mcu9t5v0__mux2_1
X$428 \$7908 \$7557 \$2258 \$8063 \$7947 \$8086 gf180mcu_fd_sc_mcu9t5v0__mux2_1
X$429 \$5018 \$5115 \$2258 \$5207 \$5106 \$5381 gf180mcu_fd_sc_mcu9t5v0__mux2_1
X$430 \$5736 \$5840 \$2259 \$5735 \$5833 \$5847 gf180mcu_fd_sc_mcu9t5v0__aoi21_1
X$431 \$2259 \$4158 \$5207 \$5240 \$5252 gf180mcu_fd_sc_mcu9t5v0__nand2_1
X$432 \$2259 \$2260 \$2658 \$2472 \$2365 \$2659 gf180mcu_fd_sc_mcu9t5v0__mux2_2
X$433 \$2260 \$2259 \$2804 \$3238 \$3338 \$3020 gf180mcu_fd_sc_mcu9t5v0__mux2_1
X$434 \$2260 \$2259 \$4213 \$4173 \$4314 \$4424 gf180mcu_fd_sc_mcu9t5v0__mux2_1
X$435 \$13085 \$13095 \$8581 \$13341 \$13083 \$2259
+ gf180mcu_fd_sc_mcu9t5v0__mux2_1
X$436 \$2259 \$5249 \$4991 \$5207 \$5240 \$5248 gf180mcu_fd_sc_mcu9t5v0__mux2_1
X$437 \$2260 \$6932 \$7576 \$7526 \$7688 \$7540 gf180mcu_fd_sc_mcu9t5v0__nand3_1
X$438 \$13849 \$2260 \$13095 \$13887 \$13881 \$13729 \$13850
+ gf180mcu_fd_sc_mcu9t5v0__aoi22_1
X$439 \$2260 \$5358 \$5240 \$6009 gf180mcu_fd_sc_mcu9t5v0__clkinv_1
X$440 \$12658 \$2260 \$6343 \$12486 \$12526 \$12525
+ gf180mcu_fd_sc_mcu9t5v0__mux2_1
X$441 \$14043 \$14219 \$13226 \$14151 \$14034 \$2260
+ gf180mcu_fd_sc_mcu9t5v0__mux2_1
X$442 \$2260 \$4137 \$4134 \$4173 \$4041 \$4174 gf180mcu_fd_sc_mcu9t5v0__mux2_1
X$443 \$2260 \$9568 \$4972 \$9608 \$9457 \$9607 gf180mcu_fd_sc_mcu9t5v0__mux2_1
X$444 \$2261 \$3931 \$3812 gf180mcu_fd_sc_mcu9t5v0__clkinv_3
X$445 \$3925 \$3931 \$3812 \$2261 gf180mcu_fd_sc_mcu9t5v0__clkbuf_8
X$446 \$2261 \$3714 \$3224 \$3581 \$3812 gf180mcu_fd_sc_mcu9t5v0__dffq_2
X$447 \$2261 \$4181 \$3015 \$4173 \$4314 gf180mcu_fd_sc_mcu9t5v0__dffq_2
X$448 \$2261 \$3596 \$3363 \$3581 \$3812 gf180mcu_fd_sc_mcu9t5v0__dffq_2
X$449 \$2261 \$4710 \$4320 \$4702 \$4849 gf180mcu_fd_sc_mcu9t5v0__dffq_2
X$450 \$2261 \$5371 \$5491 \$5358 \$5473 gf180mcu_fd_sc_mcu9t5v0__dffq_2
X$451 \$2261 \$4183 \$3343 \$4173 \$4314 gf180mcu_fd_sc_mcu9t5v0__dffq_2
X$452 \$2261 \$3600 \$3226 \$3581 \$3812 gf180mcu_fd_sc_mcu9t5v0__dffq_2
X$453 \$2261 \$4155 \$3342 \$4173 \$4041 gf180mcu_fd_sc_mcu9t5v0__dffq_2
X$454 \$2261 \$5368 \$4712 \$5358 \$5240 gf180mcu_fd_sc_mcu9t5v0__dffq_2
X$455 \$2261 \$5369 \$5490 \$5358 \$5240 gf180mcu_fd_sc_mcu9t5v0__dffq_2
X$456 \$2261 \$5005 \$5111 \$5207 \$5106 gf180mcu_fd_sc_mcu9t5v0__dffq_2
X$457 \$2261 \$3926 \$3227 \$3931 \$3812 gf180mcu_fd_sc_mcu9t5v0__dffq_2
X$458 \$2261 \$2675 \$2690 \$2679 \$2670 gf180mcu_fd_sc_mcu9t5v0__dffq_2
X$459 \$2261 \$2676 \$2663 \$2679 \$2670 gf180mcu_fd_sc_mcu9t5v0__dffq_2
X$460 \$2261 \$3018 \$3207 \$3238 \$3112 gf180mcu_fd_sc_mcu9t5v0__dffq_2
X$461 \$2805 \$2263 \$3343 \$3224 \$3334 \$3221 \$3238 \$3338 \$3367
+ gf180mcu_fd_sc_mcu9t5v0__mux4_1
X$462 \$2663 \$3224 \$2264 \$2263 \$3468 \$3203 \$3238 \$3112 \$3223
+ gf180mcu_fd_sc_mcu9t5v0__mux4_1
X$463 \$2264 \$2802 \$2898 \$2263 \$5356 \$2891 \$2791 \$2904
+ gf180mcu_fd_sc_mcu9t5v0__aoi221_1
X$464 \$4214 \$4212 \$4199 \$2264 \$4173 \$4314 \$4215
+ gf180mcu_fd_sc_mcu9t5v0__aoi22_1
X$465 \$2265 \$2476 \$2377 \$2472 \$2365 \$2379 gf180mcu_fd_sc_mcu9t5v0__mux2_1
X$466 \$2266 \$5736 \$6928 \$8572 \$8335 \$8560 gf180mcu_fd_sc_mcu9t5v0__and3_1
X$467 \$13892 \$8186 \$2266 \$13515 \$13623 \$13729 \$13732
+ gf180mcu_fd_sc_mcu9t5v0__aoi22_1
X$468 \$2267 \$2266 \$2665 \$2679 \$2791 \$2696 gf180mcu_fd_sc_mcu9t5v0__mux2_2
X$469 \$6885 \$2266 \$6343 \$6770 \$6890 \$6884 gf180mcu_fd_sc_mcu9t5v0__mux2_1
X$470 \$13345 \$13460 \$13226 \$13341 \$13452 \$2266
+ gf180mcu_fd_sc_mcu9t5v0__mux2_1
X$471 \$2266 \$2267 \$2804 \$2679 \$2791 \$2667 gf180mcu_fd_sc_mcu9t5v0__mux2_1
X$472 \$2266 \$4670 \$4134 \$4434 \$4567 \$4562 gf180mcu_fd_sc_mcu9t5v0__mux2_1
X$473 \$2266 \$2267 \$3599 \$3581 \$3812 \$3819 gf180mcu_fd_sc_mcu9t5v0__mux2_1
X$474 \$2266 \$5204 \$4972 \$5207 \$5106 \$5203 gf180mcu_fd_sc_mcu9t5v0__mux2_1
X$475 \$4156 \$2267 \$4173 \$4041 \$4031 gf180mcu_fd_sc_mcu9t5v0__nor2_1
X$476 \$4158 \$2267 \$4173 \$4314 \$4322 gf180mcu_fd_sc_mcu9t5v0__nand2_1
X$477 \$7585 \$7526 \$7688 \$2267 gf180mcu_fd_sc_mcu9t5v0__buf_8
X$478 \$2267 \$5007 \$4991 \$4951 \$5106 \$5008 gf180mcu_fd_sc_mcu9t5v0__mux2_1
X$479 \$6623 \$6497 \$6616 \$2268 gf180mcu_fd_sc_mcu9t5v0__buf_8
X$480 \$4315 \$4191 \$2268 \$4173 \$4314 \$4139 gf180mcu_fd_sc_mcu9t5v0__mux2_1
X$481 \$10240 \$10241 \$2268 \$11136 \$11182 \$11181
+ gf180mcu_fd_sc_mcu9t5v0__mux2_1
X$482 \$5360 \$5244 \$2268 \$5735 \$5833 \$5602 gf180mcu_fd_sc_mcu9t5v0__mux2_1
X$483 \$7592 \$10227 \$2268 \$7797 \$7947 \$7941 gf180mcu_fd_sc_mcu9t5v0__mux2_1
X$484 \$10667 \$9775 \$2268 \$10630 \$10782 \$10668
+ gf180mcu_fd_sc_mcu9t5v0__mux2_1
X$485 \$3328 \$3329 \$2268 \$3351 \$3463 \$3466 gf180mcu_fd_sc_mcu9t5v0__mux2_1
X$486 \$2703 \$2704 \$2268 \$2472 \$2365 \$2280 gf180mcu_fd_sc_mcu9t5v0__mux2_1
X$487 \$5632 \$6132 \$2268 \$5735 \$5473 \$5631 gf180mcu_fd_sc_mcu9t5v0__mux2_1
X$488 \$5256 \$5594 \$2268 \$6001 \$5833 \$6010 gf180mcu_fd_sc_mcu9t5v0__mux2_1
X$489 \$9905 \$10027 \$2268 \$10022 \$9900 \$10026
+ gf180mcu_fd_sc_mcu9t5v0__mux2_1
X$490 \$9343 \$8961 \$2268 \$9337 \$9221 \$9104 gf180mcu_fd_sc_mcu9t5v0__mux2_1
X$491 \$6346 \$6347 \$2268 \$6770 \$6616 \$6647 gf180mcu_fd_sc_mcu9t5v0__mux2_1
X$492 \$10233 \$10902 \$2268 \$11136 \$11025 \$11138
+ gf180mcu_fd_sc_mcu9t5v0__mux2_1
X$493 \$2269 \$2891 \$2791 gf180mcu_fd_sc_mcu9t5v0__clkinv_3
X$494 \$3925 \$2891 \$2791 \$2269 gf180mcu_fd_sc_mcu9t5v0__clkbuf_8
X$495 \$2269 \$2701 \$2806 \$2679 \$2791 gf180mcu_fd_sc_mcu9t5v0__dffq_2
X$496 \$2269 \$2698 \$2699 \$2679 \$2791 gf180mcu_fd_sc_mcu9t5v0__dffq_2
X$497 \$2269 \$2668 \$2695 \$2472 \$2670 gf180mcu_fd_sc_mcu9t5v0__dffq_2
X$498 \$2269 \$3608 \$3485 \$3581 \$3812 gf180mcu_fd_sc_mcu9t5v0__dffq_2
X$499 \$2269 \$3604 \$3602 \$3581 \$3812 gf180mcu_fd_sc_mcu9t5v0__dffq_2
X$500 \$2269 \$3927 \$3231 \$3931 \$3812 gf180mcu_fd_sc_mcu9t5v0__dffq_2
X$501 \$2269 \$2478 \$2479 \$2679 \$2670 gf180mcu_fd_sc_mcu9t5v0__dffq_2
X$502 \$2269 \$5224 \$5013 \$5207 \$5106 gf180mcu_fd_sc_mcu9t5v0__dffq_2
X$503 \$2269 \$3820 \$3349 \$3931 \$3812 gf180mcu_fd_sc_mcu9t5v0__dffq_2
X$504 \$2269 \$2678 \$2666 \$2679 \$2670 gf180mcu_fd_sc_mcu9t5v0__dffq_2
X$505 \$2269 \$2694 \$2805 \$2679 \$2670 gf180mcu_fd_sc_mcu9t5v0__dffq_2
X$506 \$2272 \$2695 \$3602 \$3335 \$3229 \$3230 \$3238 \$3338 \$3346
+ gf180mcu_fd_sc_mcu9t5v0__mux4_1
X$507 \$3602 \$3335 \$2272 \$2695 \$3468 \$3203 \$3238 \$3338 \$3347
+ gf180mcu_fd_sc_mcu9t5v0__mux4_1
X$508 \$2272 \$2695 \$2906 \$2891 \$2791 \$2907 gf180mcu_fd_sc_mcu9t5v0__mux2_1
X$509 \$2274 \$2477 \$2377 \$2472 \$2365 \$2382 gf180mcu_fd_sc_mcu9t5v0__mux2_1
X$510 \$2275 \$5736 \$6928 \$8063 \$8183 \$8197 gf180mcu_fd_sc_mcu9t5v0__and3_1
X$511 \$14521 \$2275 \$13881 \$13729 \$13886 gf180mcu_fd_sc_mcu9t5v0__nor2_1
X$512 \$7906 \$2275 \$6343 \$7797 \$7688 \$7793 gf180mcu_fd_sc_mcu9t5v0__mux2_1
X$513 \$13349 \$13345 \$13226 \$13341 \$13452 \$2275
+ gf180mcu_fd_sc_mcu9t5v0__mux2_1
X$514 \$2275 \$7410 \$4972 \$7304 \$7417 \$7409 gf180mcu_fd_sc_mcu9t5v0__mux2_1
X$515 \$2275 \$6341 \$4134 \$6136 \$6105 \$6340 gf180mcu_fd_sc_mcu9t5v0__mux2_1
X$516 \$2278 \$2479 \$3485 \$3236 \$3229 \$3230 \$3238 \$3112 \$3336
+ gf180mcu_fd_sc_mcu9t5v0__mux4_1
X$517 \$3485 \$3236 \$2278 \$2479 \$3468 \$3203 \$3238 \$3338 \$3487
+ gf180mcu_fd_sc_mcu9t5v0__mux4_1
X$518 \$2278 \$2479 \$2906 \$2891 \$2791 \$2909 gf180mcu_fd_sc_mcu9t5v0__mux2_1
X$519 \$2669 \$2479 \$2480 \$2472 \$2365 \$2478 gf180mcu_fd_sc_mcu9t5v0__mux2_2
X$520 \$2481 \$2483 \$2480 \$2472 \$2365 \$2482 gf180mcu_fd_sc_mcu9t5v0__mux2_2
X$521 \$2365 \$2472 gf180mcu_fd_sc_mcu9t5v0__filltie
X$522 \$2365 \$2472 gf180mcu_fd_sc_mcu9t5v0__filltie
X$523 \$2365 \$2472 gf180mcu_fd_sc_mcu9t5v0__filltie
X$524 \$2365 \$2472 gf180mcu_fd_sc_mcu9t5v0__filltie
X$525 \$2365 \$2472 gf180mcu_fd_sc_mcu9t5v0__filltie
X$526 \$2365 \$2472 gf180mcu_fd_sc_mcu9t5v0__filltie
X$527 \$2792 \$2473 \$2474 \$2472 \$2365 gf180mcu_fd_sc_mcu9t5v0__dffq_2
X$528 \$2365 \$2472 gf180mcu_fd_sc_mcu9t5v0__endcap
X$529 \$2366 \$2474 \$2480 \$2472 \$2670 \$2473 gf180mcu_fd_sc_mcu9t5v0__mux2_2
X$530 \$5904 \$10391 \$10514 \$2367 gf180mcu_fd_sc_mcu9t5v0__buf_8
X$531 \$6365 \$6364 \$2367 \$6136 \$6387 \$6393 gf180mcu_fd_sc_mcu9t5v0__mux2_1
X$532 \$7322 \$7969 \$2367 \$7526 \$7688 \$7436 gf180mcu_fd_sc_mcu9t5v0__mux2_1
X$533 \$2368 \$2656 \$2367 \$2472 \$2670 \$2475 gf180mcu_fd_sc_mcu9t5v0__mux2_1
X$534 \$11212 \$11541 \$2367 \$11306 \$11555 \$11331
+ gf180mcu_fd_sc_mcu9t5v0__mux2_1
X$535 \$10812 \$9924 \$2367 \$10901 \$10782 \$10932
+ gf180mcu_fd_sc_mcu9t5v0__mux2_1
X$536 \$8568 \$8863 \$2367 \$8572 \$8335 \$8586 gf180mcu_fd_sc_mcu9t5v0__mux2_1
X$537 \$6165 \$6680 \$2367 \$6497 \$6387 \$6378 gf180mcu_fd_sc_mcu9t5v0__mux2_1
X$538 \$9358 \$9460 \$2367 \$9337 \$9221 \$9357 gf180mcu_fd_sc_mcu9t5v0__mux2_1
X$539 \$2369 \$6932 \$7576 \$7797 \$7688 \$7538 gf180mcu_fd_sc_mcu9t5v0__nand3_1
X$540 \$13849 \$2369 \$6347 \$13892 \$14151 \$14337 \$14206
+ gf180mcu_fd_sc_mcu9t5v0__aoi22_1
X$541 \$2369 \$6770 \$6616 \$4738 gf180mcu_fd_sc_mcu9t5v0__clkinv_1
X$542 \$2370 \$2369 \$2658 \$2472 \$2670 \$2671 gf180mcu_fd_sc_mcu9t5v0__mux2_2
X$543 \$6888 \$2369 \$6343 \$7047 \$6890 \$6920 gf180mcu_fd_sc_mcu9t5v0__mux2_1
X$544 \$14219 \$14208 \$13226 \$14151 \$14337 \$2369
+ gf180mcu_fd_sc_mcu9t5v0__mux2_1
X$545 \$2369 \$2370 \$4142 \$3931 \$4041 \$4044 gf180mcu_fd_sc_mcu9t5v0__mux2_1
X$546 \$2369 \$2370 \$3003 \$2891 \$2791 \$2685 gf180mcu_fd_sc_mcu9t5v0__mux2_1
X$547 \$2369 \$5205 \$4972 \$5207 \$5106 \$5237 gf180mcu_fd_sc_mcu9t5v0__mux2_1
X$548 \$2369 \$4135 \$4134 \$4173 \$4041 \$4171 gf180mcu_fd_sc_mcu9t5v0__mux2_1
X$549 \$5736 \$5840 \$2370 \$6001 \$5833 \$5620 gf180mcu_fd_sc_mcu9t5v0__aoi21_1
X$550 \$2370 \$4043 \$4951 \$4849 \$4740 gf180mcu_fd_sc_mcu9t5v0__nand2_1
X$551 \$14341 \$14042 \$8581 \$14454 \$14337 \$2370
+ gf180mcu_fd_sc_mcu9t5v0__mux2_1
X$552 \$2370 \$5218 \$4991 \$5207 \$5106 \$5219 gf180mcu_fd_sc_mcu9t5v0__mux2_1
X$553 \$2899 \$2371 \$2690 \$3013 \$3354 \$3221 \$3238 \$3338 \$3341
+ gf180mcu_fd_sc_mcu9t5v0__mux4_1
X$554 \$2690 \$3013 \$2899 \$2371 \$3468 \$3203 \$3351 \$3338 \$3593
+ gf180mcu_fd_sc_mcu9t5v0__mux4_1
X$555 \$2899 \$2802 \$2898 \$2371 \$5356 \$2891 \$2791 \$2900
+ gf180mcu_fd_sc_mcu9t5v0__aoi221_1
X$556 \$2374 \$6932 \$7576 \$7304 \$7417 \$7057 gf180mcu_fd_sc_mcu9t5v0__nand3_1
X$557 \$13849 \$2374 \$13892 \$10241 \$13881 \$13729 \$13854
+ gf180mcu_fd_sc_mcu9t5v0__aoi22_1
X$558 \$2374 \$4173 \$4314 \$4208 gf180mcu_fd_sc_mcu9t5v0__clkinv_1
X$559 \$6384 \$2374 \$6343 \$6136 \$6387 \$6383 gf180mcu_fd_sc_mcu9t5v0__mux2_1
X$560 \$13867 \$14043 \$13226 \$13881 \$14034 \$2374
+ gf180mcu_fd_sc_mcu9t5v0__mux2_1
X$561 \$2374 \$5831 \$4972 \$5735 \$5473 \$5597 gf180mcu_fd_sc_mcu9t5v0__mux2_1
X$562 \$2374 \$4136 \$4134 \$4173 \$4041 \$4172 gf180mcu_fd_sc_mcu9t5v0__mux2_1
X$563 \$2376 \$2898 \$2891 \$3112 \$3017 gf180mcu_fd_sc_mcu9t5v0__nand2_1
X$564 \$5904 \$6001 \$5833 \$2377 gf180mcu_fd_sc_mcu9t5v0__buf_8
X$565 \$3495 \$3929 \$2377 \$3581 \$3812 \$3616 gf180mcu_fd_sc_mcu9t5v0__mux2_1
X$566 \$5019 \$5504 \$2377 \$5207 \$5240 \$5236 gf180mcu_fd_sc_mcu9t5v0__mux2_1
X$567 \$11332 \$11214 \$2377 \$11136 \$11182 \$11213
+ gf180mcu_fd_sc_mcu9t5v0__mux2_1
X$568 \$7941 \$8323 \$2377 \$8063 \$8183 \$7967 gf180mcu_fd_sc_mcu9t5v0__mux2_1
X$569 \$10668 \$11192 \$2377 \$10630 \$10782 \$10795
+ gf180mcu_fd_sc_mcu9t5v0__mux2_1
X$570 \$6010 \$6012 \$2377 \$6136 \$6105 \$6114 gf180mcu_fd_sc_mcu9t5v0__mux2_1
X$571 \$5631 \$5910 \$2377 \$6001 \$5833 \$5861 gf180mcu_fd_sc_mcu9t5v0__mux2_1
X$572 \$2380 \$2476 \$2666 \$3227 \$3229 \$3230 \$3238 \$3112 \$3372
+ gf180mcu_fd_sc_mcu9t5v0__mux4_1
X$573 \$2666 \$3227 \$2380 \$2476 \$3468 \$3203 \$3238 \$3338 \$3345
+ gf180mcu_fd_sc_mcu9t5v0__mux4_1
X$574 \$4217 \$4212 \$4199 \$2380 \$4173 \$4314 \$4552
+ gf180mcu_fd_sc_mcu9t5v0__aoi22_1
X$575 \$2380 \$2802 \$3351 \$3338 \$3369 gf180mcu_fd_sc_mcu9t5v0__nand2_1
X$576 \$2383 \$3931 \$4041 \$I68973 gf180mcu_fd_sc_mcu9t5v0__inv_1
X$577 \$4038 \$3931 \$4041 \$2383 gf180mcu_fd_sc_mcu9t5v0__clkbuf_8
X$578 \$2383 \$5017 \$5234 \$4951 \$5106 gf180mcu_fd_sc_mcu9t5v0__dffq_2
X$579 \$2383 \$4443 \$4693 \$4434 \$4567 gf180mcu_fd_sc_mcu9t5v0__dffq_2
X$580 \$2383 \$2705 \$3211 \$2679 \$2791 gf180mcu_fd_sc_mcu9t5v0__dffq_2
X$581 \$2383 \$2910 \$3376 \$2891 \$3112 gf180mcu_fd_sc_mcu9t5v0__dffq_2
X$582 \$2383 \$2482 \$2483 \$2472 \$2670 gf180mcu_fd_sc_mcu9t5v0__dffq_2
X$583 \$2383 \$3493 \$3494 \$3351 \$3463 gf180mcu_fd_sc_mcu9t5v0__dffq_2
X$584 \$2383 \$4717 \$4691 \$4702 \$4849 gf180mcu_fd_sc_mcu9t5v0__dffq_2
X$585 \$2383 \$5263 \$5382 \$5207 \$5240 gf180mcu_fd_sc_mcu9t5v0__dffq_2
X$586 \$2383 \$4163 \$4047 \$4173 \$4041 gf180mcu_fd_sc_mcu9t5v0__dffq_2
X$587 \$2383 \$4442 \$4583 \$4702 \$4567 gf180mcu_fd_sc_mcu9t5v0__dffq_2
X$588 \$2383 \$4049 \$4719 \$4173 \$4041 gf180mcu_fd_sc_mcu9t5v0__dffq_2
X$589 \$2383 \$4585 \$4689 \$4702 \$4567 gf180mcu_fd_sc_mcu9t5v0__dffq_2
X$590 \$2383 \$3613 \$3726 \$3581 \$3463 gf180mcu_fd_sc_mcu9t5v0__dffq_2
X$591 \$2383 \$3937 \$3724 \$3931 \$3812 gf180mcu_fd_sc_mcu9t5v0__dffq_2
X$592 \$2383 \$4161 \$3236 \$4173 \$4041 gf180mcu_fd_sc_mcu9t5v0__dffq_2
X$593 \$2383 \$4581 \$4160 \$4702 \$4567 gf180mcu_fd_sc_mcu9t5v0__dffq_2
X$594 \$2383 \$5236 \$5504 \$5207 \$5106 gf180mcu_fd_sc_mcu9t5v0__dffq_2
X$595 \$2383 \$3616 \$3929 \$3581 \$3463 gf180mcu_fd_sc_mcu9t5v0__dffq_2
X$596 \$2806 \$2384 \$3211 \$3349 \$3229 \$3230 \$3238 \$3338 \$3350
+ gf180mcu_fd_sc_mcu9t5v0__mux4_1
X$597 \$3211 \$3349 \$2806 \$2384 \$3468 \$3203 \$3238 \$3112 \$3237
+ gf180mcu_fd_sc_mcu9t5v0__mux4_1
X$598 \$2384 \$2898 \$3026 \$3025 \$5356 \$2891 \$3112 \$3722
+ gf180mcu_fd_sc_mcu9t5v0__aoi221_1
X$599 \$3378 pad_dout[0] \$I20746 \$I20755 \$I20764 \$I20773 \$I20782 \$I20791
+ \$I20800 \$I20809 \$I20818 \$I20827 \$I20836 \$I20845 \$I20854 \$I20863
+ \$I20872 \$I20881 \$I20890 \$I20899 \$I20908 \$I20917 \$I20926 \$I20935
+ \$I20944 \$I20953 \$I20962 \$I20971 \$I20980 \$I20989 \$I20998 \$I21007
+ \$I21016 \$I21025 \$I21034 \$I21043 \$I21052 \$I21061 \$I21070 \$I21079
+ \$I21088 \$I21097 \$I21106 \$I21115 \$I21124 \$I21133 \$I21142 \$I21151
+ \$I21160 \$I21169 \$I21178 \$I21187 \$I21196 \$I21205 \$I21214 \$I21223
+ \$I21232 \$I21241 \$I21250 \$I21259 \$I21268 \$I21277 \$I21286 \$I21295
+ \$I21304 \$I21313 \$2386 \$I21322 \$I21331 \$I21340 \$I21349 \$I21358
+ \$I21367 \$I21376 \$I21385 \$I21394 \$I21403 \$I21412 \$I21421 \$I21430
+ \$I21439 \$I21448 \$I21457 \$I21466 \$I21475 \$I21484 \$I21493 \$I21502
+ \$I21511 \$I21520 \$I21529 \$I21538 \$I21547 \$I21556 \$I21565 \$I21574
+ \$I21583 \$I21592 \$I21601 \$2385 \$I21610 \$I21619 \$I21628 \$I21637
+ \$I21646 \$I21655 \$I21664 \$I21673 \$2385 \$2385 \$2386 \$2385 \$2385 \$3909
+ \$2386 gf180mcu_fd_io__bi_t
X$600 \$3931 \$3812 \$2385 gf180mcu_fd_sc_mcu9t5v0__tiel
X$601 \$3931 \$3812 \$2386 gf180mcu_fd_sc_mcu9t5v0__tieh
X$602 \$2657 \$2672 \$2480 \$2472 \$2670 \$2673 gf180mcu_fd_sc_mcu9t5v0__mux2_2
X$603 \$2667 \$2666 \$2662 \$2472 \$2670 \$2678 gf180mcu_fd_sc_mcu9t5v0__mux2_2
X$604 \$2664 \$2663 \$2662 \$2472 \$2670 \$2676 gf180mcu_fd_sc_mcu9t5v0__mux2_2
X$605 \$2661 \$2690 \$2662 \$2472 \$2670 \$2675 gf180mcu_fd_sc_mcu9t5v0__mux2_2
X$606 \$2659 \$2693 \$2480 \$2472 \$2670 \$2674 gf180mcu_fd_sc_mcu9t5v0__mux2_2
X$607 \$2670 \$2472 gf180mcu_fd_sc_mcu9t5v0__filltie
X$608 \$2670 \$2472 gf180mcu_fd_sc_mcu9t5v0__filltie
X$609 \$2670 \$2472 gf180mcu_fd_sc_mcu9t5v0__filltie
X$610 \$2670 \$2472 gf180mcu_fd_sc_mcu9t5v0__filltie
X$611 \$2670 \$2472 gf180mcu_fd_sc_mcu9t5v0__filltie
X$612 \$2670 \$2472 gf180mcu_fd_sc_mcu9t5v0__filltie
X$613 \$2670 \$2472 gf180mcu_fd_sc_mcu9t5v0__endcap
X$614 \$2799 \$2474 \$3359 \$3358 \$3354 \$3221 \$3351 \$3338 \$3331
+ gf180mcu_fd_sc_mcu9t5v0__mux4_1
X$615 \$3359 \$3358 \$2799 \$2474 \$3468 \$3203 \$3351 \$3463 \$3470
+ gf180mcu_fd_sc_mcu9t5v0__mux4_1
X$616 \$2799 \$2474 \$2906 \$2679 \$2791 \$2797 gf180mcu_fd_sc_mcu9t5v0__mux2_1
X$617 \$2476 \$2898 \$2907 \$3000 \$5356 \$2891 \$2791 \$2908
+ gf180mcu_fd_sc_mcu9t5v0__aoi221_1
X$618 \$3242 \$2477 \$2699 \$3231 \$3229 \$3230 \$3238 \$3112 \$3232
+ gf180mcu_fd_sc_mcu9t5v0__mux4_1
X$619 \$2699 \$3231 \$3242 \$2477 \$3468 \$3203 \$3238 \$3338 \$3374
+ gf180mcu_fd_sc_mcu9t5v0__mux4_1
X$620 \$2477 \$2898 \$2891 \$3112 \$3024 gf180mcu_fd_sc_mcu9t5v0__nand2_1
X$621 \$10636 \$10630 \$10782 \$2480 gf180mcu_fd_sc_mcu9t5v0__buf_12
X$622 \$2677 \$2805 \$2480 \$2679 \$2791 \$2694 gf180mcu_fd_sc_mcu9t5v0__mux2_2
X$623 \$3813 \$3911 \$2480 \$3931 \$4041 \$3910 gf180mcu_fd_sc_mcu9t5v0__mux2_2
X$624 \$2671 \$2801 \$2480 \$2679 \$2791 \$2689 gf180mcu_fd_sc_mcu9t5v0__mux2_2
X$625 \$6124 \$6371 \$2480 \$6136 \$6387 \$6159 gf180mcu_fd_sc_mcu9t5v0__mux2_2
X$626 \$5255 \$5490 \$2480 \$5358 \$5473 \$5369 gf180mcu_fd_sc_mcu9t5v0__mux2_2
X$627 \$8185 \$8187 \$2480 \$8301 \$8335 \$8184 gf180mcu_fd_sc_mcu9t5v0__mux2_2
X$628 \$10798 \$10799 \$2480 \$10901 \$11025 \$10797
+ gf180mcu_fd_sc_mcu9t5v0__mux2_2
X$629 \$5243 \$5242 \$2480 \$5207 \$5240 \$5241 gf180mcu_fd_sc_mcu9t5v0__mux2_2
X$630 \$10252 \$9781 \$2480 \$10391 \$10514 \$10292
+ gf180mcu_fd_sc_mcu9t5v0__mux2_2
X$631 \$6349 \$6348 \$2480 \$6136 \$6387 \$6386 gf180mcu_fd_sc_mcu9t5v0__mux2_2
X$632 \$8741 \$8739 \$2480 \$8834 \$8717 \$8740 gf180mcu_fd_sc_mcu9t5v0__mux2_2
X$633 \$10813 \$10934 \$2480 \$10901 \$10782 \$10933
+ gf180mcu_fd_sc_mcu9t5v0__mux2_2
X$634 \$7559 \$7818 \$2480 \$7526 \$7417 \$7558 gf180mcu_fd_sc_mcu9t5v0__mux2_2
X$635 \$10811 \$10931 \$2480 \$10901 \$10782 \$10930
+ gf180mcu_fd_sc_mcu9t5v0__mux2_2
X$636 \$2696 \$2695 \$2480 \$2679 \$2670 \$2668 gf180mcu_fd_sc_mcu9t5v0__mux2_2
X$637 \$6152 \$6394 \$2480 \$6497 \$6387 \$6367 gf180mcu_fd_sc_mcu9t5v0__mux2_2
X$638 \$8582 \$8692 \$2480 \$8834 \$8717 \$8732 gf180mcu_fd_sc_mcu9t5v0__mux2_2
X$639 \$4430 \$4693 \$2480 \$4434 \$4314 \$4443 gf180mcu_fd_sc_mcu9t5v0__mux2_2
X$640 \$2681 \$2893 \$2480 \$2679 \$2670 \$2680 gf180mcu_fd_sc_mcu9t5v0__mux2_2
X$641 \$9615 \$9802 \$2480 \$9748 \$9703 \$9738 gf180mcu_fd_sc_mcu9t5v0__mux2_1
X$642 \$6921 \$7159 \$2480 \$7047 \$6890 \$7048 gf180mcu_fd_sc_mcu9t5v0__mux2_1
X$643 \$6167 \$6379 \$2480 \$6136 \$6105 \$6166 gf180mcu_fd_sc_mcu9t5v0__mux2_1
X$644 \$5385 \$5266 \$2480 \$5358 \$5240 \$5265 gf180mcu_fd_sc_mcu9t5v0__mux2_1
X$645 \$2703 \$2704 \$2658 \$2679 \$2670 \$2481 gf180mcu_fd_sc_mcu9t5v0__mux2_2
X$646 \$3376 \$2483 \$3724 \$4047 \$3229 \$3230 \$3351 \$3338 \$3375
+ gf180mcu_fd_sc_mcu9t5v0__mux4_1
X$647 \$3724 \$4047 \$3376 \$2483 \$3468 \$3203 \$3351 \$3463 \$3488
+ gf180mcu_fd_sc_mcu9t5v0__mux4_1
X$648 \$3376 \$2483 \$2906 \$3238 \$3112 \$3026 gf180mcu_fd_sc_mcu9t5v0__mux2_1
X$649 \$2996 \$2891 \$3112 \$2654 gf180mcu_fd_sc_mcu9t5v0__dlyc_1
X$650 \$2800 \$2656 \$2683 \$3216 \$3354 \$3221 \$3351 \$3338 \$3474
+ gf180mcu_fd_sc_mcu9t5v0__mux4_1
X$651 \$2683 \$3216 \$2800 \$2656 \$3468 \$3203 \$3581 \$3463 \$3590
+ gf180mcu_fd_sc_mcu9t5v0__mux4_1
X$652 \$2800 \$2802 \$2898 \$2656 \$5356 \$2891 \$3112 \$3217
+ gf180mcu_fd_sc_mcu9t5v0__aoi221_1
X$653 \$6110 \$6001 \$6105 \$2658 gf180mcu_fd_sc_mcu9t5v0__clkbuf_20
X$654 \$5256 \$5594 \$2658 \$5207 \$5240 \$5255 gf180mcu_fd_sc_mcu9t5v0__mux2_2
X$655 \$9905 \$10027 \$2658 \$10630 \$10782 \$10784
+ gf180mcu_fd_sc_mcu9t5v0__mux2_2
X$656 \$8302 \$8186 \$2658 \$8063 \$8183 \$8185 gf180mcu_fd_sc_mcu9t5v0__mux2_2
X$657 \$9343 \$8961 \$2658 \$10391 \$10282 \$10394
+ gf180mcu_fd_sc_mcu9t5v0__mux2_2
X$658 \$10041 \$10022 \$9900 \$2662 gf180mcu_fd_sc_mcu9t5v0__buf_20
X$659 \$2796 \$2795 \$2662 \$2679 \$2791 \$2794 gf180mcu_fd_sc_mcu9t5v0__mux2_2
X$660 \$3327 \$2998 \$2662 \$2891 \$3112 \$2997 gf180mcu_fd_sc_mcu9t5v0__mux2_2
X$661 \$3020 \$3207 \$2662 \$2891 \$3112 \$3018 gf180mcu_fd_sc_mcu9t5v0__mux2_2
X$662 \$4533 \$4531 \$2662 \$4434 \$4567 \$4568 gf180mcu_fd_sc_mcu9t5v0__mux2_2
X$663 \$5502 \$5862 \$2662 \$5358 \$5473 \$5501 gf180mcu_fd_sc_mcu9t5v0__mux2_2
X$664 \$10244 \$10030 \$2662 \$10022 \$10282 \$10033
+ gf180mcu_fd_sc_mcu9t5v0__mux2_2
X$665 \$10277 \$10275 \$2662 \$10022 \$10282 \$10274
+ gf180mcu_fd_sc_mcu9t5v0__mux2_2
X$666 \$7321 \$7435 \$2662 \$7304 \$7417 \$7434 gf180mcu_fd_sc_mcu9t5v0__mux2_2
X$667 \$5850 \$5892 \$2662 \$5735 \$5833 \$5849 gf180mcu_fd_sc_mcu9t5v0__mux2_2
X$668 \$8357 \$8201 \$2662 \$8063 \$8183 \$8204 gf180mcu_fd_sc_mcu9t5v0__mux2_2
X$669 \$10272 \$10270 \$2662 \$10022 \$10282 \$10271
+ gf180mcu_fd_sc_mcu9t5v0__mux2_2
X$670 \$10239 \$10238 \$2662 \$10022 \$10282 \$10237
+ gf180mcu_fd_sc_mcu9t5v0__mux2_2
X$671 \$4985 \$4984 \$2662 \$4951 \$5106 \$4983 gf180mcu_fd_sc_mcu9t5v0__mux2_2
X$672 \$9603 \$9602 \$2662 \$9608 \$9457 \$9614 gf180mcu_fd_sc_mcu9t5v0__mux2_2
X$673 \$7687 \$7799 \$2662 \$7797 \$7688 \$7798 gf180mcu_fd_sc_mcu9t5v0__mux2_2
X$674 \$2706 \$3211 \$2662 \$2679 \$2670 \$2705 gf180mcu_fd_sc_mcu9t5v0__mux2_2
X$675 \$2700 \$2699 \$2662 \$2679 \$2670 \$2698 gf180mcu_fd_sc_mcu9t5v0__mux2_2
X$676 \$10232 \$10393 \$2662 \$10391 \$10282 \$10392
+ gf180mcu_fd_sc_mcu9t5v0__mux2_2
X$677 \$8714 \$8836 \$2662 \$8834 \$8717 \$8962 gf180mcu_fd_sc_mcu9t5v0__mux2_2
X$678 \$6138 \$6345 \$2662 \$6136 \$6105 \$6137 gf180mcu_fd_sc_mcu9t5v0__mux2_2
X$679 \$3615 \$3494 \$2662 \$3581 \$3463 \$3493 gf180mcu_fd_sc_mcu9t5v0__mux2_2
X$680 \$5372 \$5491 \$2662 \$5358 \$5240 \$5371 gf180mcu_fd_sc_mcu9t5v0__mux2_2
X$681 \$6164 \$6377 \$2662 \$6136 \$6105 \$6163 gf180mcu_fd_sc_mcu9t5v0__mux2_2
X$682 \$9569 \$9103 \$2662 \$9608 \$9457 \$9610 gf180mcu_fd_sc_mcu9t5v0__mux2_2
X$683 \$5235 \$5234 \$2662 \$5207 \$5106 \$5017 gf180mcu_fd_sc_mcu9t5v0__mux2_2
X$684 \$8566 \$8702 \$2662 \$8572 \$8335 \$8585 gf180mcu_fd_sc_mcu9t5v0__mux2_2
X$685 \$2685 \$2683 \$2662 \$2679 \$2670 \$2682 gf180mcu_fd_sc_mcu9t5v0__mux2_2
X$686 \$10250 \$10249 \$2662 \$10022 \$10282 \$10248
+ gf180mcu_fd_sc_mcu9t5v0__mux2_1
X$687 \$8967 \$9116 \$2662 \$9102 \$9221 \$9115 gf180mcu_fd_sc_mcu9t5v0__mux2_1
X$688 \$2663 \$2802 \$2898 \$3224 \$3007 \$2891 \$3112 \$3021
+ gf180mcu_fd_sc_mcu9t5v0__aoi221_1
X$689 \$6110 \$5473 \$5735 \$2665 gf180mcu_fd_sc_mcu9t5v0__clkbuf_16
X$690 \$8697 \$8695 \$2665 \$8834 \$8717 \$8741 gf180mcu_fd_sc_mcu9t5v0__mux2_2
X$691 \$9735 \$9736 \$2665 \$9608 \$9457 \$9615 gf180mcu_fd_sc_mcu9t5v0__mux2_2
X$692 \$6113 \$6380 \$2665 \$6136 \$6105 \$6152 gf180mcu_fd_sc_mcu9t5v0__mux2_2
X$693 \$5115 \$5018 \$2665 \$5358 \$5240 \$5385 gf180mcu_fd_sc_mcu9t5v0__mux2_1
X$694 \$6374 \$6375 \$2665 \$6136 \$6105 \$6167 gf180mcu_fd_sc_mcu9t5v0__mux2_1
X$695 \$2666 \$2802 \$2898 \$3227 \$3007 \$3238 \$3112 \$3228
+ gf180mcu_fd_sc_mcu9t5v0__aoi221_1
X$696 \$2690 \$2802 \$2679 \$2670 \$2691 gf180mcu_fd_sc_mcu9t5v0__nand2_1
X$697 \$2670 \$2679 gf180mcu_fd_sc_mcu9t5v0__filltie
X$698 \$2670 \$2679 gf180mcu_fd_sc_mcu9t5v0__filltie
X$699 \$2670 \$2679 gf180mcu_fd_sc_mcu9t5v0__filltie
X$700 \$2670 \$2679 gf180mcu_fd_sc_mcu9t5v0__filltie
X$701 \$2670 \$2679 gf180mcu_fd_sc_mcu9t5v0__filltie
X$702 \$2670 \$2679 gf180mcu_fd_sc_mcu9t5v0__filltie
X$703 \$2670 \$2679 gf180mcu_fd_sc_mcu9t5v0__endcap
X$704 \$3000 \$2692 \$2679 \$2791 \$2901 gf180mcu_fd_sc_mcu9t5v0__nand2_1
X$705 \$3000 \$2797 \$2679 \$2791 \$2798 gf180mcu_fd_sc_mcu9t5v0__nand2_1
X$706 \$2792 \$2680 \$2893 \$2679 \$2791 gf180mcu_fd_sc_mcu9t5v0__dffq_2
X$707 \$2791 \$2679 gf180mcu_fd_sc_mcu9t5v0__filltie
X$708 \$2791 \$2679 gf180mcu_fd_sc_mcu9t5v0__filltie
X$709 \$2791 \$2679 gf180mcu_fd_sc_mcu9t5v0__filltie
X$710 \$2791 \$2679 gf180mcu_fd_sc_mcu9t5v0__filltie
X$711 \$2791 \$2679 gf180mcu_fd_sc_mcu9t5v0__filltie
X$712 \$2791 \$2679 gf180mcu_fd_sc_mcu9t5v0__filltie
X$713 \$2791 \$2679 gf180mcu_fd_sc_mcu9t5v0__endcap
X$714 \$3328 \$3329 \$2793 \$2891 \$2791 \$2681 gf180mcu_fd_sc_mcu9t5v0__mux2_2
X$715 \$2683 \$2802 \$3114 \$3000 \$3007 \$2891 \$3112 \$3008
+ gf180mcu_fd_sc_mcu9t5v0__aoi221_1
X$716 \$2691 \$3014 \$2901 \$2900 \$2891 \$2791 \$2902
+ gf180mcu_fd_sc_mcu9t5v0__aoi22_1
X$717 \$2699 \$2802 \$2898 \$3231 \$3007 \$3238 \$3112 \$3234
+ gf180mcu_fd_sc_mcu9t5v0__aoi221_1
X$718 \$4156 \$2703 \$3931 \$4041 \$4046 gf180mcu_fd_sc_mcu9t5v0__nor2_1
X$719 \$4158 \$2703 \$4173 \$4314 \$4164 gf180mcu_fd_sc_mcu9t5v0__nand2_1
X$720 \$5497 \$2703 \$5207 \$5240 \$5223 gf180mcu_fd_sc_mcu9t5v0__nand2_1
X$721 \$5375 \$5358 \$5240 \$2703 gf180mcu_fd_sc_mcu9t5v0__buf_8
X$722 \$2704 \$2703 \$3599 \$3581 \$3812 \$3719 gf180mcu_fd_sc_mcu9t5v0__mux2_1
X$723 \$2704 \$2703 \$2804 \$2891 \$2791 \$2706 gf180mcu_fd_sc_mcu9t5v0__mux2_1
X$724 \$13515 \$2704 \$13514 \$13852 \$8695 \$13510 \$13623 \$13452 \$13513
+ gf180mcu_fd_sc_mcu9t5v0__aoi222_1
X$725 \$6887 \$2704 \$6343 \$6770 \$6616 \$6643 gf180mcu_fd_sc_mcu9t5v0__mux2_1
X$726 \$13465 \$8968 \$13350 \$13623 \$13452 \$2704
+ gf180mcu_fd_sc_mcu9t5v0__mux2_1
X$727 \$2704 \$4974 \$4972 \$4951 \$4849 \$5104 gf180mcu_fd_sc_mcu9t5v0__mux2_1
X$728 \$2704 \$4409 \$4134 \$4434 \$4314 \$4432 gf180mcu_fd_sc_mcu9t5v0__mux2_1
X$729 \$2897 \$2896 \$2798 \$2895 \$4677 \$2891 \$2791 \$2892
+ gf180mcu_fd_sc_mcu9t5v0__aoi221_1
X$730 \$2795 \$2802 \$2891 \$2791 \$2897 gf180mcu_fd_sc_mcu9t5v0__nand2_1
X$731 \$3000 \$2905 \$2891 \$2791 \$3023 gf180mcu_fd_sc_mcu9t5v0__nand2_1
X$732 \$2791 \$2891 gf180mcu_fd_sc_mcu9t5v0__filltie
X$733 \$2791 \$2891 gf180mcu_fd_sc_mcu9t5v0__filltie
X$734 \$2791 \$2891 gf180mcu_fd_sc_mcu9t5v0__filltie
X$735 \$2791 \$2891 gf180mcu_fd_sc_mcu9t5v0__filltie
X$736 \$2791 \$2891 gf180mcu_fd_sc_mcu9t5v0__filltie
X$737 \$2791 \$2891 gf180mcu_fd_sc_mcu9t5v0__filltie
X$738 \$2792 \$2794 \$2795 \$2891 \$2791 gf180mcu_fd_sc_mcu9t5v0__dffq_2
X$739 \$2791 \$2891 gf180mcu_fd_sc_mcu9t5v0__endcap
X$740 \$2792 \$3931 \$4041 \$I71632 gf180mcu_fd_sc_mcu9t5v0__inv_2
X$741 \$3919 \$3931 \$3812 \$2792 gf180mcu_fd_sc_mcu9t5v0__clkbuf_8
X$742 \$2792 \$4026 \$3358 \$3931 \$4041 gf180mcu_fd_sc_mcu9t5v0__dffq_2
X$743 \$2792 \$3239 \$3212 \$3238 \$3338 gf180mcu_fd_sc_mcu9t5v0__dffq_2
X$744 \$2792 \$3240 \$3002 \$3238 \$3338 gf180mcu_fd_sc_mcu9t5v0__dffq_2
X$745 \$2792 \$3933 \$3913 \$3931 \$4041 gf180mcu_fd_sc_mcu9t5v0__dffq_2
X$746 \$2792 \$4960 \$4730 \$4951 \$5106 gf180mcu_fd_sc_mcu9t5v0__dffq_2
X$747 \$2792 \$4436 \$4536 \$4434 \$4567 gf180mcu_fd_sc_mcu9t5v0__dffq_2
X$748 \$2792 \$3355 \$3353 \$3351 \$3463 gf180mcu_fd_sc_mcu9t5v0__dffq_2
X$749 \$2792 \$4957 \$4989 \$4951 \$5106 gf180mcu_fd_sc_mcu9t5v0__dffq_2
X$750 \$2792 \$5364 \$5476 \$5358 \$5473 gf180mcu_fd_sc_mcu9t5v0__dffq_2
X$751 \$2792 \$4198 \$3467 \$4173 \$4314 gf180mcu_fd_sc_mcu9t5v0__dffq_2
X$752 \$2792 \$4178 \$4203 \$4173 \$4314 gf180mcu_fd_sc_mcu9t5v0__dffq_2
X$753 \$2792 \$3472 \$3359 \$3581 \$3463 gf180mcu_fd_sc_mcu9t5v0__dffq_2
X$754 \$2792 \$3915 \$4535 \$3931 \$3812 gf180mcu_fd_sc_mcu9t5v0__dffq_2
X$755 \$2792 \$4141 \$4200 \$4173 \$4041 gf180mcu_fd_sc_mcu9t5v0__dffq_2
X$756 \$6110 \$10022 \$10282 \$2793 gf180mcu_fd_sc_mcu9t5v0__clkbuf_20
X$757 \$5632 \$6132 \$2793 \$6001 \$6105 \$6124 gf180mcu_fd_sc_mcu9t5v0__mux2_2
X$758 \$9917 \$9795 \$2793 \$10901 \$11025 \$10811
+ gf180mcu_fd_sc_mcu9t5v0__mux2_2
X$759 \$9235 \$9239 \$2793 \$10901 \$10782 \$10813
+ gf180mcu_fd_sc_mcu9t5v0__mux2_2
X$760 \$7557 \$7908 \$2793 \$7526 \$7417 \$7559 gf180mcu_fd_sc_mcu9t5v0__mux2_2
X$761 \$10240 \$10241 \$2793 \$10630 \$10782 \$10786
+ gf180mcu_fd_sc_mcu9t5v0__mux2_1
X$762 \$7272 \$7273 \$2793 \$7304 \$7160 \$6921 gf180mcu_fd_sc_mcu9t5v0__mux2_1
X$763 \$4205 \$4212 \$4199 \$2800 \$4173 \$4314 \$4148
+ gf180mcu_fd_sc_mcu9t5v0__aoi22_1
X$764 \$4963 \$2802 \$4992 \$4542 \$4998 \$3000 \$4951 \$5106 \$4708
+ gf180mcu_fd_sc_mcu9t5v0__aoi222_1
X$765 \$4984 \$2802 \$4992 \$6003 \$5362 \$3000 \$5735 \$5833 \$5836
+ gf180mcu_fd_sc_mcu9t5v0__aoi222_1
X$766 \$5357 \$5356 \$2802 \$5358 \$5240 \$5355 gf180mcu_fd_sc_mcu9t5v0__nand3_1
X$767 \$6630 \$2802 \$2898 \$6514 \$6497 \$6616 \$6629
+ gf180mcu_fd_sc_mcu9t5v0__aoi22_1
X$768 \$4736 \$2802 \$4992 \$4204 \$5207 \$5240 \$5216
+ gf180mcu_fd_sc_mcu9t5v0__aoi22_1
X$769 \$4750 \$2802 \$2898 \$4749 \$4702 \$4849 \$4716
+ gf180mcu_fd_sc_mcu9t5v0__aoi22_1
X$770 \$4576 \$2802 \$2898 \$4577 \$4434 \$4567 \$4685
+ gf180mcu_fd_sc_mcu9t5v0__aoi22_1
X$771 \$4759 \$2802 \$2898 \$4758 \$4702 \$4849 \$4557
+ gf180mcu_fd_sc_mcu9t5v0__aoi22_1
X$772 \$6370 \$2802 \$4954 \$5635 \$6136 \$6387 \$6161
+ gf180mcu_fd_sc_mcu9t5v0__aoi22_1
X$773 \$4742 \$2802 \$4992 \$4422 \$4702 \$4567 \$4709
+ gf180mcu_fd_sc_mcu9t5v0__aoi22_1
X$774 \$7581 \$2802 \$4992 \$7544 \$7526 \$7417 \$7543
+ gf180mcu_fd_sc_mcu9t5v0__aoi22_1
X$775 \$9782 \$2802 \$4992 \$9612 \$9748 \$9703 \$9724
+ gf180mcu_fd_sc_mcu9t5v0__aoi22_1
X$776 \$11971 \$2802 \$4992 \$11972 \$11956 \$11827 \$11837
+ gf180mcu_fd_sc_mcu9t5v0__aoi22_1
X$777 \$4754 \$2802 \$2898 \$4428 \$4434 \$4314 \$4220
+ gf180mcu_fd_sc_mcu9t5v0__aoi22_1
X$778 \$10249 \$2802 \$4992 \$9719 \$11306 \$11182 \$11529
+ gf180mcu_fd_sc_mcu9t5v0__aoi22_1
X$779 \$5862 \$2802 \$2898 \$6016 \$3007 \$6001 \$6105 \$6122
+ gf180mcu_fd_sc_mcu9t5v0__aoi221_1
X$780 \$5892 \$2802 \$4992 \$5851 \$3007 \$6497 \$6616 \$6626
+ gf180mcu_fd_sc_mcu9t5v0__aoi221_1
X$781 \$10669 \$2802 \$4992 \$11192 \$5356 \$11675 \$11827 \$11836
+ gf180mcu_fd_sc_mcu9t5v0__aoi221_1
X$782 \$4531 \$2802 \$4992 \$4534 \$3007 \$4434 \$4567 \$4411
+ gf180mcu_fd_sc_mcu9t5v0__aoi221_1
X$783 \$3726 \$2802 \$4227 \$3025 \$5356 \$4173 \$4314 \$4165
+ gf180mcu_fd_sc_mcu9t5v0__aoi221_1
X$784 \$7317 \$2802 \$2898 \$7065 \$5357 \$7047 \$7160 \$6791
+ gf180mcu_fd_sc_mcu9t5v0__aoi221_1
X$785 \$6011 \$2802 \$2898 \$6012 \$5356 \$6001 \$6105 \$5899
+ gf180mcu_fd_sc_mcu9t5v0__aoi221_1
X$786 \$3242 \$2802 \$2909 \$3025 \$5356 \$2891 \$3112 \$3235
+ gf180mcu_fd_sc_mcu9t5v0__aoi221_1
X$787 \$4734 \$2802 \$4992 \$4680 \$4993 \$5207 \$5106 \$5214
+ gf180mcu_fd_sc_mcu9t5v0__aoi221_1
X$788 \$6120 \$2802 \$2898 \$5910 \$5356 \$6136 \$6105 \$6158
+ gf180mcu_fd_sc_mcu9t5v0__aoi221_1
X$789 \$9359 \$2802 \$4992 \$9460 \$5356 \$9608 \$9457 \$9586
+ gf180mcu_fd_sc_mcu9t5v0__aoi221_1
X$790 \$9116 \$2802 \$4992 \$9231 \$3007 \$9337 \$9221 \$9360
+ gf180mcu_fd_sc_mcu9t5v0__aoi221_1
X$791 \$3211 \$2802 \$2898 \$3349 \$3007 \$3581 \$3463 \$3610
+ gf180mcu_fd_sc_mcu9t5v0__aoi221_1
X$792 \$7700 \$2802 \$2898 \$8323 \$5356 \$8301 \$8183 \$8322
+ gf180mcu_fd_sc_mcu9t5v0__aoi221_1
X$793 \$3494 \$2802 \$2898 \$4187 \$4166 \$4173 \$4041 \$4048
+ gf180mcu_fd_sc_mcu9t5v0__aoi221_1
X$794 \$5491 \$2802 \$2898 \$5111 \$3007 \$6136 \$6105 \$6154
+ gf180mcu_fd_sc_mcu9t5v0__aoi221_1
X$795 \$3207 \$2802 \$3206 \$3000 \$3007 \$3238 \$3112 \$3208
+ gf180mcu_fd_sc_mcu9t5v0__aoi221_1
X$796 \$2998 \$2802 \$3200 \$3000 \$3007 \$3238 \$3112 \$3201
+ gf180mcu_fd_sc_mcu9t5v0__aoi221_1
X$797 \$5604 \$2802 \$5474 \$3000 \$5356 \$5735 \$5473 \$5603
+ gf180mcu_fd_sc_mcu9t5v0__aoi221_1
X$798 \$2806 \$2802 \$3581 \$3812 \$3721 gf180mcu_fd_sc_mcu9t5v0__nand2_1
X$799 \$8201 \$2802 \$8301 \$8335 \$8356 gf180mcu_fd_sc_mcu9t5v0__nand2_1
X$800 \$7174 \$2802 \$6770 \$6890 \$6671 gf180mcu_fd_sc_mcu9t5v0__nand2_1
X$801 \$3212 \$2802 \$3238 \$3112 \$3215 gf180mcu_fd_sc_mcu9t5v0__nand2_1
X$802 \$4535 \$2802 \$4434 \$4314 \$4413 gf180mcu_fd_sc_mcu9t5v0__nand2_1
X$803 \$4727 \$6136 \$6387 \$2802 gf180mcu_fd_sc_mcu9t5v0__buf_8
X$804 \$9582 \$9337 \$9457 \$2804 gf180mcu_fd_sc_mcu9t5v0__buf_8
X$805 \$3491 \$3490 \$2804 \$3581 \$3812 \$3615 gf180mcu_fd_sc_mcu9t5v0__mux2_1
X$806 \$6380 \$6113 \$2804 \$6001 \$6105 \$5850 gf180mcu_fd_sc_mcu9t5v0__mux2_1
X$807 \$7908 \$7557 \$2804 \$7526 \$7688 \$7321 gf180mcu_fd_sc_mcu9t5v0__mux2_1
X$808 \$9795 \$9917 \$2804 \$10022 \$10282 \$10272
+ gf180mcu_fd_sc_mcu9t5v0__mux2_1
X$809 \$9239 \$9235 \$2804 \$10022 \$10282 \$10277
+ gf180mcu_fd_sc_mcu9t5v0__mux2_1
X$810 \$9775 \$10667 \$2804 \$10022 \$10282 \$10250
+ gf180mcu_fd_sc_mcu9t5v0__mux2_1
X$811 \$8968 \$8853 \$2804 \$8834 \$8963 \$8967 gf180mcu_fd_sc_mcu9t5v0__mux2_1
X$812 \$10227 \$7592 \$2804 \$8301 \$8335 \$8357 gf180mcu_fd_sc_mcu9t5v0__mux2_1
X$813 \$8695 \$8697 \$2804 \$8572 \$8335 \$8566 gf180mcu_fd_sc_mcu9t5v0__mux2_1
X$814 \$5594 \$5256 \$2804 \$5735 \$5473 \$5372 gf180mcu_fd_sc_mcu9t5v0__mux2_1
X$815 \$6132 \$5632 \$2804 \$6001 \$5833 \$5502 gf180mcu_fd_sc_mcu9t5v0__mux2_1
X$816 \$6375 \$6374 \$2804 \$6497 \$6387 \$6164 gf180mcu_fd_sc_mcu9t5v0__mux2_1
X$817 \$5018 \$5115 \$2804 \$5207 \$5106 \$5235 gf180mcu_fd_sc_mcu9t5v0__mux2_1
X$818 \$9736 \$9735 \$2804 \$9748 \$9703 \$9603 gf180mcu_fd_sc_mcu9t5v0__mux2_1
X$819 \$4583 \$4212 \$4199 \$2806 \$4434 \$4567 \$4558
+ gf180mcu_fd_sc_mcu9t5v0__aoi22_1
X$820 \$3000 \$3009 \$2891 \$3112 \$3219 gf180mcu_fd_sc_mcu9t5v0__nand2_1
X$821 \$3586 \$2898 \$2891 \$3112 \$2999 gf180mcu_fd_sc_mcu9t5v0__nand2_1
X$822 \$3584 \$2898 \$3001 \$3000 \$5356 \$2891 \$3112 \$3213
+ gf180mcu_fd_sc_mcu9t5v0__aoi221_1
X$823 \$3023 \$2904 \$3022 \$3021 \$4677 \$2891 \$3112 \$4715
+ gf180mcu_fd_sc_mcu9t5v0__aoi221_1
X$824 \$3013 \$2898 \$3011 \$3000 \$3007 \$2891 \$3112 \$3014
+ gf180mcu_fd_sc_mcu9t5v0__aoi221_1
X$825 \$3016 \$3015 \$2906 \$2891 \$3112 \$3011 gf180mcu_fd_sc_mcu9t5v0__mux2_1
X$826 \$3002 \$2893 \$2906 \$2891 \$3112 \$3001 gf180mcu_fd_sc_mcu9t5v0__mux2_1
X$827 \$3112 \$2891 gf180mcu_fd_sc_mcu9t5v0__filltie
X$828 \$3112 \$2891 gf180mcu_fd_sc_mcu9t5v0__filltie
X$829 \$3112 \$2891 gf180mcu_fd_sc_mcu9t5v0__filltie
X$830 \$3112 \$2891 gf180mcu_fd_sc_mcu9t5v0__filltie
X$831 \$3112 \$2891 gf180mcu_fd_sc_mcu9t5v0__filltie
X$832 \$3112 \$2891 gf180mcu_fd_sc_mcu9t5v0__filltie
X$833 \$3112 \$2891 gf180mcu_fd_sc_mcu9t5v0__endcap
X$834 \$5211 \$4671 \$2892 \$5210 \$4672 \$5207 \$5106 \$5238
+ gf180mcu_fd_sc_mcu9t5v0__oai221_1
X$835 \$3002 \$2893 \$3353 \$3467 \$3587 \$3703 \$3581 \$3463 \$3588
+ gf180mcu_fd_sc_mcu9t5v0__mux4_1
X$836 \$3353 \$3467 \$3002 \$2893 \$3468 \$3203 \$3351 \$3463 \$3469
+ gf180mcu_fd_sc_mcu9t5v0__mux4_1
X$837 \$3005 \$2898 \$3202 \$3000 \$3007 \$3238 \$3112 \$2896
+ gf180mcu_fd_sc_mcu9t5v0__aoi221_1
X$838 \$12025 \$4727 \$2898 \$12500 \$11956 \$11993 \$12031
+ gf180mcu_fd_sc_mcu9t5v0__aoi22_1
X$839 \$10535 \$4727 \$2898 \$10645 \$10391 \$10514 \$10417
+ gf180mcu_fd_sc_mcu9t5v0__aoi22_1
X$840 \$11208 \$4727 \$2898 \$11205 \$11136 \$11182 \$11165
+ gf180mcu_fd_sc_mcu9t5v0__aoi22_1
X$841 \$11975 \$4727 \$2898 \$12557 \$12260 \$11993 \$12279
+ gf180mcu_fd_sc_mcu9t5v0__aoi22_1
X$842 \$4138 \$2898 \$4042 \$3000 \$5356 \$4173 \$4314 \$4412
+ gf180mcu_fd_sc_mcu9t5v0__aoi221_1
X$843 \$11541 \$2898 \$12037 \$3025 \$5356 \$11956 \$11993 \$12036
+ gf180mcu_fd_sc_mcu9t5v0__aoi221_1
X$844 \$7942 \$2898 \$8584 \$6015 \$3007 \$8572 \$8335 \$8565
+ gf180mcu_fd_sc_mcu9t5v0__aoi221_1
X$845 \$11527 \$4727 \$2898 \$11730 \$5357 \$11306 \$11555 \$11536
+ gf180mcu_fd_sc_mcu9t5v0__aoi221_1
X$846 \$10270 \$4727 \$2898 \$9923 \$11697 \$11675 \$11827 \$11848
+ gf180mcu_fd_sc_mcu9t5v0__aoi221_1
X$847 \$10679 \$4727 \$2898 \$11214 \$5356 \$11675 \$11827 \$11699
+ gf180mcu_fd_sc_mcu9t5v0__aoi221_1
X$848 \$12275 \$4727 \$2898 \$12155 \$5357 \$11956 \$11993 \$11979
+ gf180mcu_fd_sc_mcu9t5v0__aoi221_1
X$849 \$10293 \$4727 \$2898 \$10412 \$10294 \$10391 \$10282 \$10231
+ gf180mcu_fd_sc_mcu9t5v0__aoi221_1
X$850 \$9094 \$2898 \$11675 \$11827 \$11732 gf180mcu_fd_sc_mcu9t5v0__nand2_1
X$851 \$3929 \$2898 \$3931 \$3812 \$4039 gf180mcu_fd_sc_mcu9t5v0__nand2_1
X$852 \$3476 \$2898 \$3238 \$3112 \$3205 gf180mcu_fd_sc_mcu9t5v0__nand2_1
X$853 \$3216 \$2898 \$3238 \$3112 \$3113 gf180mcu_fd_sc_mcu9t5v0__nand2_1
X$854 \$4954 \$4951 \$4849 \$2898 gf180mcu_fd_sc_mcu9t5v0__buf_8
X$855 \$4209 \$4212 \$4199 \$2899 \$4434 \$4314 \$4438
+ gf180mcu_fd_sc_mcu9t5v0__aoi22_1
X$856 \$4677 \$2902 \$4575 \$4434 \$4567 \$4530 gf180mcu_fd_sc_mcu9t5v0__oai21_1
X$857 \$3017 \$2903 \$3205 \$3208 \$4677 \$3238 \$3112 \$3478
+ gf180mcu_fd_sc_mcu9t5v0__aoi221_1
X$858 \$2906 \$3602 \$3603 \$3000 \$3581 \$3463 \$3371
+ gf180mcu_fd_sc_mcu9t5v0__oai211_1
X$859 \$10017 \$10022 \$9900 \$2906 gf180mcu_fd_sc_mcu9t5v0__buf_20
X$860 \$2906 \$10413 \$10296 \$4550 \$10022 \$10282 \$10294
+ gf180mcu_fd_sc_mcu9t5v0__aoi211_1
X$861 \$2906 \$4560 \$4690 \$4550 \$4434 \$4567 \$4166
+ gf180mcu_fd_sc_mcu9t5v0__aoi211_1
X$862 \$2906 \$12940 \$12499 \$4550 \$12486 \$12376 \$12032
+ gf180mcu_fd_sc_mcu9t5v0__aoi211_1
X$863 \$2906 \$9792 \$11575 \$4550 \$11675 \$11555 \$11697
+ gf180mcu_fd_sc_mcu9t5v0__aoi211_1
X$864 \$2906 \$5629 \$5634 \$4550 \$5358 \$5240 \$5380
+ gf180mcu_fd_sc_mcu9t5v0__aoi211_1
X$865 \$2906 \$11166 \$11164 \$10901 \$11025 \$10929
+ gf180mcu_fd_sc_mcu9t5v0__oai21_1
X$866 \$2906 \$3226 \$3715 \$3000 \$3581 \$3812 \$3022
+ gf180mcu_fd_sc_mcu9t5v0__oai211_1
X$867 \$2906 \$3485 \$3486 \$3025 \$3351 \$3463 \$3210
+ gf180mcu_fd_sc_mcu9t5v0__oai211_1
X$868 \$2906 \$8093 \$8092 \$3025 \$8063 \$8183 \$8091
+ gf180mcu_fd_sc_mcu9t5v0__oai211_1
X$869 \$2906 \$3724 \$3725 \$3025 \$3581 \$3812 \$3723
+ gf180mcu_fd_sc_mcu9t5v0__oai211_1
X$870 \$2906 \$5494 \$5901 \$6015 \$6001 \$5833 \$6014
+ gf180mcu_fd_sc_mcu9t5v0__oai211_1
X$871 \$2906 \$6788 \$6937 \$6015 \$6770 \$6616 \$6787
+ gf180mcu_fd_sc_mcu9t5v0__oai211_1
X$872 \$2906 \$6677 \$6793 \$6015 \$6770 \$6616 \$6397
+ gf180mcu_fd_sc_mcu9t5v0__oai211_1
X$873 \$2906 \$6927 \$7304 \$7417 \$7309 gf180mcu_fd_sc_mcu9t5v0__nor2_1
X$874 \$2906 \$4723 \$4702 \$4849 \$4762 gf180mcu_fd_sc_mcu9t5v0__nor2_1
X$875 \$2906 \$9464 \$9608 \$9703 \$9725 gf180mcu_fd_sc_mcu9t5v0__nor2_1
X$876 \$2906 \$11716 \$11675 \$11827 \$11560 gf180mcu_fd_sc_mcu9t5v0__nor2_1
X$877 \$2906 \$4320 \$4702 \$4849 \$4746 gf180mcu_fd_sc_mcu9t5v0__nor2_1
X$878 \$2906 \$4205 \$4951 \$5106 \$5108 gf180mcu_fd_sc_mcu9t5v0__nor2_1
X$879 \$2906 \$6792 \$6770 \$6890 \$6900 gf180mcu_fd_sc_mcu9t5v0__nor2_1
X$880 \$2906 \$4200 \$4434 \$4567 \$4571 gf180mcu_fd_sc_mcu9t5v0__nor2_1
X$881 \$2906 \$4536 \$5207 \$5106 \$4854 gf180mcu_fd_sc_mcu9t5v0__nor2_1
X$882 \$2906 \$9734 \$10391 \$10282 \$10296 gf180mcu_fd_sc_mcu9t5v0__nor2_1
X$883 \$2906 \$10299 \$10391 \$10282 \$10297 gf180mcu_fd_sc_mcu9t5v0__nor2_1
X$884 \$2906 \$11698 \$11675 \$11555 \$11575 gf180mcu_fd_sc_mcu9t5v0__nor2_1
X$885 \$2906 \$4214 \$4702 \$4567 \$4686 gf180mcu_fd_sc_mcu9t5v0__nor2_1
X$886 \$2906 \$11970 \$11956 \$11827 \$11968 gf180mcu_fd_sc_mcu9t5v0__nor2_1
X$887 \$2906 \$5231 \$5735 \$5473 \$5634 gf180mcu_fd_sc_mcu9t5v0__nor2_1
X$888 \$2906 \$12385 \$12486 \$12376 \$12499 gf180mcu_fd_sc_mcu9t5v0__nor2_1
X$889 \$2906 \$11330 \$11306 \$11182 \$11329 gf180mcu_fd_sc_mcu9t5v0__nor2_1
X$890 \$2906 \$12276 \$12260 \$11993 \$11980 gf180mcu_fd_sc_mcu9t5v0__nor2_1
X$891 \$2906 \$11307 \$11956 \$11827 \$11961 gf180mcu_fd_sc_mcu9t5v0__nor2_1
X$892 \$2906 \$4691 \$4702 \$4567 \$4690 gf180mcu_fd_sc_mcu9t5v0__nor2_1
X$893 \$2906 \$5607 \$5735 \$5473 \$5608 gf180mcu_fd_sc_mcu9t5v0__nor2_1
X$894 \$2906 \$4550 \$8834 \$8963 \$8833 gf180mcu_fd_sc_mcu9t5v0__nand2_1
X$895 \$2906 \$3717 \$3581 \$3812 \$3603 gf180mcu_fd_sc_mcu9t5v0__nand2_1
X$896 \$2906 \$8087 \$8063 \$8183 \$8092 gf180mcu_fd_sc_mcu9t5v0__nand2_1
X$897 \$2906 \$6901 \$6770 \$6890 \$6793 gf180mcu_fd_sc_mcu9t5v0__nand2_1
X$898 \$2906 \$13232 \$12486 \$12526 \$12507 gf180mcu_fd_sc_mcu9t5v0__nand2_1
X$899 \$2906 \$6905 \$6770 \$6890 \$6907 gf180mcu_fd_sc_mcu9t5v0__nand2_1
X$900 \$2906 \$5902 \$6001 \$5833 \$5901 gf180mcu_fd_sc_mcu9t5v0__nand2_1
X$901 \$2906 \$3928 \$3931 \$3812 \$3486 gf180mcu_fd_sc_mcu9t5v0__nand2_1
X$902 \$2906 \$4036 \$3931 \$3812 \$3725 gf180mcu_fd_sc_mcu9t5v0__nand2_1
X$903 \$2906 \$4030 \$3931 \$3812 \$3715 gf180mcu_fd_sc_mcu9t5v0__nand2_1
X$904 \$2906 \$5107 \$5207 \$5106 \$4994 gf180mcu_fd_sc_mcu9t5v0__nand2_1
X$905 \$2906 \$11162 \$11136 \$11025 \$11164 gf180mcu_fd_sc_mcu9t5v0__nand2_1
X$906 \$2906 \$6938 \$7047 \$6890 \$6937 gf180mcu_fd_sc_mcu9t5v0__nand2_1
X$907 \$2906 \$4434 \$4567 \$4566 gf180mcu_fd_sc_mcu9t5v0__clkinv_1
X$908 \$11196 \$12382 \$2906 \$12260 \$12376 \$11728
+ gf180mcu_fd_sc_mcu9t5v0__mux2_1
X$909 \$7158 \$7159 \$2906 \$7304 \$7417 \$7415 gf180mcu_fd_sc_mcu9t5v0__mux2_1
X$910 \$5870 \$5642 \$2906 \$5735 \$5833 \$5869 gf180mcu_fd_sc_mcu9t5v0__mux2_1
X$911 \$9705 \$9704 \$2906 \$9608 \$9703 \$9570 gf180mcu_fd_sc_mcu9t5v0__mux2_1
X$912 \$5644 \$5266 \$2906 \$5358 \$5473 \$5643 gf180mcu_fd_sc_mcu9t5v0__mux2_1
X$913 \$11994 \$10905 \$2906 \$11956 \$11993 \$11958
+ gf180mcu_fd_sc_mcu9t5v0__mux2_1
X$914 \$9926 \$9787 \$2906 \$9748 \$9900 \$9798 gf180mcu_fd_sc_mcu9t5v0__mux2_1
X$915 \$3702 \$3911 \$2906 \$3931 \$4041 \$4042 gf180mcu_fd_sc_mcu9t5v0__mux2_1
X$916 \$10051 \$9802 \$2906 \$9748 \$9900 \$9925 gf180mcu_fd_sc_mcu9t5v0__mux2_1
X$917 \$8981 \$8739 \$2906 \$8834 \$8963 \$8980 gf180mcu_fd_sc_mcu9t5v0__mux2_1
X$918 \$12531 \$12530 \$2906 \$12486 \$12526 \$11959
+ gf180mcu_fd_sc_mcu9t5v0__mux2_1
X$919 \$9224 \$9107 \$2906 \$9102 \$9221 \$9223 gf180mcu_fd_sc_mcu9t5v0__mux2_1
X$920 \$8188 \$8336 \$2906 \$8301 \$8335 \$8679 gf180mcu_fd_sc_mcu9t5v0__mux2_1
X$921 \$3333 \$3220 \$2906 \$3238 \$3338 \$3114 gf180mcu_fd_sc_mcu9t5v0__mux2_1
X$922 \$3363 \$3342 \$2906 \$3238 \$3338 \$3206 gf180mcu_fd_sc_mcu9t5v0__mux2_1
X$923 \$5361 \$5242 \$2906 \$5358 \$5473 \$5474 gf180mcu_fd_sc_mcu9t5v0__mux2_1
X$924 \$12375 \$10780 \$2906 \$12260 \$12376 \$11957
+ gf180mcu_fd_sc_mcu9t5v0__mux2_1
X$925 \$11851 \$9600 \$2906 \$11675 \$11827 \$11849
+ gf180mcu_fd_sc_mcu9t5v0__mux2_1
X$926 \$8693 \$8692 \$2906 \$8572 \$8717 \$8583 gf180mcu_fd_sc_mcu9t5v0__mux2_1
X$927 \$12392 \$10934 \$2906 \$11956 \$11993 \$11984
+ gf180mcu_fd_sc_mcu9t5v0__mux2_1
X$928 \$5374 \$5490 \$2906 \$5358 \$5473 \$5492 gf180mcu_fd_sc_mcu9t5v0__mux2_1
X$929 \$11831 \$11517 \$2906 \$11675 \$11827 \$11714
+ gf180mcu_fd_sc_mcu9t5v0__mux2_1
X$930 \$11315 \$10529 \$2906 \$11306 \$11182 \$11314
+ gf180mcu_fd_sc_mcu9t5v0__mux2_1
X$931 \$9121 \$8859 \$2906 \$8834 \$8717 \$8584 gf180mcu_fd_sc_mcu9t5v0__mux2_1
X$932 \$6682 \$6379 \$2906 \$6770 \$6616 \$6797 gf180mcu_fd_sc_mcu9t5v0__mux2_1
X$933 \$3913 \$3912 \$2906 \$4173 \$4041 \$4194 gf180mcu_fd_sc_mcu9t5v0__mux2_1
X$934 \$4719 \$4693 \$2906 \$4434 \$4314 \$4227 gf180mcu_fd_sc_mcu9t5v0__mux2_1
X$935 \$3353 \$3467 \$2906 \$3351 \$3338 \$3200 gf180mcu_fd_sc_mcu9t5v0__mux2_1
X$936 \$6524 \$6371 \$2906 \$6497 \$6387 \$6398 gf180mcu_fd_sc_mcu9t5v0__mux2_1
X$937 \$5476 \$5363 \$2906 \$5358 \$5240 \$5362 gf180mcu_fd_sc_mcu9t5v0__mux2_1
X$938 \$5853 \$6394 \$2906 \$6497 \$6387 \$6369 gf180mcu_fd_sc_mcu9t5v0__mux2_1
X$939 \$10790 \$10904 \$2906 \$10901 \$10782 \$10789
+ gf180mcu_fd_sc_mcu9t5v0__mux2_1
X$940 \$8682 \$8538 \$2906 \$8572 \$8335 \$8576 gf180mcu_fd_sc_mcu9t5v0__mux2_1
X$941 \$12508 \$10931 \$2906 \$12486 \$12376 \$12037
+ gf180mcu_fd_sc_mcu9t5v0__mux2_1
X$942 \$10632 \$9903 \$2906 \$10630 \$10514 \$10631
+ gf180mcu_fd_sc_mcu9t5v0__mux2_1
X$943 \$7918 \$7917 \$2906 \$8063 \$7947 \$7949 gf180mcu_fd_sc_mcu9t5v0__mux2_1
X$944 \$4688 \$5014 \$2906 \$4702 \$4567 \$4556 gf180mcu_fd_sc_mcu9t5v0__mux2_1
X$945 \$4209 \$5109 \$2906 \$5207 \$5106 \$4998 gf180mcu_fd_sc_mcu9t5v0__mux2_1
X$946 \$3359 \$3358 \$2906 \$3351 \$3338 \$3202 gf180mcu_fd_sc_mcu9t5v0__mux2_1
X$947 \$6388 \$6139 \$2906 \$6136 \$6105 \$6350 gf180mcu_fd_sc_mcu9t5v0__mux2_1
X$948 \$9750 \$9752 \$2906 \$9748 \$9703 \$9702 gf180mcu_fd_sc_mcu9t5v0__mux2_1
X$949 \$8856 \$9781 \$2906 \$9748 \$9703 \$9777 gf180mcu_fd_sc_mcu9t5v0__mux2_1
X$950 \$6106 \$6348 \$2906 \$6497 \$6387 \$6649 gf180mcu_fd_sc_mcu9t5v0__mux2_1
X$951 \$7306 \$7418 \$2906 \$7526 \$7417 \$7532 gf180mcu_fd_sc_mcu9t5v0__mux2_1
X$952 \$7706 \$7818 \$2906 \$7797 \$7688 \$7817 gf180mcu_fd_sc_mcu9t5v0__mux2_1
X$953 \$11829 \$10285 \$2906 \$11956 \$11827 \$11828
+ gf180mcu_fd_sc_mcu9t5v0__mux2_1
X$954 \$9128 \$8862 \$2906 \$9102 \$8963 \$8979 gf180mcu_fd_sc_mcu9t5v0__mux2_1
X$955 \$7961 \$7960 \$2906 \$8063 \$7947 \$7542 gf180mcu_fd_sc_mcu9t5v0__mux2_1
X$956 \$9779 \$9083 \$2906 \$9748 \$9703 \$9778 gf180mcu_fd_sc_mcu9t5v0__mux2_1
X$957 \$6960 \$6950 \$2906 \$7047 \$6890 \$6959 gf180mcu_fd_sc_mcu9t5v0__mux2_1
X$958 \$8304 \$8187 \$2906 \$8572 \$8335 \$8574 gf180mcu_fd_sc_mcu9t5v0__mux2_1
X$959 \$3371 \$3228 \$3369 \$2908 \$3351 \$3338 \$3370
+ gf180mcu_fd_sc_mcu9t5v0__aoi22_1
X$960 \$3582 \$2997 \$2998 \$3238 \$3112 gf180mcu_fd_sc_mcu9t5v0__dffq_2
X$961 \$2998 \$3586 \$3212 \$3584 \$3468 \$3203 \$3581 \$3463 \$3585
+ gf180mcu_fd_sc_mcu9t5v0__mux4_1
X$962 \$3212 \$3584 \$2998 \$3586 \$3587 \$3703 \$3581 \$3812 \$3705
+ gf180mcu_fd_sc_mcu9t5v0__mux4_1
X$963 \$3215 \$3213 \$2999 \$3201 \$4677 \$3238 \$3112 \$3214
+ gf180mcu_fd_sc_mcu9t5v0__aoi221_1
X$964 \$10914 \$4727 \$4992 \$11717 \$11959 \$3000 \$11675 \$11827 \$11712
+ gf180mcu_fd_sc_mcu9t5v0__aoi222_1
X$965 \$7916 \$4727 \$4992 \$7915 \$7949 \$3000 \$7797 \$7947 \$7529
+ gf180mcu_fd_sc_mcu9t5v0__aoi222_1
X$966 \$10238 \$4727 \$4992 \$9581 \$11714 \$3000 \$11675 \$11555 \$11683
+ gf180mcu_fd_sc_mcu9t5v0__aoi222_1
X$967 \$9108 \$4727 \$4992 \$9344 \$9223 \$3000 \$9337 \$9221 \$9101
+ gf180mcu_fd_sc_mcu9t5v0__aoi222_1
X$968 \$3000 \$11128 \$12126 \$11169 \$11136 \$11182 \$10654
+ gf180mcu_fd_sc_mcu9t5v0__oai31_1
X$969 \$8683 \$4727 \$8576 \$3000 \$8834 \$8717 \$8835
+ gf180mcu_fd_sc_mcu9t5v0__aoi22_1
X$970 \$8840 \$4992 \$8679 \$3000 \$3007 \$8572 \$8717 \$8676
+ gf180mcu_fd_sc_mcu9t5v0__aoi221_1
X$971 \$7305 \$4727 \$7415 \$3000 \$5356 \$7304 \$7417 \$7416
+ gf180mcu_fd_sc_mcu9t5v0__aoi221_1
X$972 \$10518 \$4727 \$10789 \$3000 \$5356 \$10630 \$10782 \$10517
+ gf180mcu_fd_sc_mcu9t5v0__aoi221_1
X$973 \$6345 \$4727 \$6350 \$3000 \$3007 \$6136 \$6387 \$6651
+ gf180mcu_fd_sc_mcu9t5v0__aoi221_1
X$974 \$6772 \$4992 \$6649 \$3000 \$5356 \$6770 \$6616 \$6650
+ gf180mcu_fd_sc_mcu9t5v0__aoi221_1
X$975 \$11026 \$4727 \$11957 \$3000 \$5356 \$11956 \$11827 \$11713
+ gf180mcu_fd_sc_mcu9t5v0__aoi221_1
X$976 \$10788 \$4727 \$11958 \$3000 \$5356 \$11956 \$11827 \$11682
+ gf180mcu_fd_sc_mcu9t5v0__aoi221_1
X$977 \$3000 \$11828 \$11675 \$11827 \$11826 gf180mcu_fd_sc_mcu9t5v0__nand2_1
X$978 \$3000 \$8574 \$8572 \$8717 \$8678 gf180mcu_fd_sc_mcu9t5v0__nand2_1
X$979 \$3000 \$9702 \$9608 \$9703 \$9339 gf180mcu_fd_sc_mcu9t5v0__nand2_1
X$980 \$3000 \$4194 \$4173 \$4314 \$4193 gf180mcu_fd_sc_mcu9t5v0__nand2_1
X$981 \$3000 \$10631 \$10630 \$10514 \$10516 gf180mcu_fd_sc_mcu9t5v0__nand2_1
X$982 \$3000 \$7532 \$7526 \$7417 \$7531 gf180mcu_fd_sc_mcu9t5v0__nand2_1
X$983 \$3000 \$9570 \$9608 \$9457 \$9456 gf180mcu_fd_sc_mcu9t5v0__nand2_1
X$984 \$4723 \$4702 \$4849 \$3000 gf180mcu_fd_sc_mcu9t5v0__buf_8
X$985 \$3328 \$3002 \$3465 \$3238 \$3112 \$3240 gf180mcu_fd_sc_mcu9t5v0__mux2_1
X$986 \$9582 \$9608 \$9457 \$3003 gf180mcu_fd_sc_mcu9t5v0__buf_8
X$987 \$10902 \$10233 \$3003 \$10022 \$10282 \$10232
+ gf180mcu_fd_sc_mcu9t5v0__mux2_1
X$988 \$8961 \$9343 \$3003 \$9608 \$9703 \$9569 gf180mcu_fd_sc_mcu9t5v0__mux2_1
X$989 \$4191 \$4315 \$3003 \$4434 \$4567 \$4533 gf180mcu_fd_sc_mcu9t5v0__mux2_1
X$990 \$10241 \$10240 \$3003 \$10022 \$10282 \$10239
+ gf180mcu_fd_sc_mcu9t5v0__mux2_1
X$991 \$3329 \$3328 \$3003 \$3238 \$3338 \$3327 gf180mcu_fd_sc_mcu9t5v0__mux2_1
X$992 \$5244 \$5360 \$3003 \$5358 \$5240 \$4985 gf180mcu_fd_sc_mcu9t5v0__mux2_1
X$993 \$10027 \$9905 \$3003 \$10022 \$9900 \$10244
+ gf180mcu_fd_sc_mcu9t5v0__mux2_1
X$994 \$8186 \$8302 \$3003 \$8834 \$8717 \$8714 gf180mcu_fd_sc_mcu9t5v0__mux2_1
X$995 \$6347 \$6346 \$3003 \$6497 \$6387 \$6138 gf180mcu_fd_sc_mcu9t5v0__mux2_1
X$996 \$7273 \$7272 \$3003 \$8063 \$7947 \$7687 gf180mcu_fd_sc_mcu9t5v0__mux2_1
X$997 \$3368 \$3004 \$3581 \$3463 \$3589 gf180mcu_fd_sc_mcu9t5v0__nor2_1
X$998 \$3005 \$7304 \$7160 \$7280 gf180mcu_fd_sc_mcu9t5v0__clkinv_1
X$999 \$5481 \$7172 \$3005 \$7047 \$7160 gf180mcu_fd_sc_mcu9t5v0__dffq_2
X$1000 \$3331 \$3006 \$3332 \$3238 \$3338 \$3339 gf180mcu_fd_sc_mcu9t5v0__mux2_1
X$1001 \$4677 \$3007 \$10389 \$10391 \$10282 \$8711
+ gf180mcu_fd_sc_mcu9t5v0__nor3_1
X$1002 \$3007 \$11502 \$11504 \$12126 \$11306 \$11555 \$10898
+ gf180mcu_fd_sc_mcu9t5v0__aoi211_1
X$1003 \$3007 \$8833 \$9102 \$8963 \$9067 gf180mcu_fd_sc_mcu9t5v0__nor2_1
X$1004 \$7435 \$4727 \$4954 \$7705 \$3007 \$7797 \$7947 \$7943
+ gf180mcu_fd_sc_mcu9t5v0__aoi221_1
X$1005 \$8700 \$4954 \$8979 \$3025 \$3007 \$8834 \$8963 \$8865
+ gf180mcu_fd_sc_mcu9t5v0__aoi221_1
X$1006 \$5505 \$4954 \$5869 \$3025 \$3007 \$5735 \$5833 \$5641
+ gf180mcu_fd_sc_mcu9t5v0__aoi221_1
X$1007 \$10030 \$4727 \$4992 \$10032 \$3007 \$9748 \$9900 \$9901
+ gf180mcu_fd_sc_mcu9t5v0__aoi221_1
X$1008 \$10275 \$4727 \$11849 \$3025 \$3007 \$11675 \$11827 \$11733
+ gf180mcu_fd_sc_mcu9t5v0__aoi221_1
X$1009 \$9103 \$4727 \$4992 \$9105 \$3007 \$9102 \$9221 \$9219
+ gf180mcu_fd_sc_mcu9t5v0__aoi221_1
X$1010 \$7799 \$4727 \$4992 \$7800 \$3007 \$7797 \$7688 \$7530
+ gf180mcu_fd_sc_mcu9t5v0__aoi221_1
X$1011 \$9602 \$4727 \$9798 \$3025 \$3007 \$9748 \$9703 \$9799
+ gf180mcu_fd_sc_mcu9t5v0__aoi221_1
X$1012 \$6377 \$4727 \$6959 \$3025 \$3007 \$7047 \$6890 \$6796
+ gf180mcu_fd_sc_mcu9t5v0__aoi221_1
X$1013 \$10393 \$4727 \$4992 \$10037 \$3007 \$11675 \$11555 \$11554
+ gf180mcu_fd_sc_mcu9t5v0__aoi221_1
X$1014 \$10626 \$10630 \$10514 \$3007 gf180mcu_fd_sc_mcu9t5v0__buf_8
X$1015 \$3219 \$3217 \$3113 \$3008 \$4677 \$3238 \$3112 \$3218
+ gf180mcu_fd_sc_mcu9t5v0__aoi221_1
X$1016 \$3480 \$3012 \$3581 \$3463 \$3711 gf180mcu_fd_sc_mcu9t5v0__nor2_1
X$1017 \$3013 \$7304 \$7417 \$7173 gf180mcu_fd_sc_mcu9t5v0__clkinv_1
X$1018 \$5891 \$7058 \$3013 \$7304 \$7160 gf180mcu_fd_sc_mcu9t5v0__dffq_2
X$1019 \$3015 \$4219 \$4210 \$4542 \$4434 \$4567 \$4541
+ gf180mcu_fd_sc_mcu9t5v0__aoi22_1
X$1020 \$3015 \$4154 \$4196 \$4173 \$4041 \$4181 gf180mcu_fd_sc_mcu9t5v0__mux2_1
X$1021 \$3016 \$4150 \$3357 \$3581 \$3812 \$3816 gf180mcu_fd_sc_mcu9t5v0__mux2_1
X$1022 \$3210 \$3234 \$3024 \$3235 \$3238 \$3112 \$3233
+ gf180mcu_fd_sc_mcu9t5v0__aoi22_1
X$1023 \$7969 \$4954 \$7817 \$3025 \$5356 \$8063 \$7947 \$7971
+ gf180mcu_fd_sc_mcu9t5v0__aoi221_1
X$1024 \$3025 \$6797 \$6770 \$6890 \$6911 gf180mcu_fd_sc_mcu9t5v0__nand2_1
X$1025 \$3025 \$8980 \$8834 \$8963 \$8738 gf180mcu_fd_sc_mcu9t5v0__nand2_1
X$1026 \$3025 \$9925 \$9748 \$9900 \$9801 gf180mcu_fd_sc_mcu9t5v0__nand2_1
X$1027 \$3025 \$11984 \$11956 \$11827 \$11576 gf180mcu_fd_sc_mcu9t5v0__nand2_1
X$1028 \$3025 \$5643 \$5735 \$5473 \$5640 gf180mcu_fd_sc_mcu9t5v0__nand2_1
X$1029 \$4723 \$4173 \$4041 \$3025 gf180mcu_fd_sc_mcu9t5v0__buf_8
X$1030 \$3112 \$3238 gf180mcu_fd_sc_mcu9t5v0__filltie
X$1031 \$3112 \$3238 gf180mcu_fd_sc_mcu9t5v0__filltie
X$1032 \$3112 \$3238 gf180mcu_fd_sc_mcu9t5v0__filltie
X$1033 \$3112 \$3238 gf180mcu_fd_sc_mcu9t5v0__filltie
X$1034 \$3112 \$3238 gf180mcu_fd_sc_mcu9t5v0__filltie
X$1035 \$3112 \$3238 gf180mcu_fd_sc_mcu9t5v0__filltie
X$1036 \$3112 \$3238 gf180mcu_fd_sc_mcu9t5v0__endcap
X$1037 \$3329 \$3328 \$3352 \$3351 \$3338 \$3199 gf180mcu_fd_sc_mcu9t5v0__mux2_1
X$1038 \$10275 \$9094 \$10679 \$11214 \$3468 \$3203 \$12260 \$12376 \$12389
+ gf180mcu_fd_sc_mcu9t5v0__mux4_1
X$1039 \$6377 \$6640 \$6401 \$6680 \$3468 \$3203 \$6770 \$6890 \$6909
+ gf180mcu_fd_sc_mcu9t5v0__mux4_1
X$1040 \$6960 \$6950 \$6682 \$6379 \$3468 \$3203 \$6770 \$6890 \$6795
+ gf180mcu_fd_sc_mcu9t5v0__mux4_1
X$1041 \$3494 \$4187 \$3726 \$3929 \$3468 \$3203 \$3931 \$4041 \$4040
+ gf180mcu_fd_sc_mcu9t5v0__mux4_1
X$1042 \$11831 \$11517 \$11994 \$10905 \$3468 \$3203 \$11956 \$11993 \$11995
+ gf180mcu_fd_sc_mcu9t5v0__mux4_1
X$1043 \$8188 \$8336 \$8304 \$8187 \$3468 \$3203 \$8301 \$8335 \$8337
+ gf180mcu_fd_sc_mcu9t5v0__mux4_1
X$1044 \$5494 \$5740 \$5374 \$5490 \$3468 \$3203 \$5207 \$5240 \$5258
+ gf180mcu_fd_sc_mcu9t5v0__mux4_1
X$1045 \$8093 \$8208 \$7706 \$7818 \$3468 \$3203 \$8063 \$8183 \$8088
+ gf180mcu_fd_sc_mcu9t5v0__mux4_1
X$1046 \$9926 \$9787 \$10051 \$9802 \$3468 \$3203 \$10022 \$10282 \$10276
+ gf180mcu_fd_sc_mcu9t5v0__mux4_1
X$1047 \$5234 \$5505 \$5382 \$5504 \$3468 \$3203 \$5358 \$5473 \$5637
+ gf180mcu_fd_sc_mcu9t5v0__mux4_1
X$1048 \$3913 \$3912 \$3702 \$3911 \$3468 \$3203 \$3581 \$3812 \$4023
+ gf180mcu_fd_sc_mcu9t5v0__mux4_1
X$1049 \$5870 \$5642 \$5644 \$5266 \$3468 \$3203 \$5735 \$5833 \$5867
+ gf180mcu_fd_sc_mcu9t5v0__mux4_1
X$1050 \$9116 \$9231 \$9359 \$9460 \$3468 \$3203 \$9102 \$9221 \$9461
+ gf180mcu_fd_sc_mcu9t5v0__mux4_1
X$1051 \$10393 \$10037 \$11026 \$11179 \$3468 \$3203 \$12486 \$12526 \$12527
+ gf180mcu_fd_sc_mcu9t5v0__mux4_1
X$1052 \$6788 \$6670 \$5853 \$6394 \$3468 \$3203 \$6770 \$6890 \$6936
+ gf180mcu_fd_sc_mcu9t5v0__mux4_1
X$1053 \$10249 \$9719 \$10669 \$11192 \$3468 \$3203 \$11136 \$11182 \$11193
+ gf180mcu_fd_sc_mcu9t5v0__mux4_1
X$1054 \$5476 \$5363 \$5361 \$5242 \$3468 \$3203 \$5358 \$5473 \$5475
+ gf180mcu_fd_sc_mcu9t5v0__mux4_1
X$1055 \$10270 \$9923 \$10680 \$11541 \$3468 \$3203 \$13035 \$13083 \$13353
+ gf180mcu_fd_sc_mcu9t5v0__mux4_1
X$1056 \$5862 \$6016 \$6120 \$5910 \$3468 \$3203 \$6001 \$6105 \$6123
+ gf180mcu_fd_sc_mcu9t5v0__mux4_1
X$1057 \$4531 \$4534 \$4535 \$4138 \$3468 \$3203 \$4434 \$4567 \$4724
+ gf180mcu_fd_sc_mcu9t5v0__mux4_1
X$1058 \$11851 \$9600 \$12392 \$10934 \$3468 \$3203 \$12260 \$12376 \$12390
+ gf180mcu_fd_sc_mcu9t5v0__mux4_1
X$1059 \$10030 \$10032 \$10518 \$10236 \$3468 \$3203 \$10391 \$10514 \$10519
+ gf180mcu_fd_sc_mcu9t5v0__mux4_1
X$1060 \$10632 \$9903 \$10790 \$10904 \$3468 \$3203 \$10901 \$11025 \$10791
+ gf180mcu_fd_sc_mcu9t5v0__mux4_1
X$1061 \$9103 \$9105 \$9220 \$9217 \$3468 \$3203 \$9337 \$9221 \$9340
+ gf180mcu_fd_sc_mcu9t5v0__mux4_1
X$1062 \$6677 \$6943 \$6524 \$6371 \$3468 \$3203 \$6770 \$6616 \$6679
+ gf180mcu_fd_sc_mcu9t5v0__mux4_1
X$1063 \$9602 \$9475 \$10268 \$9924 \$3468 \$3203 \$10630 \$10514 \$10684
+ gf180mcu_fd_sc_mcu9t5v0__mux4_1
X$1064 \$7435 \$7705 \$7968 \$7969 \$3468 \$3203 \$8063 \$7947 \$7970
+ gf180mcu_fd_sc_mcu9t5v0__mux4_1
X$1065 \$9121 \$8859 \$8693 \$8692 \$3468 \$3203 \$8834 \$8717 \$8860
+ gf180mcu_fd_sc_mcu9t5v0__mux4_1
X$1066 \$8836 \$8840 \$8838 \$8535 \$3468 \$3203 \$8834 \$8717 \$8839
+ gf180mcu_fd_sc_mcu9t5v0__mux4_1
X$1067 \$8201 \$7942 \$7700 \$8323 \$3468 \$3203 \$8301 \$8183 \$8202
+ gf180mcu_fd_sc_mcu9t5v0__mux4_1
X$1068 \$11829 \$10285 \$12375 \$10780 \$3468 \$3203 \$12486 \$12376 \$12488
+ gf180mcu_fd_sc_mcu9t5v0__mux4_1
X$1069 \$7306 \$7418 \$7158 \$7159 \$3468 \$3203 \$7526 \$7417 \$7533
+ gf180mcu_fd_sc_mcu9t5v0__mux4_1
X$1070 \$9705 \$9704 \$9750 \$9752 \$3468 \$3203 \$9748 \$9703 \$9753
+ gf180mcu_fd_sc_mcu9t5v0__mux4_1
X$1071 \$4691 \$4689 \$4719 \$4693 \$3468 \$3203 \$4702 \$4567 \$4561
+ gf180mcu_fd_sc_mcu9t5v0__mux4_1
X$1072 \$10238 \$9581 \$10788 \$11515 \$3468 \$3203 \$11675 \$11555 \$11685
+ gf180mcu_fd_sc_mcu9t5v0__mux4_1
X$1073 \$5491 \$5111 \$6011 \$6012 \$3468 \$3203 \$6001 \$5833 \$5895
+ gf180mcu_fd_sc_mcu9t5v0__mux4_1
X$1074 \$4984 \$6003 \$5604 \$5601 \$3468 \$3203 \$6001 \$5833 \$5882
+ gf180mcu_fd_sc_mcu9t5v0__mux4_1
X$1075 \$6388 \$6139 \$6106 \$6348 \$3468 \$3203 \$6497 \$6387 \$6498
+ gf180mcu_fd_sc_mcu9t5v0__mux4_1
X$1076 \$12017 \$10640 \$11970 \$10799 \$3468 \$3203 \$12260 \$11993 \$12148
+ gf180mcu_fd_sc_mcu9t5v0__mux4_1
X$1077 \$5892 \$5851 \$7174 \$6364 \$3468 \$3203 \$7047 \$6890 \$6897
+ gf180mcu_fd_sc_mcu9t5v0__mux4_1
X$1078 \$11698 \$9918 \$12508 \$10931 \$3468 \$3203 \$13035 \$12930 \$13050
+ gf180mcu_fd_sc_mcu9t5v0__mux4_1
X$1079 \$9779 \$9083 \$8856 \$9781 \$3468 \$3203 \$9748 \$9703 \$9587
+ gf180mcu_fd_sc_mcu9t5v0__mux4_1
X$1080 \$7799 \$7800 \$7305 \$7685 \$3468 \$3203 \$7797 \$7688 \$7801
+ gf180mcu_fd_sc_mcu9t5v0__mux4_1
X$1081 \$6345 \$6891 \$6922 \$6772 \$3468 \$3203 \$7047 \$6890 \$7049
+ gf180mcu_fd_sc_mcu9t5v0__mux4_1
X$1082 \$14157 \$14151 \$14034 \$3203 gf180mcu_fd_sc_mcu9t5v0__buf_8
X$1083 \$9242 \$9127 \$3203 \$9102 \$9221 \$9122 gf180mcu_fd_sc_mcu9t5v0__mux2_1
X$1084 \$4200 \$4212 \$4199 \$3212 \$4173 \$4314 \$4415
+ gf180mcu_fd_sc_mcu9t5v0__aoi22_1
X$1085 \$4677 \$4674 \$3214 \$4982 \$4702 \$4567 \$4699
+ gf180mcu_fd_sc_mcu9t5v0__aoi211_1
X$1086 \$3216 \$7526 \$7417 \$7537 gf180mcu_fd_sc_mcu9t5v0__clkinv_1
X$1087 \$5891 \$7539 \$3216 \$7526 \$7688 gf180mcu_fd_sc_mcu9t5v0__dffq_2
X$1088 \$4677 \$4997 \$3218 \$4982 \$4951 \$5106 \$5105
+ gf180mcu_fd_sc_mcu9t5v0__aoi211_1
X$1089 \$3220 \$4219 \$4318 \$4204 \$4569 \$4173 \$4314 \$4206
+ gf180mcu_fd_sc_mcu9t5v0__aoi221_1
X$1090 \$5481 \$4149 \$3220 \$4173 \$4041 gf180mcu_fd_sc_mcu9t5v0__dffq_2
X$1091 \$3220 \$4044 \$4196 \$4173 \$4314 \$4149 gf180mcu_fd_sc_mcu9t5v0__mux2_1
X$1092 \$3703 \$3238 \$3338 \$3221 gf180mcu_fd_sc_mcu9t5v0__buf_8
X$1093 \$3222 \$3341 \$3332 \$3351 \$3338 \$3360 gf180mcu_fd_sc_mcu9t5v0__mux2_1
X$1094 \$3480 \$3223 \$3351 \$3338 \$3365 gf180mcu_fd_sc_mcu9t5v0__nand2_1
X$1095 \$3224 \$3598 \$4029 \$3931 \$4041 \$3714 gf180mcu_fd_sc_mcu9t5v0__mux2_1
X$1096 \$3225 \$3367 \$3229 \$3351 \$3338 \$3364 gf180mcu_fd_sc_mcu9t5v0__mux2_1
X$1097 \$3226 \$3601 \$3357 \$3581 \$3463 \$3600 gf180mcu_fd_sc_mcu9t5v0__mux2_1
X$1098 \$3227 \$3819 \$4029 \$3931 \$4041 \$3926 gf180mcu_fd_sc_mcu9t5v0__mux2_1
X$1099 \$12379 \$13341 \$13083 \$3229 gf180mcu_fd_sc_mcu9t5v0__buf_12
X$1100 \$6792 \$6789 \$7317 \$7065 \$3229 \$3334 \$7304 \$7417 \$7294
+ gf180mcu_fd_sc_mcu9t5v0__mux4_1
X$1101 \$5382 \$5504 \$5234 \$5505 \$3229 \$3230 \$5358 \$5473 \$5507
+ gf180mcu_fd_sc_mcu9t5v0__mux4_1
X$1102 \$12276 \$12157 \$12275 \$12155 \$3229 \$3334 \$12260 \$12376 \$12386
+ gf180mcu_fd_sc_mcu9t5v0__mux4_1
X$1103 \$4719 \$4693 \$4691 \$4689 \$3229 \$3230 \$4702 \$4849 \$4860
+ gf180mcu_fd_sc_mcu9t5v0__mux4_1
X$1104 \$5231 \$5503 \$6370 \$5635 \$3229 \$3334 \$5735 \$5833 \$5863
+ gf180mcu_fd_sc_mcu9t5v0__mux4_1
X$1105 \$8978 \$8863 \$8702 \$8700 \$3229 \$3230 \$9102 \$9221 \$9240
+ gf180mcu_fd_sc_mcu9t5v0__mux4_1
X$1106 \$10268 \$9924 \$9602 \$9475 \$3229 \$3230 \$10391 \$10514 \$10419
+ gf180mcu_fd_sc_mcu9t5v0__mux4_1
X$1107 \$6904 \$6905 \$6952 \$6949 \$3229 \$3334 \$7526 \$7688 \$7555
+ gf180mcu_fd_sc_mcu9t5v0__mux4_1
X$1108 \$6401 \$6680 \$6377 \$6640 \$3229 \$3230 \$6770 \$6890 \$6910
+ gf180mcu_fd_sc_mcu9t5v0__mux4_1
X$1109 \$11330 \$11847 \$11527 \$11730 \$3229 \$3334 \$11675 \$11827 \$11845
+ gf180mcu_fd_sc_mcu9t5v0__mux4_1
X$1110 \$11166 \$11207 \$11208 \$11205 \$3229 \$3334 \$11306 \$11555 \$11209
+ gf180mcu_fd_sc_mcu9t5v0__mux4_1
X$1111 \$6011 \$6012 \$5491 \$5111 \$3229 \$3230 \$6001 \$6105 \$6115
+ gf180mcu_fd_sc_mcu9t5v0__mux4_1
X$1112 \$5374 \$5490 \$5494 \$5740 \$3229 \$3230 \$5358 \$5473 \$5856
+ gf180mcu_fd_sc_mcu9t5v0__mux4_1
X$1113 \$7706 \$7818 \$8093 \$8208 \$3229 \$3230 \$7797 \$7947 \$8090
+ gf180mcu_fd_sc_mcu9t5v0__mux4_1
X$1114 \$7546 \$7928 \$7581 \$7544 \$3229 \$3334 \$8063 \$8183 \$8196
+ gf180mcu_fd_sc_mcu9t5v0__mux4_1
X$1115 \$9734 \$10414 \$10293 \$10412 \$3229 \$3334 \$10391 \$10514 \$10536
+ gf180mcu_fd_sc_mcu9t5v0__mux4_1
X$1116 \$6524 \$6371 \$6677 \$6943 \$3229 \$3230 \$6497 \$6616 \$6639
+ gf180mcu_fd_sc_mcu9t5v0__mux4_1
X$1117 \$10051 \$9802 \$9926 \$9787 \$3229 \$3230 \$10391 \$10514 \$10300
+ gf180mcu_fd_sc_mcu9t5v0__mux4_1
X$1118 \$11970 \$10799 \$12017 \$10640 \$3229 \$3230 \$11956 \$11993 \$12018
+ gf180mcu_fd_sc_mcu9t5v0__mux4_1
X$1119 \$12689 \$13232 \$11975 \$12557 \$3229 \$3334 \$13341 \$13452 \$13236
+ gf180mcu_fd_sc_mcu9t5v0__mux4_1
X$1120 \$4217 \$4748 \$4750 \$4749 \$3229 \$3334 \$4702 \$4849 \$4751
+ gf180mcu_fd_sc_mcu9t5v0__mux4_1
X$1121 \$4160 \$4756 \$4754 \$4428 \$3229 \$3334 \$4702 \$4849 \$4755
+ gf180mcu_fd_sc_mcu9t5v0__mux4_1
X$1122 \$8981 \$8739 \$9128 \$8862 \$3229 \$3230 \$9337 \$9221 \$9241
+ gf180mcu_fd_sc_mcu9t5v0__mux4_1
X$1123 \$7968 \$7969 \$7435 \$7705 \$3229 \$3230 \$8063 \$7947 \$8089
+ gf180mcu_fd_sc_mcu9t5v0__mux4_1
X$1124 \$10679 \$11214 \$10275 \$9094 \$3229 \$3230 \$12260 \$11993 \$12158
+ gf180mcu_fd_sc_mcu9t5v0__mux4_1
X$1125 \$12392 \$10934 \$11851 \$9600 \$3229 \$3230 \$12260 \$11993 \$12391
+ gf180mcu_fd_sc_mcu9t5v0__mux4_1
X$1126 \$6682 \$6379 \$6960 \$6950 \$3229 \$3230 \$7047 \$6890 \$6957
+ gf180mcu_fd_sc_mcu9t5v0__mux4_1
X$1127 \$5644 \$5266 \$5870 \$5642 \$3229 \$3230 \$5735 \$5473 \$5868
+ gf180mcu_fd_sc_mcu9t5v0__mux4_1
X$1128 \$10299 \$10676 \$10535 \$10645 \$3229 \$3334 \$10630 \$10514 \$10538
+ gf180mcu_fd_sc_mcu9t5v0__mux4_1
X$1129 \$9464 \$9783 \$9782 \$9612 \$3229 \$3334 \$10022 \$9900 \$10254
+ gf180mcu_fd_sc_mcu9t5v0__mux4_1
X$1130 \$12385 \$12688 \$12025 \$12500 \$3229 \$3334 \$12786 \$12526 \$12909
+ gf180mcu_fd_sc_mcu9t5v0__mux4_1
X$1131 \$6632 \$6628 \$6630 \$6514 \$3229 \$3334 \$7047 \$6890 \$6941
+ gf180mcu_fd_sc_mcu9t5v0__mux4_1
X$1132 \$4214 \$4712 \$4576 \$4577 \$3229 \$3334 \$4702 \$4567 \$4711
+ gf180mcu_fd_sc_mcu9t5v0__mux4_1
X$1133 \$9359 \$9460 \$9116 \$9231 \$3229 \$3230 \$9337 \$9221 \$9361
+ gf180mcu_fd_sc_mcu9t5v0__mux4_1
X$1134 \$8856 \$9781 \$9779 \$9083 \$3229 \$3230 \$10022 \$9900 \$10043
+ gf180mcu_fd_sc_mcu9t5v0__mux4_1
X$1135 \$11196 \$12382 \$11971 \$11972 \$3229 \$3334 \$12786 \$12526 \$12677
+ gf180mcu_fd_sc_mcu9t5v0__mux4_1
X$1136 \$4583 \$5013 \$4759 \$4758 \$3229 \$3334 \$4951 \$4849 \$5226
+ gf180mcu_fd_sc_mcu9t5v0__mux4_1
X$1137 \$10669 \$11192 \$10249 \$9719 \$3229 \$3230 \$11306 \$11182 \$12015
+ gf180mcu_fd_sc_mcu9t5v0__mux4_1
X$1138 \$6120 \$5910 \$5862 \$6016 \$3229 \$3230 \$6001 \$5833 \$6121
+ gf180mcu_fd_sc_mcu9t5v0__mux4_1
X$1139 \$3726 \$3929 \$3494 \$4187 \$3229 \$3230 \$4173 \$4041 \$4167
+ gf180mcu_fd_sc_mcu9t5v0__mux4_1
X$1140 \$6786 \$6785 \$3229 \$6770 \$6890 \$7175 gf180mcu_fd_sc_mcu9t5v0__mux2_1
X$1141 \$9233 \$8733 \$3229 \$9337 \$9221 \$9363 gf180mcu_fd_sc_mcu9t5v0__mux2_1
X$1142 \$13049 \$12944 \$3229 \$13035 \$12930 \$13235
+ gf180mcu_fd_sc_mcu9t5v0__mux2_1
X$1143 \$3703 \$13035 \$13083 \$3230 gf180mcu_fd_sc_mcu9t5v0__buf_12
X$1144 \$10905 \$11515 \$11517 \$9581 \$9706 \$3230 \$11306 \$11555 \$11518
+ gf180mcu_fd_sc_mcu9t5v0__mux4_1
X$1145 \$9750 \$9752 \$9705 \$9704 \$6775 \$3230 \$9608 \$9703 \$9572
+ gf180mcu_fd_sc_mcu9t5v0__mux4_1
X$1146 \$8692 \$8323 \$8859 \$7942 \$3334 \$3230 \$8572 \$8717 \$8733
+ gf180mcu_fd_sc_mcu9t5v0__mux4_1
X$1147 \$10931 \$11541 \$9918 \$9923 \$3334 \$3230 \$12786 \$12930 \$12944
+ gf180mcu_fd_sc_mcu9t5v0__mux4_1
X$1148 \$12375 \$10780 \$11829 \$10285 \$12379 \$3230 \$12260 \$12376 \$12377
+ gf180mcu_fd_sc_mcu9t5v0__mux4_1
X$1149 \$8693 \$7700 \$9121 \$8201 \$3334 \$3230 \$9102 \$9221 \$9233
+ gf180mcu_fd_sc_mcu9t5v0__mux4_1
X$1150 \$5853 \$7174 \$6788 \$5892 \$3334 \$3230 \$7047 \$6890 \$6786
+ gf180mcu_fd_sc_mcu9t5v0__mux4_1
X$1151 \$6394 \$6364 \$6670 \$5851 \$3334 \$3230 \$6770 \$6616 \$6785
+ gf180mcu_fd_sc_mcu9t5v0__mux4_1
X$1152 \$12508 \$10680 \$11698 \$10270 \$3334 \$3230 \$13035 \$12930 \$13049
+ gf180mcu_fd_sc_mcu9t5v0__mux4_1
X$1153 \$10790 \$10904 \$10632 \$9903 \$12379 \$3230 \$11136 \$11025 \$11184
+ gf180mcu_fd_sc_mcu9t5v0__mux4_1
X$1154 \$10518 \$10236 \$10030 \$10032 \$4729 \$3230 \$10022 \$9900 \$10031
+ gf180mcu_fd_sc_mcu9t5v0__mux4_1
X$1155 \$11994 \$10788 \$11831 \$10238 \$9706 \$3230 \$12260 \$11993 \$12136
+ gf180mcu_fd_sc_mcu9t5v0__mux4_1
X$1156 \$11026 \$11179 \$10393 \$10037 \$12379 \$3230 \$12786 \$12526 \$12660
+ gf180mcu_fd_sc_mcu9t5v0__mux4_1
X$1157 \$3231 \$3718 \$4029 \$3931 \$4041 \$3927 gf180mcu_fd_sc_mcu9t5v0__mux2_1
X$1158 \$3336 \$3232 \$3334 \$3238 \$3338 \$3348 gf180mcu_fd_sc_mcu9t5v0__mux2_1
X$1159 \$4677 \$3233 \$4441 \$4221 \$4173 \$4314 \$4170
+ gf180mcu_fd_sc_mcu9t5v0__oai22_1
X$1160 \$3236 \$4219 \$4210 \$4428 \$4569 \$4173 \$4314 \$4222
+ gf180mcu_fd_sc_mcu9t5v0__aoi221_1
X$1161 \$3236 \$3931 \$4041 \$3928 gf180mcu_fd_sc_mcu9t5v0__clkinv_1
X$1162 \$3480 \$3237 \$3238 \$3338 \$3337 gf180mcu_fd_sc_mcu9t5v0__nand2_1
X$1163 \$3338 \$3238 gf180mcu_fd_sc_mcu9t5v0__filltie
X$1164 \$3338 \$3238 gf180mcu_fd_sc_mcu9t5v0__filltie
X$1165 \$3338 \$3238 gf180mcu_fd_sc_mcu9t5v0__filltie
X$1166 \$3338 \$3238 gf180mcu_fd_sc_mcu9t5v0__filltie
X$1167 \$3338 \$3238 gf180mcu_fd_sc_mcu9t5v0__filltie
X$1168 \$3338 \$3238 gf180mcu_fd_sc_mcu9t5v0__filltie
X$1169 \$3338 \$3238 gf180mcu_fd_sc_mcu9t5v0__endcap
X$1170 \$3241 \$3474 \$3332 \$3351 \$3463 \$3475 gf180mcu_fd_sc_mcu9t5v0__mux2_1
X$1171 \$4160 \$4212 \$4199 \$3242 \$4173 \$4041 \$4185
+ gf180mcu_fd_sc_mcu9t5v0__aoi22_1
X$1172 \$5736 \$5840 \$3328 \$6001 \$5833 \$5842
+ gf180mcu_fd_sc_mcu9t5v0__aoi21_1
X$1173 \$3328 \$4043 \$4434 \$4314 \$4418 gf180mcu_fd_sc_mcu9t5v0__nand2_1
X$1174 \$3329 \$3328 \$4142 \$4173 \$4041 \$4176 gf180mcu_fd_sc_mcu9t5v0__mux2_1
X$1175 \$13492 \$13500 \$13498 \$13623 \$13452 \$3328
+ gf180mcu_fd_sc_mcu9t5v0__mux2_1
X$1176 \$3328 \$4733 \$4991 \$5207 \$5106 \$4961 gf180mcu_fd_sc_mcu9t5v0__mux2_1
X$1177 \$3329 \$6932 \$7576 \$7304 \$7160 \$7279
+ gf180mcu_fd_sc_mcu9t5v0__nand3_1
X$1178 \$13849 \$3329 \$13500 \$13887 \$13881 \$13729 \$13848
+ gf180mcu_fd_sc_mcu9t5v0__aoi22_1
X$1179 \$3329 \$4434 \$4567 \$4419 gf180mcu_fd_sc_mcu9t5v0__clkinv_1
X$1180 \$7270 \$3329 \$6343 \$7047 \$7160 \$7155 gf180mcu_fd_sc_mcu9t5v0__mux2_1
X$1181 \$14006 \$14009 \$13226 \$13881 \$14034 \$3329
+ gf180mcu_fd_sc_mcu9t5v0__mux2_1
X$1182 \$3329 \$4976 \$4972 \$4951 \$5106 \$4975 gf180mcu_fd_sc_mcu9t5v0__mux2_1
X$1183 \$3329 \$4410 \$4134 \$4434 \$4314 \$4433 gf180mcu_fd_sc_mcu9t5v0__mux2_1
X$1184 \$4209 \$5109 \$4963 \$4542 \$4729 \$3332 \$4951 \$5106 \$5001
+ gf180mcu_fd_sc_mcu9t5v0__mux4_1
X$1185 \$4205 \$4737 \$4736 \$4204 \$4729 \$3332 \$4702 \$4849 \$4682
+ gf180mcu_fd_sc_mcu9t5v0__mux4_1
X$1186 \$4203 \$5107 \$4734 \$4680 \$4729 \$3332 \$4702 \$4849 \$4681
+ gf180mcu_fd_sc_mcu9t5v0__mux4_1
X$1187 \$4320 \$4423 \$4742 \$4422 \$4729 \$3332 \$4951 \$4849 \$4744
+ gf180mcu_fd_sc_mcu9t5v0__mux4_1
X$1188 \$4726 \$3581 \$3812 \$3332 gf180mcu_fd_sc_mcu9t5v0__buf_8
X$1189 \$3362 \$3477 \$3332 \$3581 \$3463 \$3595 gf180mcu_fd_sc_mcu9t5v0__mux2_1
X$1190 \$3333 \$3592 \$3357 \$3581 \$3463 \$3591 gf180mcu_fd_sc_mcu9t5v0__mux2_1
X$1191 \$9706 \$13035 \$13083 \$3334 gf180mcu_fd_sc_mcu9t5v0__buf_8
X$1192 \$6639 \$6121 \$3334 \$6497 \$6616 \$6522 gf180mcu_fd_sc_mcu9t5v0__mux2_1
X$1193 \$3375 \$3350 \$3334 \$3351 \$3463 \$4859 gf180mcu_fd_sc_mcu9t5v0__mux2_1
X$1194 \$12391 \$12158 \$3334 \$12260 \$12376 \$12277
+ gf180mcu_fd_sc_mcu9t5v0__mux2_1
X$1195 \$10043 \$9361 \$3334 \$10022 \$10282 \$10251
+ gf180mcu_fd_sc_mcu9t5v0__mux2_1
X$1196 \$5856 \$6115 \$3334 \$6001 \$6105 \$6117 gf180mcu_fd_sc_mcu9t5v0__mux2_1
X$1197 \$12018 \$12015 \$3334 \$12486 \$12376 \$12493
+ gf180mcu_fd_sc_mcu9t5v0__mux2_1
X$1198 \$3346 \$3372 \$3334 \$3351 \$3338 \$3373 gf180mcu_fd_sc_mcu9t5v0__mux2_1
X$1199 \$4860 \$4167 \$3334 \$4951 \$4849 \$4967 gf180mcu_fd_sc_mcu9t5v0__mux2_1
X$1200 \$6957 \$6910 \$3334 \$7047 \$6890 \$7319 gf180mcu_fd_sc_mcu9t5v0__mux2_1
X$1201 \$5868 \$5507 \$3334 \$6001 \$5833 \$5911 gf180mcu_fd_sc_mcu9t5v0__mux2_1
X$1202 \$8090 \$8089 \$3334 \$8301 \$8183 \$8324 gf180mcu_fd_sc_mcu9t5v0__mux2_1
X$1203 \$9241 \$9240 \$3334 \$9337 \$9221 \$9126 gf180mcu_fd_sc_mcu9t5v0__mux2_1
X$1204 \$10300 \$10419 \$3334 \$10391 \$10282 \$10418
+ gf180mcu_fd_sc_mcu9t5v0__mux2_1
X$1205 \$3335 \$4219 \$4210 \$4749 \$4173 \$4314 \$4218
+ gf180mcu_fd_sc_mcu9t5v0__aoi22_1
X$1206 \$3335 \$3931 \$3812 \$3717 gf180mcu_fd_sc_mcu9t5v0__clkinv_1
X$1207 \$4426 \$4034 \$3335 \$4173 \$4041 gf180mcu_fd_sc_mcu9t5v0__dffq_2
X$1208 \$3483 \$3611 \$3337 \$3581 \$3463 \$3612
+ gf180mcu_fd_sc_mcu9t5v0__nand3_1
X$1209 \$3368 \$3344 \$3351 \$3338 \$3366 gf180mcu_fd_sc_mcu9t5v0__nand2_1
X$1210 \$3338 \$3351 gf180mcu_fd_sc_mcu9t5v0__filltie
X$1211 \$3338 \$3351 gf180mcu_fd_sc_mcu9t5v0__filltie
X$1212 \$3338 \$3351 gf180mcu_fd_sc_mcu9t5v0__filltie
X$1213 \$3338 \$3351 gf180mcu_fd_sc_mcu9t5v0__filltie
X$1214 \$3338 \$3351 gf180mcu_fd_sc_mcu9t5v0__filltie
X$1215 \$3338 \$3351 gf180mcu_fd_sc_mcu9t5v0__filltie
X$1216 \$3353 \$3356 \$3357 \$3351 \$3338 \$3355 gf180mcu_fd_sc_mcu9t5v0__mux2_1
X$1217 \$3338 \$3351 gf180mcu_fd_sc_mcu9t5v0__endcap
X$1218 \$4681 \$3339 \$4706 \$4702 \$4567 \$5844 gf180mcu_fd_sc_mcu9t5v0__mux2_1
X$1219 \$3480 \$3340 \$3581 \$3812 \$3815 gf180mcu_fd_sc_mcu9t5v0__nor2_1
X$1220 \$3342 \$4219 \$4210 \$4422 \$4173 \$4314 \$4211
+ gf180mcu_fd_sc_mcu9t5v0__aoi22_1
X$1221 \$3342 \$4424 \$4196 \$4434 \$4314 \$4155 gf180mcu_fd_sc_mcu9t5v0__mux2_1
X$1222 \$3343 \$4219 \$4210 \$4577 \$4434 \$4314 \$4425
+ gf180mcu_fd_sc_mcu9t5v0__aoi22_1
X$1223 \$3343 \$3931 \$4041 \$4030 gf180mcu_fd_sc_mcu9t5v0__clkinv_1
X$1224 \$3480 \$3345 \$3351 \$3463 \$3481 gf180mcu_fd_sc_mcu9t5v0__nand2_1
X$1225 \$3368 \$3347 \$3351 \$3463 \$3482 gf180mcu_fd_sc_mcu9t5v0__nand2_1
X$1226 \$4755 \$3348 \$4965 \$4951 \$4849 \$4966 gf180mcu_fd_sc_mcu9t5v0__mux2_1
X$1227 \$3349 \$3719 \$4029 \$3581 \$3812 \$3820 gf180mcu_fd_sc_mcu9t5v0__mux2_1
X$1228 \$3483 \$3482 \$3481 \$3351 \$3463 \$4579
+ gf180mcu_fd_sc_mcu9t5v0__nand3_1
X$1229 \$3480 \$3470 \$3351 \$3463 \$3471 gf180mcu_fd_sc_mcu9t5v0__nor2_1
X$1230 \$3368 \$3487 \$3351 \$3463 \$3606 gf180mcu_fd_sc_mcu9t5v0__nand2_1
X$1231 \$3480 \$3374 \$3351 \$3463 \$3484 gf180mcu_fd_sc_mcu9t5v0__nand2_1
X$1232 \$3483 \$3366 \$3365 \$3351 \$3463 \$3713
+ gf180mcu_fd_sc_mcu9t5v0__nand3_1
X$1233 \$3359 \$3473 \$3357 \$3351 \$3463 \$3472 gf180mcu_fd_sc_mcu9t5v0__mux2_1
X$1234 \$4315 \$3702 \$3465 \$3351 \$3463 \$3464 gf180mcu_fd_sc_mcu9t5v0__mux2_1
X$1235 \$3463 \$3351 gf180mcu_fd_sc_mcu9t5v0__filltie
X$1236 \$3463 \$3351 gf180mcu_fd_sc_mcu9t5v0__filltie
X$1237 \$3463 \$3351 gf180mcu_fd_sc_mcu9t5v0__filltie
X$1238 \$3463 \$3351 gf180mcu_fd_sc_mcu9t5v0__filltie
X$1239 \$3463 \$3351 gf180mcu_fd_sc_mcu9t5v0__filltie
X$1240 \$3463 \$3351 gf180mcu_fd_sc_mcu9t5v0__filltie
X$1241 \$3463 \$3351 gf180mcu_fd_sc_mcu9t5v0__endcap
X$1242 \$10919 \$10901 \$11025 \$3352 gf180mcu_fd_sc_mcu9t5v0__buf_8
X$1243 \$8961 \$9343 \$3352 \$9337 \$9457 \$9106 gf180mcu_fd_sc_mcu9t5v0__mux2_1
X$1244 \$8186 \$8302 \$3352 \$8834 \$8963 \$8681 gf180mcu_fd_sc_mcu9t5v0__mux2_1
X$1245 \$10241 \$10240 \$3352 \$10630 \$10782 \$10664
+ gf180mcu_fd_sc_mcu9t5v0__mux2_1
X$1246 \$7273 \$7272 \$3352 \$7526 \$7688 \$7566 gf180mcu_fd_sc_mcu9t5v0__mux2_1
X$1247 \$10902 \$10233 \$3352 \$11136 \$11182 \$11027
+ gf180mcu_fd_sc_mcu9t5v0__mux2_1
X$1248 \$6347 \$6346 \$3352 \$6497 \$6616 \$6618 gf180mcu_fd_sc_mcu9t5v0__mux2_1
X$1249 \$4191 \$4315 \$3352 \$3581 \$3812 \$3704 gf180mcu_fd_sc_mcu9t5v0__mux2_1
X$1250 \$10027 \$9905 \$3352 \$11136 \$11025 \$11143
+ gf180mcu_fd_sc_mcu9t5v0__mux2_1
X$1251 \$5244 \$5360 \$3352 \$6770 \$6616 \$6653 gf180mcu_fd_sc_mcu9t5v0__mux2_1
X$1252 \$3587 \$3581 \$3463 \$3354 gf180mcu_fd_sc_mcu9t5v0__buf_8
X$1253 \$4419 \$4043 \$4418 \$4434 \$4314 \$3356
+ gf180mcu_fd_sc_mcu9t5v0__oai21_1
X$1254 \$9125 \$3357 \$9123 \$9120 \$9124 \$9102 \$9221 \$9234
+ gf180mcu_fd_sc_mcu9t5v0__oai221_1
X$1255 \$11854 \$3357 \$11734 \$9120 \$11852 \$11675 \$11827 \$11853
+ gf180mcu_fd_sc_mcu9t5v0__oai221_1
X$1256 \$9804 \$3357 \$9928 \$9120 \$9803 \$9748 \$9900 \$9929
+ gf180mcu_fd_sc_mcu9t5v0__oai221_1
X$1257 \$10410 \$3357 \$10533 \$9120 \$10534 \$10391 \$10514 \$10532
+ gf180mcu_fd_sc_mcu9t5v0__oai221_1
X$1258 \$11217 \$3357 \$11215 \$9120 \$11333 \$11136 \$11182 \$11216
+ gf180mcu_fd_sc_mcu9t5v0__oai221_1
X$1259 \$10648 \$3357 \$10935 \$9120 \$10685 \$10630 \$10514 \$10649
+ gf180mcu_fd_sc_mcu9t5v0__oai221_1
X$1260 \$9243 \$3357 \$9739 \$9120 \$9365 \$9337 \$9221 \$9366
+ gf180mcu_fd_sc_mcu9t5v0__oai221_1
X$1261 \$11701 \$3357 \$11700 \$9120 \$11850 \$11675 \$11555 \$11702
+ gf180mcu_fd_sc_mcu9t5v0__oai221_1
X$1262 \$11315 \$3357 \$11194 \$9120 \$11317 \$11306 \$11182 \$11318
+ gf180mcu_fd_sc_mcu9t5v0__oai221_1
X$1263 \$8326 \$3357 \$8359 \$9120 \$8325 \$8301 \$8183 \$8327
+ gf180mcu_fd_sc_mcu9t5v0__oai221_1
X$1264 \$11694 \$11675 \$11555 \$3357 gf180mcu_fd_sc_mcu9t5v0__buf_8
X$1265 \$3724 \$4037 \$3357 \$3931 \$4041 \$3937 gf180mcu_fd_sc_mcu9t5v0__mux2_1
X$1266 \$6788 \$7426 \$3357 \$7304 \$7417 \$7427 gf180mcu_fd_sc_mcu9t5v0__mux2_1
X$1267 \$6677 \$6944 \$3357 \$7047 \$7160 \$7182 gf180mcu_fd_sc_mcu9t5v0__mux2_1
X$1268 \$7306 \$7421 \$3357 \$7304 \$7417 \$7420 gf180mcu_fd_sc_mcu9t5v0__mux2_1
X$1269 \$11829 \$12003 \$3357 \$11675 \$11827 \$11833
+ gf180mcu_fd_sc_mcu9t5v0__mux2_1
X$1270 \$10632 \$10521 \$3357 \$10391 \$10514 \$10520
+ gf180mcu_fd_sc_mcu9t5v0__mux2_1
X$1271 \$8188 \$7952 \$3357 \$8063 \$7947 \$8067 gf180mcu_fd_sc_mcu9t5v0__mux2_1
X$1272 \$5476 \$5365 \$3357 \$5358 \$5240 \$5364 gf180mcu_fd_sc_mcu9t5v0__mux2_1
X$1273 \$6388 \$6501 \$3357 \$6497 \$6387 \$6500 gf180mcu_fd_sc_mcu9t5v0__mux2_1
X$1274 \$11831 \$11563 \$3357 \$11675 \$11555 \$11832
+ gf180mcu_fd_sc_mcu9t5v0__mux2_1
X$1275 \$9705 \$9348 \$3357 \$9608 \$9457 \$9579 gf180mcu_fd_sc_mcu9t5v0__mux2_1
X$1276 \$3485 \$3609 \$3357 \$3581 \$3463 \$3608 gf180mcu_fd_sc_mcu9t5v0__mux2_1
X$1277 \$5494 \$5628 \$3357 \$5735 \$5473 \$5495 gf180mcu_fd_sc_mcu9t5v0__mux2_1
X$1278 \$4691 \$4761 \$3357 \$4702 \$4567 \$4717 gf180mcu_fd_sc_mcu9t5v0__mux2_1
X$1279 \$3913 \$4437 \$3357 \$3931 \$3812 \$3933 gf180mcu_fd_sc_mcu9t5v0__mux2_1
X$1280 \$3363 \$3936 \$3357 \$3581 \$3463 \$3596 gf180mcu_fd_sc_mcu9t5v0__mux2_1
X$1281 \$3602 \$3605 \$3357 \$3581 \$3463 \$3604 gf180mcu_fd_sc_mcu9t5v0__mux2_1
X$1282 \$3358 \$4219 \$4318 \$4680 \$4434 \$4567 \$4539
+ gf180mcu_fd_sc_mcu9t5v0__aoi22_1
X$1283 \$3358 \$4177 \$4196 \$4173 \$4314 \$4026 gf180mcu_fd_sc_mcu9t5v0__mux2_1
X$1284 \$5001 \$3360 \$4706 \$5207 \$5106 \$5221 gf180mcu_fd_sc_mcu9t5v0__mux2_1
X$1285 \$4711 \$3364 \$4706 \$4702 \$4849 \$4747 gf180mcu_fd_sc_mcu9t5v0__mux2_1
X$1286 \$3368 \$9340 \$9337 \$9457 \$9341 gf180mcu_fd_sc_mcu9t5v0__nor2_1
X$1287 \$3368 \$12527 \$12786 \$12930 \$12895 gf180mcu_fd_sc_mcu9t5v0__nor2_1
X$1288 \$3368 \$7049 \$7047 \$7160 \$7161 gf180mcu_fd_sc_mcu9t5v0__nor2_1
X$1289 \$3368 \$7801 \$7797 \$7947 \$7912 gf180mcu_fd_sc_mcu9t5v0__nor2_1
X$1290 \$3368 \$3585 \$3581 \$3812 \$3814 gf180mcu_fd_sc_mcu9t5v0__nor2_1
X$1291 \$3368 \$3590 \$3581 \$3812 \$3707 gf180mcu_fd_sc_mcu9t5v0__nor2_1
X$1292 \$3368 \$3712 \$3581 \$3812 \$3818 gf180mcu_fd_sc_mcu9t5v0__nor2_1
X$1293 \$3368 \$4724 \$4702 \$4849 \$4850 gf180mcu_fd_sc_mcu9t5v0__nor2_1
X$1294 \$3368 \$3593 \$3581 \$3463 \$3594 gf180mcu_fd_sc_mcu9t5v0__nor2_1
X$1295 \$3368 \$11685 \$12486 \$12376 \$12528 gf180mcu_fd_sc_mcu9t5v0__nor2_1
X$1296 \$3368 \$8839 \$8834 \$8717 \$8718 gf180mcu_fd_sc_mcu9t5v0__nor2_1
X$1297 \$9782 \$9612 \$9464 \$9783 \$3468 \$3368 \$9608 \$9703 \$9591
+ gf180mcu_fd_sc_mcu9t5v0__mux4_1
X$1298 \$3368 \$8088 \$8063 \$8183 \$8211 gf180mcu_fd_sc_mcu9t5v0__nand2_1
X$1299 \$3368 \$5258 \$5358 \$5473 \$5627 gf180mcu_fd_sc_mcu9t5v0__nand2_1
X$1300 \$3368 \$4561 \$4434 \$4567 \$4692 gf180mcu_fd_sc_mcu9t5v0__nand2_1
X$1301 \$3368 \$7318 \$7526 \$7688 \$7591 gf180mcu_fd_sc_mcu9t5v0__nand2_1
X$1302 \$3368 \$8860 \$8834 \$8963 \$8977 gf180mcu_fd_sc_mcu9t5v0__nand2_1
X$1303 \$3368 \$12148 \$12260 \$12376 \$12272 gf180mcu_fd_sc_mcu9t5v0__nand2_1
X$1304 \$3368 \$5867 \$5735 \$5833 \$5866 gf180mcu_fd_sc_mcu9t5v0__nand2_1
X$1305 \$3368 \$12390 \$12486 \$12376 \$12559 gf180mcu_fd_sc_mcu9t5v0__nand2_1
X$1306 \$3368 \$13050 \$13341 \$13083 \$13237 gf180mcu_fd_sc_mcu9t5v0__nand2_1
X$1307 \$3368 \$9587 \$9608 \$9457 \$9588 gf180mcu_fd_sc_mcu9t5v0__nand2_1
X$1308 \$3368 \$10276 \$10630 \$10514 \$10647 gf180mcu_fd_sc_mcu9t5v0__nand2_1
X$1309 \$3368 \$6795 \$7047 \$6890 \$6956 gf180mcu_fd_sc_mcu9t5v0__nand2_1
X$1310 \$3368 \$3488 \$3581 \$3463 \$3611 gf180mcu_fd_sc_mcu9t5v0__nand2_1
X$1311 \$3368 \$6936 \$7047 \$6890 \$7061 gf180mcu_fd_sc_mcu9t5v0__nand2_1
X$1312 \$14876 \$14748 \$14875 \$3368 gf180mcu_fd_sc_mcu9t5v0__buf_8
X$1313 \$5882 \$5475 \$3368 \$6001 \$6105 \$6140 gf180mcu_fd_sc_mcu9t5v0__mux2_1
X$1314 \$10519 \$10791 \$3368 \$10901 \$10782 \$10908
+ gf180mcu_fd_sc_mcu9t5v0__mux2_1
X$1315 \$4677 \$3370 \$4547 \$4546 \$4434 \$4567 \$4563
+ gf180mcu_fd_sc_mcu9t5v0__oai22_1
X$1316 \$4751 \$3373 \$4965 \$4951 \$4849 \$4964 gf180mcu_fd_sc_mcu9t5v0__mux2_1
X$1317 \$3483 \$3606 \$3484 \$3581 \$3463 \$3607
+ gf180mcu_fd_sc_mcu9t5v0__nand3_1
X$1318 \$3463 \$3581 gf180mcu_fd_sc_mcu9t5v0__filltie
X$1319 \$3463 \$3581 gf180mcu_fd_sc_mcu9t5v0__filltie
X$1320 \$3463 \$3581 gf180mcu_fd_sc_mcu9t5v0__filltie
X$1321 \$3463 \$3581 gf180mcu_fd_sc_mcu9t5v0__filltie
X$1322 \$3463 \$3581 gf180mcu_fd_sc_mcu9t5v0__filltie
X$1323 \$3463 \$3581 gf180mcu_fd_sc_mcu9t5v0__filltie
X$1324 \$3582 \$3464 \$3702 \$3581 \$3463 gf180mcu_fd_sc_mcu9t5v0__dffq_2
X$1325 \$3582 \$3583 \$3584 \$3581 \$3463 gf180mcu_fd_sc_mcu9t5v0__dffq_2
X$1326 \$3463 \$3581 gf180mcu_fd_sc_mcu9t5v0__endcap
X$1327 \$10918 \$10901 \$10782 \$3465 gf180mcu_fd_sc_mcu9t5v0__buf_8
X$1328 \$7272 \$7158 \$3465 \$7047 \$7160 \$7157 gf180mcu_fd_sc_mcu9t5v0__mux2_1
X$1329 \$10240 \$11994 \$3465 \$11956 \$11993 \$11992
+ gf180mcu_fd_sc_mcu9t5v0__mux2_1
X$1330 \$10233 \$12375 \$3465 \$12260 \$11993 \$12262
+ gf180mcu_fd_sc_mcu9t5v0__mux2_1
X$1331 \$5360 \$5361 \$3465 \$5358 \$5240 \$5359 gf180mcu_fd_sc_mcu9t5v0__mux2_1
X$1332 \$6346 \$6106 \$3465 \$6001 \$5833 \$6002 gf180mcu_fd_sc_mcu9t5v0__mux2_1
X$1333 \$9343 \$9750 \$3465 \$9748 \$9703 \$9749 gf180mcu_fd_sc_mcu9t5v0__mux2_1
X$1334 \$8302 \$8304 \$3465 \$8301 \$8183 \$8303 gf180mcu_fd_sc_mcu9t5v0__mux2_1
X$1335 \$9905 \$10790 \$3465 \$11136 \$11025 \$11139
+ gf180mcu_fd_sc_mcu9t5v0__mux2_1
X$1336 \$3466 \$3584 \$4140 \$3581 \$3812 \$3583 gf180mcu_fd_sc_mcu9t5v0__mux2_1
X$1337 \$3467 \$4219 \$4318 \$4416 \$4434 \$4314 \$4414
+ gf180mcu_fd_sc_mcu9t5v0__aoi22_1
X$1338 \$3467 \$4176 \$4196 \$4434 \$4314 \$4198 gf180mcu_fd_sc_mcu9t5v0__mux2_1
X$1339 \$15367 \$15321 \$15490 \$3468 gf180mcu_fd_sc_mcu9t5v0__buf_20
X$1340 \$7317 \$3468 \$7548 \$3480 \$7526 \$7417 \$7549
+ gf180mcu_fd_sc_mcu9t5v0__oai211_1
X$1341 \$11716 \$12380 \$11519 \$10515 \$3468 \$3480 \$12260 \$12376 \$12378
+ gf180mcu_fd_sc_mcu9t5v0__mux4_1
X$1342 \$5607 \$5839 \$6107 \$5883 \$3468 \$3480 \$6136 \$6387 \$6353
+ gf180mcu_fd_sc_mcu9t5v0__mux4_1
X$1343 \$4536 \$4989 \$4987 \$4988 \$3468 \$3480 \$4951 \$5106 \$4986
+ gf180mcu_fd_sc_mcu9t5v0__mux4_1
X$1344 \$8682 \$8538 \$8683 \$8539 \$3468 \$3480 \$8572 \$8717 \$8680
+ gf180mcu_fd_sc_mcu9t5v0__mux4_1
X$1345 \$7546 \$7928 \$7581 \$7544 \$3468 \$3480 \$7797 \$7947 \$7927
+ gf180mcu_fd_sc_mcu9t5v0__mux4_1
X$1346 \$7918 \$7917 \$7916 \$7915 \$3468 \$3480 \$7797 \$7947 \$7914
+ gf180mcu_fd_sc_mcu9t5v0__mux4_1
X$1347 \$10299 \$10676 \$10535 \$10645 \$3468 \$3480 \$10630 \$10782 \$10678
+ gf180mcu_fd_sc_mcu9t5v0__mux4_1
X$1348 \$11196 \$12382 \$11971 \$11972 \$3468 \$3480 \$12786 \$12930 \$13096
+ gf180mcu_fd_sc_mcu9t5v0__mux4_1
X$1349 \$6632 \$6628 \$6630 \$6514 \$3468 \$3480 \$7047 \$7160 \$7179
+ gf180mcu_fd_sc_mcu9t5v0__mux4_1
X$1350 \$8981 \$8739 \$8978 \$8863 \$3468 \$3480 \$9102 \$9221 \$9127
+ gf180mcu_fd_sc_mcu9t5v0__mux4_1
X$1351 \$6927 \$7167 \$7277 \$7164 \$3468 \$3480 \$7047 \$7160 \$7050
+ gf180mcu_fd_sc_mcu9t5v0__mux4_1
X$1352 \$4583 \$5013 \$4759 \$4758 \$3468 \$3480 \$4951 \$5106 \$5015
+ gf180mcu_fd_sc_mcu9t5v0__mux4_1
X$1353 \$12531 \$12530 \$10914 \$11717 \$3468 \$3480 \$12786 \$12930 \$12897
+ gf180mcu_fd_sc_mcu9t5v0__mux4_1
X$1354 \$11166 \$11207 \$11208 \$11205 \$3468 \$3480 \$11306 \$11182 \$11328
+ gf180mcu_fd_sc_mcu9t5v0__mux4_1
X$1355 \$4209 \$5109 \$4963 \$4542 \$3468 \$3480 \$4951 \$4849 \$3923
+ gf180mcu_fd_sc_mcu9t5v0__mux4_1
X$1356 \$4320 \$4423 \$4742 \$4422 \$3468 \$3480 \$4434 \$4314 \$4028
+ gf180mcu_fd_sc_mcu9t5v0__mux4_1
X$1357 \$4160 \$4756 \$4754 \$4428 \$3468 \$3480 \$4951 \$4849 \$5010
+ gf180mcu_fd_sc_mcu9t5v0__mux4_1
X$1358 \$11330 \$11847 \$11527 \$11730 \$3468 \$3480 \$11956 \$11827 \$11981
+ gf180mcu_fd_sc_mcu9t5v0__mux4_1
X$1359 \$9128 \$8862 \$8702 \$8700 \$3468 \$3480 \$9337 \$9221 \$9242
+ gf180mcu_fd_sc_mcu9t5v0__mux4_1
X$1360 \$4203 \$5107 \$4734 \$4680 \$3468 \$3480 \$4702 \$4567 \$4679
+ gf180mcu_fd_sc_mcu9t5v0__mux4_1
X$1361 \$12689 \$13232 \$11975 \$12557 \$3468 \$3480 \$13623 \$13452 \$13521
+ gf180mcu_fd_sc_mcu9t5v0__mux4_1
X$1362 \$9734 \$10414 \$10293 \$10412 \$3468 \$3480 \$10391 \$10282 \$10415
+ gf180mcu_fd_sc_mcu9t5v0__mux4_1
X$1363 \$11307 \$12663 \$10523 \$9758 \$3468 \$3480 \$13035 \$12930 \$14455
+ gf180mcu_fd_sc_mcu9t5v0__mux4_1
X$1364 \$4217 \$4748 \$4750 \$4749 \$3468 \$3480 \$4951 \$4849 \$4752
+ gf180mcu_fd_sc_mcu9t5v0__mux4_1
X$1365 \$12385 \$12688 \$12025 \$12500 \$3468 \$3480 \$12486 \$12376 \$12501
+ gf180mcu_fd_sc_mcu9t5v0__mux4_1
X$1366 \$12276 \$12157 \$12275 \$12155 \$3468 \$3480 \$12260 \$11993 \$12156
+ gf180mcu_fd_sc_mcu9t5v0__mux4_1
X$1367 \$4214 \$4712 \$4576 \$4577 \$3468 \$3480 \$4951 \$4849 \$5003
+ gf180mcu_fd_sc_mcu9t5v0__mux4_1
X$1368 \$9224 \$9107 \$9108 \$9344 \$3468 \$3480 \$9337 \$9221 \$9342
+ gf180mcu_fd_sc_mcu9t5v0__mux4_1
X$1369 \$6904 \$6905 \$6952 \$6949 \$3468 \$3480 \$7304 \$7160 \$7297
+ gf180mcu_fd_sc_mcu9t5v0__mux4_1
X$1370 \$4205 \$4737 \$4736 \$4204 \$3468 \$3480 \$4434 \$4314 \$4027
+ gf180mcu_fd_sc_mcu9t5v0__mux4_1
X$1371 \$4200 \$4730 \$4728 \$4416 \$3468 \$3480 \$4702 \$4567 \$4025
+ gf180mcu_fd_sc_mcu9t5v0__mux4_1
X$1372 \$5231 \$5503 \$6370 \$5635 \$3468 \$3480 \$5735 \$5473 \$5636
+ gf180mcu_fd_sc_mcu9t5v0__mux4_1
X$1373 \$8319 \$3468 \$7797 \$7688 \$7548 gf180mcu_fd_sc_mcu9t5v0__nand2_1
X$1374 \$6792 \$6789 \$3468 \$7304 \$7417 \$7318 gf180mcu_fd_sc_mcu9t5v0__mux2_1
X$1375 \$3480 \$3469 \$3581 \$3812 \$3706 gf180mcu_fd_sc_mcu9t5v0__nor2_1
X$1376 \$3917 \$3471 \$3589 \$3920 \$3931 \$3812 \$3921
+ gf180mcu_fd_sc_mcu9t5v0__oai31_1
X$1377 \$4145 \$4043 \$4146 \$4173 \$4041 \$3473
+ gf180mcu_fd_sc_mcu9t5v0__oai21_1
X$1378 \$4682 \$3475 \$4706 \$4702 \$4567 \$4707 gf180mcu_fd_sc_mcu9t5v0__mux2_1
X$1379 \$3476 \$7797 \$7688 \$7692 gf180mcu_fd_sc_mcu9t5v0__clkinv_1
X$1380 \$5891 \$7579 \$3476 \$7526 \$7688 gf180mcu_fd_sc_mcu9t5v0__dffq_2
X$1381 \$4677 \$4683 \$3478 \$4982 \$4702 \$4567 \$4703
+ gf180mcu_fd_sc_mcu9t5v0__aoi211_1
X$1382 \$3480 \$3479 \$3581 \$3812 \$3817 gf180mcu_fd_sc_mcu9t5v0__nor2_1
X$1383 \$3480 \$6498 \$6497 \$6616 \$6617 gf180mcu_fd_sc_mcu9t5v0__nor2_1
X$1384 \$3480 \$9753 \$9608 \$9703 \$9575 gf180mcu_fd_sc_mcu9t5v0__nor2_1
X$1385 \$3480 \$4023 \$3931 \$4041 \$4024 gf180mcu_fd_sc_mcu9t5v0__nor2_1
X$1386 \$3480 \$8337 \$8572 \$8335 \$8536 gf180mcu_fd_sc_mcu9t5v0__nor2_1
X$1387 \$3480 \$7533 \$7797 \$7688 \$7803 gf180mcu_fd_sc_mcu9t5v0__nor2_1
X$1388 \$3480 \$11995 \$12486 \$12376 \$12489 gf180mcu_fd_sc_mcu9t5v0__nor2_1
X$1389 \$3480 \$12488 \$12786 \$12526 \$12789 gf180mcu_fd_sc_mcu9t5v0__nor2_1
X$1390 \$3480 \$5895 \$6001 \$6105 \$6013 gf180mcu_fd_sc_mcu9t5v0__nand2_1
X$1391 \$3480 \$4040 \$4173 \$4314 \$4324 gf180mcu_fd_sc_mcu9t5v0__nand2_1
X$1392 \$3480 \$10684 \$10630 \$10782 \$10683 gf180mcu_fd_sc_mcu9t5v0__nand2_1
X$1393 \$3480 \$6897 \$6770 \$6890 \$7059 gf180mcu_fd_sc_mcu9t5v0__nand2_1
X$1394 \$3480 \$13353 \$13341 \$13452 \$13469 gf180mcu_fd_sc_mcu9t5v0__nand2_1
X$1395 \$3480 \$7970 \$8063 \$8183 \$8210 gf180mcu_fd_sc_mcu9t5v0__nand2_1
X$1396 \$3480 \$9461 \$9337 \$9457 \$9462 gf180mcu_fd_sc_mcu9t5v0__nand2_1
X$1397 \$3480 \$11193 \$11956 \$11993 \$12016 gf180mcu_fd_sc_mcu9t5v0__nand2_1
X$1398 \$3480 \$8202 \$8063 \$8183 \$8203 gf180mcu_fd_sc_mcu9t5v0__nand2_1
X$1399 \$3480 \$12389 \$12486 \$12376 \$12509 gf180mcu_fd_sc_mcu9t5v0__nand2_1
X$1400 \$3480 \$6909 \$7047 \$6890 \$6955 gf180mcu_fd_sc_mcu9t5v0__nand2_1
X$1401 \$3480 \$5637 \$5735 \$5473 \$5638 gf180mcu_fd_sc_mcu9t5v0__nand2_1
X$1402 \$14757 \$14748 \$14635 \$3480 gf180mcu_fd_sc_mcu9t5v0__buf_8
X$1403 \$6679 \$6123 \$3480 \$6770 \$6616 \$6678 gf180mcu_fd_sc_mcu9t5v0__mux2_1
X$1404 \$3483 \$10678 \$10682 \$5004 \$10630 \$10782 \$12690
+ gf180mcu_fd_sc_mcu9t5v0__oai211_1
X$1405 \$3483 \$5003 \$3713 \$5004 \$4951 \$5106 \$5002
+ gf180mcu_fd_sc_mcu9t5v0__oai211_1
X$1406 \$3483 \$13096 \$12019 \$5004 \$13035 \$13083 \$13097
+ gf180mcu_fd_sc_mcu9t5v0__oai211_1
X$1407 \$3483 \$5015 \$3612 \$5004 \$4951 \$5106 \$5016
+ gf180mcu_fd_sc_mcu9t5v0__oai211_1
X$1408 \$3483 \$5010 \$3607 \$5004 \$4951 \$5106 \$5011
+ gf180mcu_fd_sc_mcu9t5v0__oai211_1
X$1409 \$3483 \$4752 \$4579 \$5004 \$4702 \$4849 \$4753
+ gf180mcu_fd_sc_mcu9t5v0__oai211_1
X$1410 \$3483 \$9591 \$9589 \$5004 \$9608 \$9457 \$9727
+ gf180mcu_fd_sc_mcu9t5v0__oai211_1
X$1411 \$3483 \$10415 \$8861 \$5004 \$10391 \$10282 \$10416
+ gf180mcu_fd_sc_mcu9t5v0__oai211_1
X$1412 \$3483 \$13521 \$13523 \$5004 \$13623 \$13452 \$13522
+ gf180mcu_fd_sc_mcu9t5v0__oai211_1
X$1413 \$3483 \$7297 \$7068 \$5004 \$7304 \$7160 \$7320
+ gf180mcu_fd_sc_mcu9t5v0__oai211_1
X$1414 \$3483 \$12501 \$12691 \$5004 \$12786 \$12526 \$13102
+ gf180mcu_fd_sc_mcu9t5v0__oai211_1
X$1415 \$3483 \$5636 \$4718 \$5004 \$6001 \$5833 \$5912
+ gf180mcu_fd_sc_mcu9t5v0__oai211_1
X$1416 \$3483 \$7927 \$7060 \$5004 \$7797 \$7688 \$7808
+ gf180mcu_fd_sc_mcu9t5v0__oai211_1
X$1417 \$3483 \$7179 \$6942 \$5004 \$7304 \$7160 \$7316
+ gf180mcu_fd_sc_mcu9t5v0__oai211_1
X$1418 \$3483 \$11328 \$6162 \$5004 \$11306 \$11182 \$11731
+ gf180mcu_fd_sc_mcu9t5v0__oai211_1
X$1419 \$3483 \$11981 \$8358 \$5004 \$11956 \$11827 \$11983
+ gf180mcu_fd_sc_mcu9t5v0__oai211_1
X$1420 \$3483 \$8977 \$8203 \$8834 \$8963 \$8861
+ gf180mcu_fd_sc_mcu9t5v0__nand3_1
X$1421 \$3483 \$5627 \$6013 \$6001 \$6105 \$6942
+ gf180mcu_fd_sc_mcu9t5v0__nand3_1
X$1422 \$3483 \$10647 \$10683 \$10630 \$10782 \$10682
+ gf180mcu_fd_sc_mcu9t5v0__nand3_1
X$1423 \$3483 \$13237 \$13469 \$13341 \$13452 \$13523
+ gf180mcu_fd_sc_mcu9t5v0__nand3_1
X$1424 \$3483 \$12559 \$12509 \$12486 \$12526 \$12691
+ gf180mcu_fd_sc_mcu9t5v0__nand3_1
X$1425 \$3483 \$5866 \$5638 \$5735 \$5833 \$6162
+ gf180mcu_fd_sc_mcu9t5v0__nand3_1
X$1426 \$3483 \$7061 \$7059 \$7047 \$7160 \$7060
+ gf180mcu_fd_sc_mcu9t5v0__nand3_1
X$1427 \$3483 \$12272 \$12016 \$11956 \$11993 \$12019
+ gf180mcu_fd_sc_mcu9t5v0__nand3_1
X$1428 \$3483 \$9588 \$9462 \$9608 \$9457 \$9589
+ gf180mcu_fd_sc_mcu9t5v0__nand3_1
X$1429 \$3483 \$4692 \$4324 \$4702 \$4567 \$4718
+ gf180mcu_fd_sc_mcu9t5v0__nand3_1
X$1430 \$3483 \$8211 \$8210 \$8301 \$8183 \$8358
+ gf180mcu_fd_sc_mcu9t5v0__nand3_1
X$1431 \$3483 \$6956 \$6955 \$7047 \$6890 \$7068
+ gf180mcu_fd_sc_mcu9t5v0__nand3_1
X$1432 \$3483 \$14455 \$15321 \$15490 \$15493 gf180mcu_fd_sc_mcu9t5v0__nor2_1
X$1433 \$3483 \$12156 \$14454 \$14635 \$14524 gf180mcu_fd_sc_mcu9t5v0__nor2_1
X$1434 \$3483 \$6353 \$14454 \$14337 \$14339 gf180mcu_fd_sc_mcu9t5v0__nor2_1
X$1435 \$15753 \$15628 \$15749 \$3483 gf180mcu_fd_sc_mcu9t5v0__buf_8
X$1436 \$4156 \$3490 \$4702 \$4567 \$4584 gf180mcu_fd_sc_mcu9t5v0__nor2_1
X$1437 \$5497 \$3490 \$5358 \$5473 \$5498 gf180mcu_fd_sc_mcu9t5v0__nand2_1
X$1438 \$4158 \$3490 \$5207 \$5106 \$5114 gf180mcu_fd_sc_mcu9t5v0__nand2_1
X$1439 \$3490 \$3491 \$3701 \$4434 \$4314 \$4430 gf180mcu_fd_sc_mcu9t5v0__mux2_2
X$1440 \$5496 \$5358 \$5473 \$3490 gf180mcu_fd_sc_mcu9t5v0__buf_8
X$1441 \$3491 \$3490 \$3599 \$5358 \$5240 \$5379 gf180mcu_fd_sc_mcu9t5v0__mux2_1
X$1442 \$13515 \$3491 \$13842 \$14521 \$13881 \$13729 \$13885
+ gf180mcu_fd_sc_mcu9t5v0__aoi211_1
X$1443 \$8181 \$3491 \$6343 \$8063 \$8183 \$8180 gf180mcu_fd_sc_mcu9t5v0__mux2_1
X$1444 \$13351 \$13349 \$13226 \$13623 \$13729 \$3491
+ gf180mcu_fd_sc_mcu9t5v0__mux2_1
X$1445 \$3491 \$7682 \$4972 \$7526 \$7688 \$7681 gf180mcu_fd_sc_mcu9t5v0__mux2_1
X$1446 \$3491 \$7563 \$4134 \$7797 \$7688 \$7795 gf180mcu_fd_sc_mcu9t5v0__mux2_1
X$1447 \$3917 \$3711 \$3594 \$3710 \$3581 \$3812 \$3709
+ gf180mcu_fd_sc_mcu9t5v0__oai31_1
X$1448 \$3723 \$3610 \$3721 \$3722 \$4677 \$3581 \$3812 \$4186
+ gf180mcu_fd_sc_mcu9t5v0__aoi221_1
X$1449 \$4315 \$4191 \$3701 \$3581 \$3812 \$3813 gf180mcu_fd_sc_mcu9t5v0__mux2_2
X$1450 \$3812 \$3581 gf180mcu_fd_sc_mcu9t5v0__filltie
X$1451 \$3812 \$3581 gf180mcu_fd_sc_mcu9t5v0__filltie
X$1452 \$3812 \$3581 gf180mcu_fd_sc_mcu9t5v0__filltie
X$1453 \$3812 \$3581 gf180mcu_fd_sc_mcu9t5v0__filltie
X$1454 \$3812 \$3581 gf180mcu_fd_sc_mcu9t5v0__filltie
X$1455 \$3812 \$3581 gf180mcu_fd_sc_mcu9t5v0__filltie
X$1456 \$3812 \$3581 gf180mcu_fd_sc_mcu9t5v0__endcap
X$1457 \$3919 \$5207 \$5106 \$3582 gf180mcu_fd_sc_mcu9t5v0__clkbuf_8
X$1458 \$3582 \$5207 \$5106 \$I54383 gf180mcu_fd_sc_mcu9t5v0__clkinv_1
X$1459 \$3582 \$5212 \$5211 \$5207 \$5240 gf180mcu_fd_sc_mcu9t5v0__dffq_2
X$1460 \$3582 \$5359 \$5361 \$5358 \$5473 gf180mcu_fd_sc_mcu9t5v0__dffq_2
X$1461 \$3582 \$4983 \$4984 \$5207 \$5240 gf180mcu_fd_sc_mcu9t5v0__dffq_2
X$1462 \$3582 \$6002 \$6106 \$6001 \$6105 gf180mcu_fd_sc_mcu9t5v0__dffq_2
X$1463 \$3582 \$4174 \$4137 \$4173 \$4314 gf180mcu_fd_sc_mcu9t5v0__dffq_2
X$1464 \$3582 \$5600 \$5601 \$5735 \$5833 gf180mcu_fd_sc_mcu9t5v0__dffq_2
X$1465 \$3582 \$6893 \$5604 \$6770 \$6890 gf180mcu_fd_sc_mcu9t5v0__dffq_2
X$1466 \$3582 \$4175 \$4138 \$4173 \$4314 gf180mcu_fd_sc_mcu9t5v0__dffq_2
X$1467 \$3582 \$5245 \$5363 \$5358 \$5473 gf180mcu_fd_sc_mcu9t5v0__dffq_2
X$1468 \$3582 \$6352 \$6139 \$6136 \$6387 gf180mcu_fd_sc_mcu9t5v0__dffq_2
X$1469 \$3582 \$5478 \$5607 \$5735 \$5473 gf180mcu_fd_sc_mcu9t5v0__dffq_2
X$1470 \$3582 \$6386 \$6348 \$6497 \$6387 gf180mcu_fd_sc_mcu9t5v0__dffq_2
X$1471 \$3582 \$5241 \$5242 \$5358 \$5240 gf180mcu_fd_sc_mcu9t5v0__dffq_2
X$1472 \$3582 \$3910 \$3911 \$3931 \$3812 gf180mcu_fd_sc_mcu9t5v0__dffq_2
X$1473 \$3582 \$4568 \$4531 \$4702 \$4567 gf180mcu_fd_sc_mcu9t5v0__dffq_2
X$1474 \$3582 \$4317 \$3912 \$4434 \$4314 gf180mcu_fd_sc_mcu9t5v0__dffq_2
X$1475 \$3586 \$7047 \$7160 \$7170 gf180mcu_fd_sc_mcu9t5v0__clkinv_1
X$1476 \$5481 \$7171 \$3586 \$7047 \$7160 gf180mcu_fd_sc_mcu9t5v0__dffq_2
X$1477 \$5604 \$5601 \$4984 \$6003 \$3587 \$3703 \$5735 \$5833 \$5606
+ gf180mcu_fd_sc_mcu9t5v0__mux4_1
X$1478 \$5361 \$5242 \$5476 \$5363 \$3587 \$3703 \$5358 \$5473 \$5477
+ gf180mcu_fd_sc_mcu9t5v0__mux4_1
X$1479 \$3702 \$3911 \$3913 \$3912 \$3587 \$3703 \$3931 \$3812 \$3914
+ gf180mcu_fd_sc_mcu9t5v0__mux4_1
X$1480 \$4535 \$4138 \$4531 \$4534 \$3587 \$3703 \$4702 \$4567 \$4704
+ gf180mcu_fd_sc_mcu9t5v0__mux4_1
X$1481 \$13496 \$13623 \$13452 \$3587 gf180mcu_fd_sc_mcu9t5v0__buf_8
X$1482 \$3587 \$13341 \$13452 \$12379 gf180mcu_fd_sc_mcu9t5v0__buf_8
X$1483 \$3587 \$9102 \$9221 \$6775 gf180mcu_fd_sc_mcu9t5v0__buf_8
X$1484 \$3587 \$9337 \$9221 \$4729 gf180mcu_fd_sc_mcu9t5v0__buf_8
X$1485 \$3588 \$3705 \$4726 \$3931 \$3812 \$3932 gf180mcu_fd_sc_mcu9t5v0__mux2_1
X$1486 \$4738 \$4043 \$4740 \$4702 \$4849 \$3592
+ gf180mcu_fd_sc_mcu9t5v0__oai21_1
X$1487 \$4744 \$3595 \$4706 \$4702 \$4849 \$4741 gf180mcu_fd_sc_mcu9t5v0__mux2_1
X$1488 \$8194 \$8063 \$8183 \$3599 gf180mcu_fd_sc_mcu9t5v0__buf_8
X$1489 \$6132 \$5632 \$3599 \$5735 \$5473 \$5377 gf180mcu_fd_sc_mcu9t5v0__mux2_1
X$1490 \$6380 \$6113 \$3599 \$6001 \$5833 \$5626 gf180mcu_fd_sc_mcu9t5v0__mux2_1
X$1491 \$5594 \$5256 \$3599 \$5358 \$5240 \$5006 gf180mcu_fd_sc_mcu9t5v0__mux2_1
X$1492 \$4184 \$4158 \$4159 \$4173 \$4041 \$3601
+ gf180mcu_fd_sc_mcu9t5v0__oai21_1
X$1493 \$4035 \$4158 \$4322 \$4173 \$4314 \$3605
+ gf180mcu_fd_sc_mcu9t5v0__oai21_1
X$1494 \$4224 \$4158 \$4225 \$4173 \$4314 \$3609
+ gf180mcu_fd_sc_mcu9t5v0__oai21_1
X$1495 \$6110 \$6770 \$6616 \$3701 gf180mcu_fd_sc_mcu9t5v0__clkbuf_20
X$1496 \$10667 \$9775 \$3701 \$10630 \$10782 \$10798
+ gf180mcu_fd_sc_mcu9t5v0__mux2_2
X$1497 \$6346 \$6347 \$3701 \$6136 \$6387 \$6349 gf180mcu_fd_sc_mcu9t5v0__mux2_2
X$1498 \$8853 \$8968 \$3701 \$10022 \$10282 \$10252
+ gf180mcu_fd_sc_mcu9t5v0__mux2_2
X$1499 \$5360 \$5244 \$3701 \$5207 \$5240 \$5243 gf180mcu_fd_sc_mcu9t5v0__mux2_2
X$1500 \$7592 \$10227 \$3701 \$8572 \$8335 \$8582
+ gf180mcu_fd_sc_mcu9t5v0__mux2_2
X$1501 \$10233 \$10902 \$3701 \$10901 \$10782 \$10781
+ gf180mcu_fd_sc_mcu9t5v0__mux2_2
X$1502 \$9220 \$9217 \$9103 \$9105 \$6775 \$3703 \$9337 \$9457 \$9458
+ gf180mcu_fd_sc_mcu9t5v0__mux4_1
X$1503 \$6922 \$6772 \$6345 \$6891 \$6775 \$3703 \$6770 \$6890 \$6892
+ gf180mcu_fd_sc_mcu9t5v0__mux4_1
X$1504 \$6106 \$6348 \$6388 \$6139 \$6775 \$3703 \$6136 \$6387 \$6351
+ gf180mcu_fd_sc_mcu9t5v0__mux4_1
X$1505 \$7158 \$7159 \$7306 \$7418 \$6775 \$3703 \$7304 \$7417 \$7307
+ gf180mcu_fd_sc_mcu9t5v0__mux4_1
X$1506 \$8838 \$8535 \$8836 \$8840 \$6775 \$3703 \$8834 \$8963 \$8964
+ gf180mcu_fd_sc_mcu9t5v0__mux4_1
X$1507 \$7305 \$7685 \$7799 \$7800 \$6775 \$3703 \$7797 \$7947 \$7911
+ gf180mcu_fd_sc_mcu9t5v0__mux4_1
X$1508 \$8304 \$8187 \$8188 \$8336 \$6775 \$3703 \$8301 \$8183 \$8306
+ gf180mcu_fd_sc_mcu9t5v0__mux4_1
X$1509 \$14756 \$14748 \$14635 \$3703 gf180mcu_fd_sc_mcu9t5v0__buf_8
X$1510 \$3917 \$3706 \$3814 \$3916 \$3931 \$3812 \$3918
+ gf180mcu_fd_sc_mcu9t5v0__oai31_1
X$1511 \$3917 \$3815 \$3707 \$3922 \$3931 \$3812 \$3934
+ gf180mcu_fd_sc_mcu9t5v0__oai31_1
X$1512 \$20394 \$19154 \$5004 \$3709 \$19042 \$19324 \$19466 \$19337
+ gf180mcu_fd_sc_mcu9t5v0__aoi221_1
X$1513 \$3917 \$3923 \$3931 \$3812 \$3710 gf180mcu_fd_sc_mcu9t5v0__nand2_1
X$1514 \$4035 \$4033 \$4032 \$3717 \$4031 \$3931 \$4041 \$4034
+ gf180mcu_fd_sc_mcu9t5v0__aoi221_1
X$1515 \$5231 \$4212 \$4199 \$3726 \$5207 \$5106 \$5233
+ gf180mcu_fd_sc_mcu9t5v0__aoi22_1
X$1516 \$3931 \$3812 \$3930 gf180mcu_fd_sc_mcu9t5v0__tiel
X$1517 \$3905 \$3931 \$3812 \$3906 gf180mcu_fd_sc_mcu9t5v0__buf_1
X$1518 \$3917 \$3817 \$3818 \$3924 \$3931 \$3812 \$3935
+ gf180mcu_fd_sc_mcu9t5v0__oai31_1
X$1519 \$3907 \$3931 \$3812 \$3908 gf180mcu_fd_sc_mcu9t5v0__buf_8
X$1520 \$3906 \$3931 \$3812 \$3907 gf180mcu_fd_sc_mcu9t5v0__dlyc_1
X$1521 \$3812 \$3931 gf180mcu_fd_sc_mcu9t5v0__filltie
X$1522 \$3812 \$3931 gf180mcu_fd_sc_mcu9t5v0__filltie
X$1523 \$3812 \$3931 gf180mcu_fd_sc_mcu9t5v0__filltie
X$1524 \$3812 \$3931 gf180mcu_fd_sc_mcu9t5v0__filltie
X$1525 \$3812 \$3931 gf180mcu_fd_sc_mcu9t5v0__filltie
X$1526 \$3812 \$3931 gf180mcu_fd_sc_mcu9t5v0__filltie
X$1527 \$3812 \$3931 gf180mcu_fd_sc_mcu9t5v0__endcap
X$1528 \$4848 \$4951 \$4849 \$3905 gf180mcu_fd_sc_mcu9t5v0__dlyc_1
X$1529 \$3908 \$18858 \$19724 \$19605 \$19774 \$19723
+ gf180mcu_fd_sc_mcu9t5v0__nor3_1
X$1530 \$3908 \$14449 \$20565 \$20515 \$20718 \$20566
+ gf180mcu_fd_sc_mcu9t5v0__nand3_1
X$1531 \$3908 \$12369 \$13196 \$13341 \$13083 \$13198
+ gf180mcu_fd_sc_mcu9t5v0__nand3_1
X$1532 \$3908 \$19725 \$19605 \$19774 \$20332 gf180mcu_fd_sc_mcu9t5v0__nand2_1
X$1533 \$3908 \$19455 \$20209 \$20087 \$20327 gf180mcu_fd_sc_mcu9t5v0__nand2_1
X$1534 \$3908 \$19927 \$19774 \$19769 gf180mcu_fd_sc_mcu9t5v0__clkinv_1
X$1535 \$3908 \$18701 \$18870 \$15195 gf180mcu_fd_sc_mcu9t5v0__buf_1
X$1536 \$15363 \$3908 \$13493 \$15045 \$15204 \$15152
+ gf180mcu_fd_sc_mcu9t5v0__mux2_1
X$1537 \$18573 \$18403 \$18293 \$3909 gf180mcu_fd_sc_mcu9t5v0__buf_8
X$1538 \$3912 \$4219 \$4318 \$4988 \$4569 \$4702 \$4567 \$4673
+ gf180mcu_fd_sc_mcu9t5v0__aoi221_1
X$1539 \$3912 \$4195 \$4196 \$4173 \$4314 \$4317 gf180mcu_fd_sc_mcu9t5v0__mux2_1
X$1540 \$3914 \$4704 \$4726 \$4702 \$4849 \$4725 gf180mcu_fd_sc_mcu9t5v0__mux2_1
X$1541 \$3917 \$4025 \$3931 \$4041 \$3916 gf180mcu_fd_sc_mcu9t5v0__nand2_1
X$1542 \$3917 \$10908 \$5004 \$13623 \$13452 \$13495
+ gf180mcu_fd_sc_mcu9t5v0__oai21_1
X$1543 \$3917 \$6140 \$5004 \$6136 \$6105 \$6141
+ gf180mcu_fd_sc_mcu9t5v0__oai21_1
X$1544 \$3917 \$12489 \$12528 \$12490 \$12486 \$12526 \$12529
+ gf180mcu_fd_sc_mcu9t5v0__oai31_1
X$1545 \$3917 \$12789 \$12895 \$12896 \$12786 \$12930 \$12932
+ gf180mcu_fd_sc_mcu9t5v0__oai31_1
X$1546 \$3917 \$7803 \$7912 \$7913 \$7797 \$7947 \$7948
+ gf180mcu_fd_sc_mcu9t5v0__oai31_1
X$1547 \$3917 \$6617 \$7161 \$7162 \$7047 \$7160 \$7163
+ gf180mcu_fd_sc_mcu9t5v0__oai31_1
X$1548 \$3917 \$8536 \$8718 \$8719 \$8834 \$8717 \$8842
+ gf180mcu_fd_sc_mcu9t5v0__oai31_1
X$1549 \$3917 \$9575 \$9341 \$9574 \$9608 \$9457 \$9573
+ gf180mcu_fd_sc_mcu9t5v0__oai31_1
X$1550 \$3917 \$4024 \$4850 \$4851 \$4951 \$4849 \$4852
+ gf180mcu_fd_sc_mcu9t5v0__oai31_1
X$1551 \$3917 \$6678 \$7550 \$5004 \$7526 \$7417 \$7551
+ gf180mcu_fd_sc_mcu9t5v0__oai211_1
X$1552 \$3917 \$7549 \$7591 \$7526 \$7417 \$7550
+ gf180mcu_fd_sc_mcu9t5v0__nand3_1
X$1553 \$3917 \$9122 \$9337 \$9457 \$9471 gf180mcu_fd_sc_mcu9t5v0__nor2_1
X$1554 \$3917 \$4027 \$3931 \$4041 \$3922 gf180mcu_fd_sc_mcu9t5v0__nand2_1
X$1555 \$3917 \$8680 \$8572 \$8717 \$8719 gf180mcu_fd_sc_mcu9t5v0__nand2_1
X$1556 \$3917 \$9342 \$9337 \$9457 \$9574 gf180mcu_fd_sc_mcu9t5v0__nand2_1
X$1557 \$3917 \$4986 \$4951 \$5106 \$4851 gf180mcu_fd_sc_mcu9t5v0__nand2_1
X$1558 \$3917 \$4679 \$3931 \$4041 \$3920 gf180mcu_fd_sc_mcu9t5v0__nand2_1
X$1559 \$3917 \$4028 \$3931 \$4041 \$3924 gf180mcu_fd_sc_mcu9t5v0__nand2_1
X$1560 \$3917 \$12897 \$12786 \$12930 \$12896 gf180mcu_fd_sc_mcu9t5v0__nand2_1
X$1561 \$3917 \$7914 \$8063 \$7947 \$7913 gf180mcu_fd_sc_mcu9t5v0__nand2_1
X$1562 \$3917 \$12378 \$12486 \$12376 \$12490 gf180mcu_fd_sc_mcu9t5v0__nand2_1
X$1563 \$3917 \$7050 \$7304 \$7160 \$7162 gf180mcu_fd_sc_mcu9t5v0__nand2_1
X$1564 \$14200 \$14151 \$14337 \$3917 gf180mcu_fd_sc_mcu9t5v0__buf_8
X$1565 \$20047 \$19154 \$5004 \$3918 \$19042 \$19927 \$20087 \$20090
+ gf180mcu_fd_sc_mcu9t5v0__aoi221_1
X$1566 \$3919 \$10901 \$11025 \$9899 gf180mcu_fd_sc_mcu9t5v0__clkbuf_8
X$1567 \$3919 \$8063 \$8183 \$6619 gf180mcu_fd_sc_mcu9t5v0__clkbuf_8
X$1568 \$3919 \$7797 \$7947 \$5832 gf180mcu_fd_sc_mcu9t5v0__clkbuf_8
X$1569 \$19030 \$19154 \$5004 \$3921 \$19042 \$19027 \$19149 \$19155
+ gf180mcu_fd_sc_mcu9t5v0__aoi221_1
X$1570 \$12547 \$12526 \$12486 \$3925 gf180mcu_fd_sc_mcu9t5v0__clkbuf_16
X$1571 \$3925 \$20515 \$20718 \$18596 gf180mcu_fd_sc_mcu9t5v0__clkbuf_8
X$1572 \$3925 \$16436 \$16728 \$14010 gf180mcu_fd_sc_mcu9t5v0__clkbuf_8
X$1573 \$3925 \$10901 \$11025 \$10291 gf180mcu_fd_sc_mcu9t5v0__clkbuf_8
X$1574 \$3925 \$7797 \$7947 \$7698 gf180mcu_fd_sc_mcu9t5v0__clkbuf_8
X$1575 \$3925 \$18701 \$18870 \$18592 gf180mcu_fd_sc_mcu9t5v0__clkbuf_8
X$1576 \$3925 \$5735 \$5833 \$4426 gf180mcu_fd_sc_mcu9t5v0__clkbuf_8
X$1577 \$3925 \$22074 \$22272 \$20845 gf180mcu_fd_sc_mcu9t5v0__clkbuf_8
X$1578 \$3925 \$16436 \$16728 \$15016 gf180mcu_fd_sc_mcu9t5v0__clkbuf_8
X$1579 \$3925 \$8301 \$8335 \$6366 gf180mcu_fd_sc_mcu9t5v0__clkbuf_8
X$1580 \$3925 \$20881 \$20718 \$19740 gf180mcu_fd_sc_mcu9t5v0__clkbuf_8
X$1581 \$3925 \$11306 \$11182 \$9789 gf180mcu_fd_sc_mcu9t5v0__clkbuf_8
X$1582 \$3925 \$14748 \$14635 \$12543 gf180mcu_fd_sc_mcu9t5v0__clkbuf_8
X$1583 \$4224 \$4033 \$4032 \$3928 \$4045 \$4173 \$4041 \$4161
+ gf180mcu_fd_sc_mcu9t5v0__aoi221_1
X$1584 \$5267 pad_din[0] \$I20747 \$I20765 \$I20756 \$I20774 \$I20783 \$I20801
+ \$I20792 \$I20810 \$I20819 \$I20837 \$I20828 \$I20846 \$I20855 \$I20864
+ \$I20873 \$I20882 \$I20891 \$I20900 \$I20909 \$I20918 \$I20927 \$I20936
+ \$I20945 \$I20954 \$I20963 \$I20981 \$I20972 \$I20990 \$I20999 \$I21017
+ \$I21008 \$I21026 \$I21044 \$I21035 \$I21053 \$I21062 \$I21071 \$I21089
+ \$I21080 \$I21098 \$I21107 \$I21116 \$I21125 \$I21134 \$I21143 \$I21161
+ \$I21152 \$I21170 \$I21179 \$I21197 \$I21188 \$I21206 \$I21215 \$I21233
+ \$I21224 \$I21242 \$I21251 \$I21269 \$I21260 \$I21278 \$I21287 \$I21296
+ \$I21305 \$I21314 \$I21323 \$I21332 \$I21341 \$I21350 \$I21368 \$I21377
+ \$I21404 \$I21413 \$I21359 \$I21395 \$I21386 \$I21431 \$I21422 \$I21458
+ \$I21449 \$I21467 \$I21440 \$I21485 \$I21476 \$I21494 \$I21512 \$I21539
+ \$I21548 \$I21557 \$I21503 \$I21530 \$I21521 \$I21575 \$I21566 \$I21584
+ \$I21593 \$I21602 \$I21611 \$I21620 \$I21629 \$I21638 \$3930 \$I21647
+ \$I21665 \$I21656 \$I21674 \$3930 \$4848 gf180mcu_fd_io__in_c
X$1585 \$4047 \$3931 \$4041 \$4036 gf180mcu_fd_sc_mcu9t5v0__clkinv_1
X$1586 \$4041 \$3931 gf180mcu_fd_sc_mcu9t5v0__filltie
X$1587 \$4041 \$3931 gf180mcu_fd_sc_mcu9t5v0__filltie
X$1588 \$4041 \$3931 gf180mcu_fd_sc_mcu9t5v0__filltie
X$1589 \$4041 \$3931 gf180mcu_fd_sc_mcu9t5v0__filltie
X$1590 \$4041 \$3931 gf180mcu_fd_sc_mcu9t5v0__filltie
X$1591 \$4041 \$3931 gf180mcu_fd_sc_mcu9t5v0__filltie
X$1592 \$4041 \$3931 gf180mcu_fd_sc_mcu9t5v0__endcap
X$1593 \$4990 \$3932 \$4956 \$4951 \$4849 \$9072 gf180mcu_fd_sc_mcu9t5v0__mux2_1
X$1594 \$20390 \$19154 \$5004 \$3934 \$19042 \$19927 \$19774 \$19782
+ gf180mcu_fd_sc_mcu9t5v0__aoi221_1
X$1595 \$20092 \$19154 \$5004 \$3935 \$19042 \$19927 \$20087 \$20345
+ gf180mcu_fd_sc_mcu9t5v0__aoi221_1
X$1596 \$6009 \$4158 \$5252 \$5207 \$5240 \$3936
+ gf180mcu_fd_sc_mcu9t5v0__oai21_1
X$1597 \$7923 \$4029 \$8191 \$7283 \$8069 \$8063 \$8183 \$7958
+ gf180mcu_fd_sc_mcu9t5v0__oai221_1
X$1598 \$7957 \$4029 \$7534 \$7283 \$7956 \$8063 \$7947 \$8068
+ gf180mcu_fd_sc_mcu9t5v0__oai221_1
X$1599 \$6931 \$7283 \$4029 \$7536 \$7577 \$7526 \$7688 \$7578
+ gf180mcu_fd_sc_mcu9t5v0__oai221_1
X$1600 \$6934 \$7283 \$4029 \$7173 \$7057 \$7047 \$7160 \$7058
+ gf180mcu_fd_sc_mcu9t5v0__oai221_1
X$1601 \$7311 \$7283 \$4029 \$7313 \$7314 \$7304 \$7417 \$7424
+ gf180mcu_fd_sc_mcu9t5v0__oai221_1
X$1602 \$6933 \$7283 \$4029 \$7537 \$7538 \$7526 \$7417 \$7539
+ gf180mcu_fd_sc_mcu9t5v0__oai221_1
X$1603 \$7541 \$7283 \$4029 \$7692 \$7540 \$7526 \$7417 \$7579
+ gf180mcu_fd_sc_mcu9t5v0__oai221_1
X$1604 \$7281 \$7283 \$4029 \$7280 \$7282 \$7304 \$7160 \$7172
+ gf180mcu_fd_sc_mcu9t5v0__oai221_1
X$1605 \$6930 \$7283 \$4029 \$7170 \$7279 \$7304 \$7160 \$7171
+ gf180mcu_fd_sc_mcu9t5v0__oai221_1
X$1606 \$8074 \$8063 \$8183 \$4029 gf180mcu_fd_sc_mcu9t5v0__buf_8
X$1607 \$4029 \$8301 \$8335 \$8577 gf180mcu_fd_sc_mcu9t5v0__buf_8
X$1608 \$5111 \$5006 \$4029 \$4951 \$5106 \$5005 gf180mcu_fd_sc_mcu9t5v0__mux2_1
X$1609 \$5851 \$5626 \$4029 \$5735 \$5473 \$5625 gf180mcu_fd_sc_mcu9t5v0__mux2_1
X$1610 \$4184 \$4033 \$4032 \$4030 \$4182 \$4173 \$4041 \$4183
+ gf180mcu_fd_sc_mcu9t5v0__aoi221_1
X$1611 \$9720 \$9772 \$9608 \$9703 \$4032 gf180mcu_fd_sc_mcu9t5v0__and2_4
X$1612 \$9084 \$4032 \$8971 \$8972 \$8834 \$8963 \$8970
+ gf180mcu_fd_sc_mcu9t5v0__aoi211_1
X$1613 \$9236 \$4032 \$9364 \$9238 \$9337 \$9221 \$9237
+ gf180mcu_fd_sc_mcu9t5v0__aoi211_1
X$1614 \$9792 \$4032 \$9793 \$9794 \$9748 \$9703 \$9916
+ gf180mcu_fd_sc_mcu9t5v0__aoi211_1
X$1615 \$8087 \$4032 \$8083 \$8207 \$8301 \$8183 \$8206
+ gf180mcu_fd_sc_mcu9t5v0__aoi211_1
X$1616 \$7064 \$6939 \$4032 \$6901 \$7066 \$7047 \$7160 \$7181
+ gf180mcu_fd_sc_mcu9t5v0__aoi221_1
X$1617 \$6674 \$4033 \$4032 \$4560 \$4584 \$4434 \$4567 \$4585
+ gf180mcu_fd_sc_mcu9t5v0__aoi221_1
X$1618 \$10928 \$6939 \$4032 \$9909 \$9731 \$9608 \$9703 \$9732
+ gf180mcu_fd_sc_mcu9t5v0__aoi221_1
X$1619 \$7582 \$4033 \$4032 \$6938 \$7287 \$7047 \$7160 \$7176
+ gf180mcu_fd_sc_mcu9t5v0__aoi221_1
X$1620 \$6155 \$4033 \$4032 \$5902 \$5900 \$6001 \$5833 \$5903
+ gf180mcu_fd_sc_mcu9t5v0__aoi221_1
X$1621 \$10260 \$6939 \$4032 \$9788 \$9597 \$9608 \$9457 \$9598
+ gf180mcu_fd_sc_mcu9t5v0__aoi221_1
X$1622 \$5906 \$4033 \$4032 \$4036 \$4046 \$4173 \$4041 \$4163
+ gf180mcu_fd_sc_mcu9t5v0__aoi221_1
X$1623 \$6939 \$7047 \$6890 \$4033 gf180mcu_fd_sc_mcu9t5v0__buf_8
X$1624 \$13460 \$13226 \$13224 \$13341 \$13083 \$4035
+ gf180mcu_fd_sc_mcu9t5v0__aoi21_1
X$1625 \$4035 \$6662 \$7811 \$6663 \$7797 \$7688 \$7813
+ gf180mcu_fd_sc_mcu9t5v0__oai31_1
X$1626 \$5906 \$4158 \$4164 \$4173 \$4041 \$4037
+ gf180mcu_fd_sc_mcu9t5v0__oai21_1
X$1627 \$4038 \$12786 \$12526 gf180mcu_fd_sc_mcu9t5v0__clkinv_12
X$1628 \$12547 \$12526 \$12486 \$4038 gf180mcu_fd_sc_mcu9t5v0__clkbuf_16
X$1629 \$4038 \$16269 \$16376 \$14650 gf180mcu_fd_sc_mcu9t5v0__clkbuf_8
X$1630 \$4038 \$16914 \$17034 \$15395 gf180mcu_fd_sc_mcu9t5v0__clkbuf_8
X$1631 \$4038 \$9102 \$9221 \$8205 gf180mcu_fd_sc_mcu9t5v0__clkbuf_8
X$1632 \$4038 \$8834 \$8963 \$5264 gf180mcu_fd_sc_mcu9t5v0__clkbuf_8
X$1633 \$4038 \$6497 \$6616 \$5261 gf180mcu_fd_sc_mcu9t5v0__clkbuf_8
X$1634 \$4038 \$15045 \$15204 \$14241 gf180mcu_fd_sc_mcu9t5v0__clkbuf_8
X$1635 \$4038 \$13881 \$14034 \$13230 gf180mcu_fd_sc_mcu9t5v0__clkbuf_8
X$1636 \$4038 \$19927 \$20087 \$18838 gf180mcu_fd_sc_mcu9t5v0__clkbuf_8
X$1637 \$4038 \$11675 \$11827 \$11038 gf180mcu_fd_sc_mcu9t5v0__clkbuf_8
X$1638 \$4038 \$17085 \$17034 \$15036 gf180mcu_fd_sc_mcu9t5v0__clkbuf_8
X$1639 \$5356 \$4048 \$4039 \$4165 \$4173 \$4041 \$4189
+ gf180mcu_fd_sc_mcu9t5v0__aoi22_1
X$1640 \$4569 \$4206 \$4148 \$4173 \$4041 \$4147
+ gf180mcu_fd_sc_mcu9t5v0__oai21_1
X$1641 \$4208 \$4043 \$4151 \$4173 \$4041 \$4150
+ gf180mcu_fd_sc_mcu9t5v0__oai21_1
X$1642 \$4180 \$4211 \$4173 \$4041 \$4153 gf180mcu_fd_sc_mcu9t5v0__nand2_1
X$1643 \$4041 \$4173 gf180mcu_fd_sc_mcu9t5v0__filltie
X$1644 \$4041 \$4173 gf180mcu_fd_sc_mcu9t5v0__filltie
X$1645 \$4041 \$4173 gf180mcu_fd_sc_mcu9t5v0__filltie
X$1646 \$4041 \$4173 gf180mcu_fd_sc_mcu9t5v0__filltie
X$1647 \$4041 \$4173 gf180mcu_fd_sc_mcu9t5v0__filltie
X$1648 \$4041 \$4173 gf180mcu_fd_sc_mcu9t5v0__filltie
X$1649 \$4203 \$4143 \$4144 \$4173 \$4041 \$4178 gf180mcu_fd_sc_mcu9t5v0__mux2_1
X$1650 \$4209 \$4152 \$4144 \$4173 \$4041 \$4179 gf180mcu_fd_sc_mcu9t5v0__mux2_1
X$1651 \$4139 \$4138 \$4140 \$4173 \$4041 \$4175 gf180mcu_fd_sc_mcu9t5v0__mux2_1
X$1652 \$4041 \$4173 gf180mcu_fd_sc_mcu9t5v0__endcap
X$1653 \$11567 \$4043 \$12004 \$11956 \$11993 \$12003
+ gf180mcu_fd_sc_mcu9t5v0__oai21_1
X$1654 \$10397 \$4043 \$10665 \$10630 \$10782 \$10521
+ gf180mcu_fd_sc_mcu9t5v0__oai21_1
X$1655 \$9349 \$4043 \$9347 \$9337 \$9457 \$9348
+ gf180mcu_fd_sc_mcu9t5v0__oai21_1
X$1656 \$7573 \$4043 \$7572 \$7526 \$7688 \$7421
+ gf180mcu_fd_sc_mcu9t5v0__oai21_1
X$1657 \$4538 \$4043 \$4537 \$4434 \$4567 \$4437
+ gf180mcu_fd_sc_mcu9t5v0__oai21_1
X$1658 \$6657 \$4043 \$6656 \$6770 \$6616 \$6501
+ gf180mcu_fd_sc_mcu9t5v0__oai21_1
X$1659 \$10910 \$4043 \$12002 \$11675 \$11555 \$11563
+ gf180mcu_fd_sc_mcu9t5v0__oai21_1
X$1660 \$8311 \$4043 \$8310 \$8301 \$8183 \$7952
+ gf180mcu_fd_sc_mcu9t5v0__oai21_1
X$1661 \$5610 \$4043 \$5609 \$5735 \$5473 \$5365
+ gf180mcu_fd_sc_mcu9t5v0__oai21_1
X$1662 \$4043 \$8302 \$8301 \$8335 \$8310 gf180mcu_fd_sc_mcu9t5v0__nand2_1
X$1663 \$4043 \$7272 \$7526 \$7688 \$7572 gf180mcu_fd_sc_mcu9t5v0__nand2_1
X$1664 \$4043 \$10240 \$11956 \$11993 \$12002 gf180mcu_fd_sc_mcu9t5v0__nand2_1
X$1665 \$4043 \$6346 \$6770 \$6616 \$6656 gf180mcu_fd_sc_mcu9t5v0__nand2_1
X$1666 \$4043 \$10233 \$12260 \$11993 \$12004 gf180mcu_fd_sc_mcu9t5v0__nand2_1
X$1667 \$4043 \$9905 \$10901 \$10782 \$10665 gf180mcu_fd_sc_mcu9t5v0__nand2_1
X$1668 \$4043 \$9343 \$9337 \$9221 \$9347 gf180mcu_fd_sc_mcu9t5v0__nand2_1
X$1669 \$4315 \$4043 \$4434 \$4567 \$4537 gf180mcu_fd_sc_mcu9t5v0__nand2_1
X$1670 \$5360 \$4043 \$5735 \$5473 \$5609 gf180mcu_fd_sc_mcu9t5v0__nand2_1
X$1671 \$11726 \$12486 \$12376 \$4043 gf180mcu_fd_sc_mcu9t5v0__buf_8
X$1672 \$4047 \$4219 \$4210 \$4758 \$4569 \$4434 \$4314 \$4323
+ gf180mcu_fd_sc_mcu9t5v0__aoi221_1
X$1673 \$13630 \$13623 \$13729 \$4134 gf180mcu_fd_sc_mcu9t5v0__buf_8
X$1674 \$9736 \$9563 \$4134 \$9337 \$9457 \$9454 gf180mcu_fd_sc_mcu9t5v0__mux2_1
X$1675 \$7908 \$7910 \$4134 \$7797 \$7947 \$7909 gf180mcu_fd_sc_mcu9t5v0__mux2_1
X$1676 \$10227 \$10025 \$4134 \$10022 \$10282 \$10230
+ gf180mcu_fd_sc_mcu9t5v0__mux2_1
X$1677 \$10241 \$10509 \$4134 \$10391 \$10514 \$10508
+ gf180mcu_fd_sc_mcu9t5v0__mux2_1
X$1678 \$7273 \$7156 \$4134 \$7047 \$7160 \$7271 gf180mcu_fd_sc_mcu9t5v0__mux2_1
X$1679 \$8961 \$8960 \$4134 \$8834 \$8963 \$8959 gf180mcu_fd_sc_mcu9t5v0__mux2_1
X$1680 \$6347 \$7562 \$4134 \$7526 \$7688 \$7680 gf180mcu_fd_sc_mcu9t5v0__mux2_1
X$1681 \$5244 \$5471 \$4134 \$5358 \$5473 \$5470 gf180mcu_fd_sc_mcu9t5v0__mux2_1
X$1682 \$10027 \$10224 \$4134 \$10022 \$10282 \$10223
+ gf180mcu_fd_sc_mcu9t5v0__mux2_1
X$1683 \$8186 \$8674 \$4134 \$8572 \$8717 \$8709 gf180mcu_fd_sc_mcu9t5v0__mux2_1
X$1684 \$10902 \$11678 \$4134 \$11675 \$11555 \$11674
+ gf180mcu_fd_sc_mcu9t5v0__mux2_1
X$1685 \$6375 \$8830 \$4134 \$8834 \$8717 \$8953 gf180mcu_fd_sc_mcu9t5v0__mux2_1
X$1686 \$6380 \$5877 \$4134 \$6001 \$5833 \$6103 gf180mcu_fd_sc_mcu9t5v0__mux2_1
X$1687 \$8695 \$9071 \$4134 \$9102 \$8963 \$9100 gf180mcu_fd_sc_mcu9t5v0__mux2_1
X$1688 \$5018 \$8529 \$4134 \$8572 \$8335 \$8569 gf180mcu_fd_sc_mcu9t5v0__mux2_1
X$1689 \$8968 \$9070 \$4134 \$9102 \$8963 \$9098 gf180mcu_fd_sc_mcu9t5v0__mux2_1
X$1690 \$4191 \$4701 \$4134 \$4702 \$4567 \$4700 gf180mcu_fd_sc_mcu9t5v0__mux2_1
X$1691 \$6132 \$6131 \$4134 \$6136 \$6105 \$6129 gf180mcu_fd_sc_mcu9t5v0__mux2_1
X$1692 \$5594 \$5596 \$4134 \$5735 \$5473 \$5595 gf180mcu_fd_sc_mcu9t5v0__mux2_1
X$1693 \$9795 \$11175 \$4134 \$11136 \$11025 \$11133
+ gf180mcu_fd_sc_mcu9t5v0__mux2_1
X$1694 \$9775 \$11178 \$4134 \$11136 \$11025 \$11177
+ gf180mcu_fd_sc_mcu9t5v0__mux2_1
X$1695 \$9239 \$11135 \$4134 \$11136 \$11025 \$11134
+ gf180mcu_fd_sc_mcu9t5v0__mux2_1
X$1696 \$4135 \$4671 \$4672 \$4702 \$4849 \$4721
+ gf180mcu_fd_sc_mcu9t5v0__oai21_1
X$1697 \$4528 \$4171 \$4135 \$4173 \$4314 gf180mcu_fd_sc_mcu9t5v0__dffq_2
X$1698 \$4136 \$4671 \$4672 \$4529 \$4434 \$4567 \$4564
+ gf180mcu_fd_sc_mcu9t5v0__oai211_1
X$1699 \$4528 \$4172 \$4136 \$4173 \$4314 gf180mcu_fd_sc_mcu9t5v0__dffq_2
X$1700 \$4137 \$4671 \$4672 \$4434 \$4567 \$4565
+ gf180mcu_fd_sc_mcu9t5v0__oai21_1
X$1701 \$5904 \$10391 \$10282 \$4140 gf180mcu_fd_sc_mcu9t5v0__buf_8
X$1702 \$11181 \$11515 \$4140 \$11136 \$11182 \$11180
+ gf180mcu_fd_sc_mcu9t5v0__mux2_1
X$1703 \$8334 \$8535 \$4140 \$8572 \$8717 \$8534 gf180mcu_fd_sc_mcu9t5v0__mux2_1
X$1704 \$9104 \$9217 \$4140 \$9102 \$9221 \$9216 gf180mcu_fd_sc_mcu9t5v0__mux2_1
X$1705 \$10026 \$10236 \$4140 \$10391 \$10282 \$10235
+ gf180mcu_fd_sc_mcu9t5v0__mux2_1
X$1706 \$11138 \$11179 \$4140 \$11136 \$11025 \$11137
+ gf180mcu_fd_sc_mcu9t5v0__mux2_1
X$1707 \$5602 \$5601 \$4140 \$5735 \$5473 \$5600 gf180mcu_fd_sc_mcu9t5v0__mux2_1
X$1708 \$7686 \$7685 \$4140 \$8063 \$7947 \$7684 gf180mcu_fd_sc_mcu9t5v0__mux2_1
X$1709 \$6647 \$6772 \$4140 \$6770 \$6616 \$6771 gf180mcu_fd_sc_mcu9t5v0__mux2_1
X$1710 \$4200 \$4201 \$4144 \$4173 \$4314 \$4141 gf180mcu_fd_sc_mcu9t5v0__mux2_1
X$1711 \$12022 \$4142 \$7553 \$10529 \$10530 \$10391 \$10514 \$10531
+ gf180mcu_fd_sc_mcu9t5v0__oai221_1
X$1712 \$9720 \$9748 \$9703 \$4142 gf180mcu_fd_sc_mcu9t5v0__buf_8
X$1713 \$10241 \$10240 \$4142 \$10022 \$10282 \$10029
+ gf180mcu_fd_sc_mcu9t5v0__mux2_1
X$1714 \$8961 \$9343 \$4142 \$9608 \$9703 \$9707 gf180mcu_fd_sc_mcu9t5v0__mux2_1
X$1715 \$10902 \$10233 \$4142 \$10022 \$10282 \$10243
+ gf180mcu_fd_sc_mcu9t5v0__mux2_1
X$1716 \$8186 \$8302 \$4142 \$8063 \$8183 \$8190 gf180mcu_fd_sc_mcu9t5v0__mux2_1
X$1717 \$4191 \$4315 \$4142 \$4173 \$4314 \$4195 gf180mcu_fd_sc_mcu9t5v0__mux2_1
X$1718 \$6347 \$6346 \$4142 \$6136 \$6105 \$6142 gf180mcu_fd_sc_mcu9t5v0__mux2_1
X$1719 \$5244 \$5360 \$4142 \$5358 \$5240 \$5246 gf180mcu_fd_sc_mcu9t5v0__mux2_1
X$1720 \$10027 \$9905 \$4142 \$9748 \$9703 \$9759
+ gf180mcu_fd_sc_mcu9t5v0__mux2_1
X$1721 \$7273 \$7272 \$4142 \$7304 \$7160 \$7275 gf180mcu_fd_sc_mcu9t5v0__mux2_1
X$1722 \$4146 \$4421 \$4434 \$4314 \$4143 gf180mcu_fd_sc_mcu9t5v0__nand2_1
X$1723 \$11692 \$11956 \$11993 \$4144 gf180mcu_fd_sc_mcu9t5v0__buf_8
X$1724 \$4205 \$4540 \$4144 \$4434 \$4567 \$4573 gf180mcu_fd_sc_mcu9t5v0__mux2_1
X$1725 \$6927 \$6655 \$4144 \$6497 \$6616 \$6620 gf180mcu_fd_sc_mcu9t5v0__mux2_1
X$1726 \$8682 \$8340 \$4144 \$8301 \$8335 \$8339 gf180mcu_fd_sc_mcu9t5v0__mux2_1
X$1727 \$7918 \$7570 \$4144 \$7526 \$7688 \$7691 gf180mcu_fd_sc_mcu9t5v0__mux2_1
X$1728 \$11307 \$11145 \$4144 \$11306 \$11555 \$11562
+ gf180mcu_fd_sc_mcu9t5v0__mux2_1
X$1729 \$11716 \$12000 \$4144 \$11956 \$11993 \$11999
+ gf180mcu_fd_sc_mcu9t5v0__mux2_1
X$1730 \$5607 \$5479 \$4144 \$5358 \$5473 \$5478 gf180mcu_fd_sc_mcu9t5v0__mux2_1
X$1731 \$9224 \$9074 \$4144 \$9102 \$8963 \$9073 gf180mcu_fd_sc_mcu9t5v0__mux2_1
X$1732 \$12531 \$12263 \$4144 \$12486 \$12376 \$12381
+ gf180mcu_fd_sc_mcu9t5v0__mux2_1
X$1733 \$4536 \$4417 \$4144 \$4434 \$4314 \$4436 gf180mcu_fd_sc_mcu9t5v0__mux2_1
X$1734 \$4145 \$5736 \$5840 \$6001 \$5833 \$5486 gf180mcu_fd_sc_mcu9t5v0__and3_1
X$1735 \$4145 \$6662 \$7811 \$6663 \$6770 \$6616 \$6664
+ gf180mcu_fd_sc_mcu9t5v0__oai31_1
X$1736 \$21955 \$19154 \$21663 \$4147 \$21661 \$21946 \$21816
+ gf180mcu_fd_sc_mcu9t5v0__aoi22_1
X$1737 \$4151 \$5000 \$4434 \$4314 \$4152 gf180mcu_fd_sc_mcu9t5v0__nand2_1
X$1738 \$22842 \$19154 \$22910 \$4153 \$23027 \$22837 \$22902
+ gf180mcu_fd_sc_mcu9t5v0__aoi22_1
X$1739 \$9735 \$6939 \$4156 \$9608 \$9703 \$9731 gf180mcu_fd_sc_mcu9t5v0__nor3_1
X$1740 \$7592 \$6939 \$4156 \$9748 \$9703 \$9597 gf180mcu_fd_sc_mcu9t5v0__nor3_1
X$1741 \$7557 \$4156 \$8063 \$8183 \$8083 gf180mcu_fd_sc_mcu9t5v0__nor2_1
X$1742 \$9235 \$4156 \$9337 \$9221 \$9364 gf180mcu_fd_sc_mcu9t5v0__nor2_1
X$1743 \$9917 \$4156 \$10022 \$9900 \$9793 gf180mcu_fd_sc_mcu9t5v0__nor2_1
X$1744 \$4156 \$8853 \$9102 \$9221 \$8971 gf180mcu_fd_sc_mcu9t5v0__nor2_1
X$1745 \$4156 \$5632 \$7047 \$7160 \$7066 gf180mcu_fd_sc_mcu9t5v0__nor2_1
X$1746 \$4156 \$6113 \$7304 \$7160 \$7287 gf180mcu_fd_sc_mcu9t5v0__nor2_1
X$1747 \$4156 \$5256 \$6001 \$5833 \$5900 gf180mcu_fd_sc_mcu9t5v0__nor2_1
X$1748 \$9772 \$9748 \$9900 \$4156 gf180mcu_fd_sc_mcu9t5v0__buf_8
X$1749 \$7582 \$4158 \$7809 \$7526 \$7688 \$7426
+ gf180mcu_fd_sc_mcu9t5v0__oai21_1
X$1750 \$6674 \$4158 \$5114 \$4951 \$4849 \$4761
+ gf180mcu_fd_sc_mcu9t5v0__oai21_1
X$1751 \$6155 \$4158 \$6515 \$6136 \$6105 \$5628
+ gf180mcu_fd_sc_mcu9t5v0__oai21_1
X$1752 \$7064 \$4158 \$6945 \$7047 \$6890 \$6944
+ gf180mcu_fd_sc_mcu9t5v0__oai21_1
X$1753 \$4158 \$8853 \$10391 \$10514 \$10533 gf180mcu_fd_sc_mcu9t5v0__nand2_1
X$1754 \$4158 \$10667 \$11136 \$11182 \$11194 gf180mcu_fd_sc_mcu9t5v0__nand2_1
X$1755 \$4158 \$5632 \$7047 \$7160 \$6945 gf180mcu_fd_sc_mcu9t5v0__nand2_1
X$1756 \$4158 \$6113 \$7797 \$7688 \$7809 gf180mcu_fd_sc_mcu9t5v0__nand2_1
X$1757 \$4158 \$5256 \$6497 \$6387 \$6515 gf180mcu_fd_sc_mcu9t5v0__nand2_1
X$1758 \$9235 \$4158 \$12260 \$12376 \$11734 gf180mcu_fd_sc_mcu9t5v0__nand2_1
X$1759 \$6374 \$4158 \$8301 \$8335 \$8359 gf180mcu_fd_sc_mcu9t5v0__nand2_1
X$1760 \$9917 \$4158 \$11956 \$11993 \$11700 gf180mcu_fd_sc_mcu9t5v0__nand2_1
X$1761 \$7557 \$4158 \$11306 \$11555 \$11215 gf180mcu_fd_sc_mcu9t5v0__nand2_1
X$1762 \$7592 \$4158 \$9337 \$9457 \$9123 gf180mcu_fd_sc_mcu9t5v0__nand2_1
X$1763 \$9735 \$4158 \$10391 \$10282 \$9928 gf180mcu_fd_sc_mcu9t5v0__nand2_1
X$1764 \$8697 \$4158 \$12260 \$11993 \$9739 gf180mcu_fd_sc_mcu9t5v0__nand2_1
X$1765 \$5115 \$4158 \$10901 \$10782 \$10935 gf180mcu_fd_sc_mcu9t5v0__nand2_1
X$1766 \$11726 \$12260 \$11993 \$4158 gf180mcu_fd_sc_mcu9t5v0__buf_8
X$1767 \$4216 \$4545 \$4159 \$4543 \$4544 \$4434 \$4567 \$4427
+ gf180mcu_fd_sc_mcu9t5v0__oai221_1
X$1768 \$4160 \$4702 \$4567 \$4553 gf180mcu_fd_sc_mcu9t5v0__clkinv_1
X$1769 \$4688 \$4545 \$4164 \$4543 \$4559 \$4434 \$4567 \$4442
+ gf180mcu_fd_sc_mcu9t5v0__oai221_1
X$1770 \$5268 pad_dout[1] \$I20746 \$I20755 \$I20764 \$I20773 \$I20782 \$I20791
+ \$I20800 \$I20809 \$I20818 \$I20827 \$I20836 \$I20845 \$I20854 \$I20863
+ \$I20872 \$I20881 \$I20890 \$I20899 \$I20908 \$I20917 \$I20926 \$I20935
+ \$I20944 \$I20953 \$I20962 \$I20971 \$I20980 \$I20989 \$I20998 \$I21007
+ \$I21016 \$I21025 \$I21034 \$I21043 \$I21052 \$I21061 \$I21070 \$I21079
+ \$I21088 \$I21097 \$I21106 \$I21115 \$I21124 \$I21133 \$I21142 \$I21151
+ \$I21160 \$I21169 \$I21178 \$I21187 \$I21196 \$I21205 \$I21214 \$I21223
+ \$I21232 \$I21241 \$I21250 \$I21259 \$I21268 \$I21277 \$I21286 \$I21295
+ \$I21304 \$I21313 \$4190 \$I21322 \$I21331 \$I21340 \$I21349 \$I21358
+ \$I21367 \$I21376 \$I21385 \$I21394 \$I21403 \$I21412 \$I21421 \$I21430
+ \$I21439 \$I21448 \$I21457 \$I21466 \$I21475 \$I21484 \$I21493 \$I21502
+ \$I21511 \$I21520 \$I21529 \$I21538 \$I21547 \$I21556 \$I21565 \$I21574
+ \$I21583 \$I21592 \$I21601 \$4168 \$I21610 \$I21619 \$I21628 \$I21637
+ \$I21646 \$I21655 \$I21664 \$I21673 \$4168 \$4168 \$4190 \$4168 \$4168 \$5741
+ \$4190 gf180mcu_fd_io__bi_t
X$1771 \$5735 \$5833 \$4168 gf180mcu_fd_sc_mcu9t5v0__tiel
X$1772 \$4671 \$4170 \$5735 \$5473 \$5875 gf180mcu_fd_sc_mcu9t5v0__nand2_1
X$1773 \$4569 \$4222 \$4185 \$4173 \$4314 \$4223
+ gf180mcu_fd_sc_mcu9t5v0__oai21_1
X$1774 \$4214 \$4173 \$4314 \$4216 gf180mcu_fd_sc_mcu9t5v0__clkinv_1
X$1775 \$4677 \$4220 \$4173 \$4314 \$4221 gf180mcu_fd_sc_mcu9t5v0__nand2_1
X$1776 \$4314 \$4173 gf180mcu_fd_sc_mcu9t5v0__filltie
X$1777 \$4314 \$4173 gf180mcu_fd_sc_mcu9t5v0__filltie
X$1778 \$4314 \$4173 gf180mcu_fd_sc_mcu9t5v0__filltie
X$1779 \$4314 \$4173 gf180mcu_fd_sc_mcu9t5v0__filltie
X$1780 \$4314 \$4173 gf180mcu_fd_sc_mcu9t5v0__filltie
X$1781 \$4314 \$4173 gf180mcu_fd_sc_mcu9t5v0__filltie
X$1782 \$4314 \$4173 gf180mcu_fd_sc_mcu9t5v0__endcap
X$1783 \$13461 \$13350 \$13464 \$13341 \$13452 \$4184
+ gf180mcu_fd_sc_mcu9t5v0__aoi21_1
X$1784 \$4184 \$6662 \$7811 \$6663 \$8301 \$8183 \$8078
+ gf180mcu_fd_sc_mcu9t5v0__oai31_1
X$1785 \$4677 \$4687 \$4186 \$4982 \$4702 \$4567 \$4757
+ gf180mcu_fd_sc_mcu9t5v0__aoi211_1
X$1786 \$5261 \$5227 \$4187 \$5207 \$5240 gf180mcu_fd_sc_mcu9t5v0__dffq_2
X$1787 \$4187 \$5379 \$5378 \$5207 \$5106 \$5227 gf180mcu_fd_sc_mcu9t5v0__mux2_1
X$1788 \$4677 \$4189 \$5380 \$6160 \$6001 \$6105 \$6135
+ gf180mcu_fd_sc_mcu9t5v0__oai22_1
X$1789 \$5735 \$5833 \$4190 gf180mcu_fd_sc_mcu9t5v0__tieh
X$1790 \$4191 \$6932 \$7576 \$7797 \$7688 \$7577
+ gf180mcu_fd_sc_mcu9t5v0__nand3_1
X$1791 \$4191 \$15628 \$15490 \$4538 gf180mcu_fd_sc_mcu9t5v0__clkinv_1
X$1792 \$6646 \$4191 \$6343 \$6770 \$6616 \$6889 gf180mcu_fd_sc_mcu9t5v0__mux2_1
X$1793 \$15766 \$15832 \$13226 \$15949 \$15749 \$4191
+ gf180mcu_fd_sc_mcu9t5v0__mux2_1
X$1794 \$4191 \$4980 \$4972 \$4951 \$5106 \$4979 gf180mcu_fd_sc_mcu9t5v0__mux2_1
X$1795 \$4413 \$4412 \$4193 \$4411 \$4677 \$4434 \$4314 \$4316
+ gf180mcu_fd_sc_mcu9t5v0__aoi221_1
X$1796 \$9356 \$9337 \$9221 \$4196 gf180mcu_fd_sc_mcu9t5v0__buf_8
X$1797 \$9704 \$9707 \$4196 \$9748 \$9900 \$9754 gf180mcu_fd_sc_mcu9t5v0__mux2_1
X$1798 \$8336 \$8190 \$4196 \$8301 \$8335 \$8189 gf180mcu_fd_sc_mcu9t5v0__mux2_1
X$1799 \$5363 \$5246 \$4196 \$5207 \$5240 \$5245 gf180mcu_fd_sc_mcu9t5v0__mux2_1
X$1800 \$10285 \$10243 \$4196 \$10391 \$10514 \$10284
+ gf180mcu_fd_sc_mcu9t5v0__mux2_1
X$1801 \$6139 \$6142 \$4196 \$6497 \$6387 \$6352 gf180mcu_fd_sc_mcu9t5v0__mux2_1
X$1802 \$11517 \$10029 \$4196 \$10022 \$9900 \$10283
+ gf180mcu_fd_sc_mcu9t5v0__mux2_1
X$1803 \$9903 \$9759 \$4196 \$10022 \$9900 \$9902
+ gf180mcu_fd_sc_mcu9t5v0__mux2_1
X$1804 \$7418 \$7275 \$4196 \$7304 \$7160 \$7308 gf180mcu_fd_sc_mcu9t5v0__mux2_1
X$1805 \$11330 \$4212 \$4199 \$7968 \$11306 \$11555 \$11540
+ gf180mcu_fd_sc_mcu9t5v0__aoi22_1
X$1806 \$10299 \$4212 \$4199 \$10268 \$10391 \$10514 \$10540
+ gf180mcu_fd_sc_mcu9t5v0__aoi22_1
X$1807 \$11166 \$4212 \$4199 \$5382 \$11136 \$11182 \$11211
+ gf180mcu_fd_sc_mcu9t5v0__aoi22_1
X$1808 \$11196 \$4212 \$4199 \$10669 \$11675 \$11827 \$11729
+ gf180mcu_fd_sc_mcu9t5v0__aoi22_1
X$1809 \$11307 \$4212 \$4199 \$10518 \$11306 \$11555 \$11718
+ gf180mcu_fd_sc_mcu9t5v0__aoi22_1
X$1810 \$11716 \$4212 \$4199 \$10788 \$11956 \$11993 \$11997
+ gf180mcu_fd_sc_mcu9t5v0__aoi22_1
X$1811 \$12531 \$4212 \$4199 \$11026 \$12786 \$12930 \$12898
+ gf180mcu_fd_sc_mcu9t5v0__aoi22_1
X$1812 \$9224 \$4212 \$4199 \$9220 \$9337 \$9457 \$9459
+ gf180mcu_fd_sc_mcu9t5v0__aoi22_1
X$1813 \$12276 \$4212 \$4199 \$8978 \$12260 \$12376 \$12278
+ gf180mcu_fd_sc_mcu9t5v0__aoi22_1
X$1814 \$5607 \$4212 \$4199 \$5604 \$6001 \$6105 \$6005
+ gf180mcu_fd_sc_mcu9t5v0__aoi22_1
X$1815 \$6632 \$4212 \$4199 \$6011 \$6497 \$6616 \$6631
+ gf180mcu_fd_sc_mcu9t5v0__aoi22_1
X$1816 \$4536 \$4212 \$4199 \$4535 \$4434 \$4567 \$4570
+ gf180mcu_fd_sc_mcu9t5v0__aoi22_1
X$1817 \$9734 \$4212 \$4199 \$7700 \$9748 \$9900 \$9911
+ gf180mcu_fd_sc_mcu9t5v0__aoi22_1
X$1818 \$9464 \$4212 \$4199 \$9359 \$9337 \$9457 \$9463
+ gf180mcu_fd_sc_mcu9t5v0__aoi22_1
X$1819 \$6904 \$4212 \$4199 \$6401 \$6770 \$6890 \$6794
+ gf180mcu_fd_sc_mcu9t5v0__aoi22_1
X$1820 \$7918 \$4212 \$4199 \$7305 \$7797 \$7688 \$7804
+ gf180mcu_fd_sc_mcu9t5v0__aoi22_1
X$1821 \$6927 \$4212 \$4199 \$6922 \$7047 \$6890 \$6926
+ gf180mcu_fd_sc_mcu9t5v0__aoi22_1
X$1822 \$12689 \$4212 \$4199 \$10680 \$13341 \$13083 \$13233
+ gf180mcu_fd_sc_mcu9t5v0__aoi22_1
X$1823 \$8682 \$4212 \$4199 \$8838 \$8834 \$8717 \$8844
+ gf180mcu_fd_sc_mcu9t5v0__aoi22_1
X$1824 \$12385 \$4212 \$4199 \$10679 \$12486 \$12376 \$12505
+ gf180mcu_fd_sc_mcu9t5v0__aoi22_1
X$1825 \$7546 \$4212 \$4199 \$7174 \$7526 \$7417 \$7545
+ gf180mcu_fd_sc_mcu9t5v0__aoi22_1
X$1826 \$6792 \$4212 \$4199 \$6120 \$7304 \$7160 \$7296
+ gf180mcu_fd_sc_mcu9t5v0__aoi22_1
X$1827 \$4199 \$12535 \$12786 \$12526 \$12675 gf180mcu_fd_sc_mcu9t5v0__nand2_1
X$1828 \$15208 \$14454 \$14337 \$4199 gf180mcu_fd_sc_mcu9t5v0__buf_8
X$1829 \$4200 \$4730 \$4728 \$4416 \$4729 \$4726 \$4951 \$5106 \$4990
+ gf180mcu_fd_sc_mcu9t5v0__mux4_1
X$1830 \$4418 \$4731 \$4434 \$4314 \$4201 gf180mcu_fd_sc_mcu9t5v0__nand2_1
X$1831 \$4578 \$4203 \$4951 \$5106 \$4995 gf180mcu_fd_sc_mcu9t5v0__nand2_1
X$1832 \$4204 \$6136 \$6387 \$6361 gf180mcu_fd_sc_mcu9t5v0__clkinv_1
X$1833 \$5481 \$6392 \$4204 \$6497 \$6387 gf180mcu_fd_sc_mcu9t5v0__dffq_2
X$1834 \$5481 \$4573 \$4205 \$4702 \$4567 gf180mcu_fd_sc_mcu9t5v0__dffq_2
X$1835 \$4208 \$5736 \$5840 \$5735 \$5833 \$5623 gf180mcu_fd_sc_mcu9t5v0__and3_1
X$1836 \$4208 \$6662 \$7811 \$6663 \$6770 \$6616 \$6666
+ gf180mcu_fd_sc_mcu9t5v0__oai31_1
X$1837 \$15956 \$4210 \$16593 \$16436 \$16728 \$16592
+ gf180mcu_fd_sc_mcu9t5v0__oai21_1
X$1838 \$9787 \$4219 \$4210 \$10645 \$10391 \$10514 \$10539
+ gf180mcu_fd_sc_mcu9t5v0__aoi22_1
X$1839 \$8208 \$4219 \$4210 \$11730 \$11306 \$11555 \$11538
+ gf180mcu_fd_sc_mcu9t5v0__aoi22_1
X$1840 \$8862 \$4219 \$4210 \$12155 \$12260 \$12376 \$12387
+ gf180mcu_fd_sc_mcu9t5v0__aoi22_1
X$1841 \$4689 \$4219 \$4210 \$5635 \$5207 \$5240 \$5262
+ gf180mcu_fd_sc_mcu9t5v0__aoi22_1
X$1842 \$8859 \$4219 \$4210 \$10412 \$9748 \$9900 \$9910
+ gf180mcu_fd_sc_mcu9t5v0__aoi22_1
X$1843 \$9600 \$4219 \$4210 \$12500 \$12486 \$12376 \$12503
+ gf180mcu_fd_sc_mcu9t5v0__aoi22_1
X$1844 \$6943 \$4219 \$4210 \$7065 \$7304 \$7160 \$7295
+ gf180mcu_fd_sc_mcu9t5v0__aoi22_1
X$1845 \$6950 \$4219 \$4210 \$6949 \$7047 \$6890 \$6948
+ gf180mcu_fd_sc_mcu9t5v0__aoi22_1
X$1846 \$10640 \$4219 \$4210 \$11972 \$12260 \$11993 \$12273
+ gf180mcu_fd_sc_mcu9t5v0__aoi22_1
X$1847 \$5642 \$4219 \$4210 \$11205 \$4569 \$11136 \$11182 \$11210
+ gf180mcu_fd_sc_mcu9t5v0__aoi221_1
X$1848 \$5740 \$4219 \$4210 \$6514 \$4569 \$6497 \$6387 \$6516
+ gf180mcu_fd_sc_mcu9t5v0__aoi221_1
X$1849 \$6670 \$4219 \$4210 \$7544 \$4569 \$7526 \$7417 \$7425
+ gf180mcu_fd_sc_mcu9t5v0__aoi221_1
X$1850 \$9083 \$4219 \$4210 \$9612 \$4569 \$9608 \$9457 \$9590
+ gf180mcu_fd_sc_mcu9t5v0__aoi221_1
X$1851 \$9918 \$4219 \$4210 \$12557 \$4569 \$13623 \$13452 \$13520
+ gf180mcu_fd_sc_mcu9t5v0__aoi221_1
X$1852 \$4210 \$12535 \$12786 \$12930 \$12906 gf180mcu_fd_sc_mcu9t5v0__nand2_1
X$1853 \$15153 \$15045 \$15204 \$4210 gf180mcu_fd_sc_mcu9t5v0__buf_8
X$1854 \$12141 \$4212 \$11835 \$13623 \$13452 \$13508
+ gf180mcu_fd_sc_mcu9t5v0__and3_1
X$1855 \$4212 \$11522 \$11306 \$11182 \$11146 gf180mcu_fd_sc_mcu9t5v0__nand2_1
X$1856 \$15816 \$15949 \$15749 \$4212 gf180mcu_fd_sc_mcu9t5v0__buf_8
X$1857 \$12008 \$4212 \$12141 \$16914 \$16728 \$16858
+ gf180mcu_fd_sc_mcu9t5v0__mux2_1
X$1858 \$7908 \$4213 \$8063 \$8183 \$8207 gf180mcu_fd_sc_mcu9t5v0__nor2_1
X$1859 \$8968 \$4213 \$9102 \$9221 \$8972 gf180mcu_fd_sc_mcu9t5v0__nor2_1
X$1860 \$9239 \$4213 \$9337 \$9221 \$9238 gf180mcu_fd_sc_mcu9t5v0__nor2_1
X$1861 \$9795 \$4213 \$9748 \$9703 \$9794 gf180mcu_fd_sc_mcu9t5v0__nor2_1
X$1862 \$9720 \$9748 \$9703 \$4213 gf180mcu_fd_sc_mcu9t5v0__buf_8
X$1863 \$8695 \$8697 \$4213 \$8572 \$8717 \$8696 gf180mcu_fd_sc_mcu9t5v0__mux2_1
X$1864 \$5018 \$5115 \$4213 \$7797 \$7688 \$7593 gf180mcu_fd_sc_mcu9t5v0__mux2_1
X$1865 \$6375 \$6374 \$4213 \$7526 \$7417 \$7552 gf180mcu_fd_sc_mcu9t5v0__mux2_1
X$1866 \$4426 \$4427 \$4214 \$4434 \$4314 gf180mcu_fd_sc_mcu9t5v0__dffq_2
X$1867 \$4215 \$4425 \$4434 \$4314 \$4439 gf180mcu_fd_sc_mcu9t5v0__nand2_1
X$1868 \$4217 \$4434 \$4567 \$4548 gf180mcu_fd_sc_mcu9t5v0__clkinv_1
X$1869 \$4426 \$4440 \$4217 \$4434 \$4314 gf180mcu_fd_sc_mcu9t5v0__dffq_2
X$1870 \$4552 \$4218 \$4434 \$4567 \$4580 gf180mcu_fd_sc_mcu9t5v0__nand2_1
X$1871 \$4219 \$11835 \$13035 \$12930 \$11155 gf180mcu_fd_sc_mcu9t5v0__nand2_2
X$1872 \$13215 \$4219 \$16919 \$17038 \$16914 \$17034 \$16860
+ gf180mcu_fd_sc_mcu9t5v0__oai211_1
X$1873 \$4219 \$12142 \$11956 \$11993 \$11964 gf180mcu_fd_sc_mcu9t5v0__nor2_1
X$1874 \$12141 \$4219 \$11835 \$13623 \$13452 \$13630
+ gf180mcu_fd_sc_mcu9t5v0__nand3_1
X$1875 \$11517 \$4219 \$4318 \$10515 \$11956 \$11993 \$11996
+ gf180mcu_fd_sc_mcu9t5v0__aoi22_1
X$1876 \$7418 \$4219 \$4318 \$7915 \$7526 \$7688 \$7569
+ gf180mcu_fd_sc_mcu9t5v0__aoi22_1
X$1877 \$6139 \$4219 \$4318 \$7164 \$7047 \$7160 \$7053
+ gf180mcu_fd_sc_mcu9t5v0__aoi22_1
X$1878 \$9704 \$4219 \$4318 \$9344 \$9608 \$9457 \$9576
+ gf180mcu_fd_sc_mcu9t5v0__aoi22_1
X$1879 \$10285 \$4219 \$4318 \$11717 \$12786 \$12526 \$12661
+ gf180mcu_fd_sc_mcu9t5v0__aoi22_1
X$1880 \$14521 \$17374 \$17038 \$4219 \$17085 \$17367 \$17372
+ gf180mcu_fd_sc_mcu9t5v0__aoi22_1
X$1881 \$8336 \$4219 \$4318 \$8539 \$4569 \$8572 \$8335 \$8537
+ gf180mcu_fd_sc_mcu9t5v0__aoi221_1
X$1882 \$5363 \$4219 \$4318 \$5883 \$4569 \$6001 \$5833 \$5884
+ gf180mcu_fd_sc_mcu9t5v0__aoi221_1
X$1883 \$9903 \$4219 \$4318 \$9758 \$4569 \$11675 \$11555 \$11561
+ gf180mcu_fd_sc_mcu9t5v0__aoi221_1
X$1884 \$16078 \$15949 \$16070 \$4219 gf180mcu_fd_sc_mcu9t5v0__buf_8
X$1885 \$22905 \$19154 \$22910 \$4223 \$23183 \$23139 \$23201
+ gf180mcu_fd_sc_mcu9t5v0__aoi22_1
X$1886 \$13345 \$13226 \$13227 \$13341 \$13083 \$4224
+ gf180mcu_fd_sc_mcu9t5v0__aoi21_1
X$1887 \$4224 \$6662 \$7811 \$6663 \$8301 \$8183 \$8200
+ gf180mcu_fd_sc_mcu9t5v0__oai31_1
X$1888 \$4553 \$4545 \$4225 \$4543 \$4555 \$4434 \$4567 \$4581
+ gf180mcu_fd_sc_mcu9t5v0__oai221_1
X$1889 \$4415 \$4414 \$4434 \$4314 \$4435 gf180mcu_fd_sc_mcu9t5v0__nand2_1
X$1890 \$4314 \$4434 gf180mcu_fd_sc_mcu9t5v0__filltie
X$1891 \$4314 \$4434 gf180mcu_fd_sc_mcu9t5v0__filltie
X$1892 \$4314 \$4434 gf180mcu_fd_sc_mcu9t5v0__filltie
X$1893 \$4314 \$4434 gf180mcu_fd_sc_mcu9t5v0__filltie
X$1894 \$4314 \$4434 gf180mcu_fd_sc_mcu9t5v0__filltie
X$1895 \$4314 \$4434 gf180mcu_fd_sc_mcu9t5v0__filltie
X$1896 \$4314 \$4434 gf180mcu_fd_sc_mcu9t5v0__endcap
X$1897 \$5736 \$6928 \$4315 \$6001 \$5833 \$5889
+ gf180mcu_fd_sc_mcu9t5v0__aoi21_1
X$1898 \$14997 \$14996 \$13498 \$15045 \$14875 \$4315
+ gf180mcu_fd_sc_mcu9t5v0__mux2_1
X$1899 \$4315 \$4959 \$4991 \$4951 \$4849 \$4857 gf180mcu_fd_sc_mcu9t5v0__mux2_1
X$1900 \$4677 \$4981 \$4316 \$4982 \$4951 \$5106 \$5208
+ gf180mcu_fd_sc_mcu9t5v0__aoi211_1
X$1901 \$4318 \$12535 \$12786 \$12930 \$12010 gf180mcu_fd_sc_mcu9t5v0__and2_1
X$1902 \$15153 \$15045 \$14875 \$4318 gf180mcu_fd_sc_mcu9t5v0__buf_8
X$1903 \$4320 \$4684 \$4545 \$4702 \$4567 \$4710 gf180mcu_fd_sc_mcu9t5v0__mux2_1
X$1904 \$4548 \$4545 \$4322 \$4543 \$4551 \$4434 \$4567 \$4440
+ gf180mcu_fd_sc_mcu9t5v0__oai221_1
X$1905 \$4569 \$4323 \$4558 \$4434 \$4567 \$4582
+ gf180mcu_fd_sc_mcu9t5v0__oai21_1
X$1906 \$4409 \$4671 \$4672 \$4702 \$4567 \$4697
+ gf180mcu_fd_sc_mcu9t5v0__oai21_1
X$1907 \$4528 \$4432 \$4409 \$4434 \$4567 gf180mcu_fd_sc_mcu9t5v0__dffq_2
X$1908 \$4410 \$4671 \$4672 \$4702 \$4567 \$4698
+ gf180mcu_fd_sc_mcu9t5v0__oai21_1
X$1909 \$4528 \$4433 \$4410 \$4434 \$4567 gf180mcu_fd_sc_mcu9t5v0__dffq_2
X$1910 \$4728 \$4727 \$4992 \$4416 \$4702 \$4849 \$4675
+ gf180mcu_fd_sc_mcu9t5v0__aoi22_1
X$1911 \$4416 \$6001 \$6105 \$6008 gf180mcu_fd_sc_mcu9t5v0__clkinv_1
X$1912 \$5481 \$6148 \$4416 \$6136 \$6105 gf180mcu_fd_sc_mcu9t5v0__dffq_2
X$1913 \$4537 \$4678 \$4702 \$4567 \$4417 gf180mcu_fd_sc_mcu9t5v0__nand2_1
X$1914 \$4419 \$5736 \$5840 \$5735 \$5833 \$5841 gf180mcu_fd_sc_mcu9t5v0__and3_1
X$1915 \$4419 \$6662 \$7811 \$6663 \$6770 \$6890 \$6895
+ gf180mcu_fd_sc_mcu9t5v0__oai31_1
X$1916 \$4420 \$4539 \$4434 \$4567 \$4572 gf180mcu_fd_sc_mcu9t5v0__nand2_1
X$1917 \$4962 \$4732 \$4951 \$4849 \$4421 gf180mcu_fd_sc_mcu9t5v0__nand2_1
X$1918 \$4422 \$6497 \$6387 \$6507 gf180mcu_fd_sc_mcu9t5v0__clkinv_1
X$1919 \$5891 \$6625 \$4422 \$6497 \$6616 gf180mcu_fd_sc_mcu9t5v0__dffq_2
X$1920 \$4578 \$4423 \$4702 \$4849 \$4745 gf180mcu_fd_sc_mcu9t5v0__nor2_1
X$1921 \$5481 \$5366 \$4423 \$5358 \$5240 gf180mcu_fd_sc_mcu9t5v0__dffq_2
X$1922 \$4423 \$5248 \$4958 \$5358 \$5473 \$5366 gf180mcu_fd_sc_mcu9t5v0__mux2_1
X$1923 \$4426 \$5735 \$5473 \$I71701 gf180mcu_fd_sc_mcu9t5v0__clkinv_4
X$1924 \$4426 \$5625 \$5851 \$5735 \$5833 gf180mcu_fd_sc_mcu9t5v0__dffq_2
X$1925 \$4426 \$6627 \$6628 \$6497 \$6616 gf180mcu_fd_sc_mcu9t5v0__dffq_2
X$1926 \$4426 \$6114 \$6012 \$6001 \$6105 gf180mcu_fd_sc_mcu9t5v0__dffq_2
X$1927 \$4426 \$6509 \$6011 \$6497 \$6616 gf180mcu_fd_sc_mcu9t5v0__dffq_2
X$1928 \$4426 \$5495 \$5494 \$5358 \$5473 gf180mcu_fd_sc_mcu9t5v0__dffq_2
X$1929 \$4426 \$6519 \$6632 \$6497 \$6616 gf180mcu_fd_sc_mcu9t5v0__dffq_2
X$1930 \$4426 \$5903 \$5740 \$6001 \$6105 gf180mcu_fd_sc_mcu9t5v0__dffq_2
X$1931 \$4426 \$5009 \$4756 \$4951 \$5106 gf180mcu_fd_sc_mcu9t5v0__dffq_2
X$1932 \$4426 \$5859 \$4759 \$6001 \$6105 gf180mcu_fd_sc_mcu9t5v0__dffq_2
X$1933 \$4426 \$5861 \$5910 \$5735 \$5833 gf180mcu_fd_sc_mcu9t5v0__dffq_2
X$1934 \$4426 \$5852 \$5853 \$6001 \$5833 gf180mcu_fd_sc_mcu9t5v0__dffq_2
X$1935 \$4426 \$4858 \$4748 \$4951 \$4849 gf180mcu_fd_sc_mcu9t5v0__dffq_2
X$1936 \$4426 \$7177 \$6630 \$7304 \$7160 gf180mcu_fd_sc_mcu9t5v0__dffq_2
X$1937 \$4426 \$5257 \$5374 \$5358 \$5240 gf180mcu_fd_sc_mcu9t5v0__dffq_2
X$1938 \$4428 \$8063 \$7947 \$8081 gf180mcu_fd_sc_mcu9t5v0__clkinv_1
X$1939 \$7698 \$7966 \$4428 \$8063 \$7947 gf180mcu_fd_sc_mcu9t5v0__dffq_2
X$1940 \$4578 \$4553 \$4554 \$4550 \$4434 \$4567 \$4441
+ gf180mcu_fd_sc_mcu9t5v0__aoi211_1
X$1941 \$4578 \$4548 \$4549 \$4550 \$4434 \$4567 \$4547
+ gf180mcu_fd_sc_mcu9t5v0__aoi211_1
X$1942 \$4550 \$4556 \$4557 \$4434 \$4567 \$4687
+ gf180mcu_fd_sc_mcu9t5v0__oai21_1
X$1943 \$4671 \$4530 \$4434 \$4567 \$4529 gf180mcu_fd_sc_mcu9t5v0__nand2_1
X$1944 \$4438 \$4541 \$4434 \$4567 \$4574 gf180mcu_fd_sc_mcu9t5v0__nand2_1
X$1945 \$4567 \$4434 gf180mcu_fd_sc_mcu9t5v0__filltie
X$1946 \$4567 \$4434 gf180mcu_fd_sc_mcu9t5v0__filltie
X$1947 \$4567 \$4434 gf180mcu_fd_sc_mcu9t5v0__filltie
X$1948 \$4567 \$4434 gf180mcu_fd_sc_mcu9t5v0__filltie
X$1949 \$4567 \$4434 gf180mcu_fd_sc_mcu9t5v0__filltie
X$1950 \$4567 \$4434 gf180mcu_fd_sc_mcu9t5v0__filltie
X$1951 \$4567 \$4434 gf180mcu_fd_sc_mcu9t5v0__endcap
X$1952 \$21807 \$19154 \$21663 \$4435 \$21661 \$21946 \$21953
+ gf180mcu_fd_sc_mcu9t5v0__aoi22_1
X$1953 \$22905 \$19154 \$22910 \$4439 \$23183 \$23139 \$23199
+ gf180mcu_fd_sc_mcu9t5v0__aoi22_1
X$1954 \$4528 \$5207 \$5240 gf180mcu_fd_sc_mcu9t5v0__inv_4
X$1955 \$4973 \$4951 \$5106 \$4528 gf180mcu_fd_sc_mcu9t5v0__clkbuf_8
X$1956 \$4528 \$5237 \$5205 \$5207 \$5240 gf180mcu_fd_sc_mcu9t5v0__dffq_2
X$1957 \$4528 \$4700 \$4701 \$4702 \$4849 gf180mcu_fd_sc_mcu9t5v0__dffq_2
X$1958 \$4528 \$5200 \$5201 \$5207 \$5240 gf180mcu_fd_sc_mcu9t5v0__dffq_2
X$1959 \$4528 \$5203 \$5204 \$5207 \$5240 gf180mcu_fd_sc_mcu9t5v0__dffq_2
X$1960 \$4528 \$6488 \$6489 \$6497 \$6616 gf180mcu_fd_sc_mcu9t5v0__dffq_2
X$1961 \$4528 \$5593 \$5829 \$5735 \$5833 gf180mcu_fd_sc_mcu9t5v0__dffq_2
X$1962 \$4528 \$6129 \$6131 \$6136 \$6387 gf180mcu_fd_sc_mcu9t5v0__dffq_2
X$1963 \$4528 \$4694 \$4695 \$4702 \$4849 gf180mcu_fd_sc_mcu9t5v0__dffq_2
X$1964 \$4528 \$4975 \$4976 \$5207 \$5106 gf180mcu_fd_sc_mcu9t5v0__dffq_2
X$1965 \$4528 \$4979 \$4980 \$5207 \$5106 gf180mcu_fd_sc_mcu9t5v0__dffq_2
X$1966 \$4528 \$5470 \$5471 \$5735 \$5473 gf180mcu_fd_sc_mcu9t5v0__dffq_2
X$1967 \$4528 \$5104 \$4974 \$5207 \$5106 gf180mcu_fd_sc_mcu9t5v0__dffq_2
X$1968 \$4528 \$4562 \$4670 \$4702 \$4567 gf180mcu_fd_sc_mcu9t5v0__dffq_2
X$1969 \$4534 \$7526 \$7417 \$7536 gf180mcu_fd_sc_mcu9t5v0__clkinv_1
X$1970 \$7278 \$7578 \$4534 \$7526 \$7688 gf180mcu_fd_sc_mcu9t5v0__dffq_2
X$1971 \$4536 \$4989 \$4987 \$4988 \$4729 \$4726 \$4951 \$5106 \$4856
+ gf180mcu_fd_sc_mcu9t5v0__mux4_1
X$1972 \$4538 \$5736 \$5840 \$5735 \$5833 \$5845 gf180mcu_fd_sc_mcu9t5v0__and3_1
X$1973 \$4538 \$6662 \$7811 \$6663 \$6770 \$6890 \$6778
+ gf180mcu_fd_sc_mcu9t5v0__oai31_1
X$1974 \$14217 \$4538 \$16914 \$16728 \$16734 gf180mcu_fd_sc_mcu9t5v0__nand2_1
X$1975 \$4740 \$4739 \$4702 \$4849 \$4540 gf180mcu_fd_sc_mcu9t5v0__nand2_1
X$1976 \$4542 \$6136 \$6105 \$6150 gf180mcu_fd_sc_mcu9t5v0__clkinv_1
X$1977 \$5891 \$6363 \$4542 \$6136 \$6387 gf180mcu_fd_sc_mcu9t5v0__dffq_2
X$1978 \$10672 \$4545 \$10533 \$4543 \$10671 \$10630 \$10782 \$10800
+ gf180mcu_fd_sc_mcu9t5v0__oai221_1
X$1979 \$6517 \$4545 \$6515 \$4543 \$6518 \$6497 \$6387 \$6519
+ gf180mcu_fd_sc_mcu9t5v0__oai221_1
X$1980 \$7961 \$4545 \$7809 \$4543 \$7962 \$8063 \$7947 \$8076
+ gf180mcu_fd_sc_mcu9t5v0__oai221_1
X$1981 \$11159 \$4545 \$11194 \$4543 \$11319 \$11136 \$11025 \$11195
+ gf180mcu_fd_sc_mcu9t5v0__oai221_1
X$1982 \$6902 \$4545 \$6945 \$4543 \$6946 \$7047 \$6890 \$6947
+ gf180mcu_fd_sc_mcu9t5v0__oai221_1
X$1983 \$5229 \$4545 \$5114 \$4543 \$5228 \$5207 \$5106 \$5230
+ gf180mcu_fd_sc_mcu9t5v0__oai221_1
X$1984 \$11157 \$11136 \$11025 \$4543 gf180mcu_fd_sc_mcu9t5v0__buf_8
X$1985 \$5253 \$4732 \$4702 \$4849 \$4544 gf180mcu_fd_sc_mcu9t5v0__nand2_1
X$1986 \$11692 \$11956 \$11827 \$4545 gf180mcu_fd_sc_mcu9t5v0__buf_8
X$1987 \$12385 \$12394 \$4545 \$12260 \$12376 \$12395
+ gf180mcu_fd_sc_mcu9t5v0__mux2_1
X$1988 \$11166 \$11040 \$4545 \$10901 \$11025 \$11041
+ gf180mcu_fd_sc_mcu9t5v0__mux2_1
X$1989 \$12276 \$12160 \$4545 \$11956 \$11993 \$12038
+ gf180mcu_fd_sc_mcu9t5v0__mux2_1
X$1990 \$11330 \$11544 \$4545 \$11306 \$11555 \$11577
+ gf180mcu_fd_sc_mcu9t5v0__mux2_1
X$1991 \$9734 \$9790 \$4545 \$9608 \$9703 \$9733 gf180mcu_fd_sc_mcu9t5v0__mux2_1
X$1992 \$6904 \$7560 \$4545 \$7526 \$7417 \$7561 gf180mcu_fd_sc_mcu9t5v0__mux2_1
X$1993 \$12689 \$12561 \$4545 \$12786 \$12526 \$12798
+ gf180mcu_fd_sc_mcu9t5v0__mux2_1
X$1994 \$10299 \$10421 \$4545 \$10391 \$10282 \$10422
+ gf180mcu_fd_sc_mcu9t5v0__mux2_1
X$1995 \$4677 \$4716 \$4702 \$4567 \$4546 gf180mcu_fd_sc_mcu9t5v0__nand2_1
X$1996 \$4578 \$4748 \$4702 \$4849 \$4549 gf180mcu_fd_sc_mcu9t5v0__nor2_1
X$1997 \$4995 \$4994 \$4550 \$4951 \$5106 \$4993
+ gf180mcu_fd_sc_mcu9t5v0__aoi21_1
X$1998 \$6907 \$6908 \$4550 \$7047 \$6890 \$6954
+ gf180mcu_fd_sc_mcu9t5v0__aoi21_1
X$1999 \$12507 \$12506 \$4550 \$12486 \$12376 \$12034
+ gf180mcu_fd_sc_mcu9t5v0__aoi21_1
X$2000 \$4578 \$6517 \$6673 \$4550 \$6497 \$6616 \$6513
+ gf180mcu_fd_sc_mcu9t5v0__aoi211_1
X$2001 \$4550 \$10929 \$11165 \$10901 \$11025 \$8694
+ gf180mcu_fd_sc_mcu9t5v0__oai21_1
X$2002 \$4550 \$7542 \$7543 \$7526 \$7417 \$6896
+ gf180mcu_fd_sc_mcu9t5v0__oai21_1
X$2003 \$4550 \$11329 \$11537 \$11536 \$11306 \$11555 \$8084
+ gf180mcu_fd_sc_mcu9t5v0__oai31_1
X$2004 \$4550 \$4746 \$4745 \$4709 \$4702 \$4849 \$4683
+ gf180mcu_fd_sc_mcu9t5v0__oai31_1
X$2005 \$4550 \$9725 \$9726 \$9724 \$9608 \$9703 \$9721
+ gf180mcu_fd_sc_mcu9t5v0__oai31_1
X$2006 \$4550 \$7309 \$7419 \$7276 \$7304 \$7417 \$7274
+ gf180mcu_fd_sc_mcu9t5v0__oai31_1
X$2007 \$4550 \$5608 \$5838 \$6006 \$5735 \$5833 \$5881
+ gf180mcu_fd_sc_mcu9t5v0__oai31_1
X$2008 \$4550 \$10297 \$10298 \$10417 \$10391 \$10282 \$9915
+ gf180mcu_fd_sc_mcu9t5v0__oai31_1
X$2009 \$4550 \$11560 \$11715 \$11686 \$11675 \$11555 \$11514
+ gf180mcu_fd_sc_mcu9t5v0__oai31_1
X$2010 \$4550 \$4571 \$4676 \$4675 \$4702 \$4567 \$4674
+ gf180mcu_fd_sc_mcu9t5v0__oai31_1
X$2011 \$4550 \$11961 \$11962 \$11960 \$11956 \$11827 \$10395
+ gf180mcu_fd_sc_mcu9t5v0__oai31_1
X$2012 \$4550 \$4854 \$4855 \$4853 \$4951 \$4849 \$4981
+ gf180mcu_fd_sc_mcu9t5v0__oai31_1
X$2013 \$4550 \$11980 \$11844 \$11979 \$11956 \$11827 \$9914
+ gf180mcu_fd_sc_mcu9t5v0__oai31_1
X$2014 \$4550 \$5108 \$5217 \$5216 \$5207 \$5106 \$4997
+ gf180mcu_fd_sc_mcu9t5v0__oai31_1
X$2015 \$4550 \$11968 \$11969 \$11836 \$11956 \$11827 \$11695
+ gf180mcu_fd_sc_mcu9t5v0__oai31_1
X$2016 \$4550 \$4686 \$4713 \$4685 \$4702 \$4567 \$4714
+ gf180mcu_fd_sc_mcu9t5v0__oai31_1
X$2017 \$4550 \$11314 \$11529 \$5356 \$11306 \$11555 \$11528
+ gf180mcu_fd_sc_mcu9t5v0__oai211_1
X$2018 \$4578 \$4550 \$11956 \$11993 \$11129 gf180mcu_fd_sc_mcu9t5v0__nor2_1
X$2019 \$4578 \$4550 \$10391 \$10282 \$10389 gf180mcu_fd_sc_mcu9t5v0__nand2_1
X$2020 \$9742 \$9748 \$9900 \$4550 gf180mcu_fd_sc_mcu9t5v0__buf_8
X$2021 \$5007 \$4732 \$4951 \$4849 \$4551 gf180mcu_fd_sc_mcu9t5v0__nand2_1
X$2022 \$4578 \$4756 \$4702 \$4567 \$4554 gf180mcu_fd_sc_mcu9t5v0__nor2_1
X$2023 \$5259 \$4732 \$4951 \$5106 \$4555 gf180mcu_fd_sc_mcu9t5v0__nand2_1
X$2024 \$5113 \$4732 \$4702 \$4849 \$4559 gf180mcu_fd_sc_mcu9t5v0__nand2_1
X$2025 \$4689 \$4702 \$4567 \$4560 gf180mcu_fd_sc_mcu9t5v0__clkinv_1
X$2026 \$4671 \$4563 \$4702 \$4567 \$4696 gf180mcu_fd_sc_mcu9t5v0__nand2_1
X$2027 \$4948 \$4564 \$5880 \$6001 \$5833 \$6000
+ gf180mcu_fd_sc_mcu9t5v0__nand3_1
X$2028 \$4703 \$4565 \$4702 \$4567 \$4722 gf180mcu_fd_sc_mcu9t5v0__nor2_1
X$2029 \$4566 \$4723 \$4702 \$4849 \$4953 gf180mcu_fd_sc_mcu9t5v0__nor2_1
X$2030 \$4566 \$4702 \$4567 \$4578 gf180mcu_fd_sc_mcu9t5v0__buf_8
X$2031 \$4569 \$4673 \$4570 \$4702 \$4567 \$4705
+ gf180mcu_fd_sc_mcu9t5v0__oai21_1
X$2032 \$4578 \$4730 \$4702 \$4567 \$4676 gf180mcu_fd_sc_mcu9t5v0__nor2_1
X$2033 \$4583 \$4702 \$4567 \$4688 gf180mcu_fd_sc_mcu9t5v0__clkinv_1
X$2034 \$4677 \$4708 \$4702 \$4567 \$4575 gf180mcu_fd_sc_mcu9t5v0__nand2_1
X$2035 \$4567 \$4702 gf180mcu_fd_sc_mcu9t5v0__filltie
X$2036 \$4567 \$4702 gf180mcu_fd_sc_mcu9t5v0__filltie
X$2037 \$4567 \$4702 gf180mcu_fd_sc_mcu9t5v0__filltie
X$2038 \$4567 \$4702 gf180mcu_fd_sc_mcu9t5v0__filltie
X$2039 \$4567 \$4702 gf180mcu_fd_sc_mcu9t5v0__filltie
X$2040 \$4567 \$4702 gf180mcu_fd_sc_mcu9t5v0__filltie
X$2041 \$4567 \$4702 gf180mcu_fd_sc_mcu9t5v0__endcap
X$2042 \$4569 \$12144 \$12007 \$12537 \$12376 \$11308 \$12486
+ gf180mcu_fd_sc_mcu9t5v0__oai211_4
X$2043 \$12144 \$12145 \$4569 \$12260 \$11993 \$12006
+ gf180mcu_fd_sc_mcu9t5v0__oai21_4
X$2044 \$4569 \$16378 \$16075 \$15949 \$16070 \$15813
+ gf180mcu_fd_sc_mcu9t5v0__aoi21_1
X$2045 \$4569 \$16133 \$16378 \$16269 \$16070 \$16075
+ gf180mcu_fd_sc_mcu9t5v0__aoi21_1
X$2046 \$4569 \$11561 \$11718 \$11675 \$11827 \$11830
+ gf180mcu_fd_sc_mcu9t5v0__oai21_1
X$2047 \$4569 \$13520 \$13233 \$13623 \$13729 \$16159
+ gf180mcu_fd_sc_mcu9t5v0__oai21_1
X$2048 \$4569 \$5884 \$6005 \$6001 \$6105 \$6004
+ gf180mcu_fd_sc_mcu9t5v0__oai21_1
X$2049 \$4569 \$6516 \$6631 \$6497 \$6616 \$6633
+ gf180mcu_fd_sc_mcu9t5v0__oai21_1
X$2050 \$4569 \$11210 \$11211 \$11136 \$11182 \$11846
+ gf180mcu_fd_sc_mcu9t5v0__oai21_1
X$2051 \$4569 \$7425 \$7545 \$7526 \$7417 \$7547
+ gf180mcu_fd_sc_mcu9t5v0__oai21_1
X$2052 \$4569 \$9590 \$9463 \$9608 \$9457 \$10411
+ gf180mcu_fd_sc_mcu9t5v0__oai21_1
X$2053 \$4569 \$8537 \$8844 \$8834 \$8717 \$8843
+ gf180mcu_fd_sc_mcu9t5v0__oai21_1
X$2054 \$4569 \$12008 \$16269 \$16376 \$16078 gf180mcu_fd_sc_mcu9t5v0__nor2_1
X$2055 \$4569 \$12266 \$12260 \$12376 \$12140 gf180mcu_fd_sc_mcu9t5v0__nor2_1
X$2056 \$4569 \$14201 \$15045 \$15204 \$15153 gf180mcu_fd_sc_mcu9t5v0__nor2_1
X$2057 \$16077 \$16269 \$16070 \$4569 gf180mcu_fd_sc_mcu9t5v0__buf_8
X$2058 \$22447 \$19154 \$21663 \$4572 \$22387 \$22440 \$22896
+ gf180mcu_fd_sc_mcu9t5v0__aoi22_1
X$2059 \$21668 \$19154 \$21663 \$4574 \$21661 \$21946 \$22454
+ gf180mcu_fd_sc_mcu9t5v0__aoi22_1
X$2060 \$8344 \$8350 \$8345 \$4576 \$8572 \$8335 \$8548
+ gf180mcu_fd_sc_mcu9t5v0__aoi211_1
X$2061 \$5891 \$8689 \$4576 \$8572 \$8717 gf180mcu_fd_sc_mcu9t5v0__dffq_2
X$2062 \$4577 \$7797 \$7947 \$7584 gf180mcu_fd_sc_mcu9t5v0__clkinv_1
X$2063 \$6366 \$7694 \$4577 \$7797 \$7688 gf180mcu_fd_sc_mcu9t5v0__dffq_2
X$2064 \$4578 \$6789 \$6015 \$6770 \$6890 \$6790
+ gf180mcu_fd_sc_mcu9t5v0__oai21_1
X$2065 \$4578 \$5839 \$5735 \$5833 \$5838 gf180mcu_fd_sc_mcu9t5v0__nor2_1
X$2066 \$4578 \$7167 \$7304 \$7417 \$7419 gf180mcu_fd_sc_mcu9t5v0__nor2_1
X$2067 \$4578 \$4712 \$4702 \$4849 \$4713 gf180mcu_fd_sc_mcu9t5v0__nor2_1
X$2068 \$4578 \$12663 \$12486 \$12526 \$11962 gf180mcu_fd_sc_mcu9t5v0__nor2_1
X$2069 \$4578 \$12380 \$11956 \$11993 \$11715 gf180mcu_fd_sc_mcu9t5v0__nor2_1
X$2070 \$4578 \$12157 \$11956 \$11993 \$11844 gf180mcu_fd_sc_mcu9t5v0__nor2_1
X$2071 \$4578 \$10676 \$10391 \$10514 \$10298 gf180mcu_fd_sc_mcu9t5v0__nor2_1
X$2072 \$4578 \$6628 \$6770 \$6616 \$6673 gf180mcu_fd_sc_mcu9t5v0__nor2_1
X$2073 \$4578 \$4989 \$4951 \$4849 \$4855 gf180mcu_fd_sc_mcu9t5v0__nor2_1
X$2074 \$4578 \$11847 \$11675 \$11555 \$11537 gf180mcu_fd_sc_mcu9t5v0__nor2_1
X$2075 \$4578 \$10799 \$11956 \$11827 \$11969 gf180mcu_fd_sc_mcu9t5v0__nor2_1
X$2076 \$4578 \$9783 \$9748 \$9703 \$9726 gf180mcu_fd_sc_mcu9t5v0__nor2_1
X$2077 \$4578 \$4737 \$5207 \$5106 \$5217 gf180mcu_fd_sc_mcu9t5v0__nor2_1
X$2078 \$4578 \$6915 \$12482 \$12652 \$11823 \$12786 \$12526 \$12783
+ gf180mcu_fd_sc_mcu9t5v0__aoi221_1
X$2079 \$4578 \$12689 \$12486 \$12526 \$12506 gf180mcu_fd_sc_mcu9t5v0__nand2_1
X$2080 \$4578 \$6904 \$6770 \$6890 \$6908 gf180mcu_fd_sc_mcu9t5v0__nand2_1
X$2081 \$11168 \$11167 \$4578 \$11136 \$11182 \$10653
+ gf180mcu_fd_sc_mcu9t5v0__mux2_1
X$2082 \$22905 \$19154 \$22910 \$4580 \$23027 \$23139 \$23036
+ gf180mcu_fd_sc_mcu9t5v0__aoi22_1
X$2083 \$22905 \$19154 \$22910 \$4582 \$23183 \$23139 \$23202
+ gf180mcu_fd_sc_mcu9t5v0__aoi22_1
X$2084 \$4670 \$4671 \$4672 \$4696 \$4702 \$4849 \$5354
+ gf180mcu_fd_sc_mcu9t5v0__oai211_1
X$2085 \$7156 \$4671 \$7528 \$7527 \$4672 \$7526 \$7417 \$7413
+ gf180mcu_fd_sc_mcu9t5v0__oai221_1
X$2086 \$8960 \$4671 \$9336 \$9215 \$4672 \$9337 \$9221 \$9335
+ gf180mcu_fd_sc_mcu9t5v0__oai221_1
X$2087 \$5357 \$9101 \$4671 \$9102 \$9221 \$9215
+ gf180mcu_fd_sc_mcu9t5v0__oai21_1
X$2088 \$5357 \$5214 \$4671 \$5207 \$5240 \$5210
+ gf180mcu_fd_sc_mcu9t5v0__oai21_1
X$2089 \$5357 \$7529 \$4671 \$7526 \$7417 \$7527
+ gf180mcu_fd_sc_mcu9t5v0__oai21_1
X$2090 \$9563 \$4671 \$4672 \$9608 \$9703 \$9894
+ gf180mcu_fd_sc_mcu9t5v0__oai21_1
X$2091 \$10224 \$4671 \$4672 \$10391 \$10514 \$10386
+ gf180mcu_fd_sc_mcu9t5v0__oai21_1
X$2092 \$8674 \$4671 \$4672 \$8572 \$8717 \$8673
+ gf180mcu_fd_sc_mcu9t5v0__oai21_1
X$2093 \$5471 \$4671 \$4672 \$5735 \$5833 \$5732
+ gf180mcu_fd_sc_mcu9t5v0__oai21_1
X$2094 \$4701 \$4671 \$4672 \$4951 \$4849 \$4952
+ gf180mcu_fd_sc_mcu9t5v0__oai21_1
X$2095 \$4695 \$4671 \$4672 \$4951 \$4849 \$4946
+ gf180mcu_fd_sc_mcu9t5v0__oai21_1
X$2096 \$7562 \$4671 \$4672 \$7526 \$7417 \$7521
+ gf180mcu_fd_sc_mcu9t5v0__oai21_1
X$2097 \$8529 \$4671 \$4672 \$8834 \$8717 \$8827
+ gf180mcu_fd_sc_mcu9t5v0__oai21_1
X$2098 \$9070 \$4671 \$4672 \$9337 \$9221 \$9329
+ gf180mcu_fd_sc_mcu9t5v0__oai21_1
X$2099 \$5877 \$4671 \$4672 \$6136 \$6105 \$6134
+ gf180mcu_fd_sc_mcu9t5v0__oai21_1
X$2100 \$6341 \$4671 \$4672 \$5875 \$6136 \$6387 \$6342
+ gf180mcu_fd_sc_mcu9t5v0__oai211_1
X$2101 \$9071 \$4671 \$8957 \$4672 \$8834 \$8963 \$8956
+ gf180mcu_fd_sc_mcu9t5v0__oai211_1
X$2102 \$8830 \$4671 \$4672 \$8831 \$8834 \$8963 \$8954
+ gf180mcu_fd_sc_mcu9t5v0__oai211_1
X$2103 \$7563 \$4671 \$4672 \$7564 \$7526 \$7688 \$7794
+ gf180mcu_fd_sc_mcu9t5v0__oai211_1
X$2104 \$5596 \$4671 \$4672 \$5876 \$6001 \$5833 \$5873
+ gf180mcu_fd_sc_mcu9t5v0__oai211_1
X$2105 \$7910 \$4671 \$4672 \$8300 \$8301 \$8183 \$8299
+ gf180mcu_fd_sc_mcu9t5v0__oai211_1
X$2106 \$6131 \$4671 \$4672 \$6491 \$6497 \$6387 \$6612
+ gf180mcu_fd_sc_mcu9t5v0__oai211_1
X$2107 \$4671 \$6135 \$7526 \$7688 \$7564 gf180mcu_fd_sc_mcu9t5v0__nand2_1
X$2108 \$4671 \$6133 \$6136 \$6105 \$5876 gf180mcu_fd_sc_mcu9t5v0__nand2_1
X$2109 \$4671 \$8064 \$8301 \$8183 \$8300 gf180mcu_fd_sc_mcu9t5v0__nand2_1
X$2110 \$4671 \$7051 \$8834 \$8717 \$8831 gf180mcu_fd_sc_mcu9t5v0__nand2_1
X$2111 \$4671 \$8958 \$9102 \$8963 \$8957 gf180mcu_fd_sc_mcu9t5v0__nand2_1
X$2112 \$4671 \$6493 \$6497 \$6387 \$6491 gf180mcu_fd_sc_mcu9t5v0__nand2_1
X$2113 \$10018 \$10022 \$9900 \$4671 gf180mcu_fd_sc_mcu9t5v0__buf_8
X$2114 \$11678 \$10024 \$11680 \$11711 \$4672 \$11675 \$11555 \$11551
+ gf180mcu_fd_sc_mcu9t5v0__oai221_1
X$2115 \$10025 \$10024 \$8854 \$10023 \$4672 \$10022 \$9900 \$10390
+ gf180mcu_fd_sc_mcu9t5v0__oai221_1
X$2116 \$10509 \$10024 \$4672 \$11136 \$11025 \$11132
+ gf180mcu_fd_sc_mcu9t5v0__oai21_1
X$2117 \$11135 \$10024 \$4672 \$11023 \$10901 \$11025 \$10900
+ gf180mcu_fd_sc_mcu9t5v0__oai211_1
X$2118 \$11178 \$10024 \$4672 \$11513 \$11306 \$11555 \$11673
+ gf180mcu_fd_sc_mcu9t5v0__oai211_1
X$2119 \$11175 \$10024 \$4672 \$11508 \$11306 \$11555 \$11304
+ gf180mcu_fd_sc_mcu9t5v0__oai211_1
X$2120 \$11131 \$11136 \$11025 \$4672 gf180mcu_fd_sc_mcu9t5v0__buf_8
X$2121 \$4677 \$9067 \$11505 \$11956 \$11827 \$11943
+ gf180mcu_fd_sc_mcu9t5v0__aoi21_1
X$2122 \$11695 \$11528 \$4677 \$11675 \$11555 \$11553
+ gf180mcu_fd_sc_mcu9t5v0__aoi21_1
X$2123 \$4677 \$11514 \$11516 \$4982 \$11306 \$11555 \$11548
+ gf180mcu_fd_sc_mcu9t5v0__aoi211_1
X$2124 \$4677 \$8694 \$5633 \$4982 \$8572 \$8717 \$8828
+ gf180mcu_fd_sc_mcu9t5v0__aoi211_1
X$2125 \$4677 \$9915 \$9791 \$4982 \$9748 \$9900 \$9895
+ gf180mcu_fd_sc_mcu9t5v0__aoi211_1
X$2126 \$4677 \$6896 \$6669 \$4982 \$6770 \$6890 \$6886
+ gf180mcu_fd_sc_mcu9t5v0__aoi211_1
X$2127 \$4677 \$9721 \$9722 \$4982 \$9608 \$9703 \$9561
+ gf180mcu_fd_sc_mcu9t5v0__aoi211_1
X$2128 \$4677 \$4714 \$4715 \$4982 \$4702 \$4849 \$4720
+ gf180mcu_fd_sc_mcu9t5v0__aoi211_1
X$2129 \$4677 \$7274 \$6652 \$4982 \$7304 \$7417 \$7523
+ gf180mcu_fd_sc_mcu9t5v0__aoi211_1
X$2130 \$4677 \$10395 \$10286 \$4982 \$10391 \$10282 \$10387
+ gf180mcu_fd_sc_mcu9t5v0__aoi211_1
X$2131 \$4677 \$5881 \$5835 \$4982 \$6001 \$5833 \$5733
+ gf180mcu_fd_sc_mcu9t5v0__aoi211_1
X$2132 \$4677 \$8712 \$8713 \$4982 \$8834 \$8717 \$8710
+ gf180mcu_fd_sc_mcu9t5v0__aoi211_1
X$2133 \$4677 \$12035 \$12034 \$12033 \$11956 \$11993 \$11952
+ gf180mcu_fd_sc_mcu9t5v0__oai22_1
X$2134 \$4677 \$6906 \$6954 \$6953 \$7047 \$6890 \$7051
+ gf180mcu_fd_sc_mcu9t5v0__oai22_1
X$2135 \$4677 \$5897 \$6513 \$6512 \$6497 \$6387 \$6133
+ gf180mcu_fd_sc_mcu9t5v0__oai22_1
X$2136 \$4677 \$11574 \$12032 \$11978 \$11956 \$11827 \$11509
+ gf180mcu_fd_sc_mcu9t5v0__oai22_1
X$2137 \$4677 \$8085 \$8084 \$8063 \$8183 \$8064
+ gf180mcu_fd_sc_mcu9t5v0__oai21_1
X$2138 \$4677 \$9091 \$9914 \$8834 \$8963 \$8958
+ gf180mcu_fd_sc_mcu9t5v0__oai21_1
X$2139 \$4677 \$6523 \$6638 \$6497 \$6616 \$6493
+ gf180mcu_fd_sc_mcu9t5v0__oai21_1
X$2140 \$4677 \$9067 \$11943 \$11956 \$11827 \$11821
+ gf180mcu_fd_sc_mcu9t5v0__oai21_1
X$2141 \$5356 \$5836 \$5834 \$5603 \$4677 \$5735 \$5833 \$5835
+ gf180mcu_fd_sc_mcu9t5v0__aoi221_1
X$2142 \$8678 \$8677 \$8716 \$8676 \$4677 \$8572 \$8717 \$8713
+ gf180mcu_fd_sc_mcu9t5v0__aoi221_1
X$2143 \$9339 \$9338 \$9456 \$9219 \$4677 \$9337 \$9457 \$9336
+ gf180mcu_fd_sc_mcu9t5v0__aoi221_1
X$2144 \$9776 \$9360 \$9723 \$9586 \$4677 \$9608 \$9703 \$9722
+ gf180mcu_fd_sc_mcu9t5v0__aoi221_1
X$2145 \$10396 \$10517 \$10516 \$9901 \$4677 \$10391 \$10514 \$10286
+ gf180mcu_fd_sc_mcu9t5v0__aoi221_1
X$2146 \$11681 \$11713 \$11826 \$11554 \$4677 \$11675 \$11827 \$11680
+ gf180mcu_fd_sc_mcu9t5v0__aoi221_1
X$2147 \$6774 \$6650 \$6773 \$6651 \$4677 \$6770 \$6616 \$6652
+ gf180mcu_fd_sc_mcu9t5v0__aoi221_1
X$2148 \$7531 \$7530 \$7414 \$7416 \$4677 \$7526 \$7417 \$7528
+ gf180mcu_fd_sc_mcu9t5v0__aoi221_1
X$2149 \$9801 \$9800 \$9737 \$9799 \$4677 \$9748 \$9703 \$9791
+ gf180mcu_fd_sc_mcu9t5v0__aoi221_1
X$2150 \$5356 \$11683 \$11556 \$11682 \$4677 \$11675 \$11555 \$11516
+ gf180mcu_fd_sc_mcu9t5v0__aoi221_1
X$2151 \$8356 \$8565 \$8564 \$8322 \$4677 \$8572 \$8335 \$8854
+ gf180mcu_fd_sc_mcu9t5v0__aoi221_1
X$2152 \$6787 \$6626 \$6671 \$6368 \$4677 \$6770 \$6616 \$6669
+ gf180mcu_fd_sc_mcu9t5v0__aoi221_1
X$2153 \$5383 \$5641 \$5640 \$5639 \$4677 \$5735 \$5473 \$5633
+ gf180mcu_fd_sc_mcu9t5v0__aoi221_1
X$2154 \$4677 \$6629 \$6497 \$6616 \$6512 gf180mcu_fd_sc_mcu9t5v0__nand2_1
X$2155 \$4677 \$11837 \$11675 \$11827 \$11696 gf180mcu_fd_sc_mcu9t5v0__nand2_1
X$2156 \$4677 \$12031 \$11956 \$11993 \$11978 gf180mcu_fd_sc_mcu9t5v0__nand2_1
X$2157 \$4677 \$6951 \$7047 \$7160 \$6953 gf180mcu_fd_sc_mcu9t5v0__nand2_1
X$2158 \$4677 \$6161 \$6136 \$6105 \$6160 gf180mcu_fd_sc_mcu9t5v0__nand2_1
X$2159 \$4677 \$11168 \$11306 \$11182 \$11302 gf180mcu_fd_sc_mcu9t5v0__nand2_1
X$2160 \$4677 \$12279 \$12260 \$11993 \$12033 gf180mcu_fd_sc_mcu9t5v0__nand2_1
X$2161 \$11670 \$11675 \$11827 \$4677 gf180mcu_fd_sc_mcu9t5v0__buf_8
X$2162 \$4959 \$4732 \$4702 \$4849 \$4678 gf180mcu_fd_sc_mcu9t5v0__nand2_1
X$2163 \$4680 \$6136 \$6387 \$6359 gf180mcu_fd_sc_mcu9t5v0__clkinv_1
X$2164 \$5481 \$6391 \$4680 \$6497 \$6387 gf180mcu_fd_sc_mcu9t5v0__dffq_2
X$2165 \$5252 \$5251 \$5207 \$5240 \$4684 gf180mcu_fd_sc_mcu9t5v0__nand2_1
X$2166 \$4757 \$4697 \$4947 \$4948 \$4951 \$4849 \$6644
+ gf180mcu_fd_sc_mcu9t5v0__oai211_1
X$2167 \$4699 \$4698 \$4950 \$4948 \$4951 \$4849 \$4949
+ gf180mcu_fd_sc_mcu9t5v0__oai211_1
X$2168 \$4762 \$4702 \$4849 \$4727 gf180mcu_fd_sc_mcu9t5v0__buf_8
X$2169 \$4733 \$4732 \$4702 \$4849 \$4731 gf180mcu_fd_sc_mcu9t5v0__nand2_1
X$2170 \$4849 \$4702 gf180mcu_fd_sc_mcu9t5v0__filltie
X$2171 \$4849 \$4702 gf180mcu_fd_sc_mcu9t5v0__filltie
X$2172 \$4849 \$4702 gf180mcu_fd_sc_mcu9t5v0__filltie
X$2173 \$4849 \$4702 gf180mcu_fd_sc_mcu9t5v0__filltie
X$2174 \$4849 \$4702 gf180mcu_fd_sc_mcu9t5v0__filltie
X$2175 \$4849 \$4702 gf180mcu_fd_sc_mcu9t5v0__filltie
X$2176 \$4849 \$4702 gf180mcu_fd_sc_mcu9t5v0__endcap
X$2177 \$22133 \$19154 \$21663 \$4705 \$22387 \$22272 \$22389
+ gf180mcu_fd_sc_mcu9t5v0__aoi22_1
X$2178 \$4956 \$5207 \$5106 \$4706 gf180mcu_fd_sc_mcu9t5v0__buf_8
X$2179 \$4707 \$23329 \$23183 \$23454 \$23461 gf180mcu_fd_sc_mcu9t5v0__xnor2_1
X$2180 \$16851 \$4707 \$23183 \$23454 \$23330 gf180mcu_fd_sc_mcu9t5v0__nand2_1
X$2181 \$4712 \$5489 \$4958 \$5358 \$5473 \$5368 gf180mcu_fd_sc_mcu9t5v0__mux2_1
X$2182 \$4720 \$4946 \$4970 \$4948 \$4951 \$5106 \$4969
+ gf180mcu_fd_sc_mcu9t5v0__oai211_1
X$2183 \$5105 \$4721 \$4978 \$4948 \$4951 \$5106 \$4977
+ gf180mcu_fd_sc_mcu9t5v0__oai211_1
X$2184 \$9568 \$4971 \$8711 \$4722 \$9608 \$9457 \$9564
+ gf180mcu_fd_sc_mcu9t5v0__aoi211_1
X$2185 \$9742 \$9748 \$9703 \$4723 gf180mcu_fd_sc_mcu9t5v0__clkinv_1
X$2186 \$4723 \$6001 \$6105 \$6015 gf180mcu_fd_sc_mcu9t5v0__buf_8
X$2187 \$4856 \$4725 \$4956 \$4951 \$4849 \$4955 gf180mcu_fd_sc_mcu9t5v0__mux2_1
X$2188 \$7918 \$7917 \$7916 \$7915 \$4729 \$4726 \$8063 \$7947 \$8065
+ gf180mcu_fd_sc_mcu9t5v0__mux4_1
X$2189 \$6927 \$7167 \$7277 \$7164 \$4729 \$4726 \$7304 \$7160 \$7166
+ gf180mcu_fd_sc_mcu9t5v0__mux4_1
X$2190 \$8682 \$8538 \$8683 \$8539 \$4729 \$4726 \$8834 \$8717 \$8845
+ gf180mcu_fd_sc_mcu9t5v0__mux4_1
X$2191 \$5607 \$5839 \$6107 \$5883 \$4729 \$4726 \$6136 \$6105 \$6144
+ gf180mcu_fd_sc_mcu9t5v0__mux4_1
X$2192 \$15497 \$15628 \$15490 \$4726 gf180mcu_fd_sc_mcu9t5v0__buf_8
X$2193 \$4726 \$13035 \$13083 \$9706 gf180mcu_fd_sc_mcu9t5v0__buf_8
X$2194 \$5477 \$5606 \$4726 \$5735 \$5473 \$5605 gf180mcu_fd_sc_mcu9t5v0__mux2_1
X$2195 \$6351 \$6892 \$4726 \$7047 \$6890 \$6923 gf180mcu_fd_sc_mcu9t5v0__mux2_1
X$2196 \$7307 \$7911 \$4726 \$7797 \$7688 \$7802 gf180mcu_fd_sc_mcu9t5v0__mux2_1
X$2197 \$8306 \$8964 \$4726 \$8834 \$8717 \$8841 gf180mcu_fd_sc_mcu9t5v0__mux2_1
X$2198 \$4727 \$11130 \$9748 \$9900 \$9744 gf180mcu_fd_sc_mcu9t5v0__and2_1
X$2199 \$11129 \$4727 \$12249 \$12260 \$12376 \$12370
+ gf180mcu_fd_sc_mcu9t5v0__oai21_1
X$2200 \$11129 \$4727 \$11167 \$11136 \$11182 \$11169
+ gf180mcu_fd_sc_mcu9t5v0__oai21_1
X$2201 \$6107 \$4727 \$4992 \$5883 \$6001 \$6105 \$6006
+ gf180mcu_fd_sc_mcu9t5v0__aoi22_1
X$2202 \$7277 \$4727 \$4992 \$7164 \$7304 \$7160 \$7276
+ gf180mcu_fd_sc_mcu9t5v0__aoi22_1
X$2203 \$6952 \$4727 \$4954 \$6949 \$7047 \$6890 \$6951
+ gf180mcu_fd_sc_mcu9t5v0__aoi22_1
X$2204 \$4987 \$4727 \$4992 \$4988 \$5207 \$5106 \$4853
+ gf180mcu_fd_sc_mcu9t5v0__aoi22_1
X$2205 \$10523 \$4727 \$4992 \$9758 \$11956 \$11827 \$11960
+ gf180mcu_fd_sc_mcu9t5v0__aoi22_1
X$2206 \$11519 \$4727 \$4992 \$10515 \$11675 \$11555 \$11686
+ gf180mcu_fd_sc_mcu9t5v0__aoi22_1
X$2207 \$10268 \$4727 \$4954 \$9924 \$5356 \$9748 \$9900 \$9800
+ gf180mcu_fd_sc_mcu9t5v0__aoi221_1
X$2208 \$8978 \$4727 \$4954 \$8863 \$5356 \$8834 \$8963 \$8864
+ gf180mcu_fd_sc_mcu9t5v0__aoi221_1
X$2209 \$6401 \$4727 \$4954 \$6680 \$5356 \$6770 \$6616 \$6681
+ gf180mcu_fd_sc_mcu9t5v0__aoi221_1
X$2210 \$9220 \$4727 \$4992 \$9217 \$5356 \$9337 \$9221 \$9338
+ gf180mcu_fd_sc_mcu9t5v0__aoi221_1
X$2211 \$8838 \$4727 \$4992 \$8535 \$5356 \$8834 \$8717 \$8677
+ gf180mcu_fd_sc_mcu9t5v0__aoi221_1
X$2212 \$5382 \$4727 \$4954 \$5504 \$5356 \$5735 \$5473 \$5639
+ gf180mcu_fd_sc_mcu9t5v0__aoi221_1
X$2213 \$4727 \$11130 \$10022 \$9900 \$10018 gf180mcu_fd_sc_mcu9t5v0__nand2_1
X$2214 \$6922 \$4727 \$6770 \$6890 \$6774 gf180mcu_fd_sc_mcu9t5v0__nand2_1
X$2215 \$7968 \$4727 \$8063 \$8183 \$7944 gf180mcu_fd_sc_mcu9t5v0__nand2_1
X$2216 \$10680 \$4727 \$11956 \$11827 \$11982 gf180mcu_fd_sc_mcu9t5v0__nand2_1
X$2217 \$8702 \$4727 \$8834 \$8717 \$8737 gf180mcu_fd_sc_mcu9t5v0__nand2_1
X$2218 \$5234 \$4727 \$5358 \$5240 \$5383 gf180mcu_fd_sc_mcu9t5v0__nand2_1
X$2219 \$8836 \$4727 \$8834 \$8717 \$8716 gf180mcu_fd_sc_mcu9t5v0__nand2_1
X$2220 \$5481 \$5482 \$4728 \$5735 \$5473 gf180mcu_fd_sc_mcu9t5v0__dffq_2
X$2221 \$4728 \$5483 \$5611 \$5358 \$5473 \$5482 gf180mcu_fd_sc_mcu9t5v0__mux2_1
X$2222 \$9224 \$9107 \$9108 \$9344 \$4729 \$9706 \$9337 \$9457 \$9756
+ gf180mcu_fd_sc_mcu9t5v0__mux4_1
X$2223 \$4730 \$4961 \$4958 \$4951 \$4849 \$4960 gf180mcu_fd_sc_mcu9t5v0__mux2_1
X$2224 \$6375 \$4732 \$8301 \$8335 \$8325 gf180mcu_fd_sc_mcu9t5v0__nand2_1
X$2225 \$4999 \$4732 \$4951 \$5106 \$5000 gf180mcu_fd_sc_mcu9t5v0__nand2_1
X$2226 \$7919 \$4732 \$7797 \$7947 \$7806 gf180mcu_fd_sc_mcu9t5v0__nand2_1
X$2227 \$9795 \$4732 \$11675 \$11827 \$11850 gf180mcu_fd_sc_mcu9t5v0__nand2_1
X$2228 \$5249 \$4732 \$5207 \$5240 \$5251 gf180mcu_fd_sc_mcu9t5v0__nand2_1
X$2229 \$5018 \$4732 \$10630 \$10782 \$10685 gf180mcu_fd_sc_mcu9t5v0__nand2_1
X$2230 \$5499 \$4732 \$5207 \$5240 \$5228 gf180mcu_fd_sc_mcu9t5v0__nand2_1
X$2231 \$11838 \$4732 \$11306 \$11555 \$11543 gf180mcu_fd_sc_mcu9t5v0__nand2_1
X$2232 \$9239 \$4732 \$11675 \$11827 \$11852 gf180mcu_fd_sc_mcu9t5v0__nand2_1
X$2233 \$12548 \$4732 \$12486 \$12526 \$12560 gf180mcu_fd_sc_mcu9t5v0__nand2_1
X$2234 \$7055 \$4732 \$6770 \$6890 \$6776 gf180mcu_fd_sc_mcu9t5v0__nand2_1
X$2235 \$8695 \$4732 \$9337 \$9457 \$9365 gf180mcu_fd_sc_mcu9t5v0__nand2_1
X$2236 \$8703 \$4732 \$8572 \$8717 \$8360 gf180mcu_fd_sc_mcu9t5v0__nand2_1
X$2237 \$6676 \$4732 \$6770 \$6890 \$6946 gf180mcu_fd_sc_mcu9t5v0__nand2_1
X$2238 \$10044 \$4732 \$10630 \$10782 \$10671 gf180mcu_fd_sc_mcu9t5v0__nand2_1
X$2239 \$8968 \$4732 \$10630 \$10782 \$10534 gf180mcu_fd_sc_mcu9t5v0__nand2_1
X$2240 \$10227 \$4732 \$9337 \$9457 \$9124 gf180mcu_fd_sc_mcu9t5v0__nand2_1
X$2241 \$11520 \$4732 \$12260 \$12376 \$12139 gf180mcu_fd_sc_mcu9t5v0__nand2_1
X$2242 \$6672 \$4732 \$6770 \$6616 \$6518 gf180mcu_fd_sc_mcu9t5v0__nand2_1
X$2243 \$10265 \$4732 \$10022 \$9900 \$9913 gf180mcu_fd_sc_mcu9t5v0__nand2_1
X$2244 \$12498 \$4732 \$12486 \$12376 \$12510 gf180mcu_fd_sc_mcu9t5v0__nand2_1
X$2245 \$12384 \$4732 \$12260 \$11993 \$12159 gf180mcu_fd_sc_mcu9t5v0__nand2_1
X$2246 \$10677 \$4732 \$10630 \$10514 \$10541 gf180mcu_fd_sc_mcu9t5v0__nand2_1
X$2247 \$11202 \$4732 \$11136 \$11025 \$11039 gf180mcu_fd_sc_mcu9t5v0__nand2_1
X$2248 \$7908 \$4732 \$11306 \$11182 \$11333 gf180mcu_fd_sc_mcu9t5v0__nand2_1
X$2249 \$10792 \$4732 \$12260 \$11993 \$12138 gf180mcu_fd_sc_mcu9t5v0__nand2_1
X$2250 \$9775 \$4732 \$11306 \$11182 \$11317 gf180mcu_fd_sc_mcu9t5v0__nand2_1
X$2251 \$5888 \$4732 \$6001 \$5833 \$5887 gf180mcu_fd_sc_mcu9t5v0__nand2_1
X$2252 \$11320 \$4732 \$11306 \$11182 \$11319 gf180mcu_fd_sc_mcu9t5v0__nand2_1
X$2253 \$8685 \$4732 \$8572 \$8335 \$8341 gf180mcu_fd_sc_mcu9t5v0__nand2_1
X$2254 \$9736 \$4732 \$9748 \$9703 \$9803 gf180mcu_fd_sc_mcu9t5v0__nand2_1
X$2255 \$10245 \$4732 \$11136 \$11025 \$11029 gf180mcu_fd_sc_mcu9t5v0__nand2_1
X$2256 \$9225 \$4732 \$9337 \$9221 \$9226 gf180mcu_fd_sc_mcu9t5v0__nand2_1
X$2257 \$8075 \$4732 \$8301 \$8183 \$7962 gf180mcu_fd_sc_mcu9t5v0__nand2_1
X$2258 \$5218 \$4732 \$5207 \$5106 \$4739 gf180mcu_fd_sc_mcu9t5v0__nand2_1
X$2259 \$11963 \$11956 \$11827 \$4732 gf180mcu_fd_sc_mcu9t5v0__buf_8
X$2260 \$14241 \$15177 \$4733 \$13471 \$15045 \$15204
+ gf180mcu_fd_sc_mcu9t5v0__dffrnq_2
X$2261 \$4733 \$6663 \$6929 \$6895 \$6770 \$6890 \$6354
+ gf180mcu_fd_sc_mcu9t5v0__oai22_1
X$2262 \$4733 \$5613 \$5358 \$5473 \$5484 gf180mcu_fd_sc_mcu9t5v0__nand2_1
X$2263 \$4733 \$14211 \$15045 \$15204 \$15164 gf180mcu_fd_sc_mcu9t5v0__nand2_1
X$2264 \$4733 \$12912 \$15321 \$15204 \$15026 gf180mcu_fd_sc_mcu9t5v0__nand2_1
X$2265 \$5481 \$5738 \$4734 \$5735 \$5473 gf180mcu_fd_sc_mcu9t5v0__dffq_2
X$2266 \$4734 \$5614 \$5611 \$5735 \$5833 \$5738 gf180mcu_fd_sc_mcu9t5v0__mux2_1
X$2267 \$5481 \$5616 \$4736 \$5735 \$5833 gf180mcu_fd_sc_mcu9t5v0__dffq_2
X$2268 \$4736 \$5617 \$5611 \$5735 \$5473 \$5616 gf180mcu_fd_sc_mcu9t5v0__mux2_1
X$2269 \$5481 \$5247 \$4737 \$5207 \$5240 gf180mcu_fd_sc_mcu9t5v0__dffq_2
X$2270 \$4737 \$5219 \$4958 \$5358 \$5240 \$5247 gf180mcu_fd_sc_mcu9t5v0__mux2_1
X$2271 \$4738 \$5736 \$5840 \$6001 \$5833 \$5619 gf180mcu_fd_sc_mcu9t5v0__and3_1
X$2272 \$4738 \$6662 \$7811 \$6663 \$6770 \$6890 \$6780
+ gf180mcu_fd_sc_mcu9t5v0__oai31_1
X$2273 \$4741 \$23620 \$23454 \$23460 \$23630 gf180mcu_fd_sc_mcu9t5v0__xor2_1
X$2274 \$16851 \$4741 \$23183 \$23454 \$23194 gf180mcu_fd_sc_mcu9t5v0__nand2_1
X$2275 \$5891 \$5739 \$4742 \$6001 \$5833 gf180mcu_fd_sc_mcu9t5v0__dffq_2
X$2276 \$4742 \$5846 \$5611 \$5735 \$5833 \$5739 gf180mcu_fd_sc_mcu9t5v0__mux2_1
X$2277 \$16851 \$4747 \$22586 \$22387 \$22440 \$22456
+ gf180mcu_fd_sc_mcu9t5v0__aoi21_1
X$2278 \$4747 \$22713 \$22837 \$22846 gf180mcu_fd_sc_mcu9t5v0__clkinv_1
X$2279 \$4748 \$5008 \$4958 \$5207 \$5106 \$4858 gf180mcu_fd_sc_mcu9t5v0__mux2_1
X$2280 \$4749 \$7526 \$7688 \$7586 gf180mcu_fd_sc_mcu9t5v0__clkinv_1
X$2281 \$7698 \$7696 \$4749 \$7797 \$7688 gf180mcu_fd_sc_mcu9t5v0__dffq_2
X$2282 \$8351 \$8350 \$8345 \$4750 \$8301 \$8335 \$8349
+ gf180mcu_fd_sc_mcu9t5v0__aoi211_1
X$2283 \$6366 \$8562 \$4750 \$8572 \$8335 gf180mcu_fd_sc_mcu9t5v0__dffq_2
X$2284 \$19166 \$19042 \$19165 \$4753 \$19027 \$19149 \$18833
+ gf180mcu_fd_sc_mcu9t5v0__aoi22_1
X$2285 \$8351 \$8350 \$8345 \$4754 \$8301 \$8335 \$8353
+ gf180mcu_fd_sc_mcu9t5v0__aoi211_1
X$2286 \$6366 \$8352 \$4754 \$8572 \$8335 gf180mcu_fd_sc_mcu9t5v0__dffq_2
X$2287 \$4756 \$5222 \$4958 \$5207 \$5106 \$5009 gf180mcu_fd_sc_mcu9t5v0__mux2_1
X$2288 \$4758 \$7526 \$7688 \$7590 gf180mcu_fd_sc_mcu9t5v0__clkinv_1
X$2289 \$7698 \$7588 \$4758 \$7797 \$7688 gf180mcu_fd_sc_mcu9t5v0__dffq_2
X$2290 \$4759 \$5858 \$5860 \$5735 \$5833 \$5859 gf180mcu_fd_sc_mcu9t5v0__mux2_2
X$2291 \$4953 \$4951 \$4849 \$4954 gf180mcu_fd_sc_mcu9t5v0__buf_8
X$2292 \$4954 \$4951 \$4849 \$4992 gf180mcu_fd_sc_mcu9t5v0__buf_8
X$2293 \$4849 \$4951 gf180mcu_fd_sc_mcu9t5v0__filltie
X$2294 \$4849 \$4951 gf180mcu_fd_sc_mcu9t5v0__filltie
X$2295 \$4849 \$4951 gf180mcu_fd_sc_mcu9t5v0__filltie
X$2296 \$4849 \$4951 gf180mcu_fd_sc_mcu9t5v0__filltie
X$2297 \$4849 \$4951 gf180mcu_fd_sc_mcu9t5v0__filltie
X$2298 \$4849 \$4951 gf180mcu_fd_sc_mcu9t5v0__filltie
X$2299 \$4989 \$4857 \$4958 \$4951 \$4849 \$4957 gf180mcu_fd_sc_mcu9t5v0__mux2_1
X$2300 \$4849 \$4951 gf180mcu_fd_sc_mcu9t5v0__endcap
X$2301 \$21016 \$19154 \$5004 \$4852 \$19042 \$20881 \$21011 \$21017
+ gf180mcu_fd_sc_mcu9t5v0__aoi221_1
X$2302 \$5226 \$4859 \$4965 \$5207 \$5106 \$5225 gf180mcu_fd_sc_mcu9t5v0__mux2_1
X$2303 \$4974 \$4971 \$4951 \$5106 \$4947 gf180mcu_fd_sc_mcu9t5v0__nand2_1
X$2304 \$12658 \$4948 \$6915 \$12786 \$12930 \$12894
+ gf180mcu_fd_sc_mcu9t5v0__oai21_1
X$2305 \$7683 \$4948 \$6915 \$8063 \$8183 \$8332
+ gf180mcu_fd_sc_mcu9t5v0__oai21_1
X$2306 \$10777 \$4948 \$6915 \$10630 \$10782 \$10659
+ gf180mcu_fd_sc_mcu9t5v0__oai21_1
X$2307 \$11511 \$4948 \$6915 \$11306 \$11555 \$11512
+ gf180mcu_fd_sc_mcu9t5v0__oai21_1
X$2308 \$10229 \$4948 \$6915 \$10391 \$10514 \$10512
+ gf180mcu_fd_sc_mcu9t5v0__oai21_1
X$2309 \$8182 \$4948 \$6915 \$8572 \$8335 \$8571
+ gf180mcu_fd_sc_mcu9t5v0__oai21_1
X$2310 \$6384 \$4948 \$6000 \$6915 \$6497 \$6616 \$6645
+ gf180mcu_fd_sc_mcu9t5v0__oai211_1
X$2311 \$6382 \$4948 \$5734 \$6915 \$6497 \$6616 \$6492
+ gf180mcu_fd_sc_mcu9t5v0__oai211_1
X$2312 \$7905 \$4948 \$5874 \$6915 \$8063 \$8183 \$9099
+ gf180mcu_fd_sc_mcu9t5v0__oai211_1
X$2313 \$6885 \$4948 \$5830 \$6915 \$7047 \$7160 \$7046
+ gf180mcu_fd_sc_mcu9t5v0__oai211_1
X$2314 \$7945 \$4948 \$7522 \$6915 \$8063 \$8183 \$8060
+ gf180mcu_fd_sc_mcu9t5v0__oai211_1
X$2315 \$10655 \$4948 \$10388 \$6915 \$10630 \$10782 \$10773
+ gf180mcu_fd_sc_mcu9t5v0__oai211_1
X$2316 \$7270 \$4948 \$4949 \$6915 \$7304 \$7417 \$7300
+ gf180mcu_fd_sc_mcu9t5v0__oai211_1
X$2317 \$6887 \$4948 \$6644 \$6915 \$7047 \$7160 \$7154
+ gf180mcu_fd_sc_mcu9t5v0__oai211_1
X$2318 \$11173 \$4948 \$11174 \$6915 \$11306 \$11555 \$11506
+ gf180mcu_fd_sc_mcu9t5v0__oai211_1
X$2319 \$8181 \$4948 \$8062 \$6915 \$8301 \$8335 \$8330
+ gf180mcu_fd_sc_mcu9t5v0__oai211_1
X$2320 \$7906 \$4948 \$7411 \$6915 \$8063 \$7947 \$8061
+ gf180mcu_fd_sc_mcu9t5v0__oai211_1
X$2321 \$11507 \$4948 \$11305 \$6915 \$11675 \$11555 \$11671
+ gf180mcu_fd_sc_mcu9t5v0__oai211_1
X$2322 \$9331 \$4948 \$8829 \$6915 \$9337 \$9221 \$9332
+ gf180mcu_fd_sc_mcu9t5v0__oai211_1
X$2323 \$7269 \$4948 \$6642 \$6915 \$7526 \$7417 \$7524
+ gf180mcu_fd_sc_mcu9t5v0__oai211_1
X$2324 \$9452 \$4948 \$9560 \$6915 \$9608 \$9457 \$10385
+ gf180mcu_fd_sc_mcu9t5v0__oai211_1
X$2325 \$6913 \$4948 \$6490 \$6915 \$7047 \$6890 \$6914
+ gf180mcu_fd_sc_mcu9t5v0__oai211_1
X$2326 \$12134 \$4948 \$11677 \$6915 \$12260 \$11993 \$12255
+ gf180mcu_fd_sc_mcu9t5v0__oai211_1
X$2327 \$6641 \$4948 \$4969 \$6915 \$7047 \$6890 \$6917
+ gf180mcu_fd_sc_mcu9t5v0__oai211_1
X$2328 \$11955 \$4948 \$7525 \$6915 \$12260 \$11993 \$12373
+ gf180mcu_fd_sc_mcu9t5v0__oai211_1
X$2329 \$6888 \$4948 \$4977 \$6915 \$6770 \$6616 \$6919
+ gf180mcu_fd_sc_mcu9t5v0__oai211_1
X$2330 \$12524 \$4948 \$9567 \$6915 \$12786 \$12526 \$12784
+ gf180mcu_fd_sc_mcu9t5v0__oai211_1
X$2331 \$11550 \$4948 \$10020 \$6915 \$11956 \$11827 \$11953
+ gf180mcu_fd_sc_mcu9t5v0__oai211_1
X$2332 \$6646 \$4948 \$5206 \$6915 \$7047 \$6890 \$6918
+ gf180mcu_fd_sc_mcu9t5v0__oai211_1
X$2333 \$9746 \$4948 \$9562 \$6915 \$10022 \$9900 \$10019
+ gf180mcu_fd_sc_mcu9t5v0__oai211_1
X$2334 \$11171 \$4948 \$8952 \$6915 \$11306 \$11182 \$11303
+ gf180mcu_fd_sc_mcu9t5v0__oai211_1
X$2335 \$6496 \$4948 \$6385 \$6915 \$6497 \$6387 \$6495
+ gf180mcu_fd_sc_mcu9t5v0__oai211_1
X$2336 \$4948 \$6612 \$6611 \$6497 \$6616 \$6490
+ gf180mcu_fd_sc_mcu9t5v0__nand3_1
X$2337 \$4948 \$5472 \$5238 \$5358 \$5473 \$6385
+ gf180mcu_fd_sc_mcu9t5v0__nand3_1
X$2338 \$4948 \$7794 \$7907 \$7797 \$7947 \$8062
+ gf180mcu_fd_sc_mcu9t5v0__nand3_1
X$2339 \$4948 \$6342 \$7301 \$7304 \$7417 \$7411
+ gf180mcu_fd_sc_mcu9t5v0__nand3_1
X$2340 \$4948 \$7413 \$7565 \$7526 \$7417 \$7525
+ gf180mcu_fd_sc_mcu9t5v0__nand3_1
X$2341 \$4948 \$5872 \$5873 \$6001 \$5833 \$5874
+ gf180mcu_fd_sc_mcu9t5v0__nand3_1
X$2342 \$4948 \$11304 \$11022 \$11306 \$11182 \$11305
+ gf180mcu_fd_sc_mcu9t5v0__nand3_1
X$2343 \$4948 \$8954 \$9214 \$9337 \$9221 \$9562
+ gf180mcu_fd_sc_mcu9t5v0__nand3_1
X$2344 \$4948 \$5354 \$5353 \$5358 \$5240 \$5830
+ gf180mcu_fd_sc_mcu9t5v0__nand3_1
X$2345 \$4948 \$9335 \$9566 \$9608 \$9457 \$9567
+ gf180mcu_fd_sc_mcu9t5v0__nand3_1
X$2346 \$4948 \$11551 \$11024 \$11675 \$11555 \$11677
+ gf180mcu_fd_sc_mcu9t5v0__nand3_1
X$2347 \$8710 \$8673 \$8672 \$4948 \$8834 \$8963 \$8952
+ gf180mcu_fd_sc_mcu9t5v0__oai211_1
X$2348 \$11548 \$11132 \$11021 \$4948 \$11136 \$11182 \$11174
+ gf180mcu_fd_sc_mcu9t5v0__oai211_1
X$2349 \$9895 \$9894 \$9747 \$4948 \$9748 \$9900 \$10020
+ gf180mcu_fd_sc_mcu9t5v0__oai211_1
X$2350 \$5733 \$5732 \$5879 \$4948 \$5735 \$5833 \$5734
+ gf180mcu_fd_sc_mcu9t5v0__oai211_1
X$2351 \$10387 \$10386 \$10280 \$4948 \$10391 \$10282 \$10388
+ gf180mcu_fd_sc_mcu9t5v0__oai211_1
X$2352 \$6886 \$6134 \$6614 \$4948 \$6770 \$6616 \$6642
+ gf180mcu_fd_sc_mcu9t5v0__oai211_1
X$2353 \$9561 \$9329 \$9453 \$4948 \$9608 \$9457 \$9560
+ gf180mcu_fd_sc_mcu9t5v0__oai211_1
X$2354 \$7523 \$7521 \$7408 \$4948 \$7526 \$7417 \$7522
+ gf180mcu_fd_sc_mcu9t5v0__oai211_1
X$2355 \$8828 \$8827 \$8530 \$4948 \$8834 \$8717 \$8829
+ gf180mcu_fd_sc_mcu9t5v0__oai211_1
X$2356 \$5208 \$4952 \$5209 \$4948 \$5207 \$5106 \$5206
+ gf180mcu_fd_sc_mcu9t5v0__oai211_1
X$2357 \$5355 \$5358 \$5473 \$4948 gf180mcu_fd_sc_mcu9t5v0__buf_8
X$2358 \$4976 \$4971 \$4951 \$5106 \$4950 gf180mcu_fd_sc_mcu9t5v0__nand2_1
X$2359 \$5013 \$4951 \$5106 \$5014 gf180mcu_fd_sc_mcu9t5v0__clkinv_1
X$2360 \$5113 \$4991 \$4951 \$5106 \$5012 gf180mcu_fd_sc_mcu9t5v0__nand2_1
X$2361 \$5106 \$4951 gf180mcu_fd_sc_mcu9t5v0__filltie
X$2362 \$5106 \$4951 gf180mcu_fd_sc_mcu9t5v0__filltie
X$2363 \$5106 \$4951 gf180mcu_fd_sc_mcu9t5v0__filltie
X$2364 \$5106 \$4951 gf180mcu_fd_sc_mcu9t5v0__filltie
X$2365 \$5106 \$4951 gf180mcu_fd_sc_mcu9t5v0__filltie
X$2366 \$5106 \$4951 gf180mcu_fd_sc_mcu9t5v0__filltie
X$2367 \$5106 \$4951 gf180mcu_fd_sc_mcu9t5v0__endcap
X$2368 \$9475 \$4954 \$9608 \$9703 \$9737 gf180mcu_fd_sc_mcu9t5v0__nand2_1
X$2369 \$6640 \$4954 \$7047 \$6890 \$6958 gf180mcu_fd_sc_mcu9t5v0__nand2_1
X$2370 \$4955 \$6143 \$9072 \$16851 \$23027 \$23139 \$23144
+ gf180mcu_fd_sc_mcu9t5v0__oai31_2
X$2371 \$23457 \$19154 \$5004 \$4955 \$19042 \$23183 \$23454 \$23458
+ gf180mcu_fd_sc_mcu9t5v0__aoi221_1
X$2372 \$16851 \$4955 \$23027 \$23139 \$23143 gf180mcu_fd_sc_mcu9t5v0__nand2_1
X$2373 \$4956 \$8065 \$8063 \$8183 \$8309 gf180mcu_fd_sc_mcu9t5v0__or2_1
X$2374 \$4956 \$12933 \$14151 \$14034 \$16850 gf180mcu_fd_sc_mcu9t5v0__or2_1
X$2375 \$4956 \$12790 \$13209 \$13341 \$13452 \$14037
+ gf180mcu_fd_sc_mcu9t5v0__oai21_1
X$2376 \$13086 \$13208 \$4956 \$13341 \$13083 \$13209
+ gf180mcu_fd_sc_mcu9t5v0__oai21_1
X$2377 \$4956 \$12662 \$13881 \$14034 \$14039 gf180mcu_fd_sc_mcu9t5v0__nor2_1
X$2378 \$13836 \$13881 \$13729 \$4956 gf180mcu_fd_sc_mcu9t5v0__buf_8
X$2379 \$8845 \$8841 \$4956 \$8834 \$8963 \$8965 gf180mcu_fd_sc_mcu9t5v0__mux2_1
X$2380 \$7166 \$6923 \$4956 \$7047 \$7160 \$7165 gf180mcu_fd_sc_mcu9t5v0__mux2_1
X$2381 \$6144 \$5605 \$4956 \$6136 \$6105 \$6143 gf180mcu_fd_sc_mcu9t5v0__mux2_1
X$2382 \$9756 \$9571 \$4956 \$9748 \$9703 \$9755 gf180mcu_fd_sc_mcu9t5v0__mux2_1
X$2383 \$7960 \$4958 \$8579 \$8549 \$8550 \$8572 \$8335 \$8551
+ gf180mcu_fd_sc_mcu9t5v0__oai221_1
X$2384 \$5629 \$4958 \$5498 \$5500 \$5735 \$5473 \$5630
+ gf180mcu_fd_sc_mcu9t5v0__oai211_1
X$2385 \$5014 \$4958 \$5223 \$5012 \$5207 \$5106 \$5224
+ gf180mcu_fd_sc_mcu9t5v0__oai211_1
X$2386 \$12271 \$11956 \$11827 \$4958 gf180mcu_fd_sc_mcu9t5v0__buf_8
X$2387 \$6628 \$6510 \$4958 \$6770 \$6890 \$6627 gf180mcu_fd_sc_mcu9t5v0__mux2_1
X$2388 \$5107 \$4996 \$4958 \$5207 \$5240 \$5215 gf180mcu_fd_sc_mcu9t5v0__mux2_1
X$2389 \$7167 \$7054 \$4958 \$7047 \$7160 \$7168 gf180mcu_fd_sc_mcu9t5v0__mux2_1
X$2390 \$5839 \$5885 \$4958 \$6001 \$5833 \$6007 gf180mcu_fd_sc_mcu9t5v0__mux2_1
X$2391 \$6789 \$6675 \$4958 \$7047 \$6890 \$6899 gf180mcu_fd_sc_mcu9t5v0__mux2_1
X$2392 \$5109 \$5250 \$4958 \$5358 \$5240 \$5110 gf180mcu_fd_sc_mcu9t5v0__mux2_1
X$2393 \$14650 \$16928 \$4959 \$13471 \$17085 \$17034
+ gf180mcu_fd_sc_mcu9t5v0__dffrnq_2
X$2394 \$4959 \$6663 \$6779 \$6778 \$6770 \$6890 \$6504
+ gf180mcu_fd_sc_mcu9t5v0__oai22_1
X$2395 \$4959 \$14211 \$14345 \$11202 \$17373 \$17085 \$17367 \$17376
+ gf180mcu_fd_sc_mcu9t5v0__aoi221_1
X$2396 \$4959 \$12912 \$17085 \$17367 \$17061 gf180mcu_fd_sc_mcu9t5v0__nand2_1
X$2397 \$4959 \$5613 \$5735 \$5833 \$5843 gf180mcu_fd_sc_mcu9t5v0__nand2_1
X$2398 \$14650 \$14651 \$4962 \$13471 \$14748 \$14635
+ gf180mcu_fd_sc_mcu9t5v0__dffrnq_2
X$2399 \$4962 \$6663 \$6665 \$6664 \$6770 \$6616 \$6622
+ gf180mcu_fd_sc_mcu9t5v0__oai22_1
X$2400 \$4962 \$14211 \$14229 \$5259 \$14454 \$14635 \$14508
+ gf180mcu_fd_sc_mcu9t5v0__aoi22_1
X$2401 \$4962 \$5613 \$5735 \$5833 \$5737 gf180mcu_fd_sc_mcu9t5v0__nand2_1
X$2402 \$4962 \$12912 \$14748 \$14635 \$14770 gf180mcu_fd_sc_mcu9t5v0__nand2_1
X$2403 \$5481 \$5488 \$4963 \$5358 \$5473 gf180mcu_fd_sc_mcu9t5v0__dffq_2
X$2404 \$4963 \$5622 \$5611 \$5735 \$5473 \$5488 gf180mcu_fd_sc_mcu9t5v0__mux2_1
X$2405 \$4964 \$23336 \$23183 \$23454 \$23468 gf180mcu_fd_sc_mcu9t5v0__xnor2_1
X$2406 \$16851 \$4964 \$23183 \$23454 \$23337 gf180mcu_fd_sc_mcu9t5v0__nand2_1
X$2407 \$4965 \$12677 \$12786 \$12930 \$13044 gf180mcu_fd_sc_mcu9t5v0__or2_1
X$2408 \$13836 \$13623 \$13452 \$4965 gf180mcu_fd_sc_mcu9t5v0__buf_8
X$2409 \$6941 \$6117 \$4965 \$6770 \$6890 \$6898 gf180mcu_fd_sc_mcu9t5v0__mux2_1
X$2410 \$12909 \$12277 \$4965 \$12786 \$12930 \$12942
+ gf180mcu_fd_sc_mcu9t5v0__mux2_1
X$2411 \$11209 \$5911 \$4965 \$11136 \$11182 \$11206
+ gf180mcu_fd_sc_mcu9t5v0__mux2_1
X$2412 \$10536 \$9363 \$4965 \$10630 \$10782 \$10806
+ gf180mcu_fd_sc_mcu9t5v0__mux2_1
X$2413 \$10254 \$10251 \$4965 \$10022 \$10282 \$10253
+ gf180mcu_fd_sc_mcu9t5v0__mux2_1
X$2414 \$12386 \$9126 \$4965 \$12486 \$12526 \$12558
+ gf180mcu_fd_sc_mcu9t5v0__mux2_1
X$2415 \$10538 \$10418 \$4965 \$10391 \$10514 \$10537
+ gf180mcu_fd_sc_mcu9t5v0__mux2_1
X$2416 \$5863 \$4967 \$4965 \$6001 \$5833 \$5909 gf180mcu_fd_sc_mcu9t5v0__mux2_1
X$2417 \$11845 \$8324 \$4965 \$11956 \$11827 \$24070
+ gf180mcu_fd_sc_mcu9t5v0__mux2_1
X$2418 \$13236 \$13235 \$4965 \$13341 \$13083 \$13234
+ gf180mcu_fd_sc_mcu9t5v0__mux2_1
X$2419 \$7555 \$7319 \$4965 \$7526 \$7417 \$10269
+ gf180mcu_fd_sc_mcu9t5v0__mux2_1
X$2420 \$7294 \$6522 \$4965 \$7304 \$7160 \$7293 gf180mcu_fd_sc_mcu9t5v0__mux2_1
X$2421 \$8196 \$7175 \$4965 \$8301 \$8183 \$8312 gf180mcu_fd_sc_mcu9t5v0__mux2_1
X$2422 \$4966 \$23469 \$23032 \$23620 \$23454 \$23598
+ gf180mcu_fd_sc_mcu9t5v0__aoi21_1
X$2423 \$4966 \$23469 \$23598 \$23620 \$23454 \$23599
+ gf180mcu_fd_sc_mcu9t5v0__oai21_1
X$2424 \$16851 \$4966 \$23183 \$23454 \$23338 gf180mcu_fd_sc_mcu9t5v0__nand2_1
X$2425 \$5201 \$4971 \$5207 \$5106 \$4970 gf180mcu_fd_sc_mcu9t5v0__nand2_1
X$2426 \$9898 \$4971 \$8711 \$10022 \$10282 \$10226
+ gf180mcu_fd_sc_mcu9t5v0__aoi21_1
X$2427 \$8533 \$4971 \$8711 \$8572 \$8717 \$8333
+ gf180mcu_fd_sc_mcu9t5v0__aoi21_1
X$2428 \$10660 \$4971 \$8711 \$10630 \$10514 \$10629
+ gf180mcu_fd_sc_mcu9t5v0__aoi21_1
X$2429 \$10511 \$4971 \$8711 \$10630 \$10514 \$10628
+ gf180mcu_fd_sc_mcu9t5v0__aoi21_1
X$2430 \$8531 \$4971 \$8711 \$8834 \$8717 \$8832
+ gf180mcu_fd_sc_mcu9t5v0__aoi21_1
X$2431 \$6613 \$4971 \$6497 \$6616 \$6614 gf180mcu_fd_sc_mcu9t5v0__nand2_1
X$2432 \$8671 \$4971 \$8572 \$8717 \$8672 gf180mcu_fd_sc_mcu9t5v0__nand2_1
X$2433 \$7299 \$4971 \$7304 \$7417 \$7408 gf180mcu_fd_sc_mcu9t5v0__nand2_1
X$2434 \$7682 \$4971 \$7797 \$7947 \$7907 gf180mcu_fd_sc_mcu9t5v0__nand2_1
X$2435 \$7303 \$4971 \$7526 \$7688 \$7565 gf180mcu_fd_sc_mcu9t5v0__nand2_1
X$2436 \$9565 \$4971 \$9608 \$9703 \$9566 gf180mcu_fd_sc_mcu9t5v0__nand2_1
X$2437 \$9334 \$4971 \$9102 \$9221 \$9214 gf180mcu_fd_sc_mcu9t5v0__nand2_1
X$2438 \$4980 \$4971 \$5207 \$5240 \$5209 gf180mcu_fd_sc_mcu9t5v0__nand2_1
X$2439 \$9213 \$4971 \$9337 \$9457 \$9453 gf180mcu_fd_sc_mcu9t5v0__nand2_1
X$2440 \$6489 \$4971 \$6497 \$6616 \$6611 gf180mcu_fd_sc_mcu9t5v0__nand2_1
X$2441 \$10658 \$4971 \$10901 \$11025 \$11022 gf180mcu_fd_sc_mcu9t5v0__nand2_1
X$2442 \$10661 \$4971 \$10901 \$11025 \$11024 gf180mcu_fd_sc_mcu9t5v0__nand2_1
X$2443 \$10656 \$4971 \$10901 \$11025 \$11021 gf180mcu_fd_sc_mcu9t5v0__nand2_1
X$2444 \$5831 \$4971 \$6001 \$5833 \$5880 gf180mcu_fd_sc_mcu9t5v0__nand2_1
X$2445 \$5878 \$4971 \$6001 \$5833 \$5879 gf180mcu_fd_sc_mcu9t5v0__nand2_1
X$2446 \$5205 \$4971 \$5207 \$5106 \$4978 gf180mcu_fd_sc_mcu9t5v0__nand2_1
X$2447 \$5599 \$4971 \$6001 \$5833 \$5472 gf180mcu_fd_sc_mcu9t5v0__nand2_1
X$2448 \$5204 \$4971 \$5358 \$5240 \$5353 gf180mcu_fd_sc_mcu9t5v0__nand2_1
X$2449 \$10021 \$4971 \$9748 \$9703 \$9747 gf180mcu_fd_sc_mcu9t5v0__nand2_1
X$2450 \$8297 \$4971 \$8572 \$8335 \$8530 gf180mcu_fd_sc_mcu9t5v0__nand2_1
X$2451 \$9743 \$4971 \$10022 \$9900 \$10280 gf180mcu_fd_sc_mcu9t5v0__nand2_1
X$2452 \$7410 \$4971 \$7526 \$7417 \$7301 gf180mcu_fd_sc_mcu9t5v0__nand2_1
X$2453 \$5829 \$4971 \$6001 \$5833 \$5872 gf180mcu_fd_sc_mcu9t5v0__nand2_1
X$2454 \$11020 \$10901 \$11025 \$4971 gf180mcu_fd_sc_mcu9t5v0__buf_8
X$2455 \$11146 \$11136 \$11025 \$4972 gf180mcu_fd_sc_mcu9t5v0__buf_8
X$2456 \$9736 \$10021 \$4972 \$9748 \$9900 \$9893
+ gf180mcu_fd_sc_mcu9t5v0__mux2_1
X$2457 \$7908 \$8533 \$4972 \$8301 \$8335 \$8532 gf180mcu_fd_sc_mcu9t5v0__mux2_1
X$2458 \$7273 \$7303 \$4972 \$7304 \$7417 \$7412 gf180mcu_fd_sc_mcu9t5v0__mux2_1
X$2459 \$10241 \$10656 \$4972 \$10630 \$10782 \$10775
+ gf180mcu_fd_sc_mcu9t5v0__mux2_1
X$2460 \$10227 \$9898 \$4972 \$9748 \$9900 \$9897
+ gf180mcu_fd_sc_mcu9t5v0__mux2_1
X$2461 \$9795 \$10658 \$4972 \$10630 \$10782 \$10776
+ gf180mcu_fd_sc_mcu9t5v0__mux2_1
X$2462 \$8186 \$8671 \$4972 \$8572 \$8717 \$8708 gf180mcu_fd_sc_mcu9t5v0__mux2_1
X$2463 \$6347 \$7299 \$4972 \$7304 \$7417 \$7407 gf180mcu_fd_sc_mcu9t5v0__mux2_1
X$2464 \$10902 \$10661 \$4972 \$10630 \$10782 \$10779
+ gf180mcu_fd_sc_mcu9t5v0__mux2_1
X$2465 \$9775 \$10660 \$4972 \$10630 \$10782 \$10778
+ gf180mcu_fd_sc_mcu9t5v0__mux2_1
X$2466 \$9239 \$10511 \$4972 \$10391 \$10282 \$10510
+ gf180mcu_fd_sc_mcu9t5v0__mux2_1
X$2467 \$5244 \$5878 \$4972 \$6001 \$5833 \$5999 gf180mcu_fd_sc_mcu9t5v0__mux2_1
X$2468 \$6380 \$6613 \$4972 \$6497 \$6387 \$6494 gf180mcu_fd_sc_mcu9t5v0__mux2_1
X$2469 \$6375 \$9334 \$4972 \$9337 \$9221 \$9333 gf180mcu_fd_sc_mcu9t5v0__mux2_1
X$2470 \$8961 \$9565 \$4972 \$9608 \$9457 \$9455 gf180mcu_fd_sc_mcu9t5v0__mux2_1
X$2471 \$6132 \$6489 \$4972 \$6497 \$6387 \$6488 gf180mcu_fd_sc_mcu9t5v0__mux2_1
X$2472 \$5594 \$5829 \$4972 \$5735 \$5473 \$5593 gf180mcu_fd_sc_mcu9t5v0__mux2_1
X$2473 \$10027 \$9743 \$4972 \$9748 \$9703 \$9891
+ gf180mcu_fd_sc_mcu9t5v0__mux2_1
X$2474 \$5018 \$8297 \$4972 \$8301 \$8183 \$8296 gf180mcu_fd_sc_mcu9t5v0__mux2_1
X$2475 \$8968 \$9213 \$4972 \$9102 \$8963 \$9068 gf180mcu_fd_sc_mcu9t5v0__mux2_1
X$2476 \$8695 \$8531 \$4972 \$8572 \$8335 \$8570 gf180mcu_fd_sc_mcu9t5v0__mux2_1
X$2477 \$12483 \$12376 \$12486 \$4973 gf180mcu_fd_sc_mcu9t5v0__clkbuf_16
X$2478 \$4973 \$17085 \$17367 \$16059 gf180mcu_fd_sc_mcu9t5v0__clkbuf_8
X$2479 \$4973 \$12260 \$12376 \$10652 gf180mcu_fd_sc_mcu9t5v0__clkbuf_8
X$2480 \$4973 \$10022 \$9900 \$8329 gf180mcu_fd_sc_mcu9t5v0__clkbuf_8
X$2481 \$4973 \$7047 \$6890 \$6104 gf180mcu_fd_sc_mcu9t5v0__clkbuf_8
X$2482 \$4973 \$11306 \$11182 \$10281 gf180mcu_fd_sc_mcu9t5v0__clkbuf_8
X$2483 \$4973 \$15949 \$15749 \$15484 gf180mcu_fd_sc_mcu9t5v0__clkbuf_8
X$2484 \$4973 \$13035 \$12930 \$12259 gf180mcu_fd_sc_mcu9t5v0__clkbuf_8
X$2485 \$4973 \$15949 \$15749 \$14187 gf180mcu_fd_sc_mcu9t5v0__clkbuf_8
X$2486 \$4973 \$15045 \$14875 \$14150 gf180mcu_fd_sc_mcu9t5v0__clkbuf_8
X$2487 \$4973 \$17085 \$17034 \$16439 gf180mcu_fd_sc_mcu9t5v0__clkbuf_8
X$2488 \$4973 \$17538 \$17367 \$17020 gf180mcu_fd_sc_mcu9t5v0__clkbuf_8
X$2489 \$4973 \$8572 \$8335 \$8328 gf180mcu_fd_sc_mcu9t5v0__clkbuf_8
X$2490 \$4973 \$13623 \$13452 \$12654 gf180mcu_fd_sc_mcu9t5v0__clkbuf_8
X$2491 \$9744 \$9748 \$9703 \$4982 gf180mcu_fd_sc_mcu9t5v0__buf_8
X$2492 \$5481 \$5485 \$4987 \$5358 \$5473 gf180mcu_fd_sc_mcu9t5v0__dffq_2
X$2493 \$4987 \$5612 \$5611 \$5735 \$5473 \$5485 gf180mcu_fd_sc_mcu9t5v0__mux2_1
X$2494 \$4988 \$6136 \$6387 \$6357 gf180mcu_fd_sc_mcu9t5v0__clkinv_1
X$2495 \$5481 \$6358 \$4988 \$6136 \$6387 gf180mcu_fd_sc_mcu9t5v0__dffq_2
X$2496 \$5499 \$4991 \$5358 \$5473 \$5500 gf180mcu_fd_sc_mcu9t5v0__nand2_1
X$2497 \$8075 \$4991 \$8834 \$8717 \$8550 gf180mcu_fd_sc_mcu9t5v0__nand2_1
X$2498 \$12140 \$12260 \$12376 \$4991 gf180mcu_fd_sc_mcu9t5v0__buf_8
X$2499 \$8302 \$8685 \$4991 \$8572 \$8717 \$8684 gf180mcu_fd_sc_mcu9t5v0__mux2_1
X$2500 \$9343 \$9225 \$4991 \$9337 \$9457 \$9346 gf180mcu_fd_sc_mcu9t5v0__mux2_1
X$2501 \$5360 \$5888 \$4991 \$6001 \$6105 \$5885 gf180mcu_fd_sc_mcu9t5v0__mux2_1
X$2502 \$6346 \$7055 \$4991 \$7047 \$7160 \$7054 gf180mcu_fd_sc_mcu9t5v0__mux2_1
X$2503 \$7272 \$7919 \$4991 \$8063 \$7947 \$7950 gf180mcu_fd_sc_mcu9t5v0__mux2_1
X$2504 \$10233 \$11520 \$4991 \$12786 \$12526 \$12666
+ gf180mcu_fd_sc_mcu9t5v0__mux2_1
X$2505 \$10240 \$10792 \$4991 \$12486 \$12376 \$12137
+ gf180mcu_fd_sc_mcu9t5v0__mux2_1
X$2506 \$9904 \$10245 \$4991 \$12786 \$12526 \$12664
+ gf180mcu_fd_sc_mcu9t5v0__mux2_1
X$2507 \$5632 \$6676 \$4991 \$6770 \$6616 \$6675 gf180mcu_fd_sc_mcu9t5v0__mux2_1
X$2508 \$5256 \$6672 \$4991 \$6497 \$6387 \$6510 gf180mcu_fd_sc_mcu9t5v0__mux2_1
X$2509 \$5356 \$4992 \$12248 \$11956 \$11827 \$11710
+ gf180mcu_fd_sc_mcu9t5v0__oai21_1
X$2510 \$12248 \$4992 \$11130 \$11956 \$11993 \$13069
+ gf180mcu_fd_sc_mcu9t5v0__nand3_1
X$2511 \$6364 \$4992 \$6369 \$6015 \$5356 \$6136 \$6387 \$6368
+ gf180mcu_fd_sc_mcu9t5v0__aoi221_1
X$2512 \$6891 \$4992 \$6770 \$6890 \$6773 gf180mcu_fd_sc_mcu9t5v0__nand2_1
X$2513 \$5601 \$4992 \$5735 \$5833 \$5834 gf180mcu_fd_sc_mcu9t5v0__nand2_1
X$2514 \$10236 \$4992 \$10391 \$10514 \$10396 gf180mcu_fd_sc_mcu9t5v0__nand2_1
X$2515 \$7685 \$4992 \$7526 \$7417 \$7414 gf180mcu_fd_sc_mcu9t5v0__nand2_1
X$2516 \$11515 \$4992 \$11675 \$11555 \$11556 gf180mcu_fd_sc_mcu9t5v0__nand2_1
X$2517 \$11179 \$4992 \$11675 \$11555 \$11681 gf180mcu_fd_sc_mcu9t5v0__nand2_1
X$2518 \$14241 \$15392 \$4999 \$13471 \$15321 \$15490
+ gf180mcu_fd_sc_mcu9t5v0__dffrnq_2
X$2519 \$4999 \$6663 \$6667 \$6666 \$6770 \$6616 \$6506
+ gf180mcu_fd_sc_mcu9t5v0__oai22_1
X$2520 \$4999 \$14211 \$14229 \$5113 \$14151 \$14034 \$14164
+ gf180mcu_fd_sc_mcu9t5v0__aoi22_1
X$2521 \$4999 \$5613 \$5735 \$5833 \$5621 gf180mcu_fd_sc_mcu9t5v0__nand2_1
X$2522 \$4999 \$12912 \$15628 \$15490 \$15643 gf180mcu_fd_sc_mcu9t5v0__nand2_1
X$2523 \$20093 \$19042 \$19165 \$5002 \$19927 \$20087 \$20050
+ gf180mcu_fd_sc_mcu9t5v0__aoi22_1
X$2524 \$17093 \$5004 \$19042 \$30251 \$30185 \$30255
+ gf180mcu_fd_sc_mcu9t5v0__aoi21_1
X$2525 \$30820 \$30823 \$30824 \$30902 \$5004 \$30819 \$30763 \$30772
+ gf180mcu_fd_sc_mcu9t5v0__oai221_1
X$2526 \$25199 \$12938 \$5004 \$25191 \$25347 \$25200
+ gf180mcu_fd_sc_mcu9t5v0__oai21_1
X$2527 \$8307 \$11183 \$16850 \$5004 \$16914 \$16728 \$16849
+ gf180mcu_fd_sc_mcu9t5v0__oai211_1
X$2528 \$22077 \$19154 \$5004 \$21664 \$22074 \$22272 \$22134
+ gf180mcu_fd_sc_mcu9t5v0__aoi22_1
X$2529 \$22575 \$19154 \$5004 \$17092 \$22713 \$22440 \$22582
+ gf180mcu_fd_sc_mcu9t5v0__aoi22_1
X$2530 \$25060 \$19154 \$5004 \$23630 \$25191 \$24997 \$25062
+ gf180mcu_fd_sc_mcu9t5v0__aoi22_1
X$2531 \$24879 \$19154 \$5004 \$23639 \$24877 \$24721 \$24886
+ gf180mcu_fd_sc_mcu9t5v0__aoi22_1
X$2532 \$24853 \$19154 \$5004 \$22446 \$24877 \$24721 \$25762
+ gf180mcu_fd_sc_mcu9t5v0__aoi22_1
X$2533 \$25924 \$19154 \$5004 \$23461 \$26088 \$25918 \$26099
+ gf180mcu_fd_sc_mcu9t5v0__aoi22_1
X$2534 \$23185 \$19154 \$5004 \$23459 \$23620 \$23454 \$23623
+ gf180mcu_fd_sc_mcu9t5v0__aoi22_1
X$2535 \$24537 \$19154 \$5004 \$22845 \$24593 \$24428 \$24539
+ gf180mcu_fd_sc_mcu9t5v0__aoi22_1
X$2536 \$24725 \$19154 \$5004 \$21665 \$24877 \$24721 \$24878
+ gf180mcu_fd_sc_mcu9t5v0__aoi22_1
X$2537 \$30238 \$19154 \$5004 \$16851 \$19042 \$30054 \$30185 \$30187
+ gf180mcu_fd_sc_mcu9t5v0__aoi221_1
X$2538 \$28357 \$19154 \$5004 \$23643 \$19042 \$28211 \$28381 \$28570
+ gf180mcu_fd_sc_mcu9t5v0__aoi221_1
X$2539 \$19328 \$19154 \$5004 \$12529 \$19042 \$19324 \$19466 \$19778
+ gf180mcu_fd_sc_mcu9t5v0__aoi221_1
X$2540 \$21944 \$19154 \$5004 \$12932 \$19042 \$21661 \$21946 \$23326
+ gf180mcu_fd_sc_mcu9t5v0__aoi221_1
X$2541 \$20578 \$19154 \$5004 \$9573 \$19042 \$20515 \$20718 \$20883
+ gf180mcu_fd_sc_mcu9t5v0__aoi221_1
X$2542 \$24250 \$19154 \$5004 \$23034 \$19042 \$24593 \$24428 \$24430
+ gf180mcu_fd_sc_mcu9t5v0__aoi221_1
X$2543 \$24600 \$19154 \$5004 \$23463 \$19042 \$24877 \$24721 \$24737
+ gf180mcu_fd_sc_mcu9t5v0__aoi221_1
X$2544 \$20089 \$19154 \$5004 \$7163 \$19042 \$20209 \$20087 \$20211
+ gf180mcu_fd_sc_mcu9t5v0__aoi221_1
X$2545 \$21306 \$19154 \$5004 \$8842 \$19042 \$21184 \$21011 \$21018
+ gf180mcu_fd_sc_mcu9t5v0__aoi221_1
X$2546 \$21014 \$19154 \$5004 \$7948 \$19042 \$20881 \$20718 \$20719
+ gf180mcu_fd_sc_mcu9t5v0__aoi221_1
X$2547 \$5004 \$24325 \$25797 \$25918 \$25941 gf180mcu_fd_sc_mcu9t5v0__nand2_1
X$2548 \$5004 \$24890 \$27015 \$27153 \$27806 gf180mcu_fd_sc_mcu9t5v0__nand2_1
X$2549 \$5004 \$23468 \$23620 \$23807 \$23776 gf180mcu_fd_sc_mcu9t5v0__nand2_1
X$2550 \$5004 \$24258 \$24231 \$24428 \$24432 gf180mcu_fd_sc_mcu9t5v0__nand2_1
X$2551 \$5004 \$23640 \$23620 \$23807 \$23778 gf180mcu_fd_sc_mcu9t5v0__nand2_1
X$2552 \$5004 \$23646 \$29634 \$29424 \$29648 gf180mcu_fd_sc_mcu9t5v0__nand2_1
X$2553 \$5004 \$28050 \$27913 \$27776 \$27580 gf180mcu_fd_sc_mcu9t5v0__nand2_1
X$2554 \$29271 \$29290 \$29270 \$5004 gf180mcu_fd_sc_mcu9t5v0__buf_8
X$2555 \$14010 \$15374 \$5007 \$13471 \$15321 \$15204
+ gf180mcu_fd_sc_mcu9t5v0__dffrnq_2
X$2556 \$5007 \$8542 \$8301 \$8335 \$8347 gf180mcu_fd_sc_mcu9t5v0__or2_1
X$2557 \$5007 \$6663 \$8079 \$7813 \$7797 \$7947 \$7814
+ gf180mcu_fd_sc_mcu9t5v0__oai22_1
X$2558 \$5007 \$14229 \$14345 \$11838 \$15214 \$15321 \$15204 \$15333
+ gf180mcu_fd_sc_mcu9t5v0__aoi221_1
X$2559 \$5007 \$12912 \$15045 \$15204 \$15219 gf180mcu_fd_sc_mcu9t5v0__nand2_1
X$2560 \$20411 \$19042 \$19165 \$5011 \$20209 \$20383 \$20359
+ gf180mcu_fd_sc_mcu9t5v0__aoi22_1
X$2561 \$19788 \$19042 \$19165 \$5016 \$19324 \$19149 \$19296
+ gf180mcu_fd_sc_mcu9t5v0__aoi22_1
X$2562 \$5018 \$10040 \$11967 \$7811 \$11675 \$11827 \$11572
+ gf180mcu_fd_sc_mcu9t5v0__nor4_1
X$2563 \$5018 \$6662 \$7811 \$11306 \$11182 \$11327
+ gf180mcu_fd_sc_mcu9t5v0__nor3_1
X$2564 \$16924 \$5018 \$14217 \$16436 \$16728 \$16600
+ gf180mcu_fd_sc_mcu9t5v0__mux2_1
X$2565 \$9331 \$5018 \$6343 \$9337 \$9221 \$9330 gf180mcu_fd_sc_mcu9t5v0__mux2_1
X$2566 \$13899 \$14011 \$13226 \$13881 \$14034 \$5018
+ gf180mcu_fd_sc_mcu9t5v0__mux2_1
X$2567 \$5018 \$5115 \$6125 \$6001 \$6105 \$5865 gf180mcu_fd_sc_mcu9t5v0__mux2_1
X$2568 \$5231 \$5207 \$5106 \$5229 gf180mcu_fd_sc_mcu9t5v0__clkinv_1
X$2569 \$5106 \$5207 gf180mcu_fd_sc_mcu9t5v0__filltie
X$2570 \$5106 \$5207 gf180mcu_fd_sc_mcu9t5v0__filltie
X$2571 \$5106 \$5207 gf180mcu_fd_sc_mcu9t5v0__filltie
X$2572 \$5106 \$5207 gf180mcu_fd_sc_mcu9t5v0__filltie
X$2573 \$5106 \$5207 gf180mcu_fd_sc_mcu9t5v0__filltie
X$2574 \$5106 \$5207 gf180mcu_fd_sc_mcu9t5v0__filltie
X$2575 \$5481 \$5215 \$5107 \$5207 \$5106 gf180mcu_fd_sc_mcu9t5v0__dffq_2
X$2576 \$5106 \$5207 gf180mcu_fd_sc_mcu9t5v0__endcap
X$2577 \$13230 \$14234 \$5113 \$13471 \$14151 \$14337
+ gf180mcu_fd_sc_mcu9t5v0__dffrnq_2
X$2578 \$5113 \$6663 \$7939 \$7816 \$7797 \$7947 \$7587
+ gf180mcu_fd_sc_mcu9t5v0__oai22_1
X$2579 \$5113 \$5613 \$6001 \$5833 \$5905 gf180mcu_fd_sc_mcu9t5v0__nand2_1
X$2580 \$5113 \$12912 \$14151 \$14034 \$14165 gf180mcu_fd_sc_mcu9t5v0__nand2_1
X$2581 \$5115 \$5497 \$10901 \$11025 \$11037 gf180mcu_fd_sc_mcu9t5v0__nand2_1
X$2582 \$11533 \$10901 \$10782 \$5115 gf180mcu_fd_sc_mcu9t5v0__buf_8
X$2583 \$5233 \$5262 \$5207 \$5240 \$5260 gf180mcu_fd_sc_mcu9t5v0__nand2_1
X$2584 \$5264 \$5265 \$5266 \$5207 \$5240 gf180mcu_fd_sc_mcu9t5v0__dffq_2
X$2585 \$5261 \$5230 \$5231 \$5207 \$5240 gf180mcu_fd_sc_mcu9t5v0__dffq_2
X$2586 \$5240 \$5207 gf180mcu_fd_sc_mcu9t5v0__filltie
X$2587 \$5240 \$5207 gf180mcu_fd_sc_mcu9t5v0__filltie
X$2588 \$5240 \$5207 gf180mcu_fd_sc_mcu9t5v0__filltie
X$2589 \$5240 \$5207 gf180mcu_fd_sc_mcu9t5v0__filltie
X$2590 \$5240 \$5207 gf180mcu_fd_sc_mcu9t5v0__filltie
X$2591 \$5240 \$5207 gf180mcu_fd_sc_mcu9t5v0__filltie
X$2592 \$5240 \$5207 gf180mcu_fd_sc_mcu9t5v0__endcap
X$2593 \$13230 \$13470 \$5218 \$13471 \$13341 \$13452
+ gf180mcu_fd_sc_mcu9t5v0__dffrnq_2
X$2594 \$5218 \$6663 \$6781 \$6780 \$6770 \$6890 \$6624
+ gf180mcu_fd_sc_mcu9t5v0__oai22_1
X$2595 \$5218 \$14211 \$14345 \$12498 \$14151 \$14034 \$14230
+ gf180mcu_fd_sc_mcu9t5v0__aoi22_1
X$2596 \$5218 \$5613 \$5735 \$5833 \$5618 gf180mcu_fd_sc_mcu9t5v0__nand2_1
X$2597 \$5218 \$12912 \$13623 \$13452 \$13525 gf180mcu_fd_sc_mcu9t5v0__nand2_1
X$2598 \$5221 \$23195 \$23183 \$23139 \$23196 gf180mcu_fd_sc_mcu9t5v0__xnor2_1
X$2599 \$16851 \$5221 \$23183 \$23139 \$23332 gf180mcu_fd_sc_mcu9t5v0__nand2_1
X$2600 \$23038 \$5225 \$23027 \$23139 \$22911 gf180mcu_fd_sc_mcu9t5v0__nor2_1
X$2601 \$23038 \$5225 \$23027 \$23139 \$23152 gf180mcu_fd_sc_mcu9t5v0__nand2_1
X$2602 \$5240 \$5358 gf180mcu_fd_sc_mcu9t5v0__filltie
X$2603 \$5240 \$5358 gf180mcu_fd_sc_mcu9t5v0__filltie
X$2604 \$5240 \$5358 gf180mcu_fd_sc_mcu9t5v0__filltie
X$2605 \$5240 \$5358 gf180mcu_fd_sc_mcu9t5v0__filltie
X$2606 \$5240 \$5358 gf180mcu_fd_sc_mcu9t5v0__filltie
X$2607 \$5240 \$5358 gf180mcu_fd_sc_mcu9t5v0__filltie
X$2608 \$6016 \$5377 \$5378 \$5358 \$5240 \$5376 gf180mcu_fd_sc_mcu9t5v0__mux2_1
X$2609 \$5240 \$5358 gf180mcu_fd_sc_mcu9t5v0__endcap
X$2610 \$14521 \$5244 \$13849 \$15628 \$15749 \$15827
+ gf180mcu_fd_sc_mcu9t5v0__oai21_1
X$2611 \$5244 \$6932 \$7576 \$7526 \$7688 \$7314
+ gf180mcu_fd_sc_mcu9t5v0__nand3_1
X$2612 \$5244 \$6770 \$6616 \$5610 gf180mcu_fd_sc_mcu9t5v0__clkinv_1
X$2613 \$6382 \$5244 \$6343 \$6136 \$6387 \$6381 gf180mcu_fd_sc_mcu9t5v0__mux2_1
X$2614 \$14009 \$15766 \$13226 \$15628 \$15749 \$5244
+ gf180mcu_fd_sc_mcu9t5v0__mux2_1
X$2615 \$13230 \$13472 \$5249 \$13471 \$13341 \$13452
+ gf180mcu_fd_sc_mcu9t5v0__dffrnq_2
X$2616 \$5249 \$6663 \$6784 \$6783 \$6770 \$6890 \$6782
+ gf180mcu_fd_sc_mcu9t5v0__oai22_1
X$2617 \$5249 \$12912 \$13623 \$13729 \$13527 gf180mcu_fd_sc_mcu9t5v0__nand2_1
X$2618 \$5249 \$14211 \$14151 \$14337 \$14225 gf180mcu_fd_sc_mcu9t5v0__nand2_1
X$2619 \$5249 \$5613 \$6136 \$6105 \$6112 gf180mcu_fd_sc_mcu9t5v0__nand2_1
X$2620 \$18592 \$19744 \$5253 \$13634 \$19605 \$19774
+ gf180mcu_fd_sc_mcu9t5v0__dffrnq_2
X$2621 \$5253 \$8542 \$8301 \$8335 \$8346 gf180mcu_fd_sc_mcu9t5v0__or2_1
X$2622 \$5253 \$6663 \$8077 \$8078 \$8063 \$8183 \$7810
+ gf180mcu_fd_sc_mcu9t5v0__oai22_1
X$2623 \$5253 \$12912 \$19605 \$19466 \$19745 gf180mcu_fd_sc_mcu9t5v0__nand2_1
X$2624 \$5253 \$17656 \$14454 \$14337 \$14349 gf180mcu_fd_sc_mcu9t5v0__nand2_1
X$2625 \$5736 \$6928 \$5256 \$7304 \$7417 \$7429
+ gf180mcu_fd_sc_mcu9t5v0__aoi21_1
X$2626 \$7315 \$7304 \$7417 \$5256 gf180mcu_fd_sc_mcu9t5v0__buf_8
X$2627 \$13230 \$14523 \$5259 \$13471 \$14454 \$14635
+ gf180mcu_fd_sc_mcu9t5v0__dffrnq_2
X$2628 \$5259 \$8542 \$8301 \$8183 \$8316 gf180mcu_fd_sc_mcu9t5v0__or2_1
X$2629 \$5259 \$6663 \$8080 \$8200 \$8063 \$8183 \$8082
+ gf180mcu_fd_sc_mcu9t5v0__oai22_1
X$2630 \$5259 \$12912 \$14454 \$14337 \$14467 gf180mcu_fd_sc_mcu9t5v0__nand2_1
X$2631 \$22905 \$19154 \$22910 \$5260 \$22713 \$22837 \$23155
+ gf180mcu_fd_sc_mcu9t5v0__aoi22_1
X$2632 \$5261 \$6497 \$6616 \$I71700 gf180mcu_fd_sc_mcu9t5v0__clkinv_2
X$2633 \$5261 \$6378 \$6680 \$6136 \$6387 gf180mcu_fd_sc_mcu9t5v0__dffq_2
X$2634 \$5261 \$6163 \$6377 \$6136 \$6387 gf180mcu_fd_sc_mcu9t5v0__dffq_2
X$2635 \$5261 \$7558 \$7818 \$7526 \$7688 gf180mcu_fd_sc_mcu9t5v0__dffq_2
X$2636 \$5261 \$5630 \$5503 \$5358 \$5473 gf180mcu_fd_sc_mcu9t5v0__dffq_2
X$2637 \$5261 \$6525 \$6524 \$6497 \$6616 gf180mcu_fd_sc_mcu9t5v0__dffq_2
X$2638 \$5261 \$7594 \$7705 \$7526 \$7688 gf180mcu_fd_sc_mcu9t5v0__dffq_2
X$2639 \$5261 \$5501 \$5862 \$5735 \$5833 gf180mcu_fd_sc_mcu9t5v0__dffq_2
X$2640 \$5261 \$5376 \$6016 \$5358 \$5473 gf180mcu_fd_sc_mcu9t5v0__dffq_2
X$2641 \$5261 \$8586 \$8863 \$8572 \$8717 gf180mcu_fd_sc_mcu9t5v0__dffq_2
X$2642 \$5261 \$6400 \$6401 \$6497 \$6387 gf180mcu_fd_sc_mcu9t5v0__dffq_2
X$2643 \$5261 \$6159 \$6371 \$6136 \$6105 gf180mcu_fd_sc_mcu9t5v0__dffq_2
X$2644 \$5261 \$7436 \$7969 \$7526 \$7417 gf180mcu_fd_sc_mcu9t5v0__dffq_2
X$2645 \$5261 \$7434 \$7435 \$7526 \$7417 gf180mcu_fd_sc_mcu9t5v0__dffq_2
X$2646 \$5261 \$6947 \$6792 \$7047 \$6890 gf180mcu_fd_sc_mcu9t5v0__dffq_2
X$2647 \$5261 \$5864 \$5505 \$6001 \$5833 gf180mcu_fd_sc_mcu9t5v0__dffq_2
X$2648 \$5261 \$6402 \$6640 \$6497 \$6387 gf180mcu_fd_sc_mcu9t5v0__dffq_2
X$2649 \$5264 \$15225 \$15183 \$15037 \$15321 \$15204
+ gf180mcu_fd_sc_mcu9t5v0__dffrnq_2
X$2650 \$5264 \$12697 \$12548 \$13471 \$12786 \$12526
+ gf180mcu_fd_sc_mcu9t5v0__dffrnq_2
X$2651 \$5264 \$8834 \$8717 gf180mcu_fd_sc_mcu9t5v0__inv_4
X$2652 \$5264 \$6166 \$6379 \$6136 \$6387 gf180mcu_fd_sc_mcu9t5v0__dffq_2
X$2653 \$5264 \$5645 \$5644 \$5735 \$5833 gf180mcu_fd_sc_mcu9t5v0__dffq_2
X$2654 \$5264 \$7819 \$7706 \$7797 \$7947 gf180mcu_fd_sc_mcu9t5v0__dffq_2
X$2655 \$5264 \$7561 \$6904 \$7526 \$7688 gf180mcu_fd_sc_mcu9t5v0__dffq_2
X$2656 \$5264 \$8327 \$6960 \$8301 \$8335 gf180mcu_fd_sc_mcu9t5v0__dffq_2
X$2657 \$5264 \$9929 \$9926 \$9748 \$9900 gf180mcu_fd_sc_mcu9t5v0__dffq_2
X$2658 \$5264 \$8740 \$8739 \$8572 \$8717 gf180mcu_fd_sc_mcu9t5v0__dffq_2
X$2659 \$5264 \$9366 \$9128 \$9337 \$9457 gf180mcu_fd_sc_mcu9t5v0__dffq_2
X$2660 \$5264 \$9738 \$9802 \$9608 \$9703 gf180mcu_fd_sc_mcu9t5v0__dffq_2
X$2661 \$5264 \$10422 \$10299 \$10391 \$10514 gf180mcu_fd_sc_mcu9t5v0__dffq_2
X$2662 \$5264 \$8982 \$8981 \$9102 \$8963 gf180mcu_fd_sc_mcu9t5v0__dffq_2
X$2663 \$5264 \$6912 \$6682 \$7047 \$6890 gf180mcu_fd_sc_mcu9t5v0__dffq_2
X$2664 \$5357 \$5356 \$11675 \$11827 \$11130 gf180mcu_fd_sc_mcu9t5v0__nor2_1
X$2665 \$11982 \$12036 \$11848 \$5356 \$11956 \$11993 \$12035
+ gf180mcu_fd_sc_mcu9t5v0__aoi22_1
X$2666 \$10772 \$10391 \$10282 \$5356 gf180mcu_fd_sc_mcu9t5v0__buf_8
X$2667 \$11670 \$11675 \$11555 \$5357 gf180mcu_fd_sc_mcu9t5v0__inv_1
X$2668 \$5357 \$10231 \$10024 \$10022 \$10282 \$10023
+ gf180mcu_fd_sc_mcu9t5v0__oai21_1
X$2669 \$5357 \$11712 \$10024 \$11675 \$11827 \$11711
+ gf180mcu_fd_sc_mcu9t5v0__oai21_1
X$2670 \$5613 \$5486 \$5487 \$5737 \$5358 \$5473 \$5614
+ gf180mcu_fd_sc_mcu9t5v0__oai31_1
X$2671 \$5473 \$5358 gf180mcu_fd_sc_mcu9t5v0__filltie
X$2672 \$5473 \$5358 gf180mcu_fd_sc_mcu9t5v0__filltie
X$2673 \$5473 \$5358 gf180mcu_fd_sc_mcu9t5v0__filltie
X$2674 \$5473 \$5358 gf180mcu_fd_sc_mcu9t5v0__filltie
X$2675 \$5473 \$5358 gf180mcu_fd_sc_mcu9t5v0__filltie
X$2676 \$5473 \$5358 gf180mcu_fd_sc_mcu9t5v0__filltie
X$2677 \$5473 \$5358 gf180mcu_fd_sc_mcu9t5v0__endcap
X$2678 \$5736 \$5840 \$5360 \$6136 \$6105 \$6145
+ gf180mcu_fd_sc_mcu9t5v0__aoi21_1
X$2679 \$14197 \$14160 \$13498 \$14151 \$14034 \$5360
+ gf180mcu_fd_sc_mcu9t5v0__mux2_1
X$2680 \$8314 \$8581 \$7929 \$8301 \$8335 \$5370
+ gf180mcu_fd_sc_mcu9t5v0__aoi21_1
X$2681 \$7965 \$7937 \$7929 \$8063 \$7947 \$5375
+ gf180mcu_fd_sc_mcu9t5v0__aoi21_2
X$2682 \$5736 \$6928 \$5375 \$5735 \$5833 \$5857
+ gf180mcu_fd_sc_mcu9t5v0__aoi21_1
X$2683 \$8074 \$8301 \$8183 \$5378 gf180mcu_fd_sc_mcu9t5v0__buf_8
X$2684 \$6640 \$6403 \$5378 \$6497 \$6616 \$6402 gf180mcu_fd_sc_mcu9t5v0__mux2_1
X$2685 \$9719 \$9718 \$5378 \$9608 \$9703 \$9717 gf180mcu_fd_sc_mcu9t5v0__mux2_1
X$2686 \$8700 \$8699 \$5378 \$8572 \$8717 \$8736 gf180mcu_fd_sc_mcu9t5v0__mux2_1
X$2687 \$9475 \$9474 \$5378 \$9337 \$9457 \$9473 gf180mcu_fd_sc_mcu9t5v0__mux2_1
X$2688 \$5505 \$5865 \$5378 \$5735 \$5833 \$5864 gf180mcu_fd_sc_mcu9t5v0__mux2_1
X$2689 \$7942 \$7703 \$5378 \$7797 \$7947 \$7702 gf180mcu_fd_sc_mcu9t5v0__mux2_1
X$2690 \$7705 \$7556 \$5378 \$7797 \$7688 \$7594 gf180mcu_fd_sc_mcu9t5v0__mux2_1
X$2691 \$9231 \$9081 \$5378 \$9337 \$9221 \$9230 gf180mcu_fd_sc_mcu9t5v0__mux2_1
X$2692 \$9094 \$9093 \$5378 \$9102 \$8963 \$9092 gf180mcu_fd_sc_mcu9t5v0__mux2_1
X$2693 \$9923 \$9797 \$5378 \$10022 \$9900 \$9922
+ gf180mcu_fd_sc_mcu9t5v0__mux2_1
X$2694 \$5613 \$5619 \$5620 \$5618 \$5735 \$5473 \$5617
+ gf180mcu_fd_sc_mcu9t5v0__oai31_1
X$2695 \$5613 \$5623 \$5624 \$5621 \$5735 \$5473 \$5622
+ gf180mcu_fd_sc_mcu9t5v0__oai31_1
X$2696 \$5609 \$5887 \$5735 \$5473 \$5479 gf180mcu_fd_sc_mcu9t5v0__nand2_1
X$2697 \$5473 \$5735 gf180mcu_fd_sc_mcu9t5v0__filltie
X$2698 \$5473 \$5735 gf180mcu_fd_sc_mcu9t5v0__filltie
X$2699 \$5473 \$5735 gf180mcu_fd_sc_mcu9t5v0__filltie
X$2700 \$5473 \$5735 gf180mcu_fd_sc_mcu9t5v0__filltie
X$2701 \$5473 \$5735 gf180mcu_fd_sc_mcu9t5v0__filltie
X$2702 \$5473 \$5735 gf180mcu_fd_sc_mcu9t5v0__filltie
X$2703 \$5473 \$5735 gf180mcu_fd_sc_mcu9t5v0__endcap
X$2704 \$5481 \$6001 \$5833 \$I71628 gf180mcu_fd_sc_mcu9t5v0__inv_2
X$2705 \$5890 \$6001 \$5833 \$5481 gf180mcu_fd_sc_mcu9t5v0__clkbuf_8
X$2706 \$5481 \$6661 \$5883 \$6497 \$6616 gf180mcu_fd_sc_mcu9t5v0__dffq_2
X$2707 \$5613 \$5841 \$5842 \$5484 \$5735 \$5833 \$5483
+ gf180mcu_fd_sc_mcu9t5v0__oai31_1
X$2708 \$6015 \$5492 \$6001 \$5833 \$5898 gf180mcu_fd_sc_mcu9t5v0__nand2_1
X$2709 \$7938 \$7937 \$7929 \$7797 \$7688 \$5496
+ gf180mcu_fd_sc_mcu9t5v0__aoi21_2
X$2710 \$5736 \$6928 \$5496 \$6770 \$6890 \$6635
+ gf180mcu_fd_sc_mcu9t5v0__aoi21_1
X$2711 \$7592 \$5497 \$10022 \$10282 \$10266 gf180mcu_fd_sc_mcu9t5v0__nand2_1
X$2712 \$11724 \$11675 \$11827 \$5497 gf180mcu_fd_sc_mcu9t5v0__buf_8
X$2713 \$13230 \$14469 \$5499 \$13471 \$14454 \$14337
+ gf180mcu_fd_sc_mcu9t5v0__dffrnq_2
X$2714 \$5499 \$6663 \$8974 \$8857 \$8834 \$8963 \$8975
+ gf180mcu_fd_sc_mcu9t5v0__oai22_1
X$2715 \$5499 \$14229 \$14454 \$14635 \$14464 gf180mcu_fd_sc_mcu9t5v0__nand2_1
X$2716 \$5499 \$5613 \$6770 \$6616 \$6634 gf180mcu_fd_sc_mcu9t5v0__nand2_1
X$2717 \$5499 \$12912 \$14454 \$14337 \$14468 gf180mcu_fd_sc_mcu9t5v0__nand2_1
X$2718 \$5503 \$5735 \$5833 \$5629 gf180mcu_fd_sc_mcu9t5v0__clkinv_1
X$2719 \$7905 \$5594 \$6343 \$7797 \$7947 \$7904 gf180mcu_fd_sc_mcu9t5v0__mux2_1
X$2720 \$13460 \$13462 \$13226 \$13341 \$13452 \$5594
+ gf180mcu_fd_sc_mcu9t5v0__mux2_1
X$2721 \$6104 \$5595 \$5596 \$5735 \$5833 gf180mcu_fd_sc_mcu9t5v0__dffq_2
X$2722 \$6104 \$5597 \$5831 \$5735 \$5833 gf180mcu_fd_sc_mcu9t5v0__dffq_2
X$2723 \$5832 \$5598 \$5599 \$5735 \$5833 gf180mcu_fd_sc_mcu9t5v0__dffq_2
X$2724 \$6653 \$5604 \$6924 \$7047 \$6890 \$6893 gf180mcu_fd_sc_mcu9t5v0__mux2_1
X$2725 \$5610 \$5736 \$5840 \$6001 \$6105 \$6108 gf180mcu_fd_sc_mcu9t5v0__and3_1
X$2726 \$5610 \$6662 \$7811 \$6663 \$6770 \$6890 \$6658
+ gf180mcu_fd_sc_mcu9t5v0__oai31_1
X$2727 \$9711 \$11136 \$11025 \$5611 gf180mcu_fd_sc_mcu9t5v0__clkbuf_8
X$2728 \$7581 \$7580 \$5611 \$7526 \$7688 \$7693 gf180mcu_fd_sc_mcu9t5v0__mux2_1
X$2729 \$6107 \$6146 \$5611 \$6136 \$6105 \$6147 gf180mcu_fd_sc_mcu9t5v0__mux2_1
X$2730 \$5613 \$5845 \$5889 \$5843 \$5735 \$5833 \$5612
+ gf180mcu_fd_sc_mcu9t5v0__oai31_1
X$2731 \$7557 \$11197 \$11321 \$5613 \$11306 \$11182 \$11322
+ gf180mcu_fd_sc_mcu9t5v0__aoi211_1
X$2732 \$5613 \$12497 \$12550 \$12549 \$12486 \$12526 \$12026
+ gf180mcu_fd_sc_mcu9t5v0__oai31_1
X$2733 \$5613 \$12552 \$12553 \$12383 \$12486 \$12526 \$12028
+ gf180mcu_fd_sc_mcu9t5v0__oai31_1
X$2734 \$5613 \$11030 \$10913 \$11186 \$10901 \$11025 \$11031
+ gf180mcu_fd_sc_mcu9t5v0__oai31_1
X$2735 \$5613 \$10261 \$10048 \$10262 \$10022 \$10282 \$10263
+ gf180mcu_fd_sc_mcu9t5v0__oai31_1
X$2736 \$5613 \$8728 \$8727 \$8543 \$8572 \$8717 \$8544
+ gf180mcu_fd_sc_mcu9t5v0__oai31_1
X$2737 \$5613 \$5907 \$5857 \$5905 \$5735 \$5833 \$5858
+ gf180mcu_fd_sc_mcu9t5v0__oai31_1
X$2738 \$5613 \$6111 \$5847 \$6112 \$6001 \$6105 \$5846
+ gf180mcu_fd_sc_mcu9t5v0__oai31_1
X$2739 \$5613 \$9466 \$9592 \$9465 \$9337 \$9457 \$9117
+ gf180mcu_fd_sc_mcu9t5v0__oai31_1
X$2740 \$5613 \$7924 \$7925 \$8195 \$7797 \$7947 \$7580
+ gf180mcu_fd_sc_mcu9t5v0__oai31_1
X$2741 \$5613 \$9078 \$9229 \$9113 \$9102 \$9221 \$9114
+ gf180mcu_fd_sc_mcu9t5v0__oai31_1
X$2742 \$5613 \$7289 \$7429 \$7288 \$7304 \$7417 \$7178
+ gf180mcu_fd_sc_mcu9t5v0__oai31_1
X$2743 \$5613 \$8071 \$8192 \$8193 \$8063 \$8183 \$8070
+ gf180mcu_fd_sc_mcu9t5v0__oai31_1
X$2744 \$5613 \$6635 \$6636 \$6634 \$6497 \$6616 \$6637
+ gf180mcu_fd_sc_mcu9t5v0__oai31_1
X$2745 \$5613 \$8686 \$8723 \$8722 \$8834 \$8717 \$8847
+ gf180mcu_fd_sc_mcu9t5v0__oai31_1
X$2746 \$5613 \$9728 \$9786 \$10045 \$9748 \$9703 \$9785
+ gf180mcu_fd_sc_mcu9t5v0__oai31_1
X$2747 \$5613 \$11973 \$11974 \$11839 \$11956 \$11827 \$12021
+ gf180mcu_fd_sc_mcu9t5v0__oai31_1
X$2748 \$5613 \$11148 \$11149 \$11147 \$11136 \$11025 \$11150
+ gf180mcu_fd_sc_mcu9t5v0__oai31_1
X$2749 \$5613 \$8197 \$8318 \$8316 \$8301 \$8183 \$8317
+ gf180mcu_fd_sc_mcu9t5v0__oai31_1
X$2750 \$5613 \$10399 \$10034 \$10246 \$10630 \$10514 \$10633
+ gf180mcu_fd_sc_mcu9t5v0__oai31_1
X$2751 \$5613 \$10804 \$10927 \$10803 \$10901 \$10782 \$10643
+ gf180mcu_fd_sc_mcu9t5v0__oai31_1
X$2752 \$5613 \$11572 \$11534 \$11571 \$11675 \$11555 \$11535
+ gf180mcu_fd_sc_mcu9t5v0__oai31_1
X$2753 \$5613 \$12495 \$12496 \$12681 \$12486 \$12376 \$12149
+ gf180mcu_fd_sc_mcu9t5v0__oai31_1
X$2754 \$5613 \$6108 \$6145 \$6109 \$6136 \$6105 \$6146
+ gf180mcu_fd_sc_mcu9t5v0__oai31_1
X$2755 \$5613 \$7180 \$7292 \$7291 \$7526 \$7417 \$7430
+ gf180mcu_fd_sc_mcu9t5v0__oai31_1
X$2756 \$5613 \$8552 \$8553 \$8346 \$8572 \$8335 \$8729
+ gf180mcu_fd_sc_mcu9t5v0__oai31_1
X$2757 \$5613 \$8560 \$8348 \$8347 \$8572 \$8335 \$8561
+ gf180mcu_fd_sc_mcu9t5v0__oai31_1
X$2758 \$10245 \$5613 \$10022 \$10282 \$10246 gf180mcu_fd_sc_mcu9t5v0__nand2_1
X$2759 \$5888 \$5613 \$6001 \$6105 \$6109 gf180mcu_fd_sc_mcu9t5v0__nand2_1
X$2760 \$8075 \$5613 \$8063 \$8183 \$8195 gf180mcu_fd_sc_mcu9t5v0__nand2_1
X$2761 \$6676 \$5613 \$7047 \$7160 \$7291 gf180mcu_fd_sc_mcu9t5v0__nand2_1
X$2762 \$10792 \$5613 \$10901 \$11025 \$11147 gf180mcu_fd_sc_mcu9t5v0__nand2_1
X$2763 \$11520 \$5613 \$11306 \$11555 \$11186 gf180mcu_fd_sc_mcu9t5v0__nand2_1
X$2764 \$6672 \$5613 \$7304 \$7160 \$7288 gf180mcu_fd_sc_mcu9t5v0__nand2_1
X$2765 \$10265 \$5613 \$10391 \$10282 \$10262 gf180mcu_fd_sc_mcu9t5v0__nand2_1
X$2766 \$10044 \$5613 \$10022 \$9900 \$10045 gf180mcu_fd_sc_mcu9t5v0__nand2_1
X$2767 \$11320 \$5613 \$11956 \$11827 \$11839 gf180mcu_fd_sc_mcu9t5v0__nand2_1
X$2768 \$10677 \$5613 \$10901 \$10782 \$10803 gf180mcu_fd_sc_mcu9t5v0__nand2_1
X$2769 \$11202 \$5613 \$11675 \$11555 \$11571 gf180mcu_fd_sc_mcu9t5v0__nand2_1
X$2770 \$8685 \$5613 \$8834 \$8717 \$8722 gf180mcu_fd_sc_mcu9t5v0__nand2_1
X$2771 \$12384 \$5613 \$12486 \$12376 \$12383 gf180mcu_fd_sc_mcu9t5v0__nand2_1
X$2772 \$11190 \$11306 \$11555 \$5613 gf180mcu_fd_sc_mcu9t5v0__buf_8
X$2773 \$7431 \$7304 \$7160 \$5632 gf180mcu_fd_sc_mcu9t5v0__buf_8
X$2774 \$5635 \$9102 \$8963 \$8858 gf180mcu_fd_sc_mcu9t5v0__clkinv_1
X$2775 \$7698 \$8976 \$5635 \$8834 \$8963 gf180mcu_fd_sc_mcu9t5v0__dffq_2
X$2776 \$7698 \$7704 \$5642 \$7797 \$7947 gf180mcu_fd_sc_mcu9t5v0__dffq_2
X$2777 \$5642 \$7593 \$7553 \$7526 \$7688 \$7704 gf180mcu_fd_sc_mcu9t5v0__mux2_1
X$2778 \$5731 \$7679 \$20041 \$19927 \$20087 \$19455
+ gf180mcu_fd_sc_mcu9t5v0__nor3_1
X$2779 \$5731 \$19724 \$19927 \$19774 \$19924 gf180mcu_fd_sc_mcu9t5v0__nor2_1
X$2780 \$5731 \$19605 \$19774 \$19725 gf180mcu_fd_sc_mcu9t5v0__clkinv_1
X$2781 \$5828 \$5833 \$5735 \$5731 gf180mcu_fd_sc_mcu9t5v0__buf_8
X$2782 \$5731 \$18701 \$18870 \$14449 gf180mcu_fd_sc_mcu9t5v0__buf_1
X$2783 \$14752 \$5731 \$13493 \$14454 \$14635 \$14497
+ gf180mcu_fd_sc_mcu9t5v0__mux2_1
X$2784 \$5735 \$5833 \$5871 gf180mcu_fd_sc_mcu9t5v0__tiel
X$2785 \$6768 \$5833 \$5735 \$5827 gf180mcu_fd_sc_mcu9t5v0__buf_1
X$2786 \$5827 \$5735 \$5833 \$5828 gf180mcu_fd_sc_mcu9t5v0__dlyc_1
X$2787 \$5833 \$5735 gf180mcu_fd_sc_mcu9t5v0__filltie
X$2788 \$5833 \$5735 gf180mcu_fd_sc_mcu9t5v0__filltie
X$2789 \$5833 \$5735 gf180mcu_fd_sc_mcu9t5v0__filltie
X$2790 \$5833 \$5735 gf180mcu_fd_sc_mcu9t5v0__filltie
X$2791 \$5833 \$5735 gf180mcu_fd_sc_mcu9t5v0__filltie
X$2792 \$5833 \$5735 gf180mcu_fd_sc_mcu9t5v0__filltie
X$2793 \$5833 \$5735 gf180mcu_fd_sc_mcu9t5v0__endcap
X$2794 \$10290 \$10289 \$5736 \$10391 \$10282 \$10041 \$10794
+ gf180mcu_fd_sc_mcu9t5v0__aoi22_4
X$2795 \$10638 \$10917 \$10290 \$10901 \$10782 \$10528 \$5736
+ gf180mcu_fd_sc_mcu9t5v0__aoi22_4
X$2796 \$9714 \$9748 \$9703 \$5736 gf180mcu_fd_sc_mcu9t5v0__buf_12
X$2797 \$8311 \$5736 \$5840 \$8572 \$8717 \$8686 gf180mcu_fd_sc_mcu9t5v0__and3_1
X$2798 \$10928 \$5736 \$10924 \$10901 \$11025 \$10804
+ gf180mcu_fd_sc_mcu9t5v0__and3_1
X$2799 \$7273 \$5736 \$5840 \$8572 \$8717 \$8728 gf180mcu_fd_sc_mcu9t5v0__and3_1
X$2800 \$10260 \$5736 \$10924 \$10022 \$10282 \$10261
+ gf180mcu_fd_sc_mcu9t5v0__and3_1
X$2801 \$12022 \$5736 \$10924 \$11956 \$11993 \$11974
+ gf180mcu_fd_sc_mcu9t5v0__and3_1
X$2802 \$6009 \$5736 \$5840 \$6001 \$6105 \$6111 gf180mcu_fd_sc_mcu9t5v0__and3_1
X$2803 \$7064 \$5736 \$5840 \$7047 \$7160 \$7180 gf180mcu_fd_sc_mcu9t5v0__and3_1
X$2804 \$8961 \$5736 \$5840 \$9102 \$8963 \$9078 gf180mcu_fd_sc_mcu9t5v0__and3_1
X$2805 \$6375 \$5736 \$10924 \$9608 \$9457 \$9466
+ gf180mcu_fd_sc_mcu9t5v0__and3_1
X$2806 \$5906 \$5736 \$5840 \$6001 \$5833 \$5907 gf180mcu_fd_sc_mcu9t5v0__and3_1
X$2807 \$7908 \$5736 \$11156 \$11306 \$11182 \$11321
+ gf180mcu_fd_sc_mcu9t5v0__and3_1
X$2808 \$9239 \$5736 \$11323 \$12486 \$12376 \$12497
+ gf180mcu_fd_sc_mcu9t5v0__and3_1
X$2809 \$9795 \$5736 \$11323 \$12486 \$12376 \$12495
+ gf180mcu_fd_sc_mcu9t5v0__and3_1
X$2810 \$11570 \$5736 \$11156 \$11675 \$11555 \$9786
+ gf180mcu_fd_sc_mcu9t5v0__and3_1
X$2811 \$6347 \$5736 \$5840 \$8063 \$7947 \$8071 gf180mcu_fd_sc_mcu9t5v0__and3_1
X$2812 \$6155 \$5736 \$5840 \$7304 \$7160 \$7289 gf180mcu_fd_sc_mcu9t5v0__and3_1
X$2813 \$7582 \$5736 \$5840 \$8063 \$7947 \$7924 gf180mcu_fd_sc_mcu9t5v0__and3_1
X$2814 \$6674 \$5736 \$5840 \$6770 \$6616 \$6636 gf180mcu_fd_sc_mcu9t5v0__and3_1
X$2815 \$5736 \$9593 \$8697 \$12486 \$12526 \$12553
+ gf180mcu_fd_sc_mcu9t5v0__aoi21_1
X$2816 \$5736 \$6928 \$8315 \$8301 \$8335 \$8348
+ gf180mcu_fd_sc_mcu9t5v0__aoi21_1
X$2817 \$5736 \$5840 \$7926 \$7797 \$7947 \$7925
+ gf180mcu_fd_sc_mcu9t5v0__aoi21_1
X$2818 \$5736 \$9593 \$9232 \$9608 \$9703 \$9728
+ gf180mcu_fd_sc_mcu9t5v0__aoi21_1
X$2819 \$5736 \$9593 \$11034 \$10901 \$11025 \$10927
+ gf180mcu_fd_sc_mcu9t5v0__aoi21_1
X$2820 \$5736 \$9593 \$11533 \$11306 \$11555 \$11534
+ gf180mcu_fd_sc_mcu9t5v0__aoi21_1
X$2821 \$5736 \$6928 \$8554 \$8572 \$8335 \$8553
+ gf180mcu_fd_sc_mcu9t5v0__aoi21_1
X$2822 \$5736 \$6928 \$7534 \$8063 \$7947 \$8192
+ gf180mcu_fd_sc_mcu9t5v0__aoi21_1
X$2823 \$5736 \$6928 \$7431 \$7304 \$7160 \$7292
+ gf180mcu_fd_sc_mcu9t5v0__aoi21_1
X$2824 \$5736 \$6928 \$8198 \$8301 \$8183 \$8318
+ gf180mcu_fd_sc_mcu9t5v0__aoi21_1
X$2825 \$5736 \$6928 \$8302 \$8834 \$8717 \$8723
+ gf180mcu_fd_sc_mcu9t5v0__aoi21_1
X$2826 \$5736 \$9593 \$12494 \$11956 \$11827 \$11973
+ gf180mcu_fd_sc_mcu9t5v0__aoi21_1
X$2827 \$5736 \$9593 \$12682 \$12786 \$12526 \$12550
+ gf180mcu_fd_sc_mcu9t5v0__aoi21_1
X$2828 \$5736 \$6928 \$8191 \$8834 \$8717 \$8727
+ gf180mcu_fd_sc_mcu9t5v0__aoi21_1
X$2829 \$5736 \$6928 \$9109 \$9337 \$9221 \$9229
+ gf180mcu_fd_sc_mcu9t5v0__aoi21_1
X$2830 \$5736 \$9593 \$10259 \$10022 \$9900 \$10048
+ gf180mcu_fd_sc_mcu9t5v0__aoi21_1
X$2831 \$12937 \$7937 \$5736 \$11323 \$11324 \$12786 \$12526 \$12496
+ gf180mcu_fd_sc_mcu9t5v0__aoi221_1
X$2832 \$7937 \$11198 \$5736 \$11323 \$11324 \$11306 \$11182 \$9592
+ gf180mcu_fd_sc_mcu9t5v0__aoi221_1
X$2833 \$5736 \$9593 \$11136 \$11182 \$11197 gf180mcu_fd_sc_mcu9t5v0__nand2_1
X$2834 \$5740 \$6001 \$5833 \$5902 gf180mcu_fd_sc_mcu9t5v0__clkinv_1
X$2835 \$15015 \$13881 \$14034 \$5741 gf180mcu_fd_sc_mcu9t5v0__buf_8
X$2836 \$5832 \$6344 \$6496 \$6136 \$6387 gf180mcu_fd_sc_mcu9t5v0__dffq_2
X$2837 \$5832 \$7798 \$7799 \$7797 \$7947 gf180mcu_fd_sc_mcu9t5v0__dffq_2
X$2838 \$5832 \$8303 \$8304 \$8301 \$8335 gf180mcu_fd_sc_mcu9t5v0__dffq_2
X$2839 \$5832 \$6137 \$6345 \$6136 \$6387 gf180mcu_fd_sc_mcu9t5v0__dffq_2
X$2840 \$5832 \$7048 \$7159 \$7047 \$7160 gf180mcu_fd_sc_mcu9t5v0__dffq_2
X$2841 \$5832 \$7796 \$7683 \$7797 \$7947 gf180mcu_fd_sc_mcu9t5v0__dffq_2
X$2842 \$5832 \$8298 \$8182 \$8301 \$8335 gf180mcu_fd_sc_mcu9t5v0__dffq_2
X$2843 \$5832 \$6771 \$6772 \$6770 \$6890 gf180mcu_fd_sc_mcu9t5v0__dffq_2
X$2844 \$5832 \$8962 \$8836 \$8834 \$8963 gf180mcu_fd_sc_mcu9t5v0__dffq_2
X$2845 \$5832 \$7795 \$7563 \$7797 \$7947 gf180mcu_fd_sc_mcu9t5v0__dffq_2
X$2846 \$5832 \$7271 \$7156 \$7304 \$7160 gf180mcu_fd_sc_mcu9t5v0__dffq_2
X$2847 \$5832 \$9216 \$9217 \$9337 \$9221 gf180mcu_fd_sc_mcu9t5v0__dffq_2
X$2848 \$5832 \$8532 \$8533 \$8572 \$8335 gf180mcu_fd_sc_mcu9t5v0__dffq_2
X$2849 \$5832 \$7909 \$7910 \$8063 \$7947 gf180mcu_fd_sc_mcu9t5v0__dffq_2
X$2850 \$5832 \$8959 \$8960 \$9102 \$8963 gf180mcu_fd_sc_mcu9t5v0__dffq_2
X$2851 \$5832 \$8534 \$8535 \$8572 \$8335 gf180mcu_fd_sc_mcu9t5v0__dffq_2
X$2852 \$5832 \$8184 \$8187 \$8301 \$8183 gf180mcu_fd_sc_mcu9t5v0__dffq_2
X$2853 \$5832 \$7684 \$7685 \$7797 \$7688 gf180mcu_fd_sc_mcu9t5v0__dffq_2
X$2854 \$5832 \$7157 \$7158 \$7304 \$7160 gf180mcu_fd_sc_mcu9t5v0__dffq_2
X$2855 \$5898 \$5899 \$6014 \$6154 \$6001 \$5833 \$5897
+ gf180mcu_fd_sc_mcu9t5v0__aoi22_1
X$2856 \$5833 \$6001 gf180mcu_fd_sc_mcu9t5v0__filltie
X$2857 \$5833 \$6001 gf180mcu_fd_sc_mcu9t5v0__filltie
X$2858 \$5833 \$6001 gf180mcu_fd_sc_mcu9t5v0__filltie
X$2859 \$5833 \$6001 gf180mcu_fd_sc_mcu9t5v0__filltie
X$2860 \$5833 \$6001 gf180mcu_fd_sc_mcu9t5v0__filltie
X$2861 \$5833 \$6001 gf180mcu_fd_sc_mcu9t5v0__filltie
X$2862 \$5891 \$5849 \$5892 \$6001 \$5833 gf180mcu_fd_sc_mcu9t5v0__dffq_2
X$2863 \$5833 \$6001 gf180mcu_fd_sc_mcu9t5v0__endcap
X$2864 \$6619 \$6007 \$5839 \$6001 \$6105 gf180mcu_fd_sc_mcu9t5v0__dffq_2
X$2865 \$11156 \$10391 \$10514 \$5840 gf180mcu_fd_sc_mcu9t5v0__buf_20
X$2866 \$10910 \$10911 \$5840 \$10901 \$11025 \$11148
+ gf180mcu_fd_sc_mcu9t5v0__and3_1
X$2867 \$11567 \$10911 \$5840 \$10901 \$10782 \$10913
+ gf180mcu_fd_sc_mcu9t5v0__and3_1
X$2868 \$10397 \$10911 \$5840 \$10391 \$10282 \$10399
+ gf180mcu_fd_sc_mcu9t5v0__and3_1
X$2869 \$10911 \$5840 \$9904 \$10022 \$10282 \$10034
+ gf180mcu_fd_sc_mcu9t5v0__aoi21_1
X$2870 \$10911 \$5840 \$10240 \$10901 \$10782 \$11149
+ gf180mcu_fd_sc_mcu9t5v0__aoi21_1
X$2871 \$7938 \$7937 \$6932 \$5840 \$7929 \$8834 \$8963 \$8974
+ gf180mcu_fd_sc_mcu9t5v0__aoi221_1
X$2872 \$7965 \$7937 \$6932 \$5840 \$7929 \$7797 \$7947 \$7939
+ gf180mcu_fd_sc_mcu9t5v0__aoi221_1
X$2873 \$7936 \$7937 \$6932 \$5840 \$7929 \$8301 \$8335 \$8354
+ gf180mcu_fd_sc_mcu9t5v0__aoi221_1
X$2874 \$7931 \$7937 \$6932 \$5840 \$7929 \$8063 \$7947 \$7964
+ gf180mcu_fd_sc_mcu9t5v0__aoi221_1
X$2875 \$23144 \$23183 \$23454 \$5844 \$23328 gf180mcu_fd_sc_mcu9t5v0__xor2_1
X$2876 \$16851 \$5844 \$23183 \$23139 \$23193 gf180mcu_fd_sc_mcu9t5v0__nand2_1
X$2877 \$9711 \$11136 \$11182 \$5860 gf180mcu_fd_sc_mcu9t5v0__clkbuf_8
X$2878 \$11208 \$11535 \$5860 \$11306 \$11555 \$11573
+ gf180mcu_fd_sc_mcu9t5v0__mux2_2
X$2879 \$10293 \$10263 \$5860 \$10022 \$10282 \$10264
+ gf180mcu_fd_sc_mcu9t5v0__mux2_2
X$2880 \$12275 \$12028 \$5860 \$11956 \$11993 \$12029
+ gf180mcu_fd_sc_mcu9t5v0__mux2_2
X$2881 \$9782 \$9785 \$5860 \$9748 \$9703 \$9784 gf180mcu_fd_sc_mcu9t5v0__mux2_2
X$2882 \$10535 \$10643 \$5860 \$10630 \$10514 \$10644
+ gf180mcu_fd_sc_mcu9t5v0__mux2_2
X$2883 \$6370 \$6637 \$5860 \$6497 \$6387 \$6521 gf180mcu_fd_sc_mcu9t5v0__mux2_2
X$2884 \$7317 \$7430 \$5860 \$7304 \$7160 \$7290 gf180mcu_fd_sc_mcu9t5v0__mux2_2
X$2885 \$5870 \$10901 \$10782 \$10648 gf180mcu_fd_sc_mcu9t5v0__clkinv_1
X$2886 \$11038 \$10649 \$5870 \$10630 \$10782 gf180mcu_fd_sc_mcu9t5v0__dffq_2
X$2887 \$7183 pad_din[1] \$I20747 \$I20765 \$I20756 \$I20774 \$I20783 \$I20801
+ \$I20792 \$I20810 \$I20819 \$I20837 \$I20828 \$I20846 \$I20855 \$I20864
+ \$I20873 \$I20882 \$I20891 \$I20900 \$I20909 \$I20918 \$I20927 \$I20936
+ \$I20945 \$I20954 \$I20963 \$I20981 \$I20972 \$I20990 \$I20999 \$I21017
+ \$I21008 \$I21026 \$I21044 \$I21035 \$I21053 \$I21062 \$I21071 \$I21089
+ \$I21080 \$I21098 \$I21107 \$I21116 \$I21125 \$I21134 \$I21143 \$I21161
+ \$I21152 \$I21170 \$I21179 \$I21197 \$I21188 \$I21206 \$I21215 \$I21233
+ \$I21224 \$I21242 \$I21251 \$I21269 \$I21260 \$I21278 \$I21287 \$I21296
+ \$I21305 \$I21314 \$I21323 \$I21332 \$I21341 \$I21350 \$I21368 \$I21377
+ \$I21404 \$I21413 \$I21359 \$I21395 \$I21386 \$I21431 \$I21422 \$I21458
+ \$I21449 \$I21467 \$I21440 \$I21485 \$I21476 \$I21494 \$I21512 \$I21539
+ \$I21548 \$I21557 \$I21503 \$I21530 \$I21521 \$I21575 \$I21566 \$I21584
+ \$I21593 \$I21602 \$I21611 \$I21620 \$I21629 \$I21638 \$5871 \$I21647
+ \$I21665 \$I21656 \$I21674 \$5871 \$6883 gf180mcu_fd_io__in_c
X$2888 \$6104 \$6103 \$5877 \$6001 \$6105 gf180mcu_fd_sc_mcu9t5v0__dffq_2
X$2889 \$6104 \$5999 \$5878 \$6001 \$6105 gf180mcu_fd_sc_mcu9t5v0__dffq_2
X$2890 \$5883 \$6497 \$6616 \$6502 gf180mcu_fd_sc_mcu9t5v0__clkinv_1
X$2891 \$13230 \$14048 \$5888 \$13471 \$13881 \$14034
+ gf180mcu_fd_sc_mcu9t5v0__dffrnq_2
X$2892 \$5888 \$6663 \$6659 \$6658 \$6770 \$6616 \$6660
+ gf180mcu_fd_sc_mcu9t5v0__oai22_1
X$2893 \$5888 \$14211 \$14151 \$14337 \$14221 gf180mcu_fd_sc_mcu9t5v0__nand2_1
X$2894 \$5888 \$12912 \$14151 \$14034 \$14169 gf180mcu_fd_sc_mcu9t5v0__nand2_1
X$2895 \$5890 \$9608 \$9703 gf180mcu_fd_sc_mcu9t5v0__clkinv_8
X$2896 \$12483 \$9457 \$9608 \$5890 gf180mcu_fd_sc_mcu9t5v0__clkbuf_16
X$2897 \$5890 \$10901 \$11025 \$9760 gf180mcu_fd_sc_mcu9t5v0__clkbuf_8
X$2898 \$5890 \$7797 \$7947 \$5891 gf180mcu_fd_sc_mcu9t5v0__clkbuf_8
X$2899 \$5890 \$15949 \$16070 \$15629 gf180mcu_fd_sc_mcu9t5v0__clkbuf_8
X$2900 \$5890 \$8572 \$8717 \$7278 gf180mcu_fd_sc_mcu9t5v0__clkbuf_8
X$2901 \$5890 \$16436 \$16376 \$15329 gf180mcu_fd_sc_mcu9t5v0__clkbuf_8
X$2902 \$5891 \$7797 \$7688 \$I71627 gf180mcu_fd_sc_mcu9t5v0__inv_2
X$2903 \$5891 \$8551 \$7928 \$8572 \$8717 gf180mcu_fd_sc_mcu9t5v0__dffq_2
X$2904 \$5891 \$9357 \$9460 \$9337 \$9457 gf180mcu_fd_sc_mcu9t5v0__dffq_2
X$2905 \$5891 \$9079 \$9108 \$9102 \$9221 gf180mcu_fd_sc_mcu9t5v0__dffq_2
X$2906 \$5891 \$8073 \$7277 \$8063 \$8183 gf180mcu_fd_sc_mcu9t5v0__dffq_2
X$2907 \$5891 \$8545 \$7916 \$8572 \$8717 gf180mcu_fd_sc_mcu9t5v0__dffq_2
X$2908 \$5891 \$8966 \$7544 \$8834 \$8963 gf180mcu_fd_sc_mcu9t5v0__dffq_2
X$2909 \$5891 \$7284 \$7174 \$7304 \$7160 gf180mcu_fd_sc_mcu9t5v0__dffq_2
X$2910 \$5891 \$7693 \$7581 \$7797 \$7688 gf180mcu_fd_sc_mcu9t5v0__dffq_2
X$2911 \$5891 \$6393 \$6364 \$6497 \$6387 gf180mcu_fd_sc_mcu9t5v0__dffq_2
X$2912 \$10635 \$10630 \$10514 \$5904 gf180mcu_fd_sc_mcu9t5v0__buf_8
X$2913 \$13465 \$13226 \$13468 \$13341 \$13452 \$5906
+ gf180mcu_fd_sc_mcu9t5v0__aoi21_1
X$2914 \$5906 \$6662 \$7811 \$6663 \$7797 \$7688 \$7816
+ gf180mcu_fd_sc_mcu9t5v0__oai31_1
X$2915 \$5909 \$23339 \$23620 \$23454 \$23640 gf180mcu_fd_sc_mcu9t5v0__xnor2_1
X$2916 \$16851 \$5909 \$23183 \$23454 \$23470 gf180mcu_fd_sc_mcu9t5v0__nand2_1
X$2917 \$19903 \$19042 \$19165 \$5912 \$19927 \$19774 \$19482
+ gf180mcu_fd_sc_mcu9t5v0__aoi22_1
X$2918 \$6105 \$6001 gf180mcu_fd_sc_mcu9t5v0__filltie
X$2919 \$6105 \$6001 gf180mcu_fd_sc_mcu9t5v0__filltie
X$2920 \$6105 \$6001 gf180mcu_fd_sc_mcu9t5v0__filltie
X$2921 \$6105 \$6001 gf180mcu_fd_sc_mcu9t5v0__filltie
X$2922 \$6105 \$6001 gf180mcu_fd_sc_mcu9t5v0__filltie
X$2923 \$6105 \$6001 gf180mcu_fd_sc_mcu9t5v0__filltie
X$2924 \$6105 \$6001 gf180mcu_fd_sc_mcu9t5v0__endcap
X$2925 \$6003 \$7304 \$7417 \$7313 gf180mcu_fd_sc_mcu9t5v0__clkinv_1
X$2926 \$7278 \$7424 \$6003 \$7526 \$7417 gf180mcu_fd_sc_mcu9t5v0__dffq_2
X$2927 \$22838 \$19154 \$21663 \$6004 \$22713 \$22837 \$22718
+ gf180mcu_fd_sc_mcu9t5v0__aoi22_1
X$2928 \$6008 \$6356 \$6390 \$6136 \$6387 \$6355 gf180mcu_fd_sc_mcu9t5v0__and3_1
X$2929 \$6009 \$6662 \$7811 \$6663 \$6770 \$6890 \$6783
+ gf180mcu_fd_sc_mcu9t5v0__oai31_1
X$2930 \$6015 \$11728 \$11696 \$11675 \$11555 \$11552
+ gf180mcu_fd_sc_mcu9t5v0__aoi21_1
X$2931 \$6015 \$9777 \$9608 \$9703 \$9723 gf180mcu_fd_sc_mcu9t5v0__nand2_1
X$2932 \$6015 \$6398 \$6497 \$6387 \$6396 gf180mcu_fd_sc_mcu9t5v0__nand2_1
X$2933 \$6015 \$8583 \$8572 \$8335 \$8564 gf180mcu_fd_sc_mcu9t5v0__nand2_1
X$2934 \$6015 \$9778 \$9748 \$9703 \$9776 gf180mcu_fd_sc_mcu9t5v0__nand2_1
X$2935 \$7184 pad_dout[2] \$I20746 \$I20755 \$I20764 \$I20773 \$I20782 \$I20791
+ \$I20800 \$I20809 \$I20818 \$I20827 \$I20836 \$I20845 \$I20854 \$I20863
+ \$I20872 \$I20881 \$I20890 \$I20899 \$I20908 \$I20917 \$I20926 \$I20935
+ \$I20944 \$I20953 \$I20962 \$I20971 \$I20980 \$I20989 \$I20998 \$I21007
+ \$I21016 \$I21025 \$I21034 \$I21043 \$I21052 \$I21061 \$I21070 \$I21079
+ \$I21088 \$I21097 \$I21106 \$I21115 \$I21124 \$I21133 \$I21142 \$I21151
+ \$I21160 \$I21169 \$I21178 \$I21187 \$I21196 \$I21205 \$I21214 \$I21223
+ \$I21232 \$I21241 \$I21250 \$I21259 \$I21268 \$I21277 \$I21286 \$I21295
+ \$I21304 \$I21313 \$6127 \$I21322 \$I21331 \$I21340 \$I21349 \$I21358
+ \$I21367 \$I21376 \$I21385 \$I21394 \$I21403 \$I21412 \$I21421 \$I21430
+ \$I21439 \$I21448 \$I21457 \$I21466 \$I21475 \$I21484 \$I21493 \$I21502
+ \$I21511 \$I21520 \$I21529 \$I21538 \$I21547 \$I21556 \$I21565 \$I21574
+ \$I21583 \$I21592 \$I21601 \$6018 \$I21610 \$I21619 \$I21628 \$I21637
+ \$I21646 \$I21655 \$I21664 \$I21673 \$6018 \$6018 \$6127 \$6018 \$6018 \$7697
+ \$6127 gf180mcu_fd_io__bi_t
X$2936 \$7797 \$7688 \$6018 gf180mcu_fd_sc_mcu9t5v0__tiel
X$2937 \$6104 \$7047 \$6890 \$I68965 gf180mcu_fd_sc_mcu9t5v0__inv_1
X$2938 \$6104 \$7793 \$7906 \$7797 \$7947 gf180mcu_fd_sc_mcu9t5v0__dffq_2
X$2939 \$6104 \$6340 \$6341 \$6136 \$6387 gf180mcu_fd_sc_mcu9t5v0__dffq_2
X$2940 \$6104 \$7302 \$7269 \$7304 \$7417 gf180mcu_fd_sc_mcu9t5v0__dffq_2
X$2941 \$6104 \$6643 \$6887 \$6770 \$6890 gf180mcu_fd_sc_mcu9t5v0__dffq_2
X$2942 \$6104 \$6920 \$6888 \$6770 \$6890 gf180mcu_fd_sc_mcu9t5v0__dffq_2
X$2943 \$6104 \$6889 \$6646 \$6770 \$6890 gf180mcu_fd_sc_mcu9t5v0__dffq_2
X$2944 \$6104 \$6769 \$6641 \$6770 \$6890 gf180mcu_fd_sc_mcu9t5v0__dffq_2
X$2945 \$6104 \$6494 \$6613 \$6497 \$6616 gf180mcu_fd_sc_mcu9t5v0__dffq_2
X$2946 \$6104 \$8570 \$8531 \$8572 \$8717 gf180mcu_fd_sc_mcu9t5v0__dffq_2
X$2947 \$6104 \$7412 \$7303 \$7526 \$7417 gf180mcu_fd_sc_mcu9t5v0__dffq_2
X$2948 \$6104 \$6381 \$6382 \$6497 \$6387 gf180mcu_fd_sc_mcu9t5v0__dffq_2
X$2949 \$6104 \$6383 \$6384 \$6497 \$6387 gf180mcu_fd_sc_mcu9t5v0__dffq_2
X$2950 \$6104 \$7681 \$7682 \$7797 \$7688 gf180mcu_fd_sc_mcu9t5v0__dffq_2
X$2951 \$6104 \$6884 \$6885 \$7047 \$6890 gf180mcu_fd_sc_mcu9t5v0__dffq_2
X$2952 \$6104 \$8180 \$8181 \$8301 \$8183 gf180mcu_fd_sc_mcu9t5v0__dffq_2
X$2953 \$6104 \$7409 \$7410 \$7526 \$7417 gf180mcu_fd_sc_mcu9t5v0__dffq_2
X$2954 \$6104 \$7155 \$7270 \$7304 \$7160 gf180mcu_fd_sc_mcu9t5v0__dffq_2
X$2955 \$6150 \$6356 \$6390 \$6136 \$6105 \$6151 gf180mcu_fd_sc_mcu9t5v0__and3_1
X$2956 \$6357 \$6356 \$6390 \$6136 \$6105 \$6149 gf180mcu_fd_sc_mcu9t5v0__and3_1
X$2957 \$6105 \$6136 gf180mcu_fd_sc_mcu9t5v0__filltie
X$2958 \$6105 \$6136 gf180mcu_fd_sc_mcu9t5v0__filltie
X$2959 \$6105 \$6136 gf180mcu_fd_sc_mcu9t5v0__filltie
X$2960 \$6105 \$6136 gf180mcu_fd_sc_mcu9t5v0__filltie
X$2961 \$6105 \$6136 gf180mcu_fd_sc_mcu9t5v0__filltie
X$2962 \$6105 \$6136 gf180mcu_fd_sc_mcu9t5v0__filltie
X$2963 \$6105 \$6136 gf180mcu_fd_sc_mcu9t5v0__endcap
X$2964 \$7278 \$6147 \$6107 \$6136 \$6387 gf180mcu_fd_sc_mcu9t5v0__dffq_2
X$2965 \$10407 \$10391 \$10282 \$6110 gf180mcu_fd_sc_mcu9t5v0__clkbuf_8
X$2966 \$7926 \$7797 \$7947 \$6113 gf180mcu_fd_sc_mcu9t5v0__buf_8
X$2967 \$7698 \$6156 \$6120 \$6136 \$6387 gf180mcu_fd_sc_mcu9t5v0__dffq_2
X$2968 \$6397 \$6122 \$6396 \$6158 \$6497 \$6387 \$6523
+ gf180mcu_fd_sc_mcu9t5v0__aoi22_1
X$2969 \$8194 \$9102 \$9221 \$6125 gf180mcu_fd_sc_mcu9t5v0__buf_8
X$2970 \$6375 \$6374 \$6125 \$6136 \$6387 \$6403 gf180mcu_fd_sc_mcu9t5v0__mux2_1
X$2971 \$8695 \$8697 \$6125 \$8834 \$8963 \$8699 gf180mcu_fd_sc_mcu9t5v0__mux2_1
X$2972 \$9736 \$9735 \$6125 \$9608 \$9703 \$9474 gf180mcu_fd_sc_mcu9t5v0__mux2_1
X$2973 \$10227 \$7592 \$6125 \$7526 \$7688 \$7703
+ gf180mcu_fd_sc_mcu9t5v0__mux2_1
X$2974 \$8968 \$8853 \$6125 \$9102 \$8963 \$9081 gf180mcu_fd_sc_mcu9t5v0__mux2_1
X$2975 \$9239 \$9235 \$6125 \$9337 \$9221 \$9093 gf180mcu_fd_sc_mcu9t5v0__mux2_1
X$2976 \$9775 \$10667 \$6125 \$9748 \$9703 \$9718
+ gf180mcu_fd_sc_mcu9t5v0__mux2_1
X$2977 \$9795 \$9917 \$6125 \$9748 \$9703 \$9797 gf180mcu_fd_sc_mcu9t5v0__mux2_1
X$2978 \$7908 \$7557 \$6125 \$7526 \$7417 \$7556 gf180mcu_fd_sc_mcu9t5v0__mux2_1
X$2979 \$7797 \$7688 \$6127 gf180mcu_fd_sc_mcu9t5v0__tieh
X$2980 \$13515 \$6132 \$9736 \$13510 \$13623 \$13452 \$13511
+ gf180mcu_fd_sc_mcu9t5v0__aoi22_1
X$2981 \$6913 \$6132 \$6343 \$7047 \$6890 \$7045 gf180mcu_fd_sc_mcu9t5v0__mux2_1
X$2982 \$13351 \$13465 \$13350 \$13623 \$13452 \$6132
+ gf180mcu_fd_sc_mcu9t5v0__mux2_1
X$2983 \$6361 \$6356 \$6390 \$6136 \$6387 \$6362 gf180mcu_fd_sc_mcu9t5v0__and3_1
X$2984 \$6359 \$6356 \$6390 \$6136 \$6387 \$6360 gf180mcu_fd_sc_mcu9t5v0__and3_1
X$2985 \$6505 \$6354 \$6355 \$6136 \$6387 \$6148
+ gf180mcu_fd_sc_mcu9t5v0__aoi21_1
X$2986 \$6366 \$6367 \$6394 \$6136 \$6387 gf180mcu_fd_sc_mcu9t5v0__dffq_2
X$2987 \$6387 \$6136 gf180mcu_fd_sc_mcu9t5v0__filltie
X$2988 \$6387 \$6136 gf180mcu_fd_sc_mcu9t5v0__filltie
X$2989 \$6387 \$6136 gf180mcu_fd_sc_mcu9t5v0__filltie
X$2990 \$6387 \$6136 gf180mcu_fd_sc_mcu9t5v0__filltie
X$2991 \$6387 \$6136 gf180mcu_fd_sc_mcu9t5v0__filltie
X$2992 \$6387 \$6136 gf180mcu_fd_sc_mcu9t5v0__filltie
X$2993 \$6387 \$6136 gf180mcu_fd_sc_mcu9t5v0__endcap
X$2994 \$14339 \$6141 \$19029 \$18873 \$19027 \$18870 \$18995
+ gf180mcu_fd_sc_mcu9t5v0__oai211_1
X$2995 \$23143 \$6143 \$23027 \$23139 \$23459 gf180mcu_fd_sc_mcu9t5v0__xnor2_1
X$2996 \$16851 \$6143 \$23027 \$22837 \$22894 gf180mcu_fd_sc_mcu9t5v0__nand2_1
X$2997 \$6505 \$6504 \$6149 \$6497 \$6387 \$6358
+ gf180mcu_fd_sc_mcu9t5v0__aoi21_1
X$2998 \$6505 \$6506 \$6151 \$6497 \$6387 \$6363
+ gf180mcu_fd_sc_mcu9t5v0__aoi21_1
X$2999 \$13460 \$13350 \$16603 \$16436 \$16728 \$6155
+ gf180mcu_fd_sc_mcu9t5v0__aoi21_1
X$3000 \$6155 \$6662 \$7811 \$6663 \$7797 \$7947 \$7932
+ gf180mcu_fd_sc_mcu9t5v0__oai31_1
X$3001 \$14217 \$6155 \$15628 \$15749 \$15762 gf180mcu_fd_sc_mcu9t5v0__nand2_1
X$3002 \$13508 \$13623 \$13729 \$6343 gf180mcu_fd_sc_mcu9t5v0__buf_8
X$3003 \$11171 \$8186 \$6343 \$11136 \$11182 \$11170
+ gf180mcu_fd_sc_mcu9t5v0__mux2_1
X$3004 \$10655 \$10027 \$6343 \$10630 \$10782 \$10774
+ gf180mcu_fd_sc_mcu9t5v0__mux2_1
X$3005 \$11173 \$10241 \$6343 \$11136 \$11182 \$11172
+ gf180mcu_fd_sc_mcu9t5v0__mux2_1
X$3006 \$10229 \$10227 \$6343 \$10022 \$10282 \$10228
+ gf180mcu_fd_sc_mcu9t5v0__mux2_1
X$3007 \$11507 \$9795 \$6343 \$11306 \$11555 \$11549
+ gf180mcu_fd_sc_mcu9t5v0__mux2_1
X$3008 \$11511 \$9775 \$6343 \$11136 \$11182 \$11510
+ gf180mcu_fd_sc_mcu9t5v0__mux2_1
X$3009 \$9452 \$8968 \$6343 \$9337 \$9457 \$9451 gf180mcu_fd_sc_mcu9t5v0__mux2_1
X$3010 \$9746 \$6375 \$6343 \$9748 \$9703 \$9745 gf180mcu_fd_sc_mcu9t5v0__mux2_1
X$3011 \$7269 \$6380 \$6343 \$7304 \$7160 \$7302 gf180mcu_fd_sc_mcu9t5v0__mux2_1
X$3012 \$12134 \$10902 \$6343 \$12260 \$11993 \$12261
+ gf180mcu_fd_sc_mcu9t5v0__mux2_1
X$3013 \$12524 \$8961 \$6343 \$12486 \$12376 \$12485
+ gf180mcu_fd_sc_mcu9t5v0__mux2_1
X$3014 \$7945 \$6347 \$6343 \$8063 \$7947 \$8059 gf180mcu_fd_sc_mcu9t5v0__mux2_1
X$3015 \$7683 \$7908 \$6343 \$7797 \$7688 \$7796 gf180mcu_fd_sc_mcu9t5v0__mux2_1
X$3016 \$8182 \$8695 \$6343 \$8301 \$8183 \$8298 gf180mcu_fd_sc_mcu9t5v0__mux2_1
X$3017 \$10777 \$9239 \$6343 \$10630 \$10514 \$10627
+ gf180mcu_fd_sc_mcu9t5v0__mux2_1
X$3018 \$11955 \$7273 \$6343 \$11956 \$11827 \$11991
+ gf180mcu_fd_sc_mcu9t5v0__mux2_1
X$3019 \$11550 \$9736 \$6343 \$11675 \$11555 \$11672
+ gf180mcu_fd_sc_mcu9t5v0__mux2_1
X$3020 \$14036 \$14158 \$13498 \$14151 \$14034 \$6346
+ gf180mcu_fd_sc_mcu9t5v0__mux2_1
X$3021 \$6347 \$6932 \$7576 \$8301 \$8183 \$7956
+ gf180mcu_fd_sc_mcu9t5v0__nand3_1
X$3022 \$6347 \$6770 \$6890 \$6657 gf180mcu_fd_sc_mcu9t5v0__clkinv_1
X$3023 \$14458 \$14459 \$13226 \$14454 \$14337 \$6347
+ gf180mcu_fd_sc_mcu9t5v0__mux2_1
X$3024 \$8573 \$6356 \$6390 \$8572 \$8717 \$8540 gf180mcu_fd_sc_mcu9t5v0__and3_1
X$3025 \$7584 \$6356 \$6390 \$7526 \$7688 \$7583 gf180mcu_fd_sc_mcu9t5v0__and3_1
X$3026 \$7921 \$6356 \$6390 \$7797 \$7947 \$7922 gf180mcu_fd_sc_mcu9t5v0__and3_1
X$3027 \$7590 \$6356 \$6390 \$7526 \$7688 \$7589 gf180mcu_fd_sc_mcu9t5v0__and3_1
X$3028 \$7312 \$6356 \$6390 \$7304 \$7417 \$7575 gf180mcu_fd_sc_mcu9t5v0__and3_1
X$3029 \$10673 \$6356 \$6390 \$10630 \$10782 \$10805
+ gf180mcu_fd_sc_mcu9t5v0__and3_1
X$3030 \$9709 \$6356 \$6390 \$9608 \$9703 \$9710 gf180mcu_fd_sc_mcu9t5v0__and3_1
X$3031 \$7586 \$6356 \$6390 \$7526 \$7688 \$7815 gf180mcu_fd_sc_mcu9t5v0__and3_1
X$3032 \$9111 \$6356 \$6390 \$9102 \$8963 \$9228 gf180mcu_fd_sc_mcu9t5v0__and3_1
X$3033 \$6502 \$6356 \$6390 \$6497 \$6387 \$6503 gf180mcu_fd_sc_mcu9t5v0__and3_1
X$3034 \$8851 \$6356 \$6390 \$8834 \$8717 \$8852 gf180mcu_fd_sc_mcu9t5v0__and3_1
X$3035 \$8081 \$6356 \$6390 \$8063 \$7947 \$7940 gf180mcu_fd_sc_mcu9t5v0__and3_1
X$3036 \$8319 \$6356 \$6390 \$8301 \$8183 \$8320 gf180mcu_fd_sc_mcu9t5v0__and3_1
X$3037 \$7812 \$6356 \$6390 \$7797 \$7688 \$7935 gf180mcu_fd_sc_mcu9t5v0__and3_1
X$3038 \$6507 \$6356 \$6390 \$6497 \$6387 \$6668 gf180mcu_fd_sc_mcu9t5v0__and3_1
X$3039 \$8858 \$6356 \$6390 \$8834 \$8717 \$9087 gf180mcu_fd_sc_mcu9t5v0__and3_1
X$3040 \$10400 \$6356 \$6390 \$10391 \$10282 \$10401
+ gf180mcu_fd_sc_mcu9t5v0__and3_1
X$3041 \$11688 \$6356 \$6390 \$11675 \$11555 \$11689
+ gf180mcu_fd_sc_mcu9t5v0__and3_1
X$3042 \$10641 \$6356 \$6390 \$10630 \$10514 \$10642
+ gf180mcu_fd_sc_mcu9t5v0__and3_1
X$3043 \$11965 \$11675 \$11827 \$6356 gf180mcu_fd_sc_mcu9t5v0__buf_8
X$3044 \$6505 \$6622 \$6360 \$6497 \$6616 \$6391
+ gf180mcu_fd_sc_mcu9t5v0__aoi21_1
X$3045 \$6505 \$6624 \$6362 \$6497 \$6616 \$6392
+ gf180mcu_fd_sc_mcu9t5v0__aoi21_1
X$3046 \$6366 \$8301 \$8183 gf180mcu_fd_sc_mcu9t5v0__clkinv_8
X$3047 \$6366 \$7934 \$6514 \$7797 \$7947 gf180mcu_fd_sc_mcu9t5v0__dffq_2
X$3048 \$6366 \$8855 \$8856 \$8834 \$8963 gf180mcu_fd_sc_mcu9t5v0__dffq_2
X$3049 \$6366 \$9230 \$9231 \$9102 \$9221 gf180mcu_fd_sc_mcu9t5v0__dffq_2
X$3050 \$6366 \$8076 \$7546 \$8063 \$8183 gf180mcu_fd_sc_mcu9t5v0__dffq_2
X$3051 \$6366 \$7427 \$6788 \$7526 \$7417 gf180mcu_fd_sc_mcu9t5v0__dffq_2
X$3052 \$6366 \$7176 \$6670 \$7304 \$7160 gf180mcu_fd_sc_mcu9t5v0__dffq_2
X$3053 \$6366 \$8970 \$9083 \$9102 \$8963 gf180mcu_fd_sc_mcu9t5v0__dffq_2
X$3054 \$6366 \$9085 \$6952 \$9102 \$8963 gf180mcu_fd_sc_mcu9t5v0__dffq_2
X$3055 \$6366 \$9115 \$9116 \$9102 \$8963 gf180mcu_fd_sc_mcu9t5v0__dffq_2
X$3056 \$6366 \$9082 \$9359 \$9102 \$8963 gf180mcu_fd_sc_mcu9t5v0__dffq_2
X$3057 \$7698 \$6521 \$6370 \$6497 \$6616 gf180mcu_fd_sc_mcu9t5v0__dffq_2
X$3058 \$9596 \$9337 \$9221 \$6374 gf180mcu_fd_sc_mcu9t5v0__buf_8
X$3059 \$6374 \$8703 \$10258 \$9337 \$9457 \$9472
+ gf180mcu_fd_sc_mcu9t5v0__mux2_1
X$3060 \$6375 \$6662 \$7811 \$9337 \$9457 \$9362 gf180mcu_fd_sc_mcu9t5v0__nor3_1
X$3061 \$13849 \$6375 \$13633 \$13887 \$8557 \$13632 \$13881 \$13729 \$13896
+ gf180mcu_fd_sc_mcu9t5v0__aoi222_1
X$3062 \$14011 \$13867 \$13226 \$13881 \$13729 \$6375
+ gf180mcu_fd_sc_mcu9t5v0__mux2_1
X$3063 \$13462 \$13461 \$13226 \$13341 \$13452 \$6380
+ gf180mcu_fd_sc_mcu9t5v0__mux2_1
X$3064 \$6387 \$6497 gf180mcu_fd_sc_mcu9t5v0__filltie
X$3065 \$6387 \$6497 gf180mcu_fd_sc_mcu9t5v0__filltie
X$3066 \$6387 \$6497 gf180mcu_fd_sc_mcu9t5v0__filltie
X$3067 \$6387 \$6497 gf180mcu_fd_sc_mcu9t5v0__filltie
X$3068 \$6387 \$6497 gf180mcu_fd_sc_mcu9t5v0__filltie
X$3069 \$6387 \$6497 gf180mcu_fd_sc_mcu9t5v0__filltie
X$3070 \$6387 \$6497 gf180mcu_fd_sc_mcu9t5v0__endcap
X$3071 \$6619 \$6500 \$6388 \$6497 \$6616 gf180mcu_fd_sc_mcu9t5v0__dffq_2
X$3072 \$12012 \$11956 \$11993 \$6390 gf180mcu_fd_sc_mcu9t5v0__buf_8
X$3073 \$13078 \$14746 \$6492 \$14748 \$14635 \$14745
+ gf180mcu_fd_sc_mcu9t5v0__nand3_1
X$3074 \$13078 \$15043 \$6495 \$15045 \$15204 \$15148
+ gf180mcu_fd_sc_mcu9t5v0__nand3_1
X$3075 \$6632 \$6497 \$6616 \$6517 gf180mcu_fd_sc_mcu9t5v0__clkinv_1
X$3076 \$6616 \$6497 gf180mcu_fd_sc_mcu9t5v0__filltie
X$3077 \$6616 \$6497 gf180mcu_fd_sc_mcu9t5v0__filltie
X$3078 \$6616 \$6497 gf180mcu_fd_sc_mcu9t5v0__filltie
X$3079 \$6616 \$6497 gf180mcu_fd_sc_mcu9t5v0__filltie
X$3080 \$6616 \$6497 gf180mcu_fd_sc_mcu9t5v0__filltie
X$3081 \$6616 \$6497 gf180mcu_fd_sc_mcu9t5v0__filltie
X$3082 \$6616 \$6497 gf180mcu_fd_sc_mcu9t5v0__endcap
X$3083 \$6505 \$6660 \$6503 \$6770 \$6616 \$6661
+ gf180mcu_fd_sc_mcu9t5v0__aoi21_1
X$3084 \$6505 \$7954 \$7922 \$8063 \$8183 \$7955
+ gf180mcu_fd_sc_mcu9t5v0__aoi21_1
X$3085 \$6505 \$7423 \$7575 \$7526 \$7688 \$7535
+ gf180mcu_fd_sc_mcu9t5v0__aoi21_1
X$3086 \$6505 \$11719 \$11689 \$11675 \$11827 \$11521
+ gf180mcu_fd_sc_mcu9t5v0__aoi21_1
X$3087 \$6505 \$10036 \$9710 \$9748 \$9900 \$9761
+ gf180mcu_fd_sc_mcu9t5v0__aoi21_1
X$3088 \$6505 \$9351 \$9228 \$9337 \$9221 \$9227
+ gf180mcu_fd_sc_mcu9t5v0__aoi21_1
X$3089 \$6505 \$8541 \$8540 \$8572 \$8335 \$8343
+ gf180mcu_fd_sc_mcu9t5v0__aoi21_1
X$3090 \$6505 \$6782 \$6668 \$6770 \$6616 \$6625
+ gf180mcu_fd_sc_mcu9t5v0__aoi21_1
X$3091 \$6505 \$10634 \$10401 \$10630 \$10514 \$10524
+ gf180mcu_fd_sc_mcu9t5v0__aoi21_1
X$3092 \$11966 \$11675 \$11555 \$6505 gf180mcu_fd_sc_mcu9t5v0__buf_8
X$3093 \$6514 \$8063 \$7947 \$7812 gf180mcu_fd_sc_mcu9t5v0__clkinv_1
X$3094 \$6656 \$6776 \$6770 \$6616 \$6655 gf180mcu_fd_sc_mcu9t5v0__nand2_1
X$3095 \$6616 \$6770 gf180mcu_fd_sc_mcu9t5v0__filltie
X$3096 \$6616 \$6770 gf180mcu_fd_sc_mcu9t5v0__filltie
X$3097 \$6616 \$6770 gf180mcu_fd_sc_mcu9t5v0__filltie
X$3098 \$6616 \$6770 gf180mcu_fd_sc_mcu9t5v0__filltie
X$3099 \$6616 \$6770 gf180mcu_fd_sc_mcu9t5v0__filltie
X$3100 \$6616 \$6770 gf180mcu_fd_sc_mcu9t5v0__filltie
X$3101 \$6619 \$6654 \$6922 \$6770 \$6616 gf180mcu_fd_sc_mcu9t5v0__dffq_2
X$3102 \$6619 \$6620 \$6927 \$6770 \$6616 gf180mcu_fd_sc_mcu9t5v0__dffq_2
X$3103 \$6616 \$6770 gf180mcu_fd_sc_mcu9t5v0__endcap
X$3104 \$6618 \$6922 \$6924 \$6770 \$6890 \$6654 gf180mcu_fd_sc_mcu9t5v0__mux2_2
X$3105 \$6619 \$8063 \$7947 gf180mcu_fd_sc_mcu9t5v0__inv_4
X$3106 \$6619 \$9610 \$9103 \$9608 \$9703 gf180mcu_fd_sc_mcu9t5v0__dffq_2
X$3107 \$6619 \$9073 \$9224 \$9102 \$9221 gf180mcu_fd_sc_mcu9t5v0__dffq_2
X$3108 \$6619 \$9607 \$9568 \$9608 \$9703 gf180mcu_fd_sc_mcu9t5v0__dffq_2
X$3109 \$6619 \$8066 \$7917 \$8063 \$8183 gf180mcu_fd_sc_mcu9t5v0__dffq_2
X$3110 \$6619 \$7308 \$7418 \$7304 \$7417 gf180mcu_fd_sc_mcu9t5v0__dffq_2
X$3111 \$6619 \$7691 \$7918 \$7797 \$7688 gf180mcu_fd_sc_mcu9t5v0__dffq_2
X$3112 \$6619 \$7690 \$7305 \$7797 \$7688 gf180mcu_fd_sc_mcu9t5v0__dffq_2
X$3113 \$6619 \$8720 \$8838 \$8834 \$8717 gf180mcu_fd_sc_mcu9t5v0__dffq_2
X$3114 \$6619 \$8189 \$8336 \$8301 \$8183 gf180mcu_fd_sc_mcu9t5v0__dffq_2
X$3115 \$6619 \$9222 \$9220 \$9337 \$9221 gf180mcu_fd_sc_mcu9t5v0__dffq_2
X$3116 \$6619 \$8339 \$8682 \$8572 \$8335 gf180mcu_fd_sc_mcu9t5v0__dffq_2
X$3117 \$10917 \$11151 \$6623 \$10630 \$10514 \$10635
+ gf180mcu_fd_sc_mcu9t5v0__aoi21_4
X$3118 \$9583 \$9608 \$9703 \$6623 gf180mcu_fd_sc_mcu9t5v0__buf_8
X$3119 \$6630 \$7178 \$7063 \$7047 \$7160 \$7177 gf180mcu_fd_sc_mcu9t5v0__mux2_2
X$3120 \$22905 \$19154 \$22910 \$6633 \$23027 \$22837 \$22913
+ gf180mcu_fd_sc_mcu9t5v0__aoi22_1
X$3121 \$6900 \$6790 \$6791 \$6770 \$6890 \$6638
+ gf180mcu_fd_sc_mcu9t5v0__oai21_1
X$3122 \$13078 \$15489 \$6645 \$15628 \$15490 \$15627
+ gf180mcu_fd_sc_mcu9t5v0__nand3_1
X$3123 \$6657 \$6662 \$7811 \$6663 \$7047 \$7160 \$7169
+ gf180mcu_fd_sc_mcu9t5v0__oai31_1
X$3124 \$6932 \$6928 \$7311 \$7047 \$6890 \$6659
+ gf180mcu_fd_sc_mcu9t5v0__aoi21_1
X$3125 \$8968 \$6662 \$7811 \$9337 \$9457 \$9467 gf180mcu_fd_sc_mcu9t5v0__nor3_1
X$3126 \$9795 \$6662 \$7811 \$12786 \$12930 \$12685
+ gf180mcu_fd_sc_mcu9t5v0__nor3_1
X$3127 \$9239 \$6662 \$7811 \$12486 \$12526 \$12555
+ gf180mcu_fd_sc_mcu9t5v0__nor3_1
X$3128 \$8695 \$6662 \$7811 \$12260 \$11993 \$12152
+ gf180mcu_fd_sc_mcu9t5v0__nor3_1
X$3129 \$9775 \$6662 \$7811 \$12786 \$12526 \$12680
+ gf180mcu_fd_sc_mcu9t5v0__nor3_1
X$3130 \$7908 \$6662 \$7811 \$11956 \$11827 \$11977
+ gf180mcu_fd_sc_mcu9t5v0__nor3_1
X$3131 \$7582 \$6662 \$7811 \$6663 \$8834 \$8963 \$8849
+ gf180mcu_fd_sc_mcu9t5v0__oai31_1
X$3132 \$8311 \$6662 \$7811 \$6663 \$8572 \$8717 \$8687
+ gf180mcu_fd_sc_mcu9t5v0__oai31_1
X$3133 \$7573 \$6662 \$7811 \$6663 \$7797 \$7947 \$7920
+ gf180mcu_fd_sc_mcu9t5v0__oai31_1
X$3134 \$7064 \$6662 \$7811 \$6663 \$8301 \$8183 \$8199
+ gf180mcu_fd_sc_mcu9t5v0__oai31_1
X$3135 \$9349 \$6662 \$7811 \$6663 \$9337 \$9221 \$9350
+ gf180mcu_fd_sc_mcu9t5v0__oai31_1
X$3136 \$10260 \$6662 \$7811 \$6663 \$10901 \$10782 \$10925
+ gf180mcu_fd_sc_mcu9t5v0__oai31_1
X$3137 \$6674 \$6662 \$7811 \$6663 \$8834 \$8717 \$8857
+ gf180mcu_fd_sc_mcu9t5v0__oai31_1
X$3138 \$11567 \$6662 \$7811 \$6663 \$11675 \$11555 \$11568
+ gf180mcu_fd_sc_mcu9t5v0__oai31_1
X$3139 \$10910 \$6662 \$7811 \$6663 \$11136 \$11025 \$10916
+ gf180mcu_fd_sc_mcu9t5v0__oai31_1
X$3140 \$10397 \$6662 \$7811 \$6663 \$10391 \$10282 \$10035
+ gf180mcu_fd_sc_mcu9t5v0__oai31_1
X$3141 \$10928 \$6662 \$7811 \$6663 \$11136 \$11025 \$11160
+ gf180mcu_fd_sc_mcu9t5v0__oai31_1
X$3142 \$9355 \$9337 \$9221 \$6662 gf180mcu_fd_sc_mcu9t5v0__buf_8
X$3143 \$6676 \$6663 \$8354 \$8199 \$8301 \$8335 \$8355
+ gf180mcu_fd_sc_mcu9t5v0__oai22_1
X$3144 \$7055 \$6663 \$7310 \$7169 \$7304 \$7417 \$7423
+ gf180mcu_fd_sc_mcu9t5v0__oai22_1
X$3145 \$8685 \$6663 \$8724 \$8687 \$8572 \$8717 \$8541
+ gf180mcu_fd_sc_mcu9t5v0__oai22_1
X$3146 \$10265 \$6663 \$11033 \$10925 \$10901 \$11025 \$10926
+ gf180mcu_fd_sc_mcu9t5v0__oai22_1
X$3147 \$11520 \$6663 \$11187 \$11568 \$11675 \$11555 \$11719
+ gf180mcu_fd_sc_mcu9t5v0__oai22_1
X$3148 \$9225 \$6663 \$9110 \$9350 \$9337 \$9221 \$9351
+ gf180mcu_fd_sc_mcu9t5v0__oai22_1
X$3149 \$10677 \$6663 \$11200 \$11160 \$11136 \$11025 \$11035
+ gf180mcu_fd_sc_mcu9t5v0__oai22_1
X$3150 \$10792 \$6663 \$10793 \$10916 \$10901 \$10782 \$10634
+ gf180mcu_fd_sc_mcu9t5v0__oai22_1
X$3151 \$8075 \$6663 \$8730 \$8849 \$8834 \$8717 \$8850
+ gf180mcu_fd_sc_mcu9t5v0__oai22_1
X$3152 \$7919 \$6663 \$7953 \$7920 \$8063 \$7947 \$7954
+ gf180mcu_fd_sc_mcu9t5v0__oai22_1
X$3153 \$6672 \$6663 \$7964 \$7932 \$8063 \$7947 \$7933
+ gf180mcu_fd_sc_mcu9t5v0__oai22_1
X$3154 \$10245 \$6663 \$9906 \$10035 \$10022 \$9900 \$10036
+ gf180mcu_fd_sc_mcu9t5v0__oai22_1
X$3155 \$12906 \$12786 \$12930 \$6663 gf180mcu_fd_sc_mcu9t5v0__buf_8
X$3156 \$6932 \$6928 \$7281 \$7047 \$6890 \$6665
+ gf180mcu_fd_sc_mcu9t5v0__aoi21_1
X$3157 \$6932 \$6928 \$6934 \$7047 \$6890 \$6667
+ gf180mcu_fd_sc_mcu9t5v0__aoi21_1
X$3158 \$6670 \$7047 \$7160 \$6938 gf180mcu_fd_sc_mcu9t5v0__clkinv_1
X$3159 \$14010 \$14644 \$6672 \$13471 \$14748 \$14635
+ gf180mcu_fd_sc_mcu9t5v0__dffrnq_2
X$3160 \$11520 \$17656 \$14229 \$6672 \$10265 \$14345 \$14151 \$14337 \$14461
+ gf180mcu_fd_sc_mcu9t5v0__aoi222_1
X$3161 \$6672 \$12912 \$14454 \$14635 \$14522 gf180mcu_fd_sc_mcu9t5v0__nand2_1
X$3162 \$13349 \$13226 \$13229 \$13341 \$13083 \$6674
+ gf180mcu_fd_sc_mcu9t5v0__aoi21_1
X$3163 \$13230 \$13868 \$6676 \$13471 \$13881 \$13729
+ gf180mcu_fd_sc_mcu9t5v0__dffrnq_2
X$3164 \$6676 \$14229 \$14345 \$10677 \$14151 \$14034 \$14223
+ gf180mcu_fd_sc_mcu9t5v0__aoi22_1
X$3165 \$6676 \$12912 \$13881 \$14034 \$14012 gf180mcu_fd_sc_mcu9t5v0__nand2_1
X$3166 \$7698 \$7182 \$6677 \$7304 \$7160 gf180mcu_fd_sc_mcu9t5v0__dffq_2
X$3167 \$6958 \$6796 \$6911 \$6681 \$6770 \$6890 \$6906
+ gf180mcu_fd_sc_mcu9t5v0__aoi22_1
X$3168 \$6883 \$6770 \$6890 \$6768 gf180mcu_fd_sc_mcu9t5v0__dlyc_1
X$3169 \$6792 \$6770 \$6890 \$6902 gf180mcu_fd_sc_mcu9t5v0__clkinv_1
X$3170 \$6794 \$6948 \$6770 \$6890 \$6903 gf180mcu_fd_sc_mcu9t5v0__nand2_1
X$3171 \$7698 \$6899 \$6789 \$6770 \$6890 gf180mcu_fd_sc_mcu9t5v0__dffq_2
X$3172 \$6890 \$6770 gf180mcu_fd_sc_mcu9t5v0__filltie
X$3173 \$6890 \$6770 gf180mcu_fd_sc_mcu9t5v0__filltie
X$3174 \$6890 \$6770 gf180mcu_fd_sc_mcu9t5v0__filltie
X$3175 \$6890 \$6770 gf180mcu_fd_sc_mcu9t5v0__filltie
X$3176 \$6890 \$6770 gf180mcu_fd_sc_mcu9t5v0__filltie
X$3177 \$6890 \$6770 gf180mcu_fd_sc_mcu9t5v0__filltie
X$3178 \$6890 \$6770 gf180mcu_fd_sc_mcu9t5v0__endcap
X$3179 \$6932 \$6928 \$6931 \$7047 \$6890 \$6779
+ gf180mcu_fd_sc_mcu9t5v0__aoi21_1
X$3180 \$6932 \$6928 \$6933 \$7047 \$6890 \$6781
+ gf180mcu_fd_sc_mcu9t5v0__aoi21_1
X$3181 \$6932 \$6928 \$7541 \$7047 \$7160 \$6784
+ gf180mcu_fd_sc_mcu9t5v0__aoi21_1
X$3182 \$6932 \$6928 \$6930 \$7047 \$6890 \$6929
+ gf180mcu_fd_sc_mcu9t5v0__aoi21_1
X$3183 \$6943 \$7047 \$6890 \$6901 gf180mcu_fd_sc_mcu9t5v0__clkinv_1
X$3184 \$6890 \$7047 gf180mcu_fd_sc_mcu9t5v0__filltie
X$3185 \$6890 \$7047 gf180mcu_fd_sc_mcu9t5v0__filltie
X$3186 \$6890 \$7047 gf180mcu_fd_sc_mcu9t5v0__filltie
X$3187 \$6890 \$7047 gf180mcu_fd_sc_mcu9t5v0__filltie
X$3188 \$6890 \$7047 gf180mcu_fd_sc_mcu9t5v0__filltie
X$3189 \$6890 \$7047 gf180mcu_fd_sc_mcu9t5v0__filltie
X$3190 \$6890 \$7047 gf180mcu_fd_sc_mcu9t5v0__endcap
X$3191 \$6891 \$8063 \$7947 \$7957 gf180mcu_fd_sc_mcu9t5v0__clkinv_1
X$3192 \$7278 \$8068 \$6891 \$8063 \$8183 gf180mcu_fd_sc_mcu9t5v0__dffq_2
X$3193 \$6898 \$23035 \$23027 \$23139 \$24258 gf180mcu_fd_sc_mcu9t5v0__xnor2_1
X$3194 \$6898 \$22912 \$16851 \$23027 \$22837 \$23336
+ gf180mcu_fd_sc_mcu9t5v0__oai21_2
X$3195 \$22278 \$19154 \$22910 \$6903 \$23027 \$22837 \$23039
+ gf180mcu_fd_sc_mcu9t5v0__aoi22_1
X$3196 \$8205 \$9601 \$6905 \$9337 \$9221 gf180mcu_fd_sc_mcu9t5v0__dffq_2
X$3197 \$6905 \$9472 \$10257 \$9608 \$9457 \$9601
+ gf180mcu_fd_sc_mcu9t5v0__mux2_1
X$3198 \$7153 \$7045 \$6913 \$7047 \$7160 gf180mcu_fd_sc_mcu9t5v0__dffq_2
X$3199 \$11822 \$6914 \$11823 \$11956 \$11993 \$11988
+ gf180mcu_fd_sc_mcu9t5v0__aoi21_1
X$3200 \$12249 \$12260 \$12376 \$6915 gf180mcu_fd_sc_mcu9t5v0__buf_8
X$3201 \$11822 \$6917 \$11823 \$11956 \$11827 \$11946
+ gf180mcu_fd_sc_mcu9t5v0__aoi21_1
X$3202 \$13078 \$15803 \$6918 \$15949 \$15749 \$16268
+ gf180mcu_fd_sc_mcu9t5v0__nand3_1
X$3203 \$13078 \$15744 \$6919 \$15949 \$15749 \$15945
+ gf180mcu_fd_sc_mcu9t5v0__nand3_1
X$3204 \$10528 \$10391 \$10514 \$6924 gf180mcu_fd_sc_mcu9t5v0__buf_8
X$3205 \$8681 \$8838 \$6924 \$8572 \$8717 \$8720 gf180mcu_fd_sc_mcu9t5v0__mux2_2
X$3206 \$9106 \$9220 \$6924 \$9102 \$9221 \$9222 gf180mcu_fd_sc_mcu9t5v0__mux2_2
X$3207 \$7566 \$7305 \$6924 \$7526 \$7688 \$7690 gf180mcu_fd_sc_mcu9t5v0__mux2_2
X$3208 \$10664 \$10788 \$6924 \$10630 \$10782 \$10787
+ gf180mcu_fd_sc_mcu9t5v0__mux2_2
X$3209 \$11027 \$11026 \$6924 \$10901 \$11025 \$11141
+ gf180mcu_fd_sc_mcu9t5v0__mux2_2
X$3210 \$11143 \$10518 \$6924 \$11136 \$11025 \$11142
+ gf180mcu_fd_sc_mcu9t5v0__mux2_2
X$3211 \$6926 \$7053 \$7047 \$7160 \$7052 gf180mcu_fd_sc_mcu9t5v0__nand2_1
X$3212 \$11156 \$8301 \$8183 \$6928 gf180mcu_fd_sc_mcu9t5v0__buf_12
X$3213 \$10911 \$6928 \$10233 \$10901 \$11025 \$11030
+ gf180mcu_fd_sc_mcu9t5v0__aoi21_1
X$3214 \$6932 \$6928 \$8191 \$8063 \$8183 \$7953
+ gf180mcu_fd_sc_mcu9t5v0__aoi21_1
X$3215 \$6932 \$6928 \$8198 \$8063 \$8183 \$8080
+ gf180mcu_fd_sc_mcu9t5v0__aoi21_1
X$3216 \$6932 \$6928 \$8315 \$8063 \$8183 \$8079
+ gf180mcu_fd_sc_mcu9t5v0__aoi21_1
X$3217 \$6932 \$6928 \$9762 \$9748 \$9900 \$9906
+ gf180mcu_fd_sc_mcu9t5v0__aoi21_1
X$3218 \$6932 \$6928 \$9109 \$9102 \$9221 \$9110
+ gf180mcu_fd_sc_mcu9t5v0__aoi21_1
X$3219 \$6932 \$6928 \$10915 \$10901 \$10782 \$11187
+ gf180mcu_fd_sc_mcu9t5v0__aoi21_1
X$3220 \$6932 \$6928 \$7534 \$7526 \$7417 \$7310
+ gf180mcu_fd_sc_mcu9t5v0__aoi21_1
X$3221 \$6932 \$6928 \$8554 \$8301 \$8183 \$8077
+ gf180mcu_fd_sc_mcu9t5v0__aoi21_1
X$3222 \$6932 \$6928 \$8725 \$8834 \$8717 \$8724
+ gf180mcu_fd_sc_mcu9t5v0__aoi21_1
X$3223 \$6932 \$6928 \$9580 \$10901 \$10782 \$10793
+ gf180mcu_fd_sc_mcu9t5v0__aoi21_1
X$3224 \$6932 \$6928 \$8579 \$8834 \$8717 \$8730
+ gf180mcu_fd_sc_mcu9t5v0__aoi21_1
X$3225 \$13500 \$13093 \$13501 \$13623 \$13452 \$6930
+ gf180mcu_fd_sc_mcu9t5v0__oai21_1
X$3226 \$14996 \$13093 \$14877 \$14748 \$14875 \$6931
+ gf180mcu_fd_sc_mcu9t5v0__oai21_1
X$3227 \$6932 \$11323 \$8697 \$11956 \$11993 \$12151
+ gf180mcu_fd_sc_mcu9t5v0__aoi21_1
X$3228 \$6932 \$9593 \$7557 \$11675 \$11827 \$11840
+ gf180mcu_fd_sc_mcu9t5v0__aoi21_1
X$3229 \$6932 \$9593 \$12494 \$12486 \$12526 \$12546
+ gf180mcu_fd_sc_mcu9t5v0__aoi21_1
X$3230 \$6932 \$9593 \$12551 \$12486 \$12526 \$12554
+ gf180mcu_fd_sc_mcu9t5v0__aoi21_1
X$3231 \$6932 \$9593 \$11533 \$11306 \$11182 \$11326
+ gf180mcu_fd_sc_mcu9t5v0__aoi21_1
X$3232 \$6932 \$9593 \$12939 \$12786 \$12526 \$12684
+ gf180mcu_fd_sc_mcu9t5v0__aoi21_1
X$3233 \$6932 \$9593 \$9232 \$9608 \$9457 \$9594
+ gf180mcu_fd_sc_mcu9t5v0__aoi21_1
X$3234 \$6932 \$9593 \$9596 \$9608 \$9457 \$9470
+ gf180mcu_fd_sc_mcu9t5v0__aoi21_1
X$3235 \$10027 \$6932 \$7576 \$9608 \$9703 \$9611
+ gf180mcu_fd_sc_mcu9t5v0__nand3_1
X$3236 \$8961 \$6932 \$7576 \$9102 \$9221 \$9112
+ gf180mcu_fd_sc_mcu9t5v0__nand3_1
X$3237 \$8186 \$6932 \$7576 \$8572 \$8717 \$8578
+ gf180mcu_fd_sc_mcu9t5v0__nand3_1
X$3238 \$7273 \$6932 \$7576 \$8063 \$8183 \$8069
+ gf180mcu_fd_sc_mcu9t5v0__nand3_1
X$3239 \$10902 \$6932 \$7576 \$9748 \$9703 \$9764
+ gf180mcu_fd_sc_mcu9t5v0__nand3_1
X$3240 \$10241 \$6932 \$7576 \$9608 \$9457 \$9352
+ gf180mcu_fd_sc_mcu9t5v0__nand3_1
X$3241 \$11199 \$7937 \$6932 \$11323 \$11324 \$11136 \$11182 \$11200
+ gf180mcu_fd_sc_mcu9t5v0__aoi221_1
X$3242 \$11325 \$7937 \$6932 \$11323 \$11324 \$11306 \$11182 \$11033
+ gf180mcu_fd_sc_mcu9t5v0__aoi221_1
X$3243 \$9716 \$9748 \$9703 \$6932 gf180mcu_fd_sc_mcu9t5v0__buf_8
X$3244 \$14042 \$13093 \$14207 \$14151 \$14337 \$6933
+ gf180mcu_fd_sc_mcu9t5v0__oai21_1
X$3245 \$14163 \$13093 \$14210 \$14151 \$14034 \$6934
+ gf180mcu_fd_sc_mcu9t5v0__oai21_1
X$3246 \$9713 \$9337 \$9457 \$6939 gf180mcu_fd_sc_mcu9t5v0__buf_8
X$3247 \$7698 \$7181 \$6943 \$7304 \$7160 gf180mcu_fd_sc_mcu9t5v0__dffq_2
X$3248 \$7698 \$9089 \$6949 \$9102 \$9221 gf180mcu_fd_sc_mcu9t5v0__dffq_2
X$3249 \$6949 \$9088 \$7695 \$9102 \$8963 \$9089 gf180mcu_fd_sc_mcu9t5v0__mux2_1
X$3250 \$7698 \$7433 \$6950 \$7304 \$7417 gf180mcu_fd_sc_mcu9t5v0__dffq_2
X$3251 \$6950 \$7552 \$7553 \$7526 \$7417 \$7433 gf180mcu_fd_sc_mcu9t5v0__mux2_1
X$3252 \$8351 \$8350 \$8345 \$6952 \$8834 \$8963 \$8973
+ gf180mcu_fd_sc_mcu9t5v0__aoi211_1
X$3253 \$6960 \$8572 \$8335 \$8326 gf180mcu_fd_sc_mcu9t5v0__clkinv_1
X$3254 \$11822 \$7046 \$11823 \$11956 \$11993 \$11989
+ gf180mcu_fd_sc_mcu9t5v0__aoi21_1
X$3255 \$7160 \$7047 gf180mcu_fd_sc_mcu9t5v0__filltie
X$3256 \$7160 \$7047 gf180mcu_fd_sc_mcu9t5v0__filltie
X$3257 \$7160 \$7047 gf180mcu_fd_sc_mcu9t5v0__filltie
X$3258 \$7160 \$7047 gf180mcu_fd_sc_mcu9t5v0__filltie
X$3259 \$7160 \$7047 gf180mcu_fd_sc_mcu9t5v0__filltie
X$3260 \$7160 \$7047 gf180mcu_fd_sc_mcu9t5v0__filltie
X$3261 \$7160 \$7047 gf180mcu_fd_sc_mcu9t5v0__endcap
X$3262 \$24111 \$19154 \$21663 \$7052 \$24231 \$24109 \$24235
+ gf180mcu_fd_sc_mcu9t5v0__aoi22_1
X$3263 \$18592 \$19339 \$7055 \$13634 \$19605 \$19466
+ gf180mcu_fd_sc_mcu9t5v0__dffrnq_2
X$3264 \$7055 \$8542 \$8063 \$8183 \$8193 gf180mcu_fd_sc_mcu9t5v0__or2_1
X$3265 \$7055 \$17656 \$15210 \$14998 \$14348 \$15321 \$15204 \$15368
+ gf180mcu_fd_sc_mcu9t5v0__aoi221_1
X$3266 \$7055 \$12912 \$19605 \$19774 \$19340 gf180mcu_fd_sc_mcu9t5v0__nand2_1
X$3267 \$7937 \$7963 \$7929 \$8063 \$7947 \$7062
+ gf180mcu_fd_sc_mcu9t5v0__aoi21_1
X$3268 \$9711 \$9748 \$9900 \$7063 gf180mcu_fd_sc_mcu9t5v0__buf_4
X$3269 \$7063 \$12026 \$11976 \$11956 \$11993 \$12027
+ gf180mcu_fd_sc_mcu9t5v0__aoi21_1
X$3270 \$7063 \$8317 \$8353 \$8301 \$8335 \$8352
+ gf180mcu_fd_sc_mcu9t5v0__aoi21_1
X$3271 \$7063 \$8561 \$8349 \$8301 \$8335 \$8562
+ gf180mcu_fd_sc_mcu9t5v0__aoi21_1
X$3272 \$7063 \$9117 \$8973 \$9102 \$9221 \$9085
+ gf180mcu_fd_sc_mcu9t5v0__aoi21_1
X$3273 \$7063 \$12149 \$12150 \$12260 \$11993 \$12024
+ gf180mcu_fd_sc_mcu9t5v0__aoi21_1
X$3274 \$11971 \$12021 \$7063 \$11956 \$11993 \$12020
+ gf180mcu_fd_sc_mcu9t5v0__mux2_2
X$3275 \$13351 \$13226 \$13466 \$13341 \$13452 \$7064
+ gf180mcu_fd_sc_mcu9t5v0__aoi21_1
X$3276 \$7065 \$8301 \$8183 \$8319 gf180mcu_fd_sc_mcu9t5v0__clkinv_1
X$3277 \$7698 \$8563 \$7065 \$8301 \$8335 gf180mcu_fd_sc_mcu9t5v0__dffq_2
X$3278 \$7153 \$8059 \$7945 \$8063 \$8183 gf180mcu_fd_sc_mcu9t5v0__dffq_2
X$3279 \$7153 \$7407 \$7299 \$7526 \$7417 gf180mcu_fd_sc_mcu9t5v0__dffq_2
X$3280 \$7153 \$7680 \$7562 \$7797 \$7688 gf180mcu_fd_sc_mcu9t5v0__dffq_2
X$3281 \$11822 \$7154 \$11823 \$11956 \$11827 \$11949
+ gf180mcu_fd_sc_mcu9t5v0__aoi21_1
X$3282 \$7160 \$7304 gf180mcu_fd_sc_mcu9t5v0__filltie
X$3283 \$7160 \$7304 gf180mcu_fd_sc_mcu9t5v0__filltie
X$3284 \$7160 \$7304 gf180mcu_fd_sc_mcu9t5v0__filltie
X$3285 \$7160 \$7304 gf180mcu_fd_sc_mcu9t5v0__filltie
X$3286 \$7160 \$7304 gf180mcu_fd_sc_mcu9t5v0__filltie
X$3287 \$7160 \$7304 gf180mcu_fd_sc_mcu9t5v0__filltie
X$3288 \$7278 \$7168 \$7167 \$7304 \$7160 gf180mcu_fd_sc_mcu9t5v0__dffq_2
X$3289 \$7160 \$7304 gf180mcu_fd_sc_mcu9t5v0__endcap
X$3290 \$7164 \$7526 \$7688 \$7312 gf180mcu_fd_sc_mcu9t5v0__clkinv_1
X$3291 \$7278 \$7535 \$7164 \$7526 \$7417 gf180mcu_fd_sc_mcu9t5v0__dffq_2
X$3292 \$7165 \$21627 \$21661 \$21622 \$21665 gf180mcu_fd_sc_mcu9t5v0__xnor2_1
X$3293 \$17094 \$7165 \$8965 \$9755 \$21184 \$21011 \$21363
+ gf180mcu_fd_sc_mcu9t5v0__nor4_1
X$3294 \$13835 \$13497 \$13498 \$13623 \$13452 \$7272
+ gf180mcu_fd_sc_mcu9t5v0__mux2_1
X$3295 \$13892 \$7273 \$13853 \$13852 \$13881 \$13729 \$13851
+ gf180mcu_fd_sc_mcu9t5v0__aoi22_1
X$3296 \$7273 \$7797 \$7688 \$7573 gf180mcu_fd_sc_mcu9t5v0__clkinv_1
X$3297 \$14044 \$14458 \$13226 \$14151 \$14034 \$7273
+ gf180mcu_fd_sc_mcu9t5v0__mux2_1
X$3298 \$8344 \$8350 \$8345 \$7277 \$8301 \$8335 \$7959
+ gf180mcu_fd_sc_mcu9t5v0__aoi211_1
X$3299 \$7278 \$8301 \$8183 \$I54388 gf180mcu_fd_sc_mcu9t5v0__clkinv_1
X$3300 \$7278 \$9077 \$9105 \$9102 \$9221 gf180mcu_fd_sc_mcu9t5v0__dffq_2
X$3301 \$7278 \$9353 \$9581 \$9337 \$9457 gf180mcu_fd_sc_mcu9t5v0__dffq_2
X$3302 \$7278 \$8343 \$8539 \$8301 \$8335 gf180mcu_fd_sc_mcu9t5v0__dffq_2
X$3303 \$7278 \$9227 \$9344 \$9102 \$9221 gf180mcu_fd_sc_mcu9t5v0__dffq_2
X$3304 \$7278 \$9579 \$9705 \$9608 \$9703 gf180mcu_fd_sc_mcu9t5v0__dffq_2
X$3305 \$7278 \$8846 \$8683 \$8834 \$8963 gf180mcu_fd_sc_mcu9t5v0__dffq_2
X$3306 \$7278 \$9345 \$9107 \$9337 \$9457 gf180mcu_fd_sc_mcu9t5v0__dffq_2
X$3307 \$7278 \$8067 \$8188 \$8063 \$8183 gf180mcu_fd_sc_mcu9t5v0__dffq_2
X$3308 \$7278 \$7955 \$7915 \$8063 \$7947 gf180mcu_fd_sc_mcu9t5v0__dffq_2
X$3309 \$7278 \$7420 \$7306 \$7526 \$7417 gf180mcu_fd_sc_mcu9t5v0__dffq_2
X$3310 \$7278 \$7958 \$7800 \$8063 \$7947 gf180mcu_fd_sc_mcu9t5v0__dffq_2
X$3311 \$7278 \$8721 \$8538 \$8834 \$8717 gf180mcu_fd_sc_mcu9t5v0__dffq_2
X$3312 \$7278 \$8726 \$8840 \$8834 \$8717 gf180mcu_fd_sc_mcu9t5v0__dffq_2
X$3313 \$14340 \$13093 \$14457 \$14454 \$14337 \$7281
+ gf180mcu_fd_sc_mcu9t5v0__oai21_1
X$3314 \$8194 \$7283 \$8301 \$8183 \$8074 gf180mcu_fd_sc_mcu9t5v0__nand2_2
X$3315 \$8688 \$8577 \$8725 \$7283 \$8578 \$8572 \$8717 \$8726
+ gf180mcu_fd_sc_mcu9t5v0__oai221_1
X$3316 \$9354 \$8577 \$9580 \$7283 \$9352 \$9337 \$9221 \$9353
+ gf180mcu_fd_sc_mcu9t5v0__oai221_1
X$3317 \$9765 \$8577 \$10915 \$7283 \$9764 \$9748 \$9703 \$9766
+ gf180mcu_fd_sc_mcu9t5v0__oai221_1
X$3318 \$9763 \$8577 \$9762 \$7283 \$9611 \$9748 \$9703 \$9907
+ gf180mcu_fd_sc_mcu9t5v0__oai221_1
X$3319 \$9076 \$8577 \$9109 \$7283 \$9112 \$9102 \$8963 \$9077
+ gf180mcu_fd_sc_mcu9t5v0__oai221_1
X$3320 \$10038 \$10022 \$9900 \$7283 gf180mcu_fd_sc_mcu9t5v0__buf_8
X$3321 \$7698 \$7290 \$7317 \$7304 \$7417 gf180mcu_fd_sc_mcu9t5v0__dffq_2
X$3322 \$7293 \$23641 \$23032 \$23620 \$23807 \$23779
+ gf180mcu_fd_sc_mcu9t5v0__aoi21_1
X$3323 \$7293 \$23641 \$23779 \$23620 \$23807 \$23777
+ gf180mcu_fd_sc_mcu9t5v0__oai21_1
X$3324 \$16851 \$7293 \$23183 \$23454 \$23471 gf180mcu_fd_sc_mcu9t5v0__nand2_1
X$3325 \$7296 \$7295 \$7304 \$7417 \$7432 gf180mcu_fd_sc_mcu9t5v0__nand2_1
X$3326 \$13078 \$14336 \$7300 \$14454 \$14337 \$14452
+ gf180mcu_fd_sc_mcu9t5v0__nand3_1
X$3327 \$7417 \$7304 gf180mcu_fd_sc_mcu9t5v0__filltie
X$3328 \$7417 \$7304 gf180mcu_fd_sc_mcu9t5v0__filltie
X$3329 \$7417 \$7304 gf180mcu_fd_sc_mcu9t5v0__filltie
X$3330 \$7417 \$7304 gf180mcu_fd_sc_mcu9t5v0__filltie
X$3331 \$7417 \$7304 gf180mcu_fd_sc_mcu9t5v0__filltie
X$3332 \$7417 \$7304 gf180mcu_fd_sc_mcu9t5v0__filltie
X$3333 \$7417 \$7304 gf180mcu_fd_sc_mcu9t5v0__endcap
X$3334 \$14160 \$13093 \$14202 \$14151 \$14034 \$7311
+ gf180mcu_fd_sc_mcu9t5v0__oai21_1
X$3335 \$7931 \$7937 \$7929 \$7797 \$7947 \$7315
+ gf180mcu_fd_sc_mcu9t5v0__aoi21_2
X$3336 \$20727 \$19042 \$19165 \$7316 \$20881 \$20718 \$20846
+ gf180mcu_fd_sc_mcu9t5v0__aoi22_1
X$3337 \$19787 \$19042 \$18885 \$7320 \$19605 \$19774 \$19757
+ gf180mcu_fd_sc_mcu9t5v0__aoi22_1
X$3338 \$7417 \$7526 gf180mcu_fd_sc_mcu9t5v0__filltie
X$3339 \$7417 \$7526 gf180mcu_fd_sc_mcu9t5v0__filltie
X$3340 \$7417 \$7526 gf180mcu_fd_sc_mcu9t5v0__filltie
X$3341 \$7417 \$7526 gf180mcu_fd_sc_mcu9t5v0__filltie
X$3342 \$7417 \$7526 gf180mcu_fd_sc_mcu9t5v0__filltie
X$3343 \$7417 \$7526 gf180mcu_fd_sc_mcu9t5v0__filltie
X$3344 \$7417 \$7526 gf180mcu_fd_sc_mcu9t5v0__endcap
X$3345 \$7936 \$7937 \$7929 \$7797 \$7947 \$7431
+ gf180mcu_fd_sc_mcu9t5v0__aoi21_2
X$3346 \$22905 \$19154 \$22910 \$7432 \$23027 \$23139 \$23040
+ gf180mcu_fd_sc_mcu9t5v0__aoi22_1
X$3347 \$11822 \$7524 \$11823 \$11956 \$11827 \$11950
+ gf180mcu_fd_sc_mcu9t5v0__aoi21_1
X$3348 \$7695 \$7587 \$7589 \$7526 \$7688 \$7588
+ gf180mcu_fd_sc_mcu9t5v0__aoi21_1
X$3349 \$7688 \$7526 gf180mcu_fd_sc_mcu9t5v0__filltie
X$3350 \$7688 \$7526 gf180mcu_fd_sc_mcu9t5v0__filltie
X$3351 \$7688 \$7526 gf180mcu_fd_sc_mcu9t5v0__filltie
X$3352 \$7688 \$7526 gf180mcu_fd_sc_mcu9t5v0__filltie
X$3353 \$7688 \$7526 gf180mcu_fd_sc_mcu9t5v0__filltie
X$3354 \$7688 \$7526 gf180mcu_fd_sc_mcu9t5v0__filltie
X$3355 \$7688 \$7526 gf180mcu_fd_sc_mcu9t5v0__endcap
X$3356 \$14158 \$13093 \$14040 \$14151 \$14034 \$7534
+ gf180mcu_fd_sc_mcu9t5v0__oai21_1
X$3357 \$13095 \$13093 \$13094 \$13035 \$13083 \$7541
+ gf180mcu_fd_sc_mcu9t5v0__oai21_1
X$3358 \$7544 \$9102 \$8963 \$8851 gf180mcu_fd_sc_mcu9t5v0__clkinv_1
X$3359 \$7546 \$8063 \$8183 \$7961 gf180mcu_fd_sc_mcu9t5v0__clkinv_1
X$3360 \$22905 \$19154 \$22910 \$7547 \$23027 \$22837 \$22904
+ gf180mcu_fd_sc_mcu9t5v0__aoi22_1
X$3361 \$19168 \$19042 \$19165 \$7551 \$19027 \$19149 \$18883
+ gf180mcu_fd_sc_mcu9t5v0__aoi22_1
X$3362 \$9356 \$9608 \$9457 \$7553 gf180mcu_fd_sc_mcu9t5v0__buf_8
X$3363 \$8862 \$8696 \$7553 \$8834 \$8963 \$8734 gf180mcu_fd_sc_mcu9t5v0__mux2_1
X$3364 \$13348 \$13341 \$13083 \$7557 gf180mcu_fd_sc_mcu9t5v0__buf_8
X$3365 \$7557 \$11838 \$10258 \$12786 \$12526 \$12796
+ gf180mcu_fd_sc_mcu9t5v0__mux2_1
X$3366 \$8359 \$8360 \$8301 \$8335 \$7560 gf180mcu_fd_sc_mcu9t5v0__nand2_1
X$3367 \$7804 \$7569 \$7797 \$7688 \$7805 gf180mcu_fd_sc_mcu9t5v0__nand2_1
X$3368 \$7572 \$7806 \$7797 \$7688 \$7570 gf180mcu_fd_sc_mcu9t5v0__nand2_1
X$3369 \$10289 \$8834 \$8963 \$7576 gf180mcu_fd_sc_mcu9t5v0__buf_8
X$3370 \$13461 \$13226 \$16738 \$16914 \$16728 \$7582
+ gf180mcu_fd_sc_mcu9t5v0__aoi21_1
X$3371 \$14217 \$7582 \$17085 \$17034 \$17103 gf180mcu_fd_sc_mcu9t5v0__nand2_1
X$3372 \$7695 \$7810 \$7583 \$7797 \$7688 \$7694
+ gf180mcu_fd_sc_mcu9t5v0__aoi21_1
X$3373 \$8559 \$7937 \$7929 \$8572 \$8335 \$7585
+ gf180mcu_fd_sc_mcu9t5v0__aoi21_1
X$3374 \$10259 \$10022 \$10282 \$7592 gf180mcu_fd_sc_mcu9t5v0__buf_8
X$3375 \$7679 \$14870 \$19596 \$19927 \$19774 \$20039
+ gf180mcu_fd_sc_mcu9t5v0__nor3_1
X$3376 \$7679 \$20042 \$19927 \$20087 \$20333 gf180mcu_fd_sc_mcu9t5v0__or2_1
X$3377 \$7679 \$19462 \$19597 \$19605 \$19466 \$19598
+ gf180mcu_fd_sc_mcu9t5v0__nand3_1
X$3378 \$7792 \$7797 \$7688 \$7679 gf180mcu_fd_sc_mcu9t5v0__buf_8
X$3379 \$7679 \$14454 \$14635 \$14144 gf180mcu_fd_sc_mcu9t5v0__buf_1
X$3380 \$7797 \$7688 \$7791 gf180mcu_fd_sc_mcu9t5v0__tiel
X$3381 \$8707 \$7797 \$7688 \$7792 gf180mcu_fd_sc_mcu9t5v0__buf_1
X$3382 \$7695 \$7814 \$7815 \$7797 \$7688 \$7696
+ gf180mcu_fd_sc_mcu9t5v0__aoi21_1
X$3383 \$7688 \$7797 gf180mcu_fd_sc_mcu9t5v0__filltie
X$3384 \$7688 \$7797 gf180mcu_fd_sc_mcu9t5v0__filltie
X$3385 \$7688 \$7797 gf180mcu_fd_sc_mcu9t5v0__filltie
X$3386 \$7688 \$7797 gf180mcu_fd_sc_mcu9t5v0__filltie
X$3387 \$7688 \$7797 gf180mcu_fd_sc_mcu9t5v0__filltie
X$3388 \$7688 \$7797 gf180mcu_fd_sc_mcu9t5v0__filltie
X$3389 \$7698 \$7702 \$7942 \$7797 \$7688 gf180mcu_fd_sc_mcu9t5v0__dffq_2
X$3390 \$7698 \$7699 \$7700 \$7797 \$7688 gf180mcu_fd_sc_mcu9t5v0__dffq_2
X$3391 \$7688 \$7797 gf180mcu_fd_sc_mcu9t5v0__endcap
X$3392 \$7695 \$11035 \$10805 \$10901 \$11025 \$11036
+ gf180mcu_fd_sc_mcu9t5v0__aoi21_1
X$3393 \$7695 \$7933 \$7935 \$7797 \$7947 \$7934
+ gf180mcu_fd_sc_mcu9t5v0__aoi21_1
X$3394 \$7695 \$8082 \$7940 \$7797 \$7947 \$7966
+ gf180mcu_fd_sc_mcu9t5v0__aoi21_1
X$3395 \$7695 \$10926 \$10642 \$10901 \$10782 \$10802
+ gf180mcu_fd_sc_mcu9t5v0__aoi21_1
X$3396 \$7695 \$8355 \$8320 \$8572 \$8335 \$8563
+ gf180mcu_fd_sc_mcu9t5v0__aoi21_1
X$3397 \$7695 \$8975 \$9087 \$9102 \$8963 \$8976
+ gf180mcu_fd_sc_mcu9t5v0__aoi21_1
X$3398 \$7695 \$8850 \$8852 \$9102 \$8963 \$8966
+ gf180mcu_fd_sc_mcu9t5v0__aoi21_1
X$3399 \$11966 \$11675 \$11827 \$7695 gf180mcu_fd_sc_mcu9t5v0__buf_8
X$3400 \$9612 \$9613 \$7695 \$9337 \$9457 \$9468 gf180mcu_fd_sc_mcu9t5v0__mux2_1
X$3401 \$11730 \$11842 \$7695 \$11675 \$11827 \$11843
+ gf180mcu_fd_sc_mcu9t5v0__mux2_1
X$3402 \$11205 \$11203 \$7695 \$11136 \$11182 \$11204
+ gf180mcu_fd_sc_mcu9t5v0__mux2_1
X$3403 \$12155 \$12154 \$7695 \$11956 \$11993 \$12030
+ gf180mcu_fd_sc_mcu9t5v0__mux2_1
X$3404 \$12500 \$12795 \$7695 \$12786 \$12930 \$12687
+ gf180mcu_fd_sc_mcu9t5v0__mux2_1
X$3405 \$11972 \$12678 \$7695 \$12786 \$12526 \$12545
+ gf180mcu_fd_sc_mcu9t5v0__mux2_1
X$3406 \$12557 \$12686 \$7695 \$12786 \$12526 \$12556
+ gf180mcu_fd_sc_mcu9t5v0__mux2_1
X$3407 \$13221 \$13035 \$12930 \$7697 gf180mcu_fd_sc_mcu9t5v0__buf_8
X$3408 \$7698 \$7797 \$7947 \$I71699 gf180mcu_fd_sc_mcu9t5v0__clkinv_2
X$3409 \$7698 \$8732 \$8692 \$8572 \$8717 gf180mcu_fd_sc_mcu9t5v0__dffq_2
X$3410 \$7698 \$9468 \$9612 \$9608 \$9457 gf180mcu_fd_sc_mcu9t5v0__dffq_2
X$3411 \$7698 \$7967 \$8323 \$8063 \$7947 gf180mcu_fd_sc_mcu9t5v0__dffq_2
X$3412 \$9096 pad_din[2] \$I20747 \$I20765 \$I20756 \$I20774 \$I20783 \$I20801
+ \$I20792 \$I20810 \$I20819 \$I20837 \$I20828 \$I20846 \$I20855 \$I20864
+ \$I20873 \$I20882 \$I20891 \$I20900 \$I20909 \$I20918 \$I20927 \$I20936
+ \$I20945 \$I20954 \$I20963 \$I20981 \$I20972 \$I20990 \$I20999 \$I21017
+ \$I21008 \$I21026 \$I21044 \$I21035 \$I21053 \$I21062 \$I21071 \$I21089
+ \$I21080 \$I21098 \$I21107 \$I21116 \$I21125 \$I21134 \$I21143 \$I21161
+ \$I21152 \$I21170 \$I21179 \$I21197 \$I21188 \$I21206 \$I21215 \$I21233
+ \$I21224 \$I21242 \$I21251 \$I21269 \$I21260 \$I21278 \$I21287 \$I21296
+ \$I21305 \$I21314 \$I21323 \$I21332 \$I21341 \$I21350 \$I21368 \$I21377
+ \$I21404 \$I21413 \$I21359 \$I21395 \$I21386 \$I21431 \$I21422 \$I21458
+ \$I21449 \$I21467 \$I21440 \$I21485 \$I21476 \$I21494 \$I21512 \$I21539
+ \$I21548 \$I21557 \$I21503 \$I21530 \$I21521 \$I21575 \$I21566 \$I21584
+ \$I21593 \$I21602 \$I21611 \$I21620 \$I21629 \$I21638 \$7791 \$I21647
+ \$I21665 \$I21656 \$I21674 \$7791 \$8706 gf180mcu_fd_io__in_c
X$3413 \$7930 \$7937 \$7929 \$7797 \$7947 \$7926
+ gf180mcu_fd_sc_mcu9t5v0__aoi21_2
X$3414 \$8091 \$7943 \$7944 \$7971 \$7797 \$7947 \$8085
+ gf180mcu_fd_sc_mcu9t5v0__aoi22_1
X$3415 \$7800 \$7797 \$7947 \$7923 gf180mcu_fd_sc_mcu9t5v0__clkinv_1
X$3416 \$7915 \$7797 \$7947 \$7921 gf180mcu_fd_sc_mcu9t5v0__clkinv_1
X$3417 \$7947 \$7797 gf180mcu_fd_sc_mcu9t5v0__filltie
X$3418 \$7947 \$7797 gf180mcu_fd_sc_mcu9t5v0__filltie
X$3419 \$7947 \$7797 gf180mcu_fd_sc_mcu9t5v0__filltie
X$3420 \$7947 \$7797 gf180mcu_fd_sc_mcu9t5v0__filltie
X$3421 \$7947 \$7797 gf180mcu_fd_sc_mcu9t5v0__filltie
X$3422 \$7947 \$7797 gf180mcu_fd_sc_mcu9t5v0__filltie
X$3423 \$7947 \$7797 gf180mcu_fd_sc_mcu9t5v0__endcap
X$3424 \$8307 \$7802 \$8309 \$8301 \$8183 \$8308
+ gf180mcu_fd_sc_mcu9t5v0__oai21_1
X$3425 \$24302 \$19154 \$21663 \$7805 \$24231 \$24109 \$24239
+ gf180mcu_fd_sc_mcu9t5v0__aoi22_1
X$3426 \$21024 \$19042 \$19165 \$7808 \$21184 \$21011 \$21154
+ gf180mcu_fd_sc_mcu9t5v0__aoi22_1
X$3427 \$8695 \$10040 \$11967 \$7811 \$12486 \$12526 \$12552
+ gf180mcu_fd_sc_mcu9t5v0__nor4_1
X$3428 \$12540 \$13035 \$12930 \$7811 gf180mcu_fd_sc_mcu9t5v0__buf_8
X$3429 \$8328 \$7904 \$7905 \$8063 \$7947 gf180mcu_fd_sc_mcu9t5v0__dffq_2
X$3430 \$13734 \$8558 \$7908 \$13510 \$13623 \$13729 \$13733
+ gf180mcu_fd_sc_mcu9t5v0__aoi22_1
X$3431 \$13866 \$13893 \$13226 \$13881 \$13729 \$7908
+ gf180mcu_fd_sc_mcu9t5v0__mux2_1
X$3432 \$8344 \$8350 \$8345 \$7916 \$8572 \$8335 \$8546
+ gf180mcu_fd_sc_mcu9t5v0__aoi211_1
X$3433 \$7917 \$7950 \$7951 \$8063 \$7947 \$8066 gf180mcu_fd_sc_mcu9t5v0__mux2_1
X$3434 \$20845 \$19896 \$7919 \$13634 \$19927 \$19774
+ gf180mcu_fd_sc_mcu9t5v0__dffrnq_2
X$3435 \$7919 \$8542 \$8572 \$8335 \$8543 gf180mcu_fd_sc_mcu9t5v0__or2_1
X$3436 \$7919 \$17656 \$17964 \$14521 \$14224 \$17818 \$17952 \$17661
+ gf180mcu_fd_sc_mcu9t5v0__aoi221_1
X$3437 \$7919 \$12912 \$19605 \$19774 \$19742 gf180mcu_fd_sc_mcu9t5v0__nand2_1
X$3438 \$7928 \$8572 \$8335 \$7960 gf180mcu_fd_sc_mcu9t5v0__clkinv_1
X$3439 \$9118 \$7937 \$7929 \$9102 \$9221 \$9232
+ gf180mcu_fd_sc_mcu9t5v0__aoi21_2
X$3440 \$8691 \$8572 \$8717 \$7929 gf180mcu_fd_sc_mcu9t5v0__buf_8
X$3441 \$8580 \$8063 \$8183 \$7930 gf180mcu_fd_sc_mcu9t5v0__clkinv_1
X$3442 \$14228 \$13341 \$13452 \$7931 gf180mcu_fd_sc_mcu9t5v0__clkinv_1
X$3443 \$13736 \$13623 \$13729 \$7936 gf180mcu_fd_sc_mcu9t5v0__clkinv_1
X$3444 \$9767 \$9748 \$9703 \$7937 gf180mcu_fd_sc_mcu9t5v0__buf_4
X$3445 \$7937 \$13085 \$13341 \$13083 \$13094 gf180mcu_fd_sc_mcu9t5v0__or2_1
X$3446 \$7937 \$13098 \$13099 \$13035 \$13083 \$12682
+ gf180mcu_fd_sc_mcu9t5v0__oai21_1
X$3447 \$13047 \$7937 \$13035 \$13083 \$13099 gf180mcu_fd_sc_mcu9t5v0__nand2_1
X$3448 \$13859 \$13623 \$13729 \$7938 gf180mcu_fd_sc_mcu9t5v0__clkinv_1
X$3449 \$8072 \$8070 \$7959 \$8063 \$7947 \$8073
+ gf180mcu_fd_sc_mcu9t5v0__aoi21_1
X$3450 \$7947 \$8063 gf180mcu_fd_sc_mcu9t5v0__filltie
X$3451 \$7947 \$8063 gf180mcu_fd_sc_mcu9t5v0__filltie
X$3452 \$7947 \$8063 gf180mcu_fd_sc_mcu9t5v0__filltie
X$3453 \$7947 \$8063 gf180mcu_fd_sc_mcu9t5v0__filltie
X$3454 \$7947 \$8063 gf180mcu_fd_sc_mcu9t5v0__filltie
X$3455 \$7947 \$8063 gf180mcu_fd_sc_mcu9t5v0__filltie
X$3456 \$7947 \$8063 gf180mcu_fd_sc_mcu9t5v0__endcap
X$3457 \$12271 \$12260 \$12376 \$7951 gf180mcu_fd_sc_mcu9t5v0__buf_8
X$3458 \$8538 \$8684 \$7951 \$8834 \$8963 \$8721 gf180mcu_fd_sc_mcu9t5v0__mux2_1
X$3459 \$9107 \$9346 \$7951 \$9337 \$9221 \$9345 gf180mcu_fd_sc_mcu9t5v0__mux2_1
X$3460 \$12380 \$12137 \$7951 \$12260 \$11993 \$12264
+ gf180mcu_fd_sc_mcu9t5v0__mux2_1
X$3461 \$12663 \$12664 \$7951 \$12786 \$12526 \$12791
+ gf180mcu_fd_sc_mcu9t5v0__mux2_1
X$3462 \$12530 \$12666 \$7951 \$12786 \$12526 \$12792
+ gf180mcu_fd_sc_mcu9t5v0__mux2_1
X$3463 \$8557 \$8063 \$8183 \$7963 gf180mcu_fd_sc_mcu9t5v0__clkinv_1
X$3464 \$13855 \$13623 \$13729 \$7965 gf180mcu_fd_sc_mcu9t5v0__clkinv_1
X$3465 \$8205 \$8209 \$7968 \$8063 \$8183 gf180mcu_fd_sc_mcu9t5v0__dffq_2
X$3466 \$9097 pad_dout[3] \$I20746 \$I20755 \$I20764 \$I20773 \$I20782 \$I20791
+ \$I20800 \$I20809 \$I20818 \$I20827 \$I20836 \$I20845 \$I20854 \$I20863
+ \$I20872 \$I20881 \$I20890 \$I20899 \$I20908 \$I20917 \$I20926 \$I20935
+ \$I20944 \$I20953 \$I20962 \$I20971 \$I20980 \$I20989 \$I20998 \$I21007
+ \$I21016 \$I21025 \$I21034 \$I21043 \$I21052 \$I21061 \$I21070 \$I21079
+ \$I21088 \$I21097 \$I21106 \$I21115 \$I21124 \$I21133 \$I21142 \$I21151
+ \$I21160 \$I21169 \$I21178 \$I21187 \$I21196 \$I21205 \$I21214 \$I21223
+ \$I21232 \$I21241 \$I21250 \$I21259 \$I21268 \$I21277 \$I21286 \$I21295
+ \$I21304 \$I21313 \$7972 \$I21322 \$I21331 \$I21340 \$I21349 \$I21358
+ \$I21367 \$I21376 \$I21385 \$I21394 \$I21403 \$I21412 \$I21421 \$I21430
+ \$I21439 \$I21448 \$I21457 \$I21466 \$I21475 \$I21484 \$I21493 \$I21502
+ \$I21511 \$I21520 \$I21529 \$I21538 \$I21547 \$I21556 \$I21565 \$I21574
+ \$I21583 \$I21592 \$I21601 \$7973 \$I21610 \$I21619 \$I21628 \$I21637
+ \$I21646 \$I21655 \$I21664 \$I21673 \$7973 \$7973 \$7972 \$7973 \$7973 \$9604
+ \$7972 gf180mcu_fd_io__bi_t
X$3467 \$9608 \$9703 \$7972 gf180mcu_fd_sc_mcu9t5v0__tieh
X$3468 \$9608 \$9703 \$7973 gf180mcu_fd_sc_mcu9t5v0__tiel
X$3469 \$13078 \$13073 \$8060 \$13035 \$13083 \$13072
+ gf180mcu_fd_sc_mcu9t5v0__nand3_1
X$3470 \$11822 \$8061 \$11823 \$11956 \$11827 \$11948
+ gf180mcu_fd_sc_mcu9t5v0__aoi21_1
X$3471 \$8183 \$8063 gf180mcu_fd_sc_mcu9t5v0__filltie
X$3472 \$8183 \$8063 gf180mcu_fd_sc_mcu9t5v0__filltie
X$3473 \$8183 \$8063 gf180mcu_fd_sc_mcu9t5v0__filltie
X$3474 \$8183 \$8063 gf180mcu_fd_sc_mcu9t5v0__filltie
X$3475 \$8183 \$8063 gf180mcu_fd_sc_mcu9t5v0__filltie
X$3476 \$8183 \$8063 gf180mcu_fd_sc_mcu9t5v0__filltie
X$3477 \$8183 \$8063 gf180mcu_fd_sc_mcu9t5v0__endcap
X$3478 \$8072 \$8544 \$8546 \$8572 \$8335 \$8545
+ gf180mcu_fd_sc_mcu9t5v0__aoi21_1
X$3479 \$8072 \$9114 \$9080 \$9102 \$8963 \$9079
+ gf180mcu_fd_sc_mcu9t5v0__aoi21_1
X$3480 \$8072 \$8729 \$8548 \$8834 \$8717 \$8689
+ gf180mcu_fd_sc_mcu9t5v0__aoi21_1
X$3481 \$8848 \$9748 \$9703 \$8072 gf180mcu_fd_sc_mcu9t5v0__buf_8
X$3482 \$18596 \$19747 \$8075 \$13634 \$19605 \$19466
+ gf180mcu_fd_sc_mcu9t5v0__dffrnq_2
X$3483 \$10245 \$17656 \$14229 \$8075 \$25761 \$17542 \$17538 \$17367 \$17375
+ gf180mcu_fd_sc_mcu9t5v0__aoi222_1
X$3484 \$8075 \$12912 \$19324 \$19466 \$19478 gf180mcu_fd_sc_mcu9t5v0__nand2_1
X$3485 \$8208 \$8301 \$8183 \$8087 gf180mcu_fd_sc_mcu9t5v0__clkinv_1
X$3486 \$8093 \$11306 \$11555 \$11217 gf180mcu_fd_sc_mcu9t5v0__clkinv_1
X$3487 \$11038 \$11216 \$8093 \$11306 \$11182 gf180mcu_fd_sc_mcu9t5v0__dffq_2
X$3488 \$8313 \$8301 \$8183 \$8314 gf180mcu_fd_sc_mcu9t5v0__clkinv_1
X$3489 \$8558 \$8301 \$8183 \$8559 gf180mcu_fd_sc_mcu9t5v0__clkinv_1
X$3490 \$8183 \$8301 gf180mcu_fd_sc_mcu9t5v0__filltie
X$3491 \$8183 \$8301 gf180mcu_fd_sc_mcu9t5v0__filltie
X$3492 \$8183 \$8301 gf180mcu_fd_sc_mcu9t5v0__filltie
X$3493 \$8183 \$8301 gf180mcu_fd_sc_mcu9t5v0__filltie
X$3494 \$8183 \$8301 gf180mcu_fd_sc_mcu9t5v0__filltie
X$3495 \$8183 \$8301 gf180mcu_fd_sc_mcu9t5v0__filltie
X$3496 \$8205 \$8206 \$8208 \$8301 \$8183 gf180mcu_fd_sc_mcu9t5v0__dffq_2
X$3497 \$8205 \$8204 \$8201 \$8301 \$8183 gf180mcu_fd_sc_mcu9t5v0__dffq_2
X$3498 \$8183 \$8301 gf180mcu_fd_sc_mcu9t5v0__endcap
X$3499 \$8186 \$8301 \$8335 \$8311 gf180mcu_fd_sc_mcu9t5v0__clkinv_1
X$3500 \$14212 \$14220 \$13226 \$14151 \$14337 \$8186
+ gf180mcu_fd_sc_mcu9t5v0__mux2_1
X$3501 \$13497 \$13093 \$13458 \$13623 \$13452 \$8191
+ gf180mcu_fd_sc_mcu9t5v0__oai21_1
X$3502 \$9715 \$9716 \$9712 \$9608 \$9703 \$8194
+ gf180mcu_fd_sc_mcu9t5v0__nand3_4
X$3503 \$8313 \$8555 \$8556 \$8572 \$8335 \$8198
+ gf180mcu_fd_sc_mcu9t5v0__oai21_1
X$3504 \$8205 \$9337 \$9221 \$I71698 gf180mcu_fd_sc_mcu9t5v0__clkinv_2
X$3505 \$8205 \$9237 \$9600 \$9337 \$9457 gf180mcu_fd_sc_mcu9t5v0__dffq_2
X$3506 \$8205 \$9092 \$9094 \$9102 \$9221 gf180mcu_fd_sc_mcu9t5v0__dffq_2
X$3507 \$8205 \$9614 \$9602 \$9608 \$9703 gf180mcu_fd_sc_mcu9t5v0__dffq_2
X$3508 \$8205 \$9922 \$9923 \$9748 \$9900 gf180mcu_fd_sc_mcu9t5v0__dffq_2
X$3509 \$8205 \$9598 \$8859 \$9608 \$9703 gf180mcu_fd_sc_mcu9t5v0__dffq_2
X$3510 \$8205 \$8585 \$8702 \$8572 \$8717 gf180mcu_fd_sc_mcu9t5v0__dffq_2
X$3511 \$8205 \$9090 \$8693 \$9102 \$9221 gf180mcu_fd_sc_mcu9t5v0__dffq_2
X$3512 \$8205 \$10274 \$10275 \$10391 \$10282 gf180mcu_fd_sc_mcu9t5v0__dffq_2
X$3513 \$8205 \$9473 \$9475 \$9608 \$9457 gf180mcu_fd_sc_mcu9t5v0__dffq_2
X$3514 \$8205 \$10271 \$10270 \$10391 \$10282 gf180mcu_fd_sc_mcu9t5v0__dffq_2
X$3515 \$8205 \$8736 \$8700 \$8834 \$8717 gf180mcu_fd_sc_mcu9t5v0__dffq_2
X$3516 \$8205 \$9234 \$9121 \$9337 \$9221 gf180mcu_fd_sc_mcu9t5v0__dffq_2
X$3517 \$8205 \$8735 \$8978 \$8834 \$8717 gf180mcu_fd_sc_mcu9t5v0__dffq_2
X$3518 \$8205 \$8734 \$8862 \$8834 \$8717 gf180mcu_fd_sc_mcu9t5v0__dffq_2
X$3519 \$8329 \$8296 \$8297 \$8301 \$8335 gf180mcu_fd_sc_mcu9t5v0__dffq_2
X$3520 \$8299 \$8333 \$8332 \$8301 \$8335 \$8331
+ gf180mcu_fd_sc_mcu9t5v0__aoi21_1
X$3521 \$8328 \$8301 \$8335 gf180mcu_fd_sc_mcu9t5v0__inv_8
X$3522 \$8310 \$8341 \$8301 \$8335 \$8340 gf180mcu_fd_sc_mcu9t5v0__nand2_1
X$3523 \$8335 \$8301 gf180mcu_fd_sc_mcu9t5v0__filltie
X$3524 \$8335 \$8301 gf180mcu_fd_sc_mcu9t5v0__filltie
X$3525 \$8335 \$8301 gf180mcu_fd_sc_mcu9t5v0__filltie
X$3526 \$8335 \$8301 gf180mcu_fd_sc_mcu9t5v0__filltie
X$3527 \$8335 \$8301 gf180mcu_fd_sc_mcu9t5v0__filltie
X$3528 \$8335 \$8301 gf180mcu_fd_sc_mcu9t5v0__filltie
X$3529 \$8335 \$8301 gf180mcu_fd_sc_mcu9t5v0__endcap
X$3530 \$14154 \$14203 \$13498 \$14151 \$14337 \$8302
+ gf180mcu_fd_sc_mcu9t5v0__mux2_1
X$3531 \$8307 \$12493 \$13044 \$13035 \$12930 \$12938
+ gf180mcu_fd_sc_mcu9t5v0__oai21_1
X$3532 \$8307 \$11183 \$16850 \$16851 \$16914 \$16728 \$17091
+ gf180mcu_fd_sc_mcu9t5v0__oai211_1
X$3533 \$14201 \$15815 \$15949 \$16070 \$8307 gf180mcu_fd_sc_mcu9t5v0__nor2_1
X$3534 \$8307 \$12931 \$15628 \$15749 \$15752 gf180mcu_fd_sc_mcu9t5v0__nor2_1
X$3535 \$8308 \$22390 \$22387 \$22440 \$22446 gf180mcu_fd_sc_mcu9t5v0__xnor2_1
X$3536 \$8308 \$21363 \$22387 \$22440 \$22445 gf180mcu_fd_sc_mcu9t5v0__and2_1
X$3537 \$8312 \$22456 \$22713 \$22440 \$23463 gf180mcu_fd_sc_mcu9t5v0__xnor2_1
X$3538 \$8312 \$23027 \$22837 \$22901 gf180mcu_fd_sc_mcu9t5v0__clkinv_1
X$3539 \$15160 \$8313 \$14217 \$14748 \$14635 \$14762
+ gf180mcu_fd_sc_mcu9t5v0__mux2_1
X$3540 \$14640 \$14763 \$13226 \$14748 \$14635 \$8313
+ gf180mcu_fd_sc_mcu9t5v0__mux2_1
X$3541 \$8558 \$8555 \$8556 \$8572 \$8335 \$8315
+ gf180mcu_fd_sc_mcu9t5v0__oai21_1
X$3542 \$8328 \$9068 \$9213 \$9102 \$9221 gf180mcu_fd_sc_mcu9t5v0__dffq_2
X$3543 \$8328 \$8569 \$8529 \$8572 \$8717 gf180mcu_fd_sc_mcu9t5v0__dffq_2
X$3544 \$8328 \$9098 \$9070 \$9102 \$9221 gf180mcu_fd_sc_mcu9t5v0__dffq_2
X$3545 \$8328 \$8709 \$8674 \$8834 \$8717 gf180mcu_fd_sc_mcu9t5v0__dffq_2
X$3546 \$8328 \$9451 \$9452 \$9608 \$9457 gf180mcu_fd_sc_mcu9t5v0__dffq_2
X$3547 \$8328 \$8708 \$8671 \$8834 \$8717 gf180mcu_fd_sc_mcu9t5v0__dffq_2
X$3548 \$8329 \$10654 \$9742 \$12245 \$10630 \$10782
+ gf180mcu_fd_sc_mcu9t5v0__dffrnq_2
X$3549 \$8329 \$9748 \$9900 gf180mcu_fd_sc_mcu9t5v0__clkinv_3
X$3550 \$8329 \$9891 \$9743 \$9748 \$9900 gf180mcu_fd_sc_mcu9t5v0__dffq_2
X$3551 \$8329 \$10510 \$10511 \$10391 \$10514 gf180mcu_fd_sc_mcu9t5v0__dffq_2
X$3552 \$8329 \$9330 \$9331 \$9337 \$9457 gf180mcu_fd_sc_mcu9t5v0__dffq_2
X$3553 \$8329 \$9333 \$9334 \$9337 \$9457 gf180mcu_fd_sc_mcu9t5v0__dffq_2
X$3554 \$8329 \$9745 \$9746 \$9748 \$9900 gf180mcu_fd_sc_mcu9t5v0__dffq_2
X$3555 \$8329 \$8953 \$8830 \$8834 \$8963 gf180mcu_fd_sc_mcu9t5v0__dffq_2
X$3556 \$8329 \$9455 \$9565 \$9337 \$9457 gf180mcu_fd_sc_mcu9t5v0__dffq_2
X$3557 \$8329 \$9100 \$9071 \$9102 \$9221 gf180mcu_fd_sc_mcu9t5v0__dffq_2
X$3558 \$8329 \$9893 \$10021 \$10022 \$9900 gf180mcu_fd_sc_mcu9t5v0__dffq_2
X$3559 \$8329 \$9454 \$9563 \$9608 \$9457 gf180mcu_fd_sc_mcu9t5v0__dffq_2
X$3560 \$8329 \$9897 \$9898 \$10022 \$9900 gf180mcu_fd_sc_mcu9t5v0__dffq_2
X$3561 \$8329 \$10776 \$10658 \$10901 \$10782 gf180mcu_fd_sc_mcu9t5v0__dffq_2
X$3562 \$8329 \$10774 \$10655 \$10901 \$10782 gf180mcu_fd_sc_mcu9t5v0__dffq_2
X$3563 \$8329 \$10508 \$10509 \$10630 \$10514 gf180mcu_fd_sc_mcu9t5v0__dffq_2
X$3564 \$8329 \$11172 \$11173 \$11306 \$11182 gf180mcu_fd_sc_mcu9t5v0__dffq_2
X$3565 \$8329 \$10775 \$10656 \$10901 \$10782 gf180mcu_fd_sc_mcu9t5v0__dffq_2
X$3566 \$8329 \$10223 \$10224 \$10391 \$10282 gf180mcu_fd_sc_mcu9t5v0__dffq_2
X$3567 \$11822 \$8330 \$11823 \$11956 \$11827 \$11951
+ gf180mcu_fd_sc_mcu9t5v0__aoi21_1
X$3568 \$13075 \$8331 \$13078 \$13035 \$13083 \$13079
+ gf180mcu_fd_sc_mcu9t5v0__oai21_1
X$3569 \$8555 \$8557 \$8556 \$8572 \$8335 \$8554
+ gf180mcu_fd_sc_mcu9t5v0__oai21_1
X$3570 \$8539 \$8572 \$8335 \$8573 gf180mcu_fd_sc_mcu9t5v0__clkinv_1
X$3571 \$8335 \$8572 gf180mcu_fd_sc_mcu9t5v0__filltie
X$3572 \$8335 \$8572 gf180mcu_fd_sc_mcu9t5v0__filltie
X$3573 \$8335 \$8572 gf180mcu_fd_sc_mcu9t5v0__filltie
X$3574 \$8335 \$8572 gf180mcu_fd_sc_mcu9t5v0__filltie
X$3575 \$8335 \$8572 gf180mcu_fd_sc_mcu9t5v0__filltie
X$3576 \$8335 \$8572 gf180mcu_fd_sc_mcu9t5v0__filltie
X$3577 \$8335 \$8572 gf180mcu_fd_sc_mcu9t5v0__endcap
X$3578 \$8344 \$8350 \$8345 \$9108 \$9102 \$8963 \$9080
+ gf180mcu_fd_sc_mcu9t5v0__aoi211_1
X$3579 \$10290 \$9102 \$9221 \$8344 gf180mcu_fd_sc_mcu9t5v0__buf_8
X$3580 \$8351 \$8350 \$8345 \$11675 \$11555 \$11531
+ gf180mcu_fd_sc_mcu9t5v0__aoi21_1
X$3581 \$8351 \$8350 \$8345 \$12025 \$11956 \$11827 \$11976
+ gf180mcu_fd_sc_mcu9t5v0__aoi211_1
X$3582 \$8351 \$8350 \$8345 \$11975 \$11956 \$11827 \$12150
+ gf180mcu_fd_sc_mcu9t5v0__aoi211_1
X$3583 \$12542 \$12786 \$12526 \$8345 gf180mcu_fd_sc_mcu9t5v0__buf_8
X$3584 \$11312 \$11306 \$11182 \$8350 gf180mcu_fd_sc_mcu9t5v0__buf_8
X$3585 \$10290 \$10391 \$10282 \$8351 gf180mcu_fd_sc_mcu9t5v0__buf_8
X$3586 \$8703 \$8542 \$9337 \$9457 \$9465 gf180mcu_fd_sc_mcu9t5v0__or2_1
X$3587 \$9225 \$8542 \$9102 \$9221 \$9113 gf180mcu_fd_sc_mcu9t5v0__or2_1
X$3588 \$12548 \$8542 \$12786 \$12526 \$12681 gf180mcu_fd_sc_mcu9t5v0__or2_1
X$3589 \$12498 \$8542 \$12786 \$12526 \$12549 gf180mcu_fd_sc_mcu9t5v0__or2_1
X$3590 \$11838 \$8542 \$11306 \$11555 \$11530 gf180mcu_fd_sc_mcu9t5v0__nor2_1
X$3591 \$12675 \$12786 \$12526 \$8542 gf180mcu_fd_sc_mcu9t5v0__buf_8
X$3592 \$12682 \$8549 \$10257 \$12940 \$13048 \$13035 \$12930 \$12941
+ gf180mcu_fd_sc_mcu9t5v0__oai221_1
X$3593 \$10920 \$11312 \$11136 \$11182 \$8549 gf180mcu_fd_sc_mcu9t5v0__nand2_1
X$3594 \$8580 \$8555 \$8556 \$8572 \$8717 \$8579
+ gf180mcu_fd_sc_mcu9t5v0__oai21_1
X$3595 \$13093 \$13035 \$13083 \$8555 gf180mcu_fd_sc_mcu9t5v0__buf_8
X$3596 \$8581 \$8690 \$8572 \$8717 \$8556 gf180mcu_fd_sc_mcu9t5v0__or2_1
X$3597 \$15010 \$14514 \$13226 \$15045 \$14875 \$8557
+ gf180mcu_fd_sc_mcu9t5v0__mux2_1
X$3598 \$14763 \$15756 \$13226 \$14748 \$14875 \$8558
+ gf180mcu_fd_sc_mcu9t5v0__mux2_1
X$3599 \$8956 \$8832 \$8571 \$8834 \$8963 \$8955
+ gf180mcu_fd_sc_mcu9t5v0__aoi21_1
X$3600 \$8717 \$8572 gf180mcu_fd_sc_mcu9t5v0__filltie
X$3601 \$8717 \$8572 gf180mcu_fd_sc_mcu9t5v0__filltie
X$3602 \$8717 \$8572 gf180mcu_fd_sc_mcu9t5v0__filltie
X$3603 \$8717 \$8572 gf180mcu_fd_sc_mcu9t5v0__filltie
X$3604 \$8717 \$8572 gf180mcu_fd_sc_mcu9t5v0__filltie
X$3605 \$8717 \$8572 gf180mcu_fd_sc_mcu9t5v0__filltie
X$3606 \$8717 \$8572 gf180mcu_fd_sc_mcu9t5v0__endcap
X$3607 \$8573 \$8833 \$8835 \$8834 \$8717 \$8712
+ gf180mcu_fd_sc_mcu9t5v0__oai21_1
X$3608 \$14521 \$8580 \$13734 \$16269 \$16070 \$16147
+ gf180mcu_fd_sc_mcu9t5v0__oai21_1
X$3609 \$16148 \$15010 \$13226 \$16269 \$16376 \$8580
+ gf180mcu_fd_sc_mcu9t5v0__mux2_1
X$3610 \$8581 \$8690 \$8834 \$8717 \$8691 gf180mcu_fd_sc_mcu9t5v0__nor2_2
X$3611 \$8581 \$13098 \$13035 \$13083 \$11324 gf180mcu_fd_sc_mcu9t5v0__nor2_4
X$3612 \$8581 \$14209 \$14151 \$14337 \$14210 gf180mcu_fd_sc_mcu9t5v0__or2_1
X$3613 \$8581 \$14498 \$14748 \$14635 \$14457 gf180mcu_fd_sc_mcu9t5v0__or2_1
X$3614 \$8581 \$14341 \$14454 \$14337 \$14207 gf180mcu_fd_sc_mcu9t5v0__or2_1
X$3615 \$11199 \$8581 \$11324 \$11136 \$11182 \$11034
+ gf180mcu_fd_sc_mcu9t5v0__aoi21_1
X$3616 \$12937 \$8581 \$11324 \$13035 \$12930 \$12939
+ gf180mcu_fd_sc_mcu9t5v0__aoi21_1
X$3617 \$13046 \$8581 \$11324 \$13035 \$12930 \$13045
+ gf180mcu_fd_sc_mcu9t5v0__aoi21_1
X$3618 \$11325 \$8581 \$11324 \$11306 \$11182 \$10259
+ gf180mcu_fd_sc_mcu9t5v0__aoi21_1
X$3619 \$13047 \$8581 \$11324 \$13035 \$12930 \$12551
+ gf180mcu_fd_sc_mcu9t5v0__aoi21_1
X$3620 \$8581 \$11198 \$11324 \$11136 \$11182 \$9596
+ gf180mcu_fd_sc_mcu9t5v0__aoi21_1
X$3621 \$14456 \$14454 \$14635 \$8581 gf180mcu_fd_sc_mcu9t5v0__buf_8
X$3622 \$13098 \$13514 \$8581 \$13341 \$13452 \$8697
+ gf180mcu_fd_sc_mcu9t5v0__mux2_1
X$3623 \$13098 \$13347 \$8581 \$13341 \$13452 \$13348
+ gf180mcu_fd_sc_mcu9t5v0__mux2_1
X$3624 \$13098 \$13225 \$8581 \$13341 \$13083 \$11533
+ gf180mcu_fd_sc_mcu9t5v0__mux2_1
X$3625 \$8683 \$8847 \$8848 \$8834 \$8717 \$8846 gf180mcu_fd_sc_mcu9t5v0__mux2_1
X$3626 \$20845 \$20220 \$8685 \$13634 \$20209 \$20087
+ gf180mcu_fd_sc_mcu9t5v0__dffrnq_2
X$3627 \$8685 \$17656 \$17542 \$17498 \$17497 \$17538 \$17367 \$17039
+ gf180mcu_fd_sc_mcu9t5v0__aoi221_1
X$3628 \$8685 \$12912 \$20209 \$20383 \$20053 gf180mcu_fd_sc_mcu9t5v0__nand2_1
X$3629 \$8840 \$8834 \$8963 \$8688 gf180mcu_fd_sc_mcu9t5v0__clkinv_1
X$3630 \$13456 \$13197 \$13493 \$13341 \$13452 \$8690
+ gf180mcu_fd_sc_mcu9t5v0__mux2_1
X$3631 \$13519 \$9775 \$13350 \$13623 \$13452 \$8695
+ gf180mcu_fd_sc_mcu9t5v0__mux2_1
X$3632 \$8697 \$12384 \$10258 \$13035 \$13083 \$13100
+ gf180mcu_fd_sc_mcu9t5v0__mux2_1
X$3633 \$14241 \$15839 \$8703 \$13471 \$15628 \$15490
+ gf180mcu_fd_sc_mcu9t5v0__dffrnq_2
X$3634 \$8703 \$14211 \$14353 \$13852 \$14229 \$10044 \$14454 \$14337 \$14351
+ gf180mcu_fd_sc_mcu9t5v0__aoi222_1
X$3635 \$8703 \$12912 \$15321 \$15490 \$15517 gf180mcu_fd_sc_mcu9t5v0__nand2_1
X$3636 \$8703 \$9595 \$9608 \$9457 \$9469 gf180mcu_fd_sc_mcu9t5v0__nand2_1
X$3637 \$8706 \$8834 \$8717 \$8707 gf180mcu_fd_sc_mcu9t5v0__dlyc_1
X$3638 \$8737 \$8865 \$8738 \$8864 \$8834 \$8717 \$9091
+ gf180mcu_fd_sc_mcu9t5v0__aoi22_1
X$3639 \$8717 \$8834 gf180mcu_fd_sc_mcu9t5v0__filltie
X$3640 \$8717 \$8834 gf180mcu_fd_sc_mcu9t5v0__filltie
X$3641 \$8717 \$8834 gf180mcu_fd_sc_mcu9t5v0__filltie
X$3642 \$8717 \$8834 gf180mcu_fd_sc_mcu9t5v0__filltie
X$3643 \$8717 \$8834 gf180mcu_fd_sc_mcu9t5v0__filltie
X$3644 \$8717 \$8834 gf180mcu_fd_sc_mcu9t5v0__filltie
X$3645 \$8717 \$8834 gf180mcu_fd_sc_mcu9t5v0__endcap
X$3646 \$14203 \$13093 \$14205 \$14151 \$14337 \$8725
+ gf180mcu_fd_sc_mcu9t5v0__oai21_1
X$3647 \$8963 \$8834 gf180mcu_fd_sc_mcu9t5v0__filltie
X$3648 \$8963 \$8834 gf180mcu_fd_sc_mcu9t5v0__filltie
X$3649 \$8963 \$8834 gf180mcu_fd_sc_mcu9t5v0__filltie
X$3650 \$8963 \$8834 gf180mcu_fd_sc_mcu9t5v0__filltie
X$3651 \$8963 \$8834 gf180mcu_fd_sc_mcu9t5v0__filltie
X$3652 \$8963 \$8834 gf180mcu_fd_sc_mcu9t5v0__filltie
X$3653 \$8963 \$8834 gf180mcu_fd_sc_mcu9t5v0__endcap
X$3654 \$21501 \$19154 \$21663 \$8843 \$21661 \$21622 \$21662
+ gf180mcu_fd_sc_mcu9t5v0__aoi22_1
X$3655 \$9711 \$9608 \$9703 \$8848 gf180mcu_fd_sc_mcu9t5v0__buf_4
X$3656 \$10914 \$11031 \$8848 \$10901 \$11025 \$10912
+ gf180mcu_fd_sc_mcu9t5v0__mux2_1
X$3657 \$11519 \$11150 \$8848 \$11136 \$11025 \$11185
+ gf180mcu_fd_sc_mcu9t5v0__mux2_1
X$3658 \$10523 \$10633 \$8848 \$10391 \$10282 \$10398
+ gf180mcu_fd_sc_mcu9t5v0__mux2_1
X$3659 \$9232 \$9337 \$9221 \$8853 gf180mcu_fd_sc_mcu9t5v0__buf_8
X$3660 \$8853 \$10044 \$10258 \$10022 \$10282 \$10256
+ gf180mcu_fd_sc_mcu9t5v0__mux2_1
X$3661 \$8859 \$9748 \$9703 \$9788 gf180mcu_fd_sc_mcu9t5v0__clkinv_1
X$3662 \$13075 \$8955 \$13078 \$13341 \$13083 \$13201
+ gf180mcu_fd_sc_mcu9t5v0__oai21_1
X$3663 \$13852 \$14511 \$8961 \$13892 \$14454 \$14635 \$14213
+ gf180mcu_fd_sc_mcu9t5v0__aoi22_1
X$3664 \$8961 \$9337 \$9221 \$9349 gf180mcu_fd_sc_mcu9t5v0__clkinv_1
X$3665 \$14459 \$14212 \$13226 \$14454 \$14337 \$8961
+ gf180mcu_fd_sc_mcu9t5v0__mux2_1
X$3666 \$9083 \$9102 \$8963 \$9084 gf180mcu_fd_sc_mcu9t5v0__clkinv_1
X$3667 \$8963 \$9102 gf180mcu_fd_sc_mcu9t5v0__filltie
X$3668 \$8963 \$9102 gf180mcu_fd_sc_mcu9t5v0__filltie
X$3669 \$8963 \$9102 gf180mcu_fd_sc_mcu9t5v0__filltie
X$3670 \$8963 \$9102 gf180mcu_fd_sc_mcu9t5v0__filltie
X$3671 \$8963 \$9102 gf180mcu_fd_sc_mcu9t5v0__filltie
X$3672 \$8963 \$9102 gf180mcu_fd_sc_mcu9t5v0__filltie
X$3673 \$8963 \$9102 gf180mcu_fd_sc_mcu9t5v0__endcap
X$3674 \$17094 \$8965 \$21184 \$21011 \$21361 gf180mcu_fd_sc_mcu9t5v0__nor2_1
X$3675 \$17094 \$8965 \$20881 \$21011 \$21019 gf180mcu_fd_sc_mcu9t5v0__nand2_1
X$3676 \$13230 \$14768 \$8968 \$13471 \$14748 \$14635
+ gf180mcu_fd_sc_mcu9t5v0__dffrnq_2
X$3677 \$8968 \$14151 \$14034 \$11570 gf180mcu_fd_sc_mcu9t5v0__clkinv_1
X$3678 \$14887 \$8968 \$13518 \$14748 \$14635 \$14766
+ gf180mcu_fd_sc_mcu9t5v0__mux2_1
X$3679 \$9067 \$11710 \$11675 \$11827 \$11709 gf180mcu_fd_sc_mcu9t5v0__nor2_1
X$3680 \$22895 \$9072 \$23027 \$22837 \$23029 gf180mcu_fd_sc_mcu9t5v0__nor2_1
X$3681 \$22895 \$9072 \$23027 \$22837 \$23028 gf180mcu_fd_sc_mcu9t5v0__nand2_1
X$3682 \$9347 \$9226 \$9337 \$9221 \$9074 gf180mcu_fd_sc_mcu9t5v0__nand2_1
X$3683 \$9105 \$9337 \$9221 \$9076 gf180mcu_fd_sc_mcu9t5v0__clkinv_1
X$3684 \$9595 \$9362 \$9470 \$9469 \$9337 \$9457 \$9088
+ gf180mcu_fd_sc_mcu9t5v0__oai31_1
X$3685 \$11822 \$9099 \$11823 \$11956 \$11827 \$11947
+ gf180mcu_fd_sc_mcu9t5v0__aoi21_1
X$3686 \$9121 \$9102 \$9221 \$9125 gf180mcu_fd_sc_mcu9t5v0__clkinv_1
X$3687 \$9221 \$9102 gf180mcu_fd_sc_mcu9t5v0__filltie
X$3688 \$9221 \$9102 gf180mcu_fd_sc_mcu9t5v0__filltie
X$3689 \$9221 \$9102 gf180mcu_fd_sc_mcu9t5v0__filltie
X$3690 \$9221 \$9102 gf180mcu_fd_sc_mcu9t5v0__filltie
X$3691 \$9221 \$9102 gf180mcu_fd_sc_mcu9t5v0__filltie
X$3692 \$9221 \$9102 gf180mcu_fd_sc_mcu9t5v0__filltie
X$3693 \$9221 \$9102 gf180mcu_fd_sc_mcu9t5v0__endcap
X$3694 \$14637 \$13093 \$14503 \$14748 \$14635 \$9109
+ gf180mcu_fd_sc_mcu9t5v0__oai21_1
X$3695 \$9344 \$9337 \$9221 \$9111 gf180mcu_fd_sc_mcu9t5v0__clkinv_1
X$3696 \$13897 \$14151 \$14034 \$9118 gf180mcu_fd_sc_mcu9t5v0__clkinv_1
X$3697 \$9118 \$13862 \$14454 \$14337 \$16140 gf180mcu_fd_sc_mcu9t5v0__nor2_1
X$3698 \$10923 \$10901 \$10782 \$9120 gf180mcu_fd_sc_mcu9t5v0__buf_8
X$3699 \$9123 \$9913 \$9748 \$9900 \$9790 gf180mcu_fd_sc_mcu9t5v0__nand2_1
X$3700 \$9128 \$9337 \$9221 \$9243 gf180mcu_fd_sc_mcu9t5v0__clkinv_1
X$3701 \$9221 \$9337 gf180mcu_fd_sc_mcu9t5v0__filltie
X$3702 \$9221 \$9337 gf180mcu_fd_sc_mcu9t5v0__filltie
X$3703 \$9221 \$9337 gf180mcu_fd_sc_mcu9t5v0__filltie
X$3704 \$9221 \$9337 gf180mcu_fd_sc_mcu9t5v0__filltie
X$3705 \$9221 \$9337 gf180mcu_fd_sc_mcu9t5v0__filltie
X$3706 \$9221 \$9337 gf180mcu_fd_sc_mcu9t5v0__filltie
X$3707 \$9221 \$9337 gf180mcu_fd_sc_mcu9t5v0__endcap
X$3708 \$18592 \$19039 \$9225 \$13634 \$19027 \$19149
+ gf180mcu_fd_sc_mcu9t5v0__dffrnq_2
X$3709 \$9225 \$17656 \$17542 \$23927 \$17655 \$17538 \$17703 \$14759
+ gf180mcu_fd_sc_mcu9t5v0__aoi221_1
X$3710 \$9225 \$12912 \$19027 \$18870 \$18999 gf180mcu_fd_sc_mcu9t5v0__nand2_1
X$3711 \$12551 \$12786 \$12526 \$9235 gf180mcu_fd_sc_mcu9t5v0__buf_8
X$3712 \$9600 \$9608 \$9457 \$9236 gf180mcu_fd_sc_mcu9t5v0__clkinv_1
X$3713 \$13887 \$14042 \$9239 \$13510 \$13881 \$14034 \$13888
+ gf180mcu_fd_sc_mcu9t5v0__aoi22_1
X$3714 \$13865 \$13900 \$13226 \$13881 \$14034 \$9239
+ gf180mcu_fd_sc_mcu9t5v0__mux2_1
X$3715 \$9332 \$9608 \$9457 \$9606 gf180mcu_fd_sc_mcu9t5v0__clkinv_1
X$3716 \$9457 \$9337 gf180mcu_fd_sc_mcu9t5v0__filltie
X$3717 \$9457 \$9337 gf180mcu_fd_sc_mcu9t5v0__filltie
X$3718 \$9457 \$9337 gf180mcu_fd_sc_mcu9t5v0__filltie
X$3719 \$9457 \$9337 gf180mcu_fd_sc_mcu9t5v0__filltie
X$3720 \$9457 \$9337 gf180mcu_fd_sc_mcu9t5v0__filltie
X$3721 \$9457 \$9337 gf180mcu_fd_sc_mcu9t5v0__filltie
X$3722 \$9457 \$9337 gf180mcu_fd_sc_mcu9t5v0__endcap
X$3723 \$14501 \$14637 \$13498 \$14748 \$14635 \$9343
+ gf180mcu_fd_sc_mcu9t5v0__mux2_1
X$3724 \$9581 \$9608 \$9457 \$9354 gf180mcu_fd_sc_mcu9t5v0__clkinv_1
X$3725 \$9715 \$10406 \$9355 \$9608 \$9457 \$9583
+ gf180mcu_fd_sc_mcu9t5v0__nor3_4
X$3726 \$12270 \$10404 \$12260 \$12376 \$9355 gf180mcu_fd_sc_mcu9t5v0__or2_4
X$3727 \$9720 \$9772 \$9748 \$9703 \$9356 gf180mcu_fd_sc_mcu9t5v0__nand2_4
X$3728 \$9457 \$9608 gf180mcu_fd_sc_mcu9t5v0__filltie
X$3729 \$9457 \$9608 gf180mcu_fd_sc_mcu9t5v0__filltie
X$3730 \$9457 \$9608 gf180mcu_fd_sc_mcu9t5v0__filltie
X$3731 \$9457 \$9608 gf180mcu_fd_sc_mcu9t5v0__filltie
X$3732 \$9457 \$9608 gf180mcu_fd_sc_mcu9t5v0__filltie
X$3733 \$9457 \$9608 gf180mcu_fd_sc_mcu9t5v0__filltie
X$3734 \$9572 \$9458 \$9706 \$9608 \$9457 \$9571 gf180mcu_fd_sc_mcu9t5v0__mux2_1
X$3735 \$9457 \$9608 gf180mcu_fd_sc_mcu9t5v0__endcap
X$3736 \$9459 \$9576 \$9608 \$9703 \$9708 gf180mcu_fd_sc_mcu9t5v0__nand2_1
X$3737 \$9464 \$10901 \$11025 \$10672 gf180mcu_fd_sc_mcu9t5v0__clkinv_1
X$3738 \$10291 \$10800 \$9464 \$10901 \$10782 gf180mcu_fd_sc_mcu9t5v0__dffq_2
X$3739 \$9595 \$9467 \$9594 \$9730 \$9608 \$9703 \$9613
+ gf180mcu_fd_sc_mcu9t5v0__oai31_1
X$3740 \$23032 \$14524 \$9471 \$18885 \$19605 \$19774 \$19753
+ gf180mcu_fd_sc_mcu9t5v0__oai31_1
X$3741 \$9564 \$12894 \$13078 \$12893 \$12786 \$12930 \$12785
+ gf180mcu_fd_sc_mcu9t5v0__oai211_1
X$3742 \$13838 \$13093 \$13840 \$13881 \$13729 \$9580
+ gf180mcu_fd_sc_mcu9t5v0__oai21_1
X$3743 \$9715 \$9714 \$9712 \$9608 \$9703 \$9582
+ gf180mcu_fd_sc_mcu9t5v0__nand3_2
X$3744 \$12014 \$11306 \$11555 \$9593 gf180mcu_fd_sc_mcu9t5v0__buf_4
X$3745 \$12152 \$9595 \$12151 \$12153 \$12260 \$11993 \$12154
+ gf180mcu_fd_sc_mcu9t5v0__oai31_1
X$3746 \$9595 \$11977 \$11840 \$11841 \$11956 \$11827 \$11842
+ gf180mcu_fd_sc_mcu9t5v0__oai31_1
X$3747 \$9595 \$12546 \$12680 \$12679 \$12786 \$12526 \$12678
+ gf180mcu_fd_sc_mcu9t5v0__oai31_1
X$3748 \$9595 \$12685 \$12684 \$12683 \$12786 \$12526 \$12686
+ gf180mcu_fd_sc_mcu9t5v0__oai31_1
X$3749 \$9595 \$12554 \$12555 \$12908 \$12786 \$12526 \$12795
+ gf180mcu_fd_sc_mcu9t5v0__oai31_1
X$3750 \$9595 \$11326 \$11327 \$11201 \$11306 \$11182 \$11203
+ gf180mcu_fd_sc_mcu9t5v0__oai31_1
X$3751 \$12498 \$9595 \$12786 \$12930 \$12908 gf180mcu_fd_sc_mcu9t5v0__nand2_1
X$3752 \$12384 \$9595 \$12260 \$12376 \$12153 gf180mcu_fd_sc_mcu9t5v0__nand2_1
X$3753 \$11202 \$9595 \$11136 \$11182 \$11201 gf180mcu_fd_sc_mcu9t5v0__nand2_1
X$3754 \$10044 \$9595 \$9748 \$9703 \$9730 gf180mcu_fd_sc_mcu9t5v0__nand2_1
X$3755 \$11320 \$9595 \$12786 \$12526 \$12679 gf180mcu_fd_sc_mcu9t5v0__nand2_1
X$3756 \$11838 \$9595 \$11956 \$11827 \$11841 gf180mcu_fd_sc_mcu9t5v0__nand2_1
X$3757 \$12548 \$9595 \$12786 \$12526 \$12683 gf180mcu_fd_sc_mcu9t5v0__nand2_1
X$3758 \$12010 \$12786 \$12526 \$9595 gf180mcu_fd_sc_mcu9t5v0__buf_8
X$3759 \$13846 \$13341 \$13083 \$9604 gf180mcu_fd_sc_mcu9t5v0__buf_8
X$3760 \$9605 \$20333 \$20209 \$20383 \$20375 gf180mcu_fd_sc_mcu9t5v0__nand2_1
X$3761 \$9605 \$19597 \$20209 \$20087 \$20041 gf180mcu_fd_sc_mcu9t5v0__nand2_1
X$3762 \$9605 \$19605 \$19466 \$19462 gf180mcu_fd_sc_mcu9t5v0__clkinv_1
X$3763 \$9701 \$9703 \$9608 \$9605 gf180mcu_fd_sc_mcu9t5v0__buf_8
X$3764 \$9605 \$14454 \$14635 \$14870 gf180mcu_fd_sc_mcu9t5v0__buf_1
X$3765 \$13075 \$9606 \$13078 \$13881 \$13729 \$13832
+ gf180mcu_fd_sc_mcu9t5v0__oai21_1
X$3766 \$9608 \$9703 \$9741 gf180mcu_fd_sc_mcu9t5v0__tiel
X$3767 \$9700 \$9703 \$9608 \$9701 gf180mcu_fd_sc_mcu9t5v0__buf_1
X$3768 \$9758 \$9608 \$9703 \$9709 gf180mcu_fd_sc_mcu9t5v0__clkinv_1
X$3769 \$9703 \$9608 gf180mcu_fd_sc_mcu9t5v0__filltie
X$3770 \$9703 \$9608 gf180mcu_fd_sc_mcu9t5v0__filltie
X$3771 \$9703 \$9608 gf180mcu_fd_sc_mcu9t5v0__filltie
X$3772 \$9703 \$9608 gf180mcu_fd_sc_mcu9t5v0__filltie
X$3773 \$9703 \$9608 gf180mcu_fd_sc_mcu9t5v0__filltie
X$3774 \$9703 \$9608 gf180mcu_fd_sc_mcu9t5v0__filltie
X$3775 \$9703 \$9608 gf180mcu_fd_sc_mcu9t5v0__endcap
X$3776 \$10651 \$10630 \$10782 \$9700 gf180mcu_fd_sc_mcu9t5v0__dlyc_1
X$3777 \$9926 \$9748 \$9703 \$9804 gf180mcu_fd_sc_mcu9t5v0__clkinv_1
X$3778 \$9703 \$9748 gf180mcu_fd_sc_mcu9t5v0__filltie
X$3779 \$9703 \$9748 gf180mcu_fd_sc_mcu9t5v0__filltie
X$3780 \$9703 \$9748 gf180mcu_fd_sc_mcu9t5v0__filltie
X$3781 \$9703 \$9748 gf180mcu_fd_sc_mcu9t5v0__filltie
X$3782 \$9703 \$9748 gf180mcu_fd_sc_mcu9t5v0__filltie
X$3783 \$9703 \$9748 gf180mcu_fd_sc_mcu9t5v0__filltie
X$3784 \$9760 \$9761 \$9758 \$9748 \$9703 gf180mcu_fd_sc_mcu9t5v0__dffq_2
X$3785 \$9899 \$9754 \$9704 \$9748 \$9703 gf180mcu_fd_sc_mcu9t5v0__dffq_2
X$3786 \$10291 \$9732 \$9787 \$9748 \$9703 gf180mcu_fd_sc_mcu9t5v0__dffq_2
X$3787 \$9789 \$9733 \$9734 \$9748 \$9703 gf180mcu_fd_sc_mcu9t5v0__dffq_2
X$3788 \$9703 \$9748 gf180mcu_fd_sc_mcu9t5v0__endcap
X$3789 \$11307 \$12663 \$10523 \$9758 \$12379 \$9706 \$12786 \$12930 \$12933
+ gf180mcu_fd_sc_mcu9t5v0__mux4_1
X$3790 \$12531 \$12530 \$10914 \$11717 \$12379 \$9706 \$12786 \$12526 \$12662
+ gf180mcu_fd_sc_mcu9t5v0__mux4_1
X$3791 \$11716 \$12380 \$11519 \$10515 \$12379 \$9706 \$12486 \$12376 \$12790
+ gf180mcu_fd_sc_mcu9t5v0__mux4_1
X$3792 \$11184 \$10031 \$9706 \$11136 \$11182 \$11183
+ gf180mcu_fd_sc_mcu9t5v0__mux2_1
X$3793 \$12377 \$12660 \$9706 \$12786 \$12930 \$12931
+ gf180mcu_fd_sc_mcu9t5v0__mux2_1
X$3794 \$21147 \$19154 \$21663 \$9708 \$21498 \$21308 \$21360
+ gf180mcu_fd_sc_mcu9t5v0__aoi22_1
X$3795 \$11525 \$11526 \$11191 \$11306 \$11555 \$9711
+ gf180mcu_fd_sc_mcu9t5v0__oai21_4
X$3796 \$10039 \$9715 \$10526 \$9712 \$9748 \$9900 \$9720
+ gf180mcu_fd_sc_mcu9t5v0__nand4_4
X$3797 \$11153 \$11152 \$10901 \$11025 \$9712 gf180mcu_fd_sc_mcu9t5v0__and2_2
X$3798 \$10288 \$10405 \$10403 \$10391 \$10282 \$9713
+ gf180mcu_fd_sc_mcu9t5v0__nor3_1
X$3799 \$10404 \$11308 \$10525 \$11136 \$11182 \$9714
+ gf180mcu_fd_sc_mcu9t5v0__oai21_4
X$3800 \$9714 \$11136 \$11182 \$11154 gf180mcu_fd_sc_mcu9t5v0__buf_8
X$3801 \$13220 \$13092 \$13219 \$13341 \$13083 \$9715
+ gf180mcu_fd_sc_mcu9t5v0__oai21_4
X$3802 \$9715 \$10406 \$10405 \$10391 \$10514 \$10407
+ gf180mcu_fd_sc_mcu9t5v0__nor3_4
X$3803 \$10406 \$9715 \$10630 \$10514 \$10638 gf180mcu_fd_sc_mcu9t5v0__nor2_1
X$3804 \$12011 \$12260 \$11993 \$9716 gf180mcu_fd_sc_mcu9t5v0__buf_8
X$3805 \$9760 \$9717 \$9719 \$9748 \$9900 gf180mcu_fd_sc_mcu9t5v0__dffq_2
X$3806 \$21389 \$19042 \$19165 \$9727 \$21498 \$21308 \$21031
+ gf180mcu_fd_sc_mcu9t5v0__aoi22_1
X$3807 \$11034 \$10901 \$11025 \$9735 gf180mcu_fd_sc_mcu9t5v0__buf_8
X$3808 \$9735 \$10677 \$10258 \$10630 \$10782 \$10675
+ gf180mcu_fd_sc_mcu9t5v0__mux2_1
X$3809 \$13865 \$13519 \$13350 \$13623 \$13452 \$9736
+ gf180mcu_fd_sc_mcu9t5v0__mux2_1
X$3810 \$9739 \$12159 \$12260 \$11993 \$12160 gf180mcu_fd_sc_mcu9t5v0__nand2_1
X$3811 \$11042 pad_din[3] \$I20747 \$I20765 \$I20756 \$I20774 \$I20783 \$I20801
+ \$I20792 \$I20810 \$I20819 \$I20837 \$I20828 \$I20846 \$I20855 \$I20864
+ \$I20873 \$I20882 \$I20891 \$I20900 \$I20909 \$I20918 \$I20927 \$I20936
+ \$I20945 \$I20954 \$I20963 \$I20981 \$I20972 \$I20990 \$I20999 \$I21017
+ \$I21008 \$I21026 \$I21044 \$I21035 \$I21053 \$I21062 \$I21071 \$I21089
+ \$I21080 \$I21098 \$I21107 \$I21116 \$I21125 \$I21134 \$I21143 \$I21161
+ \$I21152 \$I21170 \$I21179 \$I21197 \$I21188 \$I21206 \$I21215 \$I21233
+ \$I21224 \$I21242 \$I21251 \$I21269 \$I21260 \$I21278 \$I21287 \$I21296
+ \$I21305 \$I21314 \$I21323 \$I21332 \$I21341 \$I21350 \$I21368 \$I21377
+ \$I21404 \$I21413 \$I21359 \$I21395 \$I21386 \$I21431 \$I21422 \$I21458
+ \$I21449 \$I21467 \$I21440 \$I21485 \$I21476 \$I21494 \$I21512 \$I21539
+ \$I21548 \$I21557 \$I21503 \$I21530 \$I21521 \$I21575 \$I21566 \$I21584
+ \$I21593 \$I21602 \$I21611 \$I21620 \$I21629 \$I21638 \$9741 \$I21647
+ \$I21665 \$I21656 \$I21674 \$9741 \$10651 gf180mcu_fd_io__in_c
X$3812 \$9904 \$9748 \$9900 \$9905 gf180mcu_fd_sc_mcu9t5v0__buf_8
X$3813 \$9787 \$9748 \$9900 \$9909 gf180mcu_fd_sc_mcu9t5v0__clkinv_1
X$3814 \$9904 \$9748 \$9900 \$9762 gf180mcu_fd_sc_mcu9t5v0__clkinv_1
X$3815 \$9918 \$9748 \$9900 \$9792 gf180mcu_fd_sc_mcu9t5v0__clkinv_1
X$3816 \$9911 \$9910 \$9748 \$9900 \$9912 gf180mcu_fd_sc_mcu9t5v0__nand2_1
X$3817 \$9760 \$9907 \$10032 \$9748 \$9900 gf180mcu_fd_sc_mcu9t5v0__dffq_2
X$3818 \$9760 \$9766 \$10037 \$9748 \$9900 gf180mcu_fd_sc_mcu9t5v0__dffq_2
X$3819 \$10291 \$9784 \$9782 \$9748 \$9900 gf180mcu_fd_sc_mcu9t5v0__dffq_2
X$3820 \$9899 \$9749 \$9750 \$9748 \$9900 gf180mcu_fd_sc_mcu9t5v0__dffq_2
X$3821 \$9899 \$9902 \$9903 \$9748 \$9900 gf180mcu_fd_sc_mcu9t5v0__dffq_2
X$3822 \$9789 \$9916 \$9918 \$9748 \$9900 gf180mcu_fd_sc_mcu9t5v0__dffq_2
X$3823 \$9900 \$9748 gf180mcu_fd_sc_mcu9t5v0__filltie
X$3824 \$9900 \$9748 gf180mcu_fd_sc_mcu9t5v0__filltie
X$3825 \$9900 \$9748 gf180mcu_fd_sc_mcu9t5v0__filltie
X$3826 \$9900 \$9748 gf180mcu_fd_sc_mcu9t5v0__filltie
X$3827 \$9900 \$9748 gf180mcu_fd_sc_mcu9t5v0__filltie
X$3828 \$9900 \$9748 gf180mcu_fd_sc_mcu9t5v0__filltie
X$3829 \$9900 \$9748 gf180mcu_fd_sc_mcu9t5v0__endcap
X$3830 \$10394 \$9752 \$10662 \$10630 \$10514 \$10513
+ gf180mcu_fd_sc_mcu9t5v0__mux2_2
X$3831 \$9899 \$10513 \$9752 \$10391 \$10514 gf180mcu_fd_sc_mcu9t5v0__dffq_2
X$3832 \$21362 \$21661 \$21622 \$9755 \$21664 gf180mcu_fd_sc_mcu9t5v0__xor2_1
X$3833 \$16851 \$9755 \$21362 \$21498 \$21622 \$21627
+ gf180mcu_fd_sc_mcu9t5v0__aoi21_1
X$3834 \$9760 \$10901 \$11025 gf180mcu_fd_sc_mcu9t5v0__inv_3
X$3835 \$9760 \$11832 \$11831 \$11675 \$11827 gf180mcu_fd_sc_mcu9t5v0__dffq_2
X$3836 \$9760 \$12264 \$12380 \$12260 \$12376 gf180mcu_fd_sc_mcu9t5v0__dffq_2
X$3837 \$9760 \$11185 \$11519 \$11136 \$11182 gf180mcu_fd_sc_mcu9t5v0__dffq_2
X$3838 \$9760 \$10398 \$10523 \$10391 \$10514 gf180mcu_fd_sc_mcu9t5v0__dffq_2
X$3839 \$9760 \$10524 \$10515 \$10391 \$10514 gf180mcu_fd_sc_mcu9t5v0__dffq_2
X$3840 \$9760 \$11521 \$11717 \$11306 \$11555 gf180mcu_fd_sc_mcu9t5v0__dffq_2
X$3841 \$9760 \$12792 \$12530 \$13035 \$12930 gf180mcu_fd_sc_mcu9t5v0__dffq_2
X$3842 \$9760 \$11833 \$11829 \$11956 \$11827 gf180mcu_fd_sc_mcu9t5v0__dffq_2
X$3843 \$9760 \$10520 \$10632 \$10630 \$10514 gf180mcu_fd_sc_mcu9t5v0__dffq_2
X$3844 \$9760 \$10033 \$10030 \$10022 \$9900 gf180mcu_fd_sc_mcu9t5v0__dffq_2
X$3845 \$9760 \$10912 \$10914 \$11136 \$11025 gf180mcu_fd_sc_mcu9t5v0__dffq_2
X$3846 \$9760 \$10531 \$10640 \$10630 \$10514 gf180mcu_fd_sc_mcu9t5v0__dffq_2
X$3847 \$10032 \$10022 \$9900 \$9763 gf180mcu_fd_sc_mcu9t5v0__clkinv_1
X$3848 \$10037 \$10022 \$9900 \$9765 gf180mcu_fd_sc_mcu9t5v0__clkinv_1
X$3849 \$13506 \$13623 \$13452 \$9767 gf180mcu_fd_sc_mcu9t5v0__buf_8
X$3850 \$10922 \$10921 \$10920 \$10901 \$11025 \$9772
+ gf180mcu_fd_sc_mcu9t5v0__nand3_4
X$3851 \$11038 \$13636 \$9775 \$13471 \$13623 \$13729
+ gf180mcu_fd_sc_mcu9t5v0__dffrnq_2
X$3852 \$9775 \$13341 \$13083 \$12022 gf180mcu_fd_sc_mcu9t5v0__clkinv_1
X$3853 \$13516 \$9775 \$13518 \$13623 \$13452 \$13517
+ gf180mcu_fd_sc_mcu9t5v0__mux2_1
X$3854 \$9775 \$13516 \$14521 \$13623 \$13729 \$13857
+ gf180mcu_fd_sc_mcu9t5v0__mux2_1
X$3855 \$9779 \$10391 \$10282 \$10410 gf180mcu_fd_sc_mcu9t5v0__clkinv_1
X$3856 \$10291 \$10532 \$9779 \$10630 \$10514 gf180mcu_fd_sc_mcu9t5v0__dffq_2
X$3857 \$10291 \$10292 \$9781 \$10391 \$10282 gf180mcu_fd_sc_mcu9t5v0__dffq_2
X$3858 \$10291 \$10255 \$9783 \$10391 \$10282 gf180mcu_fd_sc_mcu9t5v0__dffq_2
X$3859 \$9783 \$10256 \$10257 \$10022 \$10282 \$10255
+ gf180mcu_fd_sc_mcu9t5v0__mux2_1
X$3860 \$9789 \$11306 \$11182 gf180mcu_fd_sc_mcu9t5v0__inv_4
X$3861 \$9789 \$11161 \$11207 \$11306 \$11555 gf180mcu_fd_sc_mcu9t5v0__dffq_2
X$3862 \$9789 \$12556 \$12557 \$12486 \$12526 gf180mcu_fd_sc_mcu9t5v0__dffq_2
X$3863 \$9789 \$12941 \$12688 \$13035 \$13083 gf180mcu_fd_sc_mcu9t5v0__dffq_2
X$3864 \$9789 \$10930 \$10931 \$10901 \$11025 gf180mcu_fd_sc_mcu9t5v0__dffq_2
X$3865 \$9789 \$10808 \$10679 \$10901 \$11025 gf180mcu_fd_sc_mcu9t5v0__dffq_2
X$3866 \$9789 \$10810 \$10680 \$10901 \$10782 gf180mcu_fd_sc_mcu9t5v0__dffq_2
X$3867 \$9789 \$10295 \$10414 \$10391 \$10282 gf180mcu_fd_sc_mcu9t5v0__dffq_2
X$3868 \$9789 \$10807 \$10676 \$10901 \$10782 gf180mcu_fd_sc_mcu9t5v0__dffq_2
X$3869 \$9789 \$11843 \$11730 \$11956 \$11827 gf180mcu_fd_sc_mcu9t5v0__dffq_2
X$3870 \$9789 \$11204 \$11205 \$11306 \$11182 gf180mcu_fd_sc_mcu9t5v0__dffq_2
X$3871 \$9789 \$12687 \$12500 \$12786 \$12526 gf180mcu_fd_sc_mcu9t5v0__dffq_2
X$3872 \$9789 \$12030 \$12155 \$12260 \$11993 gf180mcu_fd_sc_mcu9t5v0__dffq_2
X$3873 \$9789 \$12029 \$12275 \$12260 \$11993 gf180mcu_fd_sc_mcu9t5v0__dffq_2
X$3874 \$9789 \$10050 \$10268 \$10022 \$9900 gf180mcu_fd_sc_mcu9t5v0__dffq_2
X$3875 \$14521 \$9795 \$13510 \$14151 \$14034 \$14162
+ gf180mcu_fd_sc_mcu9t5v0__oai21_1
X$3876 \$13900 \$13866 \$13226 \$13881 \$14034 \$9795
+ gf180mcu_fd_sc_mcu9t5v0__mux2_1
X$3877 \$11043 pad_dout[4] \$I20746 \$I20755 \$I20764 \$I20773 \$I20782
+ \$I20791 \$I20800 \$I20809 \$I20818 \$I20827 \$I20836 \$I20845 \$I20854
+ \$I20863 \$I20872 \$I20881 \$I20890 \$I20899 \$I20908 \$I20917 \$I20926
+ \$I20935 \$I20944 \$I20953 \$I20962 \$I20971 \$I20980 \$I20989 \$I20998
+ \$I21007 \$I21016 \$I21025 \$I21034 \$I21043 \$I21052 \$I21061 \$I21070
+ \$I21079 \$I21088 \$I21097 \$I21106 \$I21115 \$I21124 \$I21133 \$I21142
+ \$I21151 \$I21160 \$I21169 \$I21178 \$I21187 \$I21196 \$I21205 \$I21214
+ \$I21223 \$I21232 \$I21241 \$I21250 \$I21259 \$I21268 \$I21277 \$I21286
+ \$I21295 \$I21304 \$I21313 \$9930 \$I21322 \$I21331 \$I21340 \$I21349
+ \$I21358 \$I21367 \$I21376 \$I21385 \$I21394 \$I21403 \$I21412 \$I21421
+ \$I21430 \$I21439 \$I21448 \$I21457 \$I21466 \$I21475 \$I21484 \$I21493
+ \$I21502 \$I21511 \$I21520 \$I21529 \$I21538 \$I21547 \$I21556 \$I21565
+ \$I21574 \$I21583 \$I21592 \$I21601 \$9805 \$I21610 \$I21619 \$I21628
+ \$I21637 \$I21646 \$I21655 \$I21664 \$I21673 \$9805 \$9805 \$9930 \$9805
+ \$9805 \$11545 \$9930 gf180mcu_fd_io__bi_t
X$3878 \$11675 \$11555 \$9805 gf180mcu_fd_sc_mcu9t5v0__tiel
X$3879 \$9899 \$10901 \$10782 \$I71630 gf180mcu_fd_sc_mcu9t5v0__inv_2
X$3880 \$9899 \$12381 \$12531 \$12260 \$12376 gf180mcu_fd_sc_mcu9t5v0__dffq_2
X$3881 \$9899 \$11142 \$10518 \$11136 \$11182 gf180mcu_fd_sc_mcu9t5v0__dffq_2
X$3882 \$9899 \$12791 \$12663 \$12786 \$12930 gf180mcu_fd_sc_mcu9t5v0__dffq_2
X$3883 \$9899 \$10235 \$10236 \$10022 \$10282 gf180mcu_fd_sc_mcu9t5v0__dffq_2
X$3884 \$9899 \$10237 \$10238 \$10391 \$10282 gf180mcu_fd_sc_mcu9t5v0__dffq_2
X$3885 \$9899 \$10787 \$10788 \$10901 \$10782 gf180mcu_fd_sc_mcu9t5v0__dffq_2
X$3886 \$9899 \$10785 \$10905 \$10901 \$10782 gf180mcu_fd_sc_mcu9t5v0__dffq_2
X$3887 \$9899 \$11141 \$11026 \$11136 \$11025 gf180mcu_fd_sc_mcu9t5v0__dffq_2
X$3888 \$9899 \$10284 \$10285 \$10391 \$10282 gf180mcu_fd_sc_mcu9t5v0__dffq_2
X$3889 \$9899 \$11999 \$11716 \$12260 \$11993 gf180mcu_fd_sc_mcu9t5v0__dffq_2
X$3890 \$9899 \$10783 \$10904 \$10901 \$10782 gf180mcu_fd_sc_mcu9t5v0__dffq_2
X$3891 \$9899 \$11562 \$11307 \$11675 \$11555 gf180mcu_fd_sc_mcu9t5v0__dffq_2
X$3892 \$9899 \$10283 \$11517 \$10391 \$10282 gf180mcu_fd_sc_mcu9t5v0__dffq_2
X$3893 \$10039 \$10022 \$9900 \$10040 gf180mcu_fd_sc_mcu9t5v0__buf_8
X$3894 \$9900 \$10022 gf180mcu_fd_sc_mcu9t5v0__filltie
X$3895 \$9900 \$10022 gf180mcu_fd_sc_mcu9t5v0__filltie
X$3896 \$9900 \$10022 gf180mcu_fd_sc_mcu9t5v0__filltie
X$3897 \$9900 \$10022 gf180mcu_fd_sc_mcu9t5v0__filltie
X$3898 \$9900 \$10022 gf180mcu_fd_sc_mcu9t5v0__filltie
X$3899 \$9900 \$10022 gf180mcu_fd_sc_mcu9t5v0__filltie
X$3900 \$9900 \$10022 gf180mcu_fd_sc_mcu9t5v0__endcap
X$3901 \$15152 \$14990 \$13498 \$15045 \$14875 \$9904
+ gf180mcu_fd_sc_mcu9t5v0__mux2_1
X$3902 \$22278 \$19154 \$22910 \$9912 \$22713 \$22837 \$22866
+ gf180mcu_fd_sc_mcu9t5v0__aoi22_1
X$3903 \$12939 \$13035 \$12930 \$9917 gf180mcu_fd_sc_mcu9t5v0__buf_8
X$3904 \$9917 \$12548 \$10258 \$13035 \$13083 \$13101
+ gf180mcu_fd_sc_mcu9t5v0__mux2_1
X$3905 \$11038 \$10932 \$9924 \$10901 \$11025 gf180mcu_fd_sc_mcu9t5v0__dffq_2
X$3906 \$9928 \$10541 \$10391 \$10514 \$10421 gf180mcu_fd_sc_mcu9t5v0__nand2_1
X$3907 \$11675 \$11555 \$9930 gf180mcu_fd_sc_mcu9t5v0__tieh
X$3908 \$10652 \$10653 \$10017 \$12245 \$10630 \$10782
+ gf180mcu_fd_sc_mcu9t5v0__dffrnq_2
X$3909 \$10018 \$10022 \$10282 \$10024 gf180mcu_fd_sc_mcu9t5v0__buf_8
X$3910 \$10019 \$10022 \$10282 \$10225 gf180mcu_fd_sc_mcu9t5v0__clkinv_1
X$3911 \$10265 \$10258 \$10022 \$10282 \$10267 gf180mcu_fd_sc_mcu9t5v0__nand2_1
X$3912 \$11038 \$10052 \$10051 \$10022 \$10282 gf180mcu_fd_sc_mcu9t5v0__dffq_2
X$3913 \$10282 \$10022 gf180mcu_fd_sc_mcu9t5v0__filltie
X$3914 \$10282 \$10022 gf180mcu_fd_sc_mcu9t5v0__filltie
X$3915 \$10282 \$10022 gf180mcu_fd_sc_mcu9t5v0__filltie
X$3916 \$10282 \$10022 gf180mcu_fd_sc_mcu9t5v0__filltie
X$3917 \$10282 \$10022 gf180mcu_fd_sc_mcu9t5v0__filltie
X$3918 \$10282 \$10022 gf180mcu_fd_sc_mcu9t5v0__filltie
X$3919 \$10282 \$10022 gf180mcu_fd_sc_mcu9t5v0__endcap
X$3920 \$11553 \$11552 \$10024 \$11675 \$11555 \$11513
+ gf180mcu_fd_sc_mcu9t5v0__oai21_1
X$3921 \$10024 \$11509 \$11306 \$11182 \$11023 gf180mcu_fd_sc_mcu9t5v0__nand2_1
X$3922 \$10024 \$11952 \$11675 \$11555 \$11508 gf180mcu_fd_sc_mcu9t5v0__nand2_1
X$3923 \$10281 \$10230 \$10025 \$10391 \$10282 gf180mcu_fd_sc_mcu9t5v0__dffq_2
X$3924 \$10027 \$10391 \$10514 \$10397 gf180mcu_fd_sc_mcu9t5v0__clkinv_1
X$3925 \$17111 \$10027 \$14217 \$16914 \$17034 \$17053
+ gf180mcu_fd_sc_mcu9t5v0__mux2_1
X$3926 \$16458 \$17115 \$13226 \$17085 \$17034 \$10027
+ gf180mcu_fd_sc_mcu9t5v0__mux2_1
X$3927 \$11522 \$11690 \$10921 \$10922 \$11306 \$11555 \$10038
+ gf180mcu_fd_sc_mcu9t5v0__oai211_2
X$3928 \$10404 \$10525 \$10391 \$10514 \$10039 gf180mcu_fd_sc_mcu9t5v0__and2_2
X$3929 \$10040 \$11967 \$12540 \$12675 \$12486 \$12526 \$12542
+ gf180mcu_fd_sc_mcu9t5v0__oai31_2
X$3930 \$13230 \$14046 \$10044 \$13471 \$13881 \$14034
+ gf180mcu_fd_sc_mcu9t5v0__dffrnq_2
X$3931 \$10044 \$12912 \$14151 \$14034 \$14047 gf180mcu_fd_sc_mcu9t5v0__nand2_1
X$3932 \$13075 \$10225 \$13078 \$13035 \$13083 \$13074
+ gf180mcu_fd_sc_mcu9t5v0__oai21_1
X$3933 \$10390 \$10226 \$10512 \$10391 \$10514 \$11176
+ gf180mcu_fd_sc_mcu9t5v0__aoi21_1
X$3934 \$13893 \$13899 \$13226 \$13623 \$13729 \$10227
+ gf180mcu_fd_sc_mcu9t5v0__mux2_1
X$3935 \$10281 \$10228 \$10229 \$10391 \$10282 gf180mcu_fd_sc_mcu9t5v0__dffq_2
X$3936 \$14497 \$14507 \$13498 \$14748 \$14635 \$10233
+ gf180mcu_fd_sc_mcu9t5v0__mux2_1
X$3937 \$13839 \$13838 \$13498 \$13881 \$13729 \$10240
+ gf180mcu_fd_sc_mcu9t5v0__mux2_1
X$3938 \$10241 \$11306 \$11555 \$10910 gf180mcu_fd_sc_mcu9t5v0__clkinv_1
X$3939 \$14007 \$14044 \$13226 \$13881 \$14034 \$10241
+ gf180mcu_fd_sc_mcu9t5v0__mux2_1
X$3940 \$14010 \$17506 \$10245 \$13634 \$17538 \$17367
+ gf180mcu_fd_sc_mcu9t5v0__dffrnq_2
X$3941 \$10245 \$12912 \$17085 \$17367 \$17505 gf180mcu_fd_sc_mcu9t5v0__nand2_1
X$3942 \$10291 \$10248 \$10249 \$10391 \$10282 gf180mcu_fd_sc_mcu9t5v0__dffq_2
X$3943 \$22857 \$10253 \$23032 \$22713 \$22837 \$22856
+ gf180mcu_fd_sc_mcu9t5v0__aoi21_1
X$3944 \$22857 \$10253 \$22856 \$22713 \$22837 \$22722
+ gf180mcu_fd_sc_mcu9t5v0__oai21_1
X$3945 \$10413 \$10257 \$10266 \$10267 \$10391 \$10514 \$10295
+ gf180mcu_fd_sc_mcu9t5v0__oai211_1
X$3946 \$11162 \$10257 \$11037 \$11163 \$11136 \$11025 \$11161
+ gf180mcu_fd_sc_mcu9t5v0__oai211_1
X$3947 \$12271 \$12260 \$12376 \$10257 gf180mcu_fd_sc_mcu9t5v0__buf_8
X$3948 \$12382 \$13223 \$10257 \$13341 \$13452 \$13222
+ gf180mcu_fd_sc_mcu9t5v0__mux2_1
X$3949 \$12157 \$13100 \$10257 \$13341 \$13452 \$13231
+ gf180mcu_fd_sc_mcu9t5v0__mux2_1
X$3950 \$10676 \$10675 \$10257 \$10630 \$10782 \$10807
+ gf180mcu_fd_sc_mcu9t5v0__mux2_1
X$3951 \$11847 \$12796 \$10257 \$13035 \$12930 \$12943
+ gf180mcu_fd_sc_mcu9t5v0__mux2_1
X$3952 \$13232 \$13101 \$10257 \$13341 \$13083 \$13352
+ gf180mcu_fd_sc_mcu9t5v0__mux2_1
X$3953 \$11202 \$10258 \$11136 \$11182 \$11163 gf180mcu_fd_sc_mcu9t5v0__nand2_1
X$3954 \$12498 \$10258 \$13035 \$12930 \$13048 gf180mcu_fd_sc_mcu9t5v0__nand2_1
X$3955 \$12267 \$12486 \$12376 \$10258 gf180mcu_fd_sc_mcu9t5v0__buf_8
X$3956 \$12494 \$11320 \$10258 \$13035 \$13083 \$13223
+ gf180mcu_fd_sc_mcu9t5v0__mux2_1
X$3957 \$13899 \$13226 \$13864 \$13881 \$13729 \$10260
+ gf180mcu_fd_sc_mcu9t5v0__aoi21_1
X$3958 \$14217 \$10260 \$15321 \$15490 \$15506 gf180mcu_fd_sc_mcu9t5v0__nand2_1
X$3959 \$10291 \$10264 \$10293 \$10391 \$10282 gf180mcu_fd_sc_mcu9t5v0__dffq_2
X$3960 \$14241 \$15521 \$10265 \$13471 \$15321 \$15490
+ gf180mcu_fd_sc_mcu9t5v0__dffrnq_2
X$3961 \$10265 \$12912 \$15321 \$15204 \$15340 gf180mcu_fd_sc_mcu9t5v0__nand2_1
X$3962 \$10269 \$23335 \$23620 \$23454 \$23639 gf180mcu_fd_sc_mcu9t5v0__xnor2_1
X$3963 \$16851 \$10269 \$23464 \$23195 \$23183 \$23454 \$23472
+ gf180mcu_fd_sc_mcu9t5v0__aoi211_2
X$3964 \$10281 \$12258 \$12484 \$13634 \$12260 \$12376
+ gf180mcu_fd_sc_mcu9t5v0__dffrnq_2
X$3965 \$10281 \$12522 \$12657 \$13634 \$12786 \$12526
+ gf180mcu_fd_sc_mcu9t5v0__dffrnq_2
X$3966 \$10281 \$11136 \$11182 gf180mcu_fd_sc_mcu9t5v0__clkinv_3
X$3967 \$10281 \$10903 \$10780 \$10901 \$11025 gf180mcu_fd_sc_mcu9t5v0__dffq_2
X$3968 \$10281 \$10392 \$10393 \$10391 \$10514 gf180mcu_fd_sc_mcu9t5v0__dffq_2
X$3969 \$10281 \$11991 \$11955 \$11956 \$11993 gf180mcu_fd_sc_mcu9t5v0__dffq_2
X$3970 \$10281 \$11177 \$11178 \$11136 \$11182 gf180mcu_fd_sc_mcu9t5v0__dffq_2
X$3971 \$10281 \$11510 \$11511 \$11306 \$11555 gf180mcu_fd_sc_mcu9t5v0__dffq_2
X$3972 \$10281 \$11672 \$11550 \$11675 \$11827 gf180mcu_fd_sc_mcu9t5v0__dffq_2
X$3973 \$10281 \$11134 \$11135 \$11136 \$11182 gf180mcu_fd_sc_mcu9t5v0__dffq_2
X$3974 \$10281 \$10627 \$10777 \$10630 \$10782 gf180mcu_fd_sc_mcu9t5v0__dffq_2
X$3975 \$10281 \$11137 \$11179 \$11136 \$11182 gf180mcu_fd_sc_mcu9t5v0__dffq_2
X$3976 \$10281 \$12485 \$12524 \$12486 \$12526 gf180mcu_fd_sc_mcu9t5v0__dffq_2
X$3977 \$10281 \$11133 \$11175 \$11136 \$11182 gf180mcu_fd_sc_mcu9t5v0__dffq_2
X$3978 \$10281 \$11549 \$11507 \$11675 \$11555 gf180mcu_fd_sc_mcu9t5v0__dffq_2
X$3979 \$10281 \$10778 \$10660 \$10901 \$10782 gf180mcu_fd_sc_mcu9t5v0__dffq_2
X$3980 \$10281 \$10779 \$10661 \$10901 \$10782 gf180mcu_fd_sc_mcu9t5v0__dffq_2
X$3981 \$10281 \$11180 \$11515 \$11306 \$11182 gf180mcu_fd_sc_mcu9t5v0__dffq_2
X$3982 \$10288 \$10403 \$10391 \$10282 \$10289 gf180mcu_fd_sc_mcu9t5v0__nor2_2
X$3983 \$10515 \$10391 \$10282 \$10400 gf180mcu_fd_sc_mcu9t5v0__clkinv_1
X$3984 \$10282 \$10391 gf180mcu_fd_sc_mcu9t5v0__filltie
X$3985 \$10282 \$10391 gf180mcu_fd_sc_mcu9t5v0__filltie
X$3986 \$10282 \$10391 gf180mcu_fd_sc_mcu9t5v0__filltie
X$3987 \$10282 \$10391 gf180mcu_fd_sc_mcu9t5v0__filltie
X$3988 \$10282 \$10391 gf180mcu_fd_sc_mcu9t5v0__filltie
X$3989 \$10282 \$10391 gf180mcu_fd_sc_mcu9t5v0__filltie
X$3990 \$10282 \$10391 gf180mcu_fd_sc_mcu9t5v0__endcap
X$3991 \$12008 \$11522 \$12007 \$12006 \$11956 \$11993 \$10288
+ gf180mcu_fd_sc_mcu9t5v0__aoi22_2
X$3992 \$11154 \$10288 \$11153 \$11136 \$11025 \$10919
+ gf180mcu_fd_sc_mcu9t5v0__nand3_4
X$3993 \$12935 \$12672 \$12668 \$12142 \$12786 \$12930 \$10290
+ gf180mcu_fd_sc_mcu9t5v0__and4_4
X$3994 \$10291 \$10901 \$11025 \$I68976 gf180mcu_fd_sc_mcu9t5v0__inv_1
X$3995 \$10291 \$10802 \$10412 \$10630 \$10782 gf180mcu_fd_sc_mcu9t5v0__dffq_2
X$3996 \$10291 \$10644 \$10535 \$10630 \$10782 gf180mcu_fd_sc_mcu9t5v0__dffq_2
X$3997 \$10291 \$11195 \$11196 \$11136 \$11182 gf180mcu_fd_sc_mcu9t5v0__dffq_2
X$3998 \$10291 \$12024 \$11975 \$11956 \$11993 gf180mcu_fd_sc_mcu9t5v0__dffq_2
X$3999 \$10291 \$11532 \$11527 \$11306 \$11555 gf180mcu_fd_sc_mcu9t5v0__dffq_2
X$4000 \$10291 \$11318 \$12017 \$11306 \$11555 gf180mcu_fd_sc_mcu9t5v0__dffq_2
X$4001 \$10291 \$11036 \$10645 \$10901 \$10782 gf180mcu_fd_sc_mcu9t5v0__dffq_2
X$4002 \$10291 \$11573 \$11208 \$11675 \$11555 gf180mcu_fd_sc_mcu9t5v0__dffq_2
X$4003 \$10291 \$10795 \$11192 \$10901 \$10782 gf180mcu_fd_sc_mcu9t5v0__dffq_2
X$4004 \$10291 \$10797 \$10799 \$10901 \$10782 gf180mcu_fd_sc_mcu9t5v0__dffq_2
X$4005 \$10291 \$12027 \$12025 \$12260 \$11993 gf180mcu_fd_sc_mcu9t5v0__dffq_2
X$4006 \$10291 \$10796 \$10669 \$10901 \$10782 gf180mcu_fd_sc_mcu9t5v0__dffq_2
X$4007 \$11822 \$10385 \$11823 \$11956 \$11827 \$11945
+ gf180mcu_fd_sc_mcu9t5v0__aoi21_1
X$4008 \$10526 \$10525 \$10404 \$10391 \$10514 \$10405
+ gf180mcu_fd_sc_mcu9t5v0__nand3_4
X$4009 \$10414 \$10391 \$10514 \$10413 gf180mcu_fd_sc_mcu9t5v0__clkinv_1
X$4010 \$10514 \$10391 gf180mcu_fd_sc_mcu9t5v0__filltie
X$4011 \$10514 \$10391 gf180mcu_fd_sc_mcu9t5v0__filltie
X$4012 \$10514 \$10391 gf180mcu_fd_sc_mcu9t5v0__filltie
X$4013 \$10514 \$10391 gf180mcu_fd_sc_mcu9t5v0__filltie
X$4014 \$10514 \$10391 gf180mcu_fd_sc_mcu9t5v0__filltie
X$4015 \$10514 \$10391 gf180mcu_fd_sc_mcu9t5v0__filltie
X$4016 \$10514 \$10391 gf180mcu_fd_sc_mcu9t5v0__endcap
X$4017 \$11153 \$11152 \$11136 \$11025 \$10403 gf180mcu_fd_sc_mcu9t5v0__nand2_1
X$4018 \$10404 \$12270 \$12486 \$12376 \$12011 gf180mcu_fd_sc_mcu9t5v0__nor2_2
X$4019 \$12269 \$12260 \$12376 \$10404 gf180mcu_fd_sc_mcu9t5v0__clkbuf_8
X$4020 \$13216 \$13341 \$13083 \$10406 gf180mcu_fd_sc_mcu9t5v0__buf_8
X$4021 \$10917 \$10920 \$10407 \$10901 \$10782 \$10636
+ gf180mcu_fd_sc_mcu9t5v0__aoi21_4
X$4022 \$22905 \$19154 \$22910 \$10411 \$22713 \$22837 \$22858
+ gf180mcu_fd_sc_mcu9t5v0__aoi22_1
X$4023 \$10412 \$10630 \$10514 \$10641 gf180mcu_fd_sc_mcu9t5v0__clkinv_1
X$4024 \$20415 \$19042 \$18885 \$10416 \$20515 \$20383 \$20416
+ gf180mcu_fd_sc_mcu9t5v0__aoi22_1
X$4025 \$10636 \$10630 \$10514 \$10662 gf180mcu_fd_sc_mcu9t5v0__buf_8
X$4026 \$10772 \$10630 \$10514 \$10626 gf180mcu_fd_sc_mcu9t5v0__clkinv_1
X$4027 \$10540 \$10539 \$10630 \$10514 \$10646 gf180mcu_fd_sc_mcu9t5v0__nand2_1
X$4028 \$10514 \$10630 gf180mcu_fd_sc_mcu9t5v0__filltie
X$4029 \$10514 \$10630 gf180mcu_fd_sc_mcu9t5v0__filltie
X$4030 \$10514 \$10630 gf180mcu_fd_sc_mcu9t5v0__filltie
X$4031 \$10514 \$10630 gf180mcu_fd_sc_mcu9t5v0__filltie
X$4032 \$10514 \$10630 gf180mcu_fd_sc_mcu9t5v0__filltie
X$4033 \$10514 \$10630 gf180mcu_fd_sc_mcu9t5v0__filltie
X$4034 \$10514 \$10630 gf180mcu_fd_sc_mcu9t5v0__endcap
X$4035 \$10525 \$10526 \$11956 \$11827 \$11967 gf180mcu_fd_sc_mcu9t5v0__and2_1
X$4036 \$12008 \$12141 \$11835 \$12486 \$12526 \$10525
+ gf180mcu_fd_sc_mcu9t5v0__nand3_4
X$4037 \$12266 \$10526 \$12260 \$11993 \$11963 gf180mcu_fd_sc_mcu9t5v0__nor2_1
X$4038 \$11308 \$11306 \$11182 \$10526 gf180mcu_fd_sc_mcu9t5v0__buf_8
X$4039 \$10640 \$10630 \$10782 \$10529 gf180mcu_fd_sc_mcu9t5v0__clkinv_1
X$4040 \$10920 \$10794 \$10667 \$10630 \$10782 \$10530
+ gf180mcu_fd_sc_mcu9t5v0__nand3_1
X$4041 \$10537 \$24861 \$24877 \$24721 \$24890 gf180mcu_fd_sc_mcu9t5v0__xnor2_1
X$4042 \$16851 \$10537 \$24877 \$24721 \$24889 gf180mcu_fd_sc_mcu9t5v0__nand2_1
X$4043 \$10900 \$10628 \$10659 \$10901 \$10782 \$10899
+ gf180mcu_fd_sc_mcu9t5v0__aoi21_1
X$4044 \$11673 \$10629 \$11512 \$11675 \$11555 \$11825
+ gf180mcu_fd_sc_mcu9t5v0__aoi21_1
X$4045 \$10645 \$10630 \$10782 \$10673 gf180mcu_fd_sc_mcu9t5v0__clkinv_1
X$4046 \$10782 \$10630 gf180mcu_fd_sc_mcu9t5v0__filltie
X$4047 \$10782 \$10630 gf180mcu_fd_sc_mcu9t5v0__filltie
X$4048 \$10782 \$10630 gf180mcu_fd_sc_mcu9t5v0__filltie
X$4049 \$10782 \$10630 gf180mcu_fd_sc_mcu9t5v0__filltie
X$4050 \$10782 \$10630 gf180mcu_fd_sc_mcu9t5v0__filltie
X$4051 \$10782 \$10630 gf180mcu_fd_sc_mcu9t5v0__filltie
X$4052 \$10782 \$10630 gf180mcu_fd_sc_mcu9t5v0__endcap
X$4053 \$22278 \$19154 \$22910 \$10646 \$22713 \$22837 \$22869
+ gf180mcu_fd_sc_mcu9t5v0__aoi22_1
X$4054 \$10652 \$12653 \$11505 \$12245 \$12526 \$12786
+ gf180mcu_fd_sc_mcu9t5v0__dffsnq_2
X$4055 \$10652 \$11708 \$11707 \$12245 \$11675 \$11827
+ gf180mcu_fd_sc_mcu9t5v0__dffrnq_2
X$4056 \$10652 \$13191 \$13029 \$12245 \$13341 \$13452
+ gf180mcu_fd_sc_mcu9t5v0__dffrnq_2
X$4057 \$10652 \$13190 \$13068 \$12245 \$13341 \$13452
+ gf180mcu_fd_sc_mcu9t5v0__dffrnq_2
X$4058 \$10652 \$12883 \$12885 \$12245 \$12786 \$12930
+ gf180mcu_fd_sc_mcu9t5v0__dffrnq_2
X$4059 \$10652 \$12123 \$12365 \$12245 \$12260 \$12376
+ gf180mcu_fd_sc_mcu9t5v0__dffrnq_2
X$4060 \$10652 \$10898 \$10772 \$12245 \$10901 \$10782
+ gf180mcu_fd_sc_mcu9t5v0__dffrnq_2
X$4061 \$10652 \$13826 \$13442 \$12245 \$13881 \$13729
+ gf180mcu_fd_sc_mcu9t5v0__dffrnq_2
X$4062 \$10652 \$12511 \$12652 \$12245 \$12786 \$12526
+ gf180mcu_fd_sc_mcu9t5v0__dffrnq_2
X$4063 \$10652 \$12128 \$12247 \$12245 \$12260 \$11993
+ gf180mcu_fd_sc_mcu9t5v0__dffrnq_2
X$4064 \$10652 \$11669 \$11670 \$12245 \$11675 \$11555
+ gf180mcu_fd_sc_mcu9t5v0__dffrnq_2
X$4065 \$10652 \$12486 \$12376 gf180mcu_fd_sc_mcu9t5v0__clkinv_8
X$4066 \$10652 \$11170 \$11171 \$11306 \$11182 gf180mcu_fd_sc_mcu9t5v0__dffq_2
X$4067 \$10784 \$10904 \$10662 \$10901 \$11025 \$10783
+ gf180mcu_fd_sc_mcu9t5v0__mux2_2
X$4068 \$10781 \$10780 \$10662 \$10901 \$10782 \$10903
+ gf180mcu_fd_sc_mcu9t5v0__mux2_2
X$4069 \$10786 \$10905 \$10662 \$10901 \$11025 \$10785
+ gf180mcu_fd_sc_mcu9t5v0__mux2_1
X$4070 \$10665 \$11029 \$10901 \$11025 \$11145 gf180mcu_fd_sc_mcu9t5v0__nand2_1
X$4071 \$12494 \$11306 \$11555 \$10667 gf180mcu_fd_sc_mcu9t5v0__buf_8
X$4072 \$11038 \$12564 \$10677 \$13471 \$12786 \$12526
+ gf180mcu_fd_sc_mcu9t5v0__dffrnq_2
X$4073 \$10677 \$12912 \$12786 \$12930 \$12565 gf180mcu_fd_sc_mcu9t5v0__nand2_1
X$4074 \$13078 \$13198 \$10773 \$13341 \$13083 \$13482
+ gf180mcu_fd_sc_mcu9t5v0__nand3_1
X$4075 \$10922 \$10921 \$10901 \$10782 \$10794 gf180mcu_fd_sc_mcu9t5v0__and2_1
X$4076 \$11032 \$10794 \$10901 \$10782 \$10923 gf180mcu_fd_sc_mcu9t5v0__nand2_1
X$4077 \$10782 \$10901 gf180mcu_fd_sc_mcu9t5v0__filltie
X$4078 \$10782 \$10901 gf180mcu_fd_sc_mcu9t5v0__filltie
X$4079 \$10782 \$10901 gf180mcu_fd_sc_mcu9t5v0__filltie
X$4080 \$10782 \$10901 gf180mcu_fd_sc_mcu9t5v0__filltie
X$4081 \$10782 \$10901 gf180mcu_fd_sc_mcu9t5v0__filltie
X$4082 \$10782 \$10901 gf180mcu_fd_sc_mcu9t5v0__filltie
X$4083 \$10782 \$10901 gf180mcu_fd_sc_mcu9t5v0__endcap
X$4084 \$12259 \$11139 \$10790 \$11136 \$11182 gf180mcu_fd_sc_mcu9t5v0__dffq_2
X$4085 \$18592 \$19743 \$10792 \$13634 \$19605 \$19774
+ gf180mcu_fd_sc_mcu9t5v0__dffrnq_2
X$4086 \$10792 \$17656 \$14345 \$12384 \$14151 \$14337 \$14347
+ gf180mcu_fd_sc_mcu9t5v0__aoi22_1
X$4087 \$10792 \$12912 \$19605 \$19466 \$19613 gf180mcu_fd_sc_mcu9t5v0__nand2_1
X$4088 \$10806 \$23644 \$23620 \$23807 \$23646 gf180mcu_fd_sc_mcu9t5v0__xnor2_1
X$4089 \$16851 \$10806 \$23620 \$23807 \$23820 gf180mcu_fd_sc_mcu9t5v0__nand2_1
X$4090 \$13075 \$10899 \$13078 \$13881 \$13729 \$13622
+ gf180mcu_fd_sc_mcu9t5v0__oai21_1
X$4091 \$11032 \$10917 \$10901 \$11025 \$10918 gf180mcu_fd_sc_mcu9t5v0__nand2_2
X$4092 \$10935 \$11039 \$10901 \$11025 \$11040 gf180mcu_fd_sc_mcu9t5v0__nand2_1
X$4093 \$11038 \$10933 \$10934 \$10901 \$11025 gf180mcu_fd_sc_mcu9t5v0__dffq_2
X$4094 \$11025 \$10901 gf180mcu_fd_sc_mcu9t5v0__filltie
X$4095 \$11025 \$10901 gf180mcu_fd_sc_mcu9t5v0__filltie
X$4096 \$11025 \$10901 gf180mcu_fd_sc_mcu9t5v0__filltie
X$4097 \$11025 \$10901 gf180mcu_fd_sc_mcu9t5v0__filltie
X$4098 \$11025 \$10901 gf180mcu_fd_sc_mcu9t5v0__filltie
X$4099 \$11025 \$10901 gf180mcu_fd_sc_mcu9t5v0__filltie
X$4100 \$11025 \$10901 gf180mcu_fd_sc_mcu9t5v0__endcap
X$4101 \$10902 \$11675 \$11555 \$11567 gf180mcu_fd_sc_mcu9t5v0__clkinv_1
X$4102 \$16462 \$10902 \$14217 \$16436 \$16376 \$16463
+ gf180mcu_fd_sc_mcu9t5v0__mux2_1
X$4103 \$14220 \$16458 \$13226 \$16436 \$16376 \$10902
+ gf180mcu_fd_sc_mcu9t5v0__mux2_1
X$4104 \$11154 \$11136 \$11025 \$10911 gf180mcu_fd_sc_mcu9t5v0__buf_8
X$4105 \$14507 \$13093 \$14504 \$14748 \$14635 \$10915
+ gf180mcu_fd_sc_mcu9t5v0__oai21_1
X$4106 \$11155 \$11723 \$10921 \$11136 \$11025 \$10917
+ gf180mcu_fd_sc_mcu9t5v0__and3_4
X$4107 \$11722 \$11306 \$11182 \$10920 gf180mcu_fd_sc_mcu9t5v0__buf_8
X$4108 \$10922 \$10921 \$11675 \$11555 \$11693 gf180mcu_fd_sc_mcu9t5v0__nand2_1
X$4109 \$11691 \$11675 \$11555 \$10921 gf180mcu_fd_sc_mcu9t5v0__buf_8
X$4110 \$11835 \$13038 \$13092 \$11155 \$13035 \$13083 \$10922
+ gf180mcu_fd_sc_mcu9t5v0__oai31_4
X$4111 \$12013 \$11136 \$11025 \$10924 gf180mcu_fd_sc_mcu9t5v0__buf_4
X$4112 \$13865 \$13226 \$13228 \$13341 \$13083 \$10928
+ gf180mcu_fd_sc_mcu9t5v0__aoi21_1
X$4113 \$11129 \$11130 \$11136 \$11025 \$11020 gf180mcu_fd_sc_mcu9t5v0__and2_1
X$4114 \$11128 \$12126 \$11136 \$11025 \$11168 gf180mcu_fd_sc_mcu9t5v0__nor2_1
X$4115 \$11032 \$11309 \$11136 \$11025 \$11157 gf180mcu_fd_sc_mcu9t5v0__nand2_1
X$4116 \$11129 \$11130 \$11136 \$11025 \$11131 gf180mcu_fd_sc_mcu9t5v0__nand2_1
X$4117 \$11025 \$11136 gf180mcu_fd_sc_mcu9t5v0__filltie
X$4118 \$11025 \$11136 gf180mcu_fd_sc_mcu9t5v0__filltie
X$4119 \$11025 \$11136 gf180mcu_fd_sc_mcu9t5v0__filltie
X$4120 \$11025 \$11136 gf180mcu_fd_sc_mcu9t5v0__filltie
X$4121 \$11025 \$11136 gf180mcu_fd_sc_mcu9t5v0__filltie
X$4122 \$11025 \$11136 gf180mcu_fd_sc_mcu9t5v0__filltie
X$4123 \$11038 \$11041 \$11166 \$11136 \$11025 gf180mcu_fd_sc_mcu9t5v0__dffq_2
X$4124 \$11025 \$11136 gf180mcu_fd_sc_mcu9t5v0__endcap
X$4125 \$12936 \$13042 \$12935 \$13035 \$12930 \$11032
+ gf180mcu_fd_sc_mcu9t5v0__and3_2
X$4126 \$11038 \$11956 \$11993 gf180mcu_fd_sc_mcu9t5v0__clkbuf_2
X$4127 \$11038 \$12911 \$11320 \$13471 \$12786 \$12930
+ gf180mcu_fd_sc_mcu9t5v0__dffrnq_2
X$4128 \$11038 \$13356 \$13519 \$13471 \$13341 \$13452
+ gf180mcu_fd_sc_mcu9t5v0__dffrnq_2
X$4129 \$11038 \$12694 \$12384 \$13471 \$12786 \$12526
+ gf180mcu_fd_sc_mcu9t5v0__dffrnq_2
X$4130 \$11038 \$11702 \$11698 \$11675 \$11827 gf180mcu_fd_sc_mcu9t5v0__dffq_2
X$4131 \$11038 \$12562 \$12392 \$12486 \$12526 gf180mcu_fd_sc_mcu9t5v0__dffq_2
X$4132 \$11038 \$12038 \$12276 \$12260 \$11993 gf180mcu_fd_sc_mcu9t5v0__dffq_2
X$4133 \$11038 \$12395 \$12385 \$12486 \$12376 gf180mcu_fd_sc_mcu9t5v0__dffq_2
X$4134 \$11038 \$11213 \$11214 \$11306 \$11182 gf180mcu_fd_sc_mcu9t5v0__dffq_2
X$4135 \$11038 \$11331 \$11541 \$11306 \$11182 gf180mcu_fd_sc_mcu9t5v0__dffq_2
X$4136 \$11038 \$11577 \$11330 \$11675 \$11555 gf180mcu_fd_sc_mcu9t5v0__dffq_2
X$4137 \$11038 \$11853 \$11851 \$11956 \$11827 gf180mcu_fd_sc_mcu9t5v0__dffq_2
X$4138 \$11502 \$11306 \$11182 \$11128 gf180mcu_fd_sc_mcu9t5v0__clkinv_1
X$4139 \$11156 \$11154 \$11190 \$11136 \$11182 \$11191
+ gf180mcu_fd_sc_mcu9t5v0__aoi21_4
X$4140 \$11207 \$11136 \$11182 \$11162 gf180mcu_fd_sc_mcu9t5v0__clkinv_1
X$4141 \$12017 \$11136 \$11182 \$11315 gf180mcu_fd_sc_mcu9t5v0__clkinv_1
X$4142 \$11182 \$11136 gf180mcu_fd_sc_mcu9t5v0__filltie
X$4143 \$11182 \$11136 gf180mcu_fd_sc_mcu9t5v0__filltie
X$4144 \$11182 \$11136 gf180mcu_fd_sc_mcu9t5v0__filltie
X$4145 \$11182 \$11136 gf180mcu_fd_sc_mcu9t5v0__filltie
X$4146 \$11182 \$11136 gf180mcu_fd_sc_mcu9t5v0__filltie
X$4147 \$11182 \$11136 gf180mcu_fd_sc_mcu9t5v0__filltie
X$4148 \$11182 \$11136 gf180mcu_fd_sc_mcu9t5v0__endcap
X$4149 \$11522 \$11690 \$11306 \$11555 \$11151 gf180mcu_fd_sc_mcu9t5v0__or2_1
X$4150 \$13502 \$12794 \$14161 \$12007 \$13623 \$13729 \$11152
+ gf180mcu_fd_sc_mcu9t5v0__oai31_1
X$4151 \$12009 \$11956 \$11993 \$11153 gf180mcu_fd_sc_mcu9t5v0__buf_8
X$4152 \$11155 \$11723 \$11722 \$11721 \$11675 \$11827 \$11724
+ gf180mcu_fd_sc_mcu9t5v0__and4_2
X$4153 \$11155 \$11723 \$11721 \$11675 \$11827 \$11525
+ gf180mcu_fd_sc_mcu9t5v0__nand3_2
X$4154 \$11155 \$11723 \$11721 \$11675 \$11555 \$11309
+ gf180mcu_fd_sc_mcu9t5v0__and3_1
X$4155 \$12146 \$12260 \$11993 \$11156 gf180mcu_fd_sc_mcu9t5v0__clkbuf_8
X$4156 \$11196 \$11306 \$11182 \$11159 gf180mcu_fd_sc_mcu9t5v0__clkinv_1
X$4157 \$11505 \$11502 \$11306 \$11555 \$11167 gf180mcu_fd_sc_mcu9t5v0__nor2_1
X$4158 \$13075 \$11176 \$13078 \$13035 \$13083 \$13076
+ gf180mcu_fd_sc_mcu9t5v0__oai21_1
X$4159 \$11526 \$11525 \$11191 \$11527 \$11306 \$11182 \$11310
+ gf180mcu_fd_sc_mcu9t5v0__oai211_1
X$4160 \$11309 \$11306 \$11182 \$11312 gf180mcu_fd_sc_mcu9t5v0__buf_8
X$4161 \$11182 \$11306 gf180mcu_fd_sc_mcu9t5v0__filltie
X$4162 \$11182 \$11306 gf180mcu_fd_sc_mcu9t5v0__filltie
X$4163 \$11182 \$11306 gf180mcu_fd_sc_mcu9t5v0__filltie
X$4164 \$11182 \$11306 gf180mcu_fd_sc_mcu9t5v0__filltie
X$4165 \$11182 \$11306 gf180mcu_fd_sc_mcu9t5v0__filltie
X$4166 \$11182 \$11306 gf180mcu_fd_sc_mcu9t5v0__filltie
X$4167 \$11182 \$11306 gf180mcu_fd_sc_mcu9t5v0__endcap
X$4168 \$14201 \$12669 \$12786 \$12930 \$11190 gf180mcu_fd_sc_mcu9t5v0__nor2_1
X$4169 \$13633 \$13341 \$13452 \$11198 gf180mcu_fd_sc_mcu9t5v0__clkinv_1
X$4170 \$13853 \$13623 \$13729 \$11199 gf180mcu_fd_sc_mcu9t5v0__clkinv_1
X$4171 \$14241 \$15842 \$11202 \$13471 \$15949 \$16070
+ gf180mcu_fd_sc_mcu9t5v0__dffrnq_2
X$4172 \$11202 \$12912 \$15949 \$16070 \$15841 gf180mcu_fd_sc_mcu9t5v0__nand2_1
X$4173 \$11206 \$23472 \$23620 \$23454 \$23643 gf180mcu_fd_sc_mcu9t5v0__xnor2_1
X$4174 \$16851 \$11206 \$23183 \$23454 \$23601 gf180mcu_fd_sc_mcu9t5v0__nand2_1
X$4175 \$11215 \$11543 \$11306 \$11555 \$11544 gf180mcu_fd_sc_mcu9t5v0__nand2_1
X$4176 \$11821 \$11502 \$11302 \$11675 \$11555 \$11669
+ gf180mcu_fd_sc_mcu9t5v0__oai21_1
X$4177 \$13078 \$15354 \$11303 \$15321 \$15490 \$15355
+ gf180mcu_fd_sc_mcu9t5v0__nand3_1
X$4178 \$11531 \$11530 \$11322 \$11310 \$11306 \$11555 \$11532
+ gf180mcu_fd_sc_mcu9t5v0__oai31_1
X$4179 \$11540 \$11538 \$11306 \$11555 \$11539 gf180mcu_fd_sc_mcu9t5v0__nand2_1
X$4180 \$11555 \$11306 gf180mcu_fd_sc_mcu9t5v0__filltie
X$4181 \$11555 \$11306 gf180mcu_fd_sc_mcu9t5v0__filltie
X$4182 \$11555 \$11306 gf180mcu_fd_sc_mcu9t5v0__filltie
X$4183 \$11555 \$11306 gf180mcu_fd_sc_mcu9t5v0__filltie
X$4184 \$11555 \$11306 gf180mcu_fd_sc_mcu9t5v0__filltie
X$4185 \$11555 \$11306 gf180mcu_fd_sc_mcu9t5v0__filltie
X$4186 \$11555 \$11306 gf180mcu_fd_sc_mcu9t5v0__endcap
X$4187 \$11320 \$14345 \$13857 \$13510 \$14344 \$14151 \$14337 \$14350
+ gf180mcu_fd_sc_mcu9t5v0__aoi221_1
X$4188 \$11320 \$12912 \$13035 \$12930 \$13052 gf180mcu_fd_sc_mcu9t5v0__nand2_1
X$4189 \$12014 \$11956 \$11993 \$11323 gf180mcu_fd_sc_mcu9t5v0__buf_4
X$4190 \$15636 \$15628 \$15490 \$11325 gf180mcu_fd_sc_mcu9t5v0__clkinv_1
X$4191 \$12480 \$13070 \$12925 \$13069 \$13035 \$13083 \$11502
+ gf180mcu_fd_sc_mcu9t5v0__nand4_1
X$4192 \$11709 \$11502 \$11675 \$11555 \$11504 gf180mcu_fd_sc_mcu9t5v0__nor2_1
X$4193 \$11505 \$13030 \$12126 \$13067 \$13035 \$12930 \$12926
+ gf180mcu_fd_sc_mcu9t5v0__aoi211_1
X$4194 \$12367 \$12888 \$11505 \$12786 \$12930 \$12925
+ gf180mcu_fd_sc_mcu9t5v0__oai21_1
X$4195 \$12369 \$11505 \$12486 \$12376 \$12249 gf180mcu_fd_sc_mcu9t5v0__nor2_1
X$4196 \$11505 \$11707 \$11956 \$11827 \$11942 gf180mcu_fd_sc_mcu9t5v0__nand2_1
X$4197 \$11505 \$12260 \$11993 \$12248 gf180mcu_fd_sc_mcu9t5v0__clkinv_1
X$4198 \$13078 \$13830 \$11506 \$13881 \$13729 \$13880
+ gf180mcu_fd_sc_mcu9t5v0__nand3_1
X$4199 \$13494 \$11518 \$13341 \$13452 \$13208 gf180mcu_fd_sc_mcu9t5v0__nor2_1
X$4200 \$14462 \$14516 \$11520 \$13634 \$14454 \$14337
+ gf180mcu_fd_sc_mcu9t5v0__dffrnq_2
X$4201 \$11520 \$12912 \$14151 \$14337 \$14227 gf180mcu_fd_sc_mcu9t5v0__nand2_1
X$4202 \$11964 \$11834 \$11690 \$11522 \$11721 \$11956 \$11827 \$11965
+ gf180mcu_fd_sc_mcu9t5v0__oai221_4
X$4203 \$12005 \$11956 \$11993 \$11522 gf180mcu_fd_sc_mcu9t5v0__buf_8
X$4204 \$11525 \$11725 \$11726 \$11675 \$11555 \$11692
+ gf180mcu_fd_sc_mcu9t5v0__oai21_4
X$4205 \$12142 \$12672 \$12668 \$12786 \$12526 \$12935 \$11526
+ gf180mcu_fd_sc_mcu9t5v0__nand4_2
X$4206 \$22278 \$19154 \$22910 \$11539 \$23027 \$22837 \$23042
+ gf180mcu_fd_sc_mcu9t5v0__aoi22_1
X$4207 \$15369 \$15321 \$15490 \$11545 gf180mcu_fd_sc_mcu9t5v0__buf_8
X$4208 \$11546 \$11675 \$11555 \$11668 gf180mcu_fd_sc_mcu9t5v0__dlyc_1
X$4209 \$11667 \$11675 \$11555 \$11546 gf180mcu_fd_sc_mcu9t5v0__buf_1
X$4210 \$11547 \$23183 \$23139 \$15203 gf180mcu_fd_sc_mcu9t5v0__clkbuf_1
X$4211 \$18133 \$11547 \$13620 \$18137 \$18293 \$18988
+ gf180mcu_fd_sc_mcu9t5v0__nor3_1
X$4212 \$11547 \$21357 \$24231 \$24109 \$24531 gf180mcu_fd_sc_mcu9t5v0__or2_1
X$4213 \$11547 \$21357 \$20083 \$24231 \$24109 \$24233
+ gf180mcu_fd_sc_mcu9t5v0__aoi21_1
X$4214 \$11547 \$12369 \$13196 \$13035 \$13083 \$13073
+ gf180mcu_fd_sc_mcu9t5v0__nand3_1
X$4215 \$20083 \$11547 \$24231 \$24109 \$24056 gf180mcu_fd_sc_mcu9t5v0__nand2_1
X$4216 \$11668 \$11675 \$11555 \$11547 gf180mcu_fd_sc_mcu9t5v0__buf_8
X$4217 \$14338 \$11547 \$13081 \$14454 \$14337 \$14199
+ gf180mcu_fd_sc_mcu9t5v0__mux2_1
X$4218 \$14338 \$11547 \$13493 \$14151 \$14034 \$14036
+ gf180mcu_fd_sc_mcu9t5v0__mux2_1
X$4219 \$13032 \$11547 \$12512 \$13035 \$12930 \$13031
+ gf180mcu_fd_sc_mcu9t5v0__mux2_1
X$4220 \$11547 \$15804 \$14143 \$15949 \$15749 \$15944
+ gf180mcu_fd_sc_mcu9t5v0__mux2_1
X$4221 \$11675 \$11555 \$11705 gf180mcu_fd_sc_mcu9t5v0__tiel
X$4222 \$11576 \$11699 \$11732 \$11733 \$11675 \$11555 \$11574
+ gf180mcu_fd_sc_mcu9t5v0__aoi22_1
X$4223 \$11555 \$11675 gf180mcu_fd_sc_mcu9t5v0__filltie
X$4224 \$11555 \$11675 gf180mcu_fd_sc_mcu9t5v0__filltie
X$4225 \$11555 \$11675 gf180mcu_fd_sc_mcu9t5v0__filltie
X$4226 \$11555 \$11675 gf180mcu_fd_sc_mcu9t5v0__filltie
X$4227 \$11555 \$11675 gf180mcu_fd_sc_mcu9t5v0__filltie
X$4228 \$11555 \$11675 gf180mcu_fd_sc_mcu9t5v0__filltie
X$4229 \$11555 \$11675 gf180mcu_fd_sc_mcu9t5v0__endcap
X$4230 \$11570 \$13226 \$13341 \$13452 \$13468 gf180mcu_fd_sc_mcu9t5v0__nor2_1
X$4231 \$11570 \$13862 \$15628 \$15490 \$15819 gf180mcu_fd_sc_mcu9t5v0__nor2_1
X$4232 \$11570 \$12912 \$14894 \$14895 \$14748 \$14875 \$14768
+ gf180mcu_fd_sc_mcu9t5v0__aoi22_1
X$4233 \$12651 \$12786 \$12526 \$11667 gf180mcu_fd_sc_mcu9t5v0__dlyc_1
X$4234 \$11671 \$11675 \$11827 \$11824 gf180mcu_fd_sc_mcu9t5v0__clkinv_1
X$4235 \$12259 \$11674 \$11678 \$11675 \$11827 gf180mcu_fd_sc_mcu9t5v0__dffq_2
X$4236 \$12126 \$11941 \$11706 \$11675 \$11827 \$11708
+ gf180mcu_fd_sc_mcu9t5v0__nor3_1
X$4237 \$11720 \$12006 \$11835 \$11675 \$11827 \$11834
+ gf180mcu_fd_sc_mcu9t5v0__aoi21_1
X$4238 \$11717 \$11675 \$11827 \$11688 gf180mcu_fd_sc_mcu9t5v0__clkinv_1
X$4239 \$11693 \$11725 \$11726 \$11675 \$11827 \$11694
+ gf180mcu_fd_sc_mcu9t5v0__oai21_2
X$4240 \$11827 \$11675 gf180mcu_fd_sc_mcu9t5v0__filltie
X$4241 \$11827 \$11675 gf180mcu_fd_sc_mcu9t5v0__filltie
X$4242 \$11827 \$11675 gf180mcu_fd_sc_mcu9t5v0__filltie
X$4243 \$11827 \$11675 gf180mcu_fd_sc_mcu9t5v0__filltie
X$4244 \$11827 \$11675 gf180mcu_fd_sc_mcu9t5v0__filltie
X$4245 \$11827 \$11675 gf180mcu_fd_sc_mcu9t5v0__filltie
X$4246 \$11827 \$11675 gf180mcu_fd_sc_mcu9t5v0__endcap
X$4247 \$12537 \$12670 \$12536 \$12538 \$12486 \$12526 \$11690
+ gf180mcu_fd_sc_mcu9t5v0__aoi211_4
X$4248 \$12008 \$12538 \$13214 \$13091 \$13035 \$13083 \$11691
+ gf180mcu_fd_sc_mcu9t5v0__aoi211_4
X$4249 \$11698 \$11956 \$11827 \$11701 gf180mcu_fd_sc_mcu9t5v0__clkinv_1
X$4250 \$11700 \$12560 \$12486 \$12526 \$12561 gf180mcu_fd_sc_mcu9t5v0__nand2_1
X$4251 \$13064 pad_din[4] \$I20747 \$I20765 \$I20756 \$I20774 \$I20783 \$I20801
+ \$I20792 \$I20810 \$I20819 \$I20837 \$I20828 \$I20846 \$I20855 \$I20864
+ \$I20873 \$I20882 \$I20891 \$I20900 \$I20909 \$I20918 \$I20927 \$I20936
+ \$I20945 \$I20954 \$I20963 \$I20981 \$I20972 \$I20990 \$I20999 \$I21017
+ \$I21008 \$I21026 \$I21044 \$I21035 \$I21053 \$I21062 \$I21071 \$I21089
+ \$I21080 \$I21098 \$I21107 \$I21116 \$I21125 \$I21134 \$I21143 \$I21161
+ \$I21152 \$I21170 \$I21179 \$I21197 \$I21188 \$I21206 \$I21215 \$I21233
+ \$I21224 \$I21242 \$I21251 \$I21269 \$I21260 \$I21278 \$I21287 \$I21296
+ \$I21305 \$I21314 \$I21323 \$I21332 \$I21341 \$I21350 \$I21368 \$I21377
+ \$I21404 \$I21413 \$I21359 \$I21395 \$I21386 \$I21431 \$I21422 \$I21458
+ \$I21449 \$I21467 \$I21440 \$I21485 \$I21476 \$I21494 \$I21512 \$I21539
+ \$I21548 \$I21557 \$I21503 \$I21530 \$I21521 \$I21575 \$I21566 \$I21584
+ \$I21593 \$I21602 \$I21611 \$I21620 \$I21629 \$I21638 \$11705 \$I21647
+ \$I21665 \$I21656 \$I21674 \$11705 \$12651 gf180mcu_fd_io__in_c
X$4252 \$11707 \$12125 \$11956 \$11827 \$11706 gf180mcu_fd_sc_mcu9t5v0__nor2_1
X$4253 \$12247 \$11707 \$12365 \$12246 \$12260 \$12376 \$12127
+ gf180mcu_fd_sc_mcu9t5v0__and4_1
X$4254 \$11707 \$12125 \$11956 \$11827 \$11941 gf180mcu_fd_sc_mcu9t5v0__and2_1
X$4255 \$12247 \$11707 \$12365 \$12260 \$12376 \$12367
+ gf180mcu_fd_sc_mcu9t5v0__nand3_1
X$4256 \$12247 \$12482 \$11709 \$12480 \$11823 \$12486 \$12376 \$12368
+ gf180mcu_fd_sc_mcu9t5v0__aoi221_1
X$4257 \$12142 \$11720 \$12006 \$11956 \$11993 \$11723
+ gf180mcu_fd_sc_mcu9t5v0__nand3_2
X$4258 \$12535 \$12532 \$12537 \$12671 \$12486 \$12526 \$11720
+ gf180mcu_fd_sc_mcu9t5v0__oai211_1
X$4259 \$13040 \$13041 \$13091 \$13035 \$12930 \$11721
+ gf180mcu_fd_sc_mcu9t5v0__aoi21_2
X$4260 \$12672 \$12537 \$11835 \$12526 \$12668 \$11722 \$12670 \$12786
+ gf180mcu_fd_sc_mcu9t5v0__aoi221_4
X$4261 \$12267 \$11724 \$11956 \$11993 \$12271 gf180mcu_fd_sc_mcu9t5v0__or2_4
X$4262 \$12935 \$13042 \$12936 \$12786 \$12526 \$11725
+ gf180mcu_fd_sc_mcu9t5v0__nand3_2
X$4263 \$12539 \$12486 \$12526 \$11726 gf180mcu_fd_sc_mcu9t5v0__buf_8
X$4264 \$11729 \$12273 \$12260 \$11993 \$12274 gf180mcu_fd_sc_mcu9t5v0__nand2_1
X$4265 \$19904 \$19042 \$18885 \$11731 \$19927 \$19774 \$19758
+ gf180mcu_fd_sc_mcu9t5v0__aoi22_1
X$4266 \$11734 \$12510 \$12486 \$12376 \$12394 gf180mcu_fd_sc_mcu9t5v0__nand2_1
X$4267 \$11821 \$11942 \$11956 \$11827 \$11944 gf180mcu_fd_sc_mcu9t5v0__nand2_1
X$4268 \$12129 \$12260 \$11993 \$11822 gf180mcu_fd_sc_mcu9t5v0__buf_8
X$4269 \$12514 \$11823 \$12486 \$12376 \$12130 gf180mcu_fd_sc_mcu9t5v0__and2_1
X$4270 \$12480 \$11944 \$17810 \$11823 \$17818 \$17703 \$17811
+ gf180mcu_fd_sc_mcu9t5v0__aoi211_1
X$4271 \$12885 \$12482 \$13827 \$13196 \$11823 \$13623 \$13729 \$13724
+ gf180mcu_fd_sc_mcu9t5v0__aoi221_1
X$4272 \$13068 \$12482 \$14627 \$13196 \$11823 \$14748 \$14635 \$15798
+ gf180mcu_fd_sc_mcu9t5v0__aoi221_1
X$4273 \$13485 \$11823 \$13623 \$13452 \$13339 gf180mcu_fd_sc_mcu9t5v0__nand2_1
X$4274 \$16579 \$16436 \$16728 \$11823 gf180mcu_fd_sc_mcu9t5v0__buf_8
X$4275 \$13075 \$11824 \$13078 \$13341 \$13452 \$13340
+ gf180mcu_fd_sc_mcu9t5v0__oai21_1
X$4276 \$13075 \$11825 \$13078 \$13035 \$13083 \$13077
+ gf180mcu_fd_sc_mcu9t5v0__oai21_1
X$4277 \$11965 \$12012 \$11956 \$11827 \$11966 gf180mcu_fd_sc_mcu9t5v0__nand2_2
X$4278 \$11827 \$11956 gf180mcu_fd_sc_mcu9t5v0__filltie
X$4279 \$11827 \$11956 gf180mcu_fd_sc_mcu9t5v0__filltie
X$4280 \$11827 \$11956 gf180mcu_fd_sc_mcu9t5v0__filltie
X$4281 \$11827 \$11956 gf180mcu_fd_sc_mcu9t5v0__filltie
X$4282 \$11827 \$11956 gf180mcu_fd_sc_mcu9t5v0__filltie
X$4283 \$11827 \$11956 gf180mcu_fd_sc_mcu9t5v0__filltie
X$4284 \$11827 \$11956 gf180mcu_fd_sc_mcu9t5v0__endcap
X$4285 \$22443 \$19154 \$21663 \$11830 \$22713 \$22440 \$22583
+ gf180mcu_fd_sc_mcu9t5v0__aoi22_1
X$4286 \$11835 \$12533 \$12145 \$12526 \$12905 \$12270 \$12671 \$12786
+ gf180mcu_fd_sc_mcu9t5v0__aoi221_4
X$4287 \$12008 \$13215 \$11835 \$13341 \$13083 \$13219
+ gf180mcu_fd_sc_mcu9t5v0__nand3_2
X$4288 \$11835 \$13884 \$13881 \$13729 \$13093 gf180mcu_fd_sc_mcu9t5v0__nor2_2
X$4289 \$11835 \$12145 \$12144 \$12008 \$13341 \$13083 \$13041
+ gf180mcu_fd_sc_mcu9t5v0__oai31_1
X$4290 \$13215 \$11835 \$13035 \$12930 \$12936 gf180mcu_fd_sc_mcu9t5v0__nand2_1
X$4291 \$14041 \$13881 \$14034 \$11835 gf180mcu_fd_sc_mcu9t5v0__buf_8
X$4292 \$15036 \$15056 \$11838 \$15037 \$15045 \$14875
+ gf180mcu_fd_sc_mcu9t5v0__dffrnq_2
X$4293 \$11838 \$12912 \$15045 \$14875 \$15033 gf180mcu_fd_sc_mcu9t5v0__nand2_1
X$4294 \$22278 \$19154 \$22910 \$11846 \$23027 \$22837 \$23041
+ gf180mcu_fd_sc_mcu9t5v0__aoi22_1
X$4295 \$13230 \$12943 \$11847 \$12786 \$12930 gf180mcu_fd_sc_mcu9t5v0__dffq_2
X$4296 \$11851 \$11956 \$11993 \$11854 gf180mcu_fd_sc_mcu9t5v0__clkinv_1
X$4297 \$13065 pad_dout[5] \$I20746 \$I20755 \$I20764 \$I20773 \$I20782
+ \$I20791 \$I20800 \$I20809 \$I20818 \$I20827 \$I20836 \$I20845 \$I20854
+ \$I20863 \$I20872 \$I20881 \$I20890 \$I20899 \$I20908 \$I20917 \$I20926
+ \$I20935 \$I20944 \$I20953 \$I20962 \$I20971 \$I20980 \$I20989 \$I20998
+ \$I21007 \$I21016 \$I21025 \$I21034 \$I21043 \$I21052 \$I21061 \$I21070
+ \$I21079 \$I21088 \$I21097 \$I21106 \$I21115 \$I21124 \$I21133 \$I21142
+ \$I21151 \$I21160 \$I21169 \$I21178 \$I21187 \$I21196 \$I21205 \$I21214
+ \$I21223 \$I21232 \$I21241 \$I21250 \$I21259 \$I21268 \$I21277 \$I21286
+ \$I21295 \$I21304 \$I21313 \$13533 \$I21322 \$I21331 \$I21340 \$I21349
+ \$I21358 \$I21367 \$I21376 \$I21385 \$I21394 \$I21403 \$I21412 \$I21421
+ \$I21430 \$I21439 \$I21448 \$I21457 \$I21466 \$I21475 \$I21484 \$I21493
+ \$I21502 \$I21511 \$I21520 \$I21529 \$I21538 \$I21547 \$I21556 \$I21565
+ \$I21574 \$I21583 \$I21592 \$I21601 \$11855 \$I21610 \$I21619 \$I21628
+ \$I21637 \$I21646 \$I21655 \$I21664 \$I21673 \$11855 \$11855 \$13533 \$11855
+ \$11855 \$13737 \$13533 gf180mcu_fd_io__bi_t
X$4298 \$13623 \$13452 \$11855 gf180mcu_fd_sc_mcu9t5v0__tiel
X$4299 \$12247 \$11941 \$11956 \$11993 \$11987 gf180mcu_fd_sc_mcu9t5v0__nor2_1
X$4300 \$11943 \$13194 \$13337 \$13078 \$13341 \$13083 \$15350
+ gf180mcu_fd_sc_mcu9t5v0__oai211_1
X$4301 \$12130 \$11945 \$12131 \$12260 \$11993 \$12132
+ gf180mcu_fd_sc_mcu9t5v0__oai21_1
X$4302 \$12130 \$11946 \$12131 \$12260 \$11993 \$12251
+ gf180mcu_fd_sc_mcu9t5v0__oai21_1
X$4303 \$12130 \$11947 \$12131 \$12260 \$11993 \$12133
+ gf180mcu_fd_sc_mcu9t5v0__oai21_1
X$4304 \$12130 \$11948 \$12131 \$12260 \$12376 \$12254
+ gf180mcu_fd_sc_mcu9t5v0__oai21_1
X$4305 \$11949 \$12130 \$12131 \$12260 \$12376 \$12372
+ gf180mcu_fd_sc_mcu9t5v0__oai21_1
X$4306 \$12130 \$11950 \$12131 \$12260 \$12376 \$12257
+ gf180mcu_fd_sc_mcu9t5v0__oai21_1
X$4307 \$12130 \$11951 \$12131 \$12260 \$12376 \$12521
+ gf180mcu_fd_sc_mcu9t5v0__oai21_1
X$4308 \$11953 \$11956 \$11993 \$11990 gf180mcu_fd_sc_mcu9t5v0__clkinv_1
X$4309 \$12011 \$12146 \$12010 \$11956 \$11993 \$12012
+ gf180mcu_fd_sc_mcu9t5v0__aoi21_2
X$4310 \$12013 \$11956 \$11993 \$12014 gf180mcu_fd_sc_mcu9t5v0__buf_8
X$4311 \$11997 \$11996 \$11956 \$11993 \$11998 gf180mcu_fd_sc_mcu9t5v0__nand2_1
X$4312 \$11993 \$11956 gf180mcu_fd_sc_mcu9t5v0__filltie
X$4313 \$11993 \$11956 gf180mcu_fd_sc_mcu9t5v0__filltie
X$4314 \$11993 \$11956 gf180mcu_fd_sc_mcu9t5v0__filltie
X$4315 \$11993 \$11956 gf180mcu_fd_sc_mcu9t5v0__filltie
X$4316 \$11993 \$11956 gf180mcu_fd_sc_mcu9t5v0__filltie
X$4317 \$11993 \$11956 gf180mcu_fd_sc_mcu9t5v0__filltie
X$4318 \$11993 \$11956 gf180mcu_fd_sc_mcu9t5v0__endcap
X$4319 \$12543 \$12544 \$11970 \$12786 \$12526 gf180mcu_fd_sc_mcu9t5v0__dffq_2
X$4320 \$12543 \$12020 \$11971 \$12260 \$11993 gf180mcu_fd_sc_mcu9t5v0__dffq_2
X$4321 \$12543 \$12545 \$11972 \$12486 \$12526 gf180mcu_fd_sc_mcu9t5v0__dffq_2
X$4322 \$19046 \$19042 \$18885 \$11983 \$18701 \$18870 \$18847
+ gf180mcu_fd_sc_mcu9t5v0__aoi22_1
X$4323 \$12126 \$12127 \$11987 \$12260 \$11993 \$12128
+ gf180mcu_fd_sc_mcu9t5v0__nor3_1
X$4324 \$12130 \$11988 \$12131 \$12260 \$12376 \$12250
+ gf180mcu_fd_sc_mcu9t5v0__oai21_1
X$4325 \$12130 \$11989 \$12131 \$12260 \$11993 \$12256
+ gf180mcu_fd_sc_mcu9t5v0__oai21_1
X$4326 \$13075 \$11990 \$13078 \$13881 \$13729 \$13834
+ gf180mcu_fd_sc_mcu9t5v0__oai21_1
X$4327 \$12259 \$11992 \$11994 \$12260 \$11993 gf180mcu_fd_sc_mcu9t5v0__dffq_2
X$4328 \$12126 \$12125 \$12124 \$12260 \$11993 \$12123
+ gf180mcu_fd_sc_mcu9t5v0__nor3_1
X$4329 \$12005 \$12007 \$12009 \$11993 \$12008 \$12146 \$12006 \$12260
+ gf180mcu_fd_sc_mcu9t5v0__aoi221_4
X$4330 \$12141 \$12142 \$12260 \$11993 \$12005 gf180mcu_fd_sc_mcu9t5v0__nor2_4
X$4331 \$12140 \$12260 \$11993 \$12267 gf180mcu_fd_sc_mcu9t5v0__buf_8
X$4332 \$12004 \$12139 \$12260 \$11993 \$12263 gf180mcu_fd_sc_mcu9t5v0__nand2_1
X$4333 \$12002 \$12138 \$12260 \$11993 \$12000 gf180mcu_fd_sc_mcu9t5v0__nand2_1
X$4334 \$11993 \$12260 gf180mcu_fd_sc_mcu9t5v0__filltie
X$4335 \$11993 \$12260 gf180mcu_fd_sc_mcu9t5v0__filltie
X$4336 \$11993 \$12260 gf180mcu_fd_sc_mcu9t5v0__filltie
X$4337 \$11993 \$12260 gf180mcu_fd_sc_mcu9t5v0__filltie
X$4338 \$11993 \$12260 gf180mcu_fd_sc_mcu9t5v0__filltie
X$4339 \$11993 \$12260 gf180mcu_fd_sc_mcu9t5v0__filltie
X$4340 \$11993 \$12260 gf180mcu_fd_sc_mcu9t5v0__endcap
X$4341 \$23628 \$19154 \$21663 \$11998 \$23620 \$23807 \$23629
+ gf180mcu_fd_sc_mcu9t5v0__aoi22_1
X$4342 \$12144 \$12145 \$12008 \$12007 \$12486 \$12376 \$12269
+ gf180mcu_fd_sc_mcu9t5v0__oai31_4
X$4343 \$13218 \$13502 \$12794 \$13881 \$13729 \$12007 \$13883
+ gf180mcu_fd_sc_mcu9t5v0__or4_4
X$4344 \$12008 \$12903 \$12534 \$12794 \$12786 \$12526 \$12266
+ gf180mcu_fd_sc_mcu9t5v0__or4_1
X$4345 \$12144 \$12145 \$12008 \$12260 \$12376 \$12009
+ gf180mcu_fd_sc_mcu9t5v0__oai21_4
X$4346 \$12533 \$13215 \$12008 \$15045 \$14875 \$13218
+ gf180mcu_fd_sc_mcu9t5v0__aoi21_1
X$4347 \$12008 \$15815 \$16076 \$15949 \$15749 \$15753
+ gf180mcu_fd_sc_mcu9t5v0__oai21_1
X$4348 \$12008 \$16269 \$16070 \$14201 gf180mcu_fd_sc_mcu9t5v0__inv_1
X$4349 \$12533 \$12008 \$15949 \$15749 \$15816 gf180mcu_fd_sc_mcu9t5v0__nor2_1
X$4350 \$14521 \$17707 \$17038 \$12008 \$17818 \$17703 \$17706
+ gf180mcu_fd_sc_mcu9t5v0__aoi22_1
X$4351 \$12008 \$16378 \$16269 \$16376 \$16379 gf180mcu_fd_sc_mcu9t5v0__nand2_1
X$4352 \$12008 \$15366 \$16269 \$16070 \$16076 gf180mcu_fd_sc_mcu9t5v0__nand2_1
X$4353 \$12008 \$13837 \$13881 \$13729 \$13836 gf180mcu_fd_sc_mcu9t5v0__nand2_1
X$4354 \$12008 \$12793 \$12904 \$12786 \$12930 \$12668
+ gf180mcu_fd_sc_mcu9t5v0__mux2_2
X$4355 \$16132 \$16269 \$16070 \$12008 gf180mcu_fd_sc_mcu9t5v0__buf_8
X$4356 \$12146 \$12260 \$12376 \$12013 gf180mcu_fd_sc_mcu9t5v0__buf_8
X$4357 \$12022 \$13862 \$13881 \$13729 \$15502 gf180mcu_fd_sc_mcu9t5v0__nor2_1
X$4358 \$12022 \$12912 \$13529 \$13528 \$13623 \$13452 \$13636
+ gf180mcu_fd_sc_mcu9t5v0__aoi22_1
X$4359 \$12365 \$12246 \$12486 \$12376 \$12124 gf180mcu_fd_sc_mcu9t5v0__nor2_1
X$4360 \$12365 \$12246 \$12260 \$12376 \$12125 gf180mcu_fd_sc_mcu9t5v0__and2_1
X$4361 \$12126 \$12886 \$13066 \$13341 \$13083 \$13190
+ gf180mcu_fd_sc_mcu9t5v0__nor3_1
X$4362 \$12126 \$12246 \$12884 \$12786 \$12526 \$12883
+ gf180mcu_fd_sc_mcu9t5v0__nor3_1
X$4363 \$12480 \$13193 \$13341 \$13083 \$12126 gf180mcu_fd_sc_mcu9t5v0__nor2_1
X$4364 \$12126 \$12887 \$12486 \$12526 \$12511 gf180mcu_fd_sc_mcu9t5v0__nor2_1
X$4365 \$13029 \$12127 \$12652 \$12786 \$12930 \$12887
+ gf180mcu_fd_sc_mcu9t5v0__aoi21_1
X$4366 \$13029 \$12127 \$13192 \$13341 \$13083 \$13191
+ gf180mcu_fd_sc_mcu9t5v0__aoi21_1
X$4367 \$12480 \$13193 \$12127 \$13029 \$13341 \$13083 \$13192
+ gf180mcu_fd_sc_mcu9t5v0__oai22_1
X$4368 \$13197 \$12369 \$13196 \$13341 \$13083 \$12129
+ gf180mcu_fd_sc_mcu9t5v0__nand3_1
X$4369 \$13486 \$17023 \$16914 \$17034 \$12131 gf180mcu_fd_sc_mcu9t5v0__and2_1
X$4370 \$14487 \$13078 \$12131 \$14488 \$14454 \$14635 \$17237
+ gf180mcu_fd_sc_mcu9t5v0__oai211_1
X$4371 \$14872 \$13078 \$12131 \$15042 \$15045 \$15204 \$15198
+ gf180mcu_fd_sc_mcu9t5v0__oai211_1
X$4372 \$13829 \$13078 \$12131 \$13880 \$13881 \$14034 \$14485
+ gf180mcu_fd_sc_mcu9t5v0__oai211_1
X$4373 \$15144 \$13078 \$12131 \$13482 \$15045 \$15204 \$15145
+ gf180mcu_fd_sc_mcu9t5v0__oai211_1
X$4374 \$13032 \$13078 \$12131 \$13072 \$13035 \$13083 \$13071
+ gf180mcu_fd_sc_mcu9t5v0__oai211_1
X$4375 \$14335 \$13078 \$12131 \$14451 \$14454 \$14337 \$14450
+ gf180mcu_fd_sc_mcu9t5v0__oai211_1
X$4376 \$15741 \$13078 \$12131 \$15355 \$15949 \$15749 \$15802
+ gf180mcu_fd_sc_mcu9t5v0__oai211_1
X$4377 \$13338 \$12132 \$13341 \$13452 \$13444 gf180mcu_fd_sc_mcu9t5v0__nand2_1
X$4378 \$12927 \$12133 \$13035 \$12930 \$12889 gf180mcu_fd_sc_mcu9t5v0__nand2_1
X$4379 \$12259 \$12261 \$12134 \$12260 \$12376 gf180mcu_fd_sc_mcu9t5v0__dffq_2
X$4380 \$12379 \$12136 \$13035 \$13083 \$13086 gf180mcu_fd_sc_mcu9t5v0__nor2_1
X$4381 \$19469 \$12141 \$14521 \$17538 \$17703 \$17540
+ gf180mcu_fd_sc_mcu9t5v0__aoi21_1
X$4382 \$12141 \$12794 \$16381 \$16133 \$16269 \$16070 \$16382
+ gf180mcu_fd_sc_mcu9t5v0__oai31_1
X$4383 \$12141 \$16133 \$16914 \$16728 \$16856 gf180mcu_fd_sc_mcu9t5v0__nand2_1
X$4384 \$16731 \$16914 \$16728 \$12141 gf180mcu_fd_sc_mcu9t5v0__buf_8
X$4385 \$13502 \$12794 \$13883 \$13881 \$13729 \$12142
+ gf180mcu_fd_sc_mcu9t5v0__or3_4
X$4386 \$13088 \$12145 \$12142 \$13035 \$13083 \$12935
+ gf180mcu_fd_sc_mcu9t5v0__oai21_2
X$4387 \$12142 \$12537 \$12671 \$13035 \$12930 \$12538
+ gf180mcu_fd_sc_mcu9t5v0__nand3_2
X$4388 \$12142 \$12672 \$12668 \$13035 \$12930 \$13042
+ gf180mcu_fd_sc_mcu9t5v0__nand3_2
X$4389 \$13218 \$12142 \$13341 \$13452 \$13220 gf180mcu_fd_sc_mcu9t5v0__nor2_2
X$4390 \$12145 \$12144 \$13035 \$12930 \$12672 gf180mcu_fd_sc_mcu9t5v0__nor2_2
X$4391 \$13039 \$13341 \$13083 \$12144 gf180mcu_fd_sc_mcu9t5v0__clkbuf_8
X$4392 \$12904 \$13037 \$12145 \$13039 \$13035 \$12930 \$13038
+ gf180mcu_fd_sc_mcu9t5v0__aoi211_2
X$4393 \$13089 \$13341 \$13452 \$12145 gf180mcu_fd_sc_mcu9t5v0__buf_8
X$4394 \$13230 \$13231 \$12157 \$13341 \$13083 gf180mcu_fd_sc_mcu9t5v0__dffq_2
X$4395 \$25799 \$28090 \$12245 \$28089 \$25585 \$28211
+ gf180mcu_fd_sc_mcu9t5v0__dffrnq_4
X$4396 \$18568 \$20880 \$19024 \$12245 \$21308 \$21184
+ gf180mcu_fd_sc_mcu9t5v0__dffsnq_2
X$4397 \$20826 \$20874 \$20368 \$12245 \$21011 \$20881
+ gf180mcu_fd_sc_mcu9t5v0__dffsnq_2
X$4398 \$27005 \$26673 \$25584 \$12245 \$27153 \$27015
+ gf180mcu_fd_sc_mcu9t5v0__dffsnq_2
X$4399 \$21791 \$22109 \$22110 \$12245 \$22272 \$22387
+ gf180mcu_fd_sc_mcu9t5v0__dffsnq_2
X$4400 \$18562 \$19315 \$19316 \$12245 \$19466 \$19605
+ gf180mcu_fd_sc_mcu9t5v0__dffsnq_2
X$4401 \$17020 \$16368 \$16369 \$12245 \$16269 \$16376
+ gf180mcu_fd_sc_mcu9t5v0__dffrnq_2
X$4402 \$15484 \$15623 \$15742 \$12245 \$15628 \$15749
+ gf180mcu_fd_sc_mcu9t5v0__dffrnq_2
X$4403 \$21791 \$21794 \$21291 \$12245 \$21661 \$21946
+ gf180mcu_fd_sc_mcu9t5v0__dffrnq_2
X$4404 \$23308 \$22432 \$22433 \$12245 \$22387 \$22440
+ gf180mcu_fd_sc_mcu9t5v0__dffrnq_2
X$4405 \$16059 \$16362 \$16425 \$12245 \$16269 \$16376
+ gf180mcu_fd_sc_mcu9t5v0__dffrnq_2
X$4406 \$16059 \$15938 \$15939 \$12245 \$15949 \$16070
+ gf180mcu_fd_sc_mcu9t5v0__dffrnq_2
X$4407 \$20826 \$20873 \$20869 \$12245 \$20881 \$21011
+ gf180mcu_fd_sc_mcu9t5v0__dffrnq_2
X$4408 \$16059 \$16420 \$16423 \$12245 \$16436 \$16728
+ gf180mcu_fd_sc_mcu9t5v0__dffrnq_2
X$4409 \$16059 \$17532 \$17232 \$12245 \$17538 \$17703
+ gf180mcu_fd_sc_mcu9t5v0__dffrnq_2
X$4410 \$21791 \$22108 \$22431 \$12245 \$22074 \$22272
+ gf180mcu_fd_sc_mcu9t5v0__dffrnq_2
X$4411 \$16059 \$16573 \$16119 \$12245 \$16436 \$16728
+ gf180mcu_fd_sc_mcu9t5v0__dffrnq_2
X$4412 \$15484 \$16367 \$16062 \$12245 \$16269 \$16376
+ gf180mcu_fd_sc_mcu9t5v0__dffrnq_2
X$4413 \$21791 \$21611 \$21490 \$12245 \$21498 \$21622
+ gf180mcu_fd_sc_mcu9t5v0__dffrnq_2
X$4414 \$17020 \$17362 \$17025 \$12245 \$17538 \$17703
+ gf180mcu_fd_sc_mcu9t5v0__dffrnq_2
X$4415 \$15484 \$15738 \$15739 \$12245 \$15949 \$16070
+ gf180mcu_fd_sc_mcu9t5v0__dffrnq_2
X$4416 \$15484 \$16064 \$15142 \$12245 \$15949 \$16070
+ gf180mcu_fd_sc_mcu9t5v0__dffrnq_2
X$4417 \$16059 \$17016 \$17017 \$12245 \$16914 \$17034
+ gf180mcu_fd_sc_mcu9t5v0__dffrnq_2
X$4418 \$15484 \$15039 \$15141 \$12245 \$15045 \$15204
+ gf180mcu_fd_sc_mcu9t5v0__dffrnq_2
X$4419 \$15484 \$15349 \$15736 \$12245 \$15321 \$15490
+ gf180mcu_fd_sc_mcu9t5v0__dffrnq_2
X$4420 \$16059 \$15347 \$15348 \$12245 \$15321 \$15490
+ gf180mcu_fd_sc_mcu9t5v0__dffrnq_2
X$4421 \$23308 \$22567 \$22824 \$12245 \$22713 \$22837
+ gf180mcu_fd_sc_mcu9t5v0__dffrnq_2
X$4422 \$20826 \$21294 \$23176 \$12245 \$22387 \$22440
+ gf180mcu_fd_sc_mcu9t5v0__dffrnq_2
X$4423 \$20826 \$21796 \$19457 \$12245 \$21661 \$21946
+ gf180mcu_fd_sc_mcu9t5v0__dffrnq_2
X$4424 \$12654 \$14186 \$14142 \$12245 \$14151 \$14337
+ gf180mcu_fd_sc_mcu9t5v0__dffrnq_2
X$4425 \$18562 \$18522 \$18397 \$12245 \$18403 \$18576
+ gf180mcu_fd_sc_mcu9t5v0__dffrnq_2
X$4426 \$12654 \$13480 \$12480 \$12245 \$13623 \$13729
+ gf180mcu_fd_sc_mcu9t5v0__dffrnq_2
X$4427 \$12654 \$13031 \$13032 \$12245 \$13035 \$13083
+ gf180mcu_fd_sc_mcu9t5v0__dffrnq_2
X$4428 \$12654 \$14484 \$14335 \$12245 \$14454 \$14635
+ gf180mcu_fd_sc_mcu9t5v0__dffrnq_2
X$4429 \$12654 \$13621 \$13725 \$12245 \$13623 \$13729
+ gf180mcu_fd_sc_mcu9t5v0__dffrnq_2
X$4430 \$12654 \$13444 \$13199 \$12245 \$13341 \$13452
+ gf180mcu_fd_sc_mcu9t5v0__dffrnq_2
X$4431 \$23321 \$23923 \$26085 \$12245 \$25797 \$25918
+ gf180mcu_fd_sc_mcu9t5v0__dffrnq_2
X$4432 \$25799 \$28536 \$28489 \$12245 \$28534 \$28689
+ gf180mcu_fd_sc_mcu9t5v0__dffrnq_2
X$4433 \$27005 \$27911 \$27912 \$12245 \$27913 \$28089
+ gf180mcu_fd_sc_mcu9t5v0__dffrnq_2
X$4434 \$27005 \$28209 \$27152 \$12245 \$28211 \$28381
+ gf180mcu_fd_sc_mcu9t5v0__dffrnq_2
X$4435 \$25799 \$27916 \$27917 \$12245 \$27913 \$28089
+ gf180mcu_fd_sc_mcu9t5v0__dffrnq_2
X$4436 \$23323 \$24595 \$18015 \$12245 \$24593 \$24721
+ gf180mcu_fd_sc_mcu9t5v0__dffrnq_2
X$4437 \$23321 \$25306 \$17707 \$12245 \$25191 \$25347
+ gf180mcu_fd_sc_mcu9t5v0__dffrnq_2
X$4438 \$21658 \$21140 \$21141 \$12245 \$21184 \$21308
+ gf180mcu_fd_sc_mcu9t5v0__dffrnq_2
X$4439 \$23321 \$24594 \$24107 \$12245 \$24593 \$24721
+ gf180mcu_fd_sc_mcu9t5v0__dffrnq_2
X$4440 \$23321 \$24995 \$17099 \$12245 \$24877 \$24997
+ gf180mcu_fd_sc_mcu9t5v0__dffrnq_2
X$4441 \$21658 \$22127 \$22071 \$12245 \$22074 \$22272
+ gf180mcu_fd_sc_mcu9t5v0__dffrnq_2
X$4442 \$18568 \$21659 \$21802 \$12245 \$21661 \$21946
+ gf180mcu_fd_sc_mcu9t5v0__dffrnq_2
X$4443 \$18568 \$20878 \$20838 \$12245 \$20881 \$21011
+ gf180mcu_fd_sc_mcu9t5v0__dffrnq_2
X$4444 \$23321 \$24295 \$23925 \$12245 \$24231 \$24428
+ gf180mcu_fd_sc_mcu9t5v0__dffrnq_2
X$4445 \$16059 \$18134 \$18135 \$12245 \$18137 \$18293
+ gf180mcu_fd_sc_mcu9t5v0__dffrnq_2
X$4446 \$21658 \$22712 \$22573 \$12245 \$22713 \$22837
+ gf180mcu_fd_sc_mcu9t5v0__dffrnq_2
X$4447 \$17020 \$18251 \$18290 \$12245 \$18137 \$18293
+ gf180mcu_fd_sc_mcu9t5v0__dffrnq_2
X$4448 \$15484 \$18242 \$18001 \$12245 \$18137 \$18293
+ gf180mcu_fd_sc_mcu9t5v0__dffrnq_2
X$4449 \$16059 \$17994 \$18286 \$12245 \$18137 \$18293
+ gf180mcu_fd_sc_mcu9t5v0__dffrnq_2
X$4450 \$15484 \$16838 \$16909 \$12245 \$16914 \$17034
+ gf180mcu_fd_sc_mcu9t5v0__dffrnq_2
X$4451 \$15484 \$16063 \$16123 \$12245 \$15949 \$16070
+ gf180mcu_fd_sc_mcu9t5v0__dffrnq_2
X$4452 \$17020 \$18136 \$18005 \$12245 \$18137 \$18293
+ gf180mcu_fd_sc_mcu9t5v0__dffrnq_2
X$4453 \$17020 \$18000 \$18244 \$12245 \$18137 \$18293
+ gf180mcu_fd_sc_mcu9t5v0__dffrnq_2
X$4454 \$27005 \$27769 \$25745 \$12245 \$27637 \$27776
+ gf180mcu_fd_sc_mcu9t5v0__dffrnq_2
X$4455 \$23616 \$25189 \$25047 \$12245 \$25191 \$25347
+ gf180mcu_fd_sc_mcu9t5v0__dffrnq_2
X$4456 \$23616 \$24989 \$22434 \$12245 \$24877 \$24997
+ gf180mcu_fd_sc_mcu9t5v0__dffrnq_2
X$4457 \$23616 \$24427 \$24527 \$12245 \$24593 \$24721
+ gf180mcu_fd_sc_mcu9t5v0__dffrnq_2
X$4458 \$23616 \$24588 \$24589 \$12245 \$24593 \$24721
+ gf180mcu_fd_sc_mcu9t5v0__dffrnq_2
X$4459 \$23616 \$24990 \$25049 \$12245 \$24877 \$24997
+ gf180mcu_fd_sc_mcu9t5v0__dffrnq_2
X$4460 \$27005 \$26081 \$25303 \$12245 \$26088 \$26220
+ gf180mcu_fd_sc_mcu9t5v0__dffrnq_2
X$4461 \$12654 \$13878 \$13829 \$12245 \$13881 \$14034
+ gf180mcu_fd_sc_mcu9t5v0__dffrnq_2
X$4462 \$20826 \$22114 \$21937 \$12245 \$22074 \$22272
+ gf180mcu_fd_sc_mcu9t5v0__dffrnq_2
X$4463 \$20826 \$21350 \$21614 \$12245 \$21498 \$21622
+ gf180mcu_fd_sc_mcu9t5v0__dffrnq_2
X$4464 \$18562 \$18802 \$18980 \$12245 \$18701 \$18870
+ gf180mcu_fd_sc_mcu9t5v0__dffrnq_2
X$4465 \$12654 \$13998 \$13484 \$12245 \$13881 \$14034
+ gf180mcu_fd_sc_mcu9t5v0__dffrnq_2
X$4466 \$23616 \$23182 \$23452 \$12245 \$23183 \$23454
+ gf180mcu_fd_sc_mcu9t5v0__dffrnq_2
X$4467 \$21658 \$22710 \$22834 \$12245 \$22713 \$22837
+ gf180mcu_fd_sc_mcu9t5v0__dffrnq_2
X$4468 \$23321 \$23322 \$23614 \$12245 \$23183 \$23454
+ gf180mcu_fd_sc_mcu9t5v0__dffrnq_2
X$4469 \$18562 \$19269 \$19139 \$12245 \$19027 \$19149
+ gf180mcu_fd_sc_mcu9t5v0__dffrnq_2
X$4470 \$23323 \$23324 \$23453 \$12245 \$23183 \$23454
+ gf180mcu_fd_sc_mcu9t5v0__dffrnq_2
X$4471 \$18568 \$19272 \$19273 \$12245 \$19324 \$19466
+ gf180mcu_fd_sc_mcu9t5v0__dffrnq_2
X$4472 \$23321 \$24054 \$20344 \$12245 \$23926 \$24109
+ gf180mcu_fd_sc_mcu9t5v0__dffrnq_2
X$4473 \$20826 \$18400 \$18289 \$12245 \$18403 \$18576
+ gf180mcu_fd_sc_mcu9t5v0__dffrnq_2
X$4474 \$23323 \$24108 \$23927 \$12245 \$23926 \$24109
+ gf180mcu_fd_sc_mcu9t5v0__dffrnq_2
X$4475 \$18568 \$18812 \$18567 \$12245 \$18701 \$18870
+ gf180mcu_fd_sc_mcu9t5v0__dffrnq_2
X$4476 \$20826 \$20334 \$20204 \$12245 \$20209 \$20383
+ gf180mcu_fd_sc_mcu9t5v0__dffrnq_2
X$4477 \$21658 \$23024 \$22829 \$12245 \$23027 \$23139
+ gf180mcu_fd_sc_mcu9t5v0__dffrnq_2
X$4478 \$21658 \$22384 \$22437 \$12245 \$22387 \$22440
+ gf180mcu_fd_sc_mcu9t5v0__dffrnq_2
X$4479 \$17020 \$17536 \$17650 \$12245 \$17538 \$17703
+ gf180mcu_fd_sc_mcu9t5v0__dffrnq_2
X$4480 \$21658 \$22707 \$22708 \$12245 \$22713 \$22837
+ gf180mcu_fd_sc_mcu9t5v0__dffrnq_2
X$4481 \$18562 \$19721 \$19453 \$12245 \$19605 \$19774
+ gf180mcu_fd_sc_mcu9t5v0__dffrnq_2
X$4482 \$20826 \$22826 \$22827 \$12245 \$22713 \$22837
+ gf180mcu_fd_sc_mcu9t5v0__dffrnq_2
X$4483 \$23616 \$23181 \$23319 \$12245 \$23183 \$23454
+ gf180mcu_fd_sc_mcu9t5v0__dffrnq_2
X$4484 \$20826 \$21301 \$21303 \$12245 \$21498 \$21622
+ gf180mcu_fd_sc_mcu9t5v0__dffrnq_2
X$4485 \$21658 \$21139 \$21007 \$12245 \$21184 \$21308
+ gf180mcu_fd_sc_mcu9t5v0__dffrnq_2
X$4486 \$21658 \$21655 \$21799 \$12245 \$21661 \$21946
+ gf180mcu_fd_sc_mcu9t5v0__dffrnq_2
X$4487 \$21658 \$22125 \$22126 \$12245 \$22074 \$22272
+ gf180mcu_fd_sc_mcu9t5v0__dffrnq_2
X$4488 \$25799 \$27777 \$27638 \$12245 \$27637 \$27776
+ gf180mcu_fd_sc_mcu9t5v0__dffrnq_2
X$4489 \$23616 \$24049 \$19728 \$12245 \$23926 \$24109
+ gf180mcu_fd_sc_mcu9t5v0__dffrnq_2
X$4490 \$21658 \$23026 \$23136 \$12245 \$23027 \$23139
+ gf180mcu_fd_sc_mcu9t5v0__dffrnq_2
X$4491 \$23321 \$25057 \$20885 \$12245 \$25191 \$25347
+ gf180mcu_fd_sc_mcu9t5v0__dffrnq_2
X$4492 \$21658 \$22711 \$22570 \$12245 \$22713 \$22837
+ gf180mcu_fd_sc_mcu9t5v0__dffrnq_2
X$4493 \$23321 \$24876 \$24993 \$12245 \$24877 \$24997
+ gf180mcu_fd_sc_mcu9t5v0__dffrnq_2
X$4494 \$18568 \$21182 \$21183 \$12245 \$21184 \$21308
+ gf180mcu_fd_sc_mcu9t5v0__dffrnq_2
X$4495 \$23308 \$22889 \$23135 \$12245 \$23027 \$22837
+ gf180mcu_fd_sc_mcu9t5v0__dffrnq_2
X$4496 \$20826 \$20711 \$20571 \$12245 \$20881 \$20718
+ gf180mcu_fd_sc_mcu9t5v0__dffrnq_2
X$4497 \$20826 \$21356 \$21302 \$12245 \$21498 \$21308
+ gf180mcu_fd_sc_mcu9t5v0__dffrnq_2
X$4498 \$23615 \$23447 \$23754 \$12245 \$23620 \$23454
+ gf180mcu_fd_sc_mcu9t5v0__dffrnq_2
X$4499 \$20826 \$20710 \$20570 \$12245 \$20881 \$20718
+ gf180mcu_fd_sc_mcu9t5v0__dffrnq_2
X$4500 \$21658 \$22890 \$22828 \$12245 \$23027 \$22837
+ gf180mcu_fd_sc_mcu9t5v0__dffrnq_2
X$4501 \$23321 \$26353 \$25748 \$12245 \$26401 \$26220
+ gf180mcu_fd_sc_mcu9t5v0__dffrnq_2
X$4502 \$21658 \$21618 \$21616 \$12245 \$21661 \$21622
+ gf180mcu_fd_sc_mcu9t5v0__dffrnq_2
X$4503 \$23321 \$25919 \$25921 \$12245 \$26088 \$25918
+ gf180mcu_fd_sc_mcu9t5v0__dffrnq_2
X$4504 \$16059 \$17484 \$17355 \$12245 \$17538 \$17367
+ gf180mcu_fd_sc_mcu9t5v0__dffrnq_2
X$4505 \$21658 \$21940 \$21798 \$12245 \$22074 \$21946
+ gf180mcu_fd_sc_mcu9t5v0__dffrnq_2
X$4506 \$16059 \$16363 \$16571 \$12245 \$16436 \$16376
+ gf180mcu_fd_sc_mcu9t5v0__dffrnq_2
X$4507 \$18568 \$20572 \$20715 \$12245 \$20881 \$20718
+ gf180mcu_fd_sc_mcu9t5v0__dffrnq_2
X$4508 \$23616 \$24226 \$24046 \$12245 \$24231 \$24109
+ gf180mcu_fd_sc_mcu9t5v0__dffrnq_2
X$4509 \$18568 \$19601 \$19602 \$12245 \$19605 \$19466
+ gf180mcu_fd_sc_mcu9t5v0__dffrnq_2
X$4510 \$23616 \$23449 \$23585 \$12245 \$23620 \$23454
+ gf180mcu_fd_sc_mcu9t5v0__dffrnq_2
X$4511 \$20826 \$21355 \$21495 \$12245 \$21498 \$21308
+ gf180mcu_fd_sc_mcu9t5v0__dffrnq_2
X$4512 \$21658 \$22892 \$23025 \$12245 \$23027 \$22837
+ gf180mcu_fd_sc_mcu9t5v0__dffrnq_2
X$4513 \$18568 \$19145 \$19146 \$12245 \$19324 \$19149
+ gf180mcu_fd_sc_mcu9t5v0__dffrnq_2
X$4514 \$21658 \$21941 \$22070 \$12245 \$22074 \$21946
+ gf180mcu_fd_sc_mcu9t5v0__dffrnq_2
X$4515 \$18568 \$18569 \$18528 \$12245 \$18701 \$18576
+ gf180mcu_fd_sc_mcu9t5v0__dffrnq_2
X$4516 \$18568 \$20082 \$20083 \$12245 \$20209 \$20087
+ gf180mcu_fd_sc_mcu9t5v0__dffrnq_2
X$4517 \$23321 \$26219 \$17374 \$12245 \$26401 \$26220
+ gf180mcu_fd_sc_mcu9t5v0__dffrnq_2
X$4518 \$23321 \$26217 \$26218 \$12245 \$26401 \$26220
+ gf180mcu_fd_sc_mcu9t5v0__dffrnq_2
X$4519 \$25799 \$28380 \$28337 \$12245 \$28534 \$28381
+ gf180mcu_fd_sc_mcu9t5v0__dffrnq_2
X$4520 \$18568 \$13195 \$19600 \$12245 \$19605 \$19466
+ gf180mcu_fd_sc_mcu9t5v0__dffrnq_2
X$4521 \$17020 \$18249 \$18250 \$12245 \$18403 \$18293
+ gf180mcu_fd_sc_mcu9t5v0__dffrnq_2
X$4522 \$18568 \$19771 \$19773 \$12245 \$19927 \$19774
+ gf180mcu_fd_sc_mcu9t5v0__dffrnq_2
X$4523 \$27005 \$26854 \$25590 \$12245 \$27015 \$26856
+ gf180mcu_fd_sc_mcu9t5v0__dffrnq_2
X$4524 \$23616 \$23619 \$23587 \$12245 \$23620 \$23454
+ gf180mcu_fd_sc_mcu9t5v0__dffrnq_2
X$4525 \$18568 \$20084 \$20336 \$12245 \$20209 \$20087
+ gf180mcu_fd_sc_mcu9t5v0__dffrnq_2
X$4526 \$21658 \$22832 \$22831 \$12245 \$23027 \$22837
+ gf180mcu_fd_sc_mcu9t5v0__dffrnq_2
X$4527 \$18568 \$20378 \$20335 \$12245 \$20515 \$20383
+ gf180mcu_fd_sc_mcu9t5v0__dffrnq_2
X$4528 \$21658 \$21657 \$21800 \$12245 \$21661 \$21622
+ gf180mcu_fd_sc_mcu9t5v0__dffrnq_2
X$4529 \$16059 \$17077 \$17229 \$12245 \$17085 \$17034
+ gf180mcu_fd_sc_mcu9t5v0__dffrnq_2
X$4530 \$16059 \$17941 \$17690 \$12245 \$18137 \$17952
+ gf180mcu_fd_sc_mcu9t5v0__dffrnq_2
X$4531 \$18568 \$18814 \$18866 \$12245 \$19027 \$18870
+ gf180mcu_fd_sc_mcu9t5v0__dffrnq_2
X$4532 \$17020 \$18401 \$18292 \$12245 \$18403 \$18293
+ gf180mcu_fd_sc_mcu9t5v0__dffrnq_2
X$4533 \$21658 \$22271 \$22120 \$12245 \$22387 \$22272
+ gf180mcu_fd_sc_mcu9t5v0__dffrnq_2
X$4534 \$23616 \$24528 \$24291 \$12245 \$24593 \$24428
+ gf180mcu_fd_sc_mcu9t5v0__dffrnq_2
X$4535 \$15484 \$15485 \$15735 \$12245 \$15628 \$15490
+ gf180mcu_fd_sc_mcu9t5v0__dffrnq_2
X$4536 \$23616 \$24227 \$24103 \$12245 \$24231 \$24109
+ gf180mcu_fd_sc_mcu9t5v0__dffrnq_2
X$4537 \$23323 \$24298 \$17040 \$12245 \$24593 \$24428
+ gf180mcu_fd_sc_mcu9t5v0__dffrnq_2
X$4538 \$23616 \$23588 \$23451 \$12245 \$23620 \$23454
+ gf180mcu_fd_sc_mcu9t5v0__dffrnq_2
X$4539 \$16059 \$17352 \$17226 \$12245 \$17538 \$17367
+ gf180mcu_fd_sc_mcu9t5v0__dffrnq_2
X$4540 \$16059 \$17998 \$17943 \$12245 \$18137 \$17952
+ gf180mcu_fd_sc_mcu9t5v0__dffrnq_2
X$4541 \$16059 \$17693 \$17642 \$12245 \$17818 \$17703
+ gf180mcu_fd_sc_mcu9t5v0__dffrnq_2
X$4542 \$16059 \$16834 \$16723 \$12245 \$16914 \$16728
+ gf180mcu_fd_sc_mcu9t5v0__dffrnq_2
X$4543 \$20826 \$21935 \$21936 \$12245 \$22074 \$21946
+ gf180mcu_fd_sc_mcu9t5v0__dffrnq_2
X$4544 \$20826 \$18565 \$18003 \$12245 \$18701 \$18576
+ gf180mcu_fd_sc_mcu9t5v0__dffrnq_2
X$4545 \$20826 \$19595 \$19320 \$12245 \$19605 \$19466
+ gf180mcu_fd_sc_mcu9t5v0__dffrnq_2
X$4546 \$23321 \$23137 \$23138 \$12245 \$23183 \$23139
+ gf180mcu_fd_sc_mcu9t5v0__dffrnq_2
X$4547 \$18562 \$19459 \$19594 \$12245 \$19605 \$19466
+ gf180mcu_fd_sc_mcu9t5v0__dffrnq_2
X$4548 \$20826 \$20830 \$20865 \$12245 \$20881 \$20718
+ gf180mcu_fd_sc_mcu9t5v0__dffrnq_2
X$4549 \$23321 \$23760 \$23806 \$12245 \$23926 \$23807
+ gf180mcu_fd_sc_mcu9t5v0__dffrnq_2
X$4550 \$27005 \$27443 \$27314 \$12245 \$27637 \$27449
+ gf180mcu_fd_sc_mcu9t5v0__dffrnq_2
X$4551 \$18562 \$18700 \$17646 \$12245 \$19027 \$18870
+ gf180mcu_fd_sc_mcu9t5v0__dffrnq_2
X$4552 \$23616 \$22827 \$22118 \$12245 \$23926 \$23807
+ gf180mcu_fd_sc_mcu9t5v0__dffrnq_2
X$4553 \$25799 \$27773 \$27635 \$12245 \$27913 \$27776
+ gf180mcu_fd_sc_mcu9t5v0__dffrnq_2
X$4554 \$23616 \$23448 \$22121 \$12245 \$23620 \$23454
+ gf180mcu_fd_sc_mcu9t5v0__dffrnq_2
X$4555 \$21658 \$22891 \$23023 \$12245 \$23027 \$22837
+ gf180mcu_fd_sc_mcu9t5v0__dffrnq_2
X$4556 \$12654 \$13828 \$13997 \$12245 \$13881 \$13729
+ gf180mcu_fd_sc_mcu9t5v0__dffrnq_2
X$4557 \$23616 \$23758 \$23802 \$12245 \$23926 \$23807
+ gf180mcu_fd_sc_mcu9t5v0__dffrnq_2
X$4558 \$17020 \$18004 \$17945 \$12245 \$18137 \$17952
+ gf180mcu_fd_sc_mcu9t5v0__dffrnq_2
X$4559 \$16059 \$18396 \$17692 \$12245 \$18403 \$18293
+ gf180mcu_fd_sc_mcu9t5v0__dffrnq_2
X$4560 \$17020 \$17361 \$17235 \$12245 \$17538 \$17367
+ gf180mcu_fd_sc_mcu9t5v0__dffrnq_2
X$4561 \$17020 \$16065 \$16066 \$12245 \$16269 \$16070
+ gf180mcu_fd_sc_mcu9t5v0__dffrnq_2
X$4562 \$12654 \$14629 \$14483 \$12245 \$14748 \$14635
+ gf180mcu_fd_sc_mcu9t5v0__dffrnq_2
X$4563 \$21791 \$21934 \$21795 \$12245 \$22074 \$21946
+ gf180mcu_fd_sc_mcu9t5v0__dffrnq_2
X$4564 \$15484 \$15740 \$15741 \$12245 \$15949 \$15749
+ gf180mcu_fd_sc_mcu9t5v0__dffrnq_2
X$4565 \$16059 \$18285 \$18241 \$12245 \$18403 \$18293
+ gf180mcu_fd_sc_mcu9t5v0__dffrnq_2
X$4566 \$18562 \$20324 \$20369 \$12245 \$20209 \$20087
+ gf180mcu_fd_sc_mcu9t5v0__dffrnq_2
X$4567 \$18562 \$20198 \$20076 \$12245 \$20209 \$20087
+ gf180mcu_fd_sc_mcu9t5v0__dffrnq_2
X$4568 \$20826 \$20199 \$18858 \$12245 \$20209 \$20087
+ gf180mcu_fd_sc_mcu9t5v0__dffrnq_2
X$4569 \$18562 \$18561 \$18799 \$12245 \$18701 \$18576
+ gf180mcu_fd_sc_mcu9t5v0__dffrnq_2
X$4570 \$17020 \$17698 \$17814 \$12245 \$17818 \$17703
+ gf180mcu_fd_sc_mcu9t5v0__dffrnq_2
X$4571 \$17020 \$17026 \$17027 \$12245 \$17085 \$17034
+ gf180mcu_fd_sc_mcu9t5v0__dffrnq_2
X$4572 \$21791 \$20706 \$20557 \$12245 \$20881 \$20718
+ gf180mcu_fd_sc_mcu9t5v0__dffrnq_2
X$4573 \$17020 \$16842 \$16843 \$12245 \$16914 \$16728
+ gf180mcu_fd_sc_mcu9t5v0__dffrnq_2
X$4574 \$18562 \$19592 \$19138 \$12245 \$19605 \$19466
+ gf180mcu_fd_sc_mcu9t5v0__dffrnq_2
X$4575 \$21791 \$21288 \$20559 \$12245 \$21498 \$21308
+ gf180mcu_fd_sc_mcu9t5v0__dffrnq_2
X$4576 \$15484 \$15312 \$15144 \$12245 \$15321 \$15204
+ gf180mcu_fd_sc_mcu9t5v0__dffrnq_2
X$4577 \$17020 \$17081 \$17022 \$12245 \$17085 \$17034
+ gf180mcu_fd_sc_mcu9t5v0__dffrnq_2
X$4578 \$14187 \$15196 \$15197 \$12245 \$15321 \$15204
+ gf180mcu_fd_sc_mcu9t5v0__dffrnq_2
X$4579 \$17020 \$16839 \$17018 \$12245 \$16914 \$16728
+ gf180mcu_fd_sc_mcu9t5v0__dffrnq_2
X$4580 \$25799 \$26676 \$17498 \$12245 \$26675 \$26521
+ gf180mcu_fd_sc_mcu9t5v0__dffrnq_2
X$4581 \$12654 \$15313 \$15146 \$12245 \$15321 \$15204
+ gf180mcu_fd_sc_mcu9t5v0__dffrnq_2
X$4582 \$12654 \$14630 \$14631 \$12245 \$14748 \$14635
+ gf180mcu_fd_sc_mcu9t5v0__dffrnq_2
X$4583 \$17020 \$17699 \$17700 \$12245 \$17818 \$17703
+ gf180mcu_fd_sc_mcu9t5v0__dffrnq_2
X$4584 \$15484 \$14445 \$14446 \$12245 \$14454 \$14337
+ gf180mcu_fd_sc_mcu9t5v0__dffrnq_2
X$4585 \$15484 \$15310 \$15190 \$12245 \$15628 \$15490
+ gf180mcu_fd_sc_mcu9t5v0__dffrnq_2
X$4586 \$18562 \$18807 \$18563 \$12245 \$18701 \$18576
+ gf180mcu_fd_sc_mcu9t5v0__dffrnq_2
X$4587 \$18562 \$18861 \$18984 \$12245 \$19027 \$18870
+ gf180mcu_fd_sc_mcu9t5v0__dffrnq_2
X$4588 \$18562 \$19456 \$18985 \$12245 \$19605 \$19466
+ gf180mcu_fd_sc_mcu9t5v0__dffrnq_2
X$4589 \$15484 \$15486 \$15487 \$12245 \$15628 \$15490
+ gf180mcu_fd_sc_mcu9t5v0__dffrnq_2
X$4590 \$15484 \$16576 \$16577 \$12245 \$16914 \$16728
+ gf180mcu_fd_sc_mcu9t5v0__dffrnq_2
X$4591 \$15484 \$17487 \$17643 \$12245 \$17538 \$17367
+ gf180mcu_fd_sc_mcu9t5v0__dffrnq_2
X$4592 \$15484 \$14867 \$15040 \$12245 \$15045 \$14875
+ gf180mcu_fd_sc_mcu9t5v0__dffrnq_2
X$4593 \$19307 \$29123 \$29270 \$12245 gf180mcu_fd_sc_mcu9t5v0__buf_20
X$4594 \$12885 \$12886 \$12786 \$12526 \$12246 gf180mcu_fd_sc_mcu9t5v0__and2_1
X$4595 \$12248 \$12365 \$12480 \$12486 \$12376 \$13194
+ gf180mcu_fd_sc_mcu9t5v0__oai21_1
X$4596 \$12369 \$12248 \$12260 \$12376 \$12482 gf180mcu_fd_sc_mcu9t5v0__nor2_1
X$4597 \$12516 \$12250 \$12486 \$12526 \$12515 gf180mcu_fd_sc_mcu9t5v0__nand2_1
X$4598 \$12252 \$12251 \$12260 \$12376 \$12371 gf180mcu_fd_sc_mcu9t5v0__nand2_1
X$4599 \$12253 \$12517 \$12260 \$12376 \$12252 gf180mcu_fd_sc_mcu9t5v0__nand2_1
X$4600 \$12654 \$12371 \$12253 \$12655 \$12486 \$12376
+ gf180mcu_fd_sc_mcu9t5v0__dffrnq_2
X$4601 \$12253 \$13487 \$13200 \$13486 \$13445 \$13341 \$13452 \$13446
+ gf180mcu_fd_sc_mcu9t5v0__aoi221_1
X$4602 \$12891 \$12254 \$12786 \$12930 \$12928 gf180mcu_fd_sc_mcu9t5v0__nand2_1
X$4603 \$13078 \$14486 \$12255 \$14454 \$14635 \$14451
+ gf180mcu_fd_sc_mcu9t5v0__nand3_1
X$4604 \$12374 \$12256 \$12260 \$12376 \$12258 gf180mcu_fd_sc_mcu9t5v0__nand2_1
X$4605 \$12929 \$12257 \$13035 \$12930 \$13034 gf180mcu_fd_sc_mcu9t5v0__nand2_1
X$4606 \$12259 \$13489 \$13624 \$13634 \$13623 \$13729
+ gf180mcu_fd_sc_mcu9t5v0__dffrnq_2
X$4607 \$12259 \$12787 \$12659 \$13634 \$12786 \$12930
+ gf180mcu_fd_sc_mcu9t5v0__dffrnq_2
X$4608 \$12259 \$13343 \$13207 \$13634 \$13341 \$13452
+ gf180mcu_fd_sc_mcu9t5v0__dffrnq_2
X$4609 \$12259 \$14199 \$14338 \$13634 \$14151 \$14337
+ gf180mcu_fd_sc_mcu9t5v0__dffrnq_2
X$4610 \$12259 \$14038 \$14002 \$13634 \$14151 \$14034
+ gf180mcu_fd_sc_mcu9t5v0__dffrnq_2
X$4611 \$12259 \$13036 \$13080 \$13634 \$13035 \$12930
+ gf180mcu_fd_sc_mcu9t5v0__dffrnq_2
X$4612 \$12259 \$13082 \$13084 \$13634 \$13341 \$13083
+ gf180mcu_fd_sc_mcu9t5v0__dffrnq_2
X$4613 \$12259 \$13205 \$13206 \$13634 \$13341 \$13083
+ gf180mcu_fd_sc_mcu9t5v0__dffrnq_2
X$4614 \$12259 \$13730 \$13626 \$13634 \$13881 \$13729
+ gf180mcu_fd_sc_mcu9t5v0__dffrnq_2
X$4615 \$12259 \$13455 \$13456 \$13634 \$13623 \$13452
+ gf180mcu_fd_sc_mcu9t5v0__dffrnq_2
X$4616 \$12259 \$13453 \$13454 \$13634 \$13623 \$13452
+ gf180mcu_fd_sc_mcu9t5v0__dffrnq_2
X$4617 \$12259 \$13035 \$13083 gf180mcu_fd_sc_mcu9t5v0__inv_4
X$4618 \$12259 \$12262 \$12375 \$12260 \$12376 gf180mcu_fd_sc_mcu9t5v0__dffq_2
X$4619 \$12259 \$12525 \$12658 \$12786 \$12526 gf180mcu_fd_sc_mcu9t5v0__dffq_2
X$4620 \$12278 \$12387 \$12260 \$12376 \$12388 gf180mcu_fd_sc_mcu9t5v0__nand2_1
X$4621 \$12376 \$12260 gf180mcu_fd_sc_mcu9t5v0__filltie
X$4622 \$12376 \$12260 gf180mcu_fd_sc_mcu9t5v0__filltie
X$4623 \$12376 \$12260 gf180mcu_fd_sc_mcu9t5v0__filltie
X$4624 \$12376 \$12260 gf180mcu_fd_sc_mcu9t5v0__filltie
X$4625 \$12376 \$12260 gf180mcu_fd_sc_mcu9t5v0__filltie
X$4626 \$12376 \$12260 gf180mcu_fd_sc_mcu9t5v0__filltie
X$4627 \$12376 \$12260 gf180mcu_fd_sc_mcu9t5v0__endcap
X$4628 \$12535 \$12793 \$12266 \$12486 \$12526 \$12536
+ gf180mcu_fd_sc_mcu9t5v0__oai21_2
X$4629 \$14201 \$12535 \$12270 \$12786 \$12930 \$12539
+ gf180mcu_fd_sc_mcu9t5v0__nand3_1
X$4630 \$22278 \$19154 \$22910 \$12274 \$22713 \$22837 \$22723
+ gf180mcu_fd_sc_mcu9t5v0__aoi22_1
X$4631 \$15143 \$12480 \$14027 \$12368 \$15045 \$15204 \$15192
+ gf180mcu_fd_sc_mcu9t5v0__oai31_1
X$4632 \$14483 \$12369 \$14748 \$14635 \$14627 gf180mcu_fd_sc_mcu9t5v0__and2_1
X$4633 \$13997 \$12369 \$13881 \$13729 \$13827 gf180mcu_fd_sc_mcu9t5v0__and2_1
X$4634 \$14147 \$12369 \$14148 \$14151 \$14034 \$13999
+ gf180mcu_fd_sc_mcu9t5v0__and3_1
X$4635 \$12369 \$13193 \$13195 \$13623 \$13452 \$13480
+ gf180mcu_fd_sc_mcu9t5v0__aoi21_1
X$4636 \$12480 \$13341 \$13452 \$12369 gf180mcu_fd_sc_mcu9t5v0__clkinv_1
X$4637 \$14144 \$12369 \$13196 \$15321 \$15490 \$15354
+ gf180mcu_fd_sc_mcu9t5v0__nand3_1
X$4638 \$15142 \$12369 \$13196 \$15628 \$15749 \$15796
+ gf180mcu_fd_sc_mcu9t5v0__nand3_1
X$4639 \$14631 \$12369 \$13196 \$14748 \$14875 \$14746
+ gf180mcu_fd_sc_mcu9t5v0__nand3_1
X$4640 \$13442 \$12369 \$13196 \$13341 \$13452 \$13337
+ gf180mcu_fd_sc_mcu9t5v0__nand3_1
X$4641 \$14188 \$12369 \$14148 \$14151 \$14337 \$14189
+ gf180mcu_fd_sc_mcu9t5v0__nand3_1
X$4642 \$14449 \$12369 \$14148 \$14454 \$14635 \$14486
+ gf180mcu_fd_sc_mcu9t5v0__nand3_1
X$4643 \$15804 \$12369 \$14148 \$15628 \$15749 \$15744
+ gf180mcu_fd_sc_mcu9t5v0__nand3_1
X$4644 \$14001 \$12369 \$13196 \$13881 \$14034 \$13830
+ gf180mcu_fd_sc_mcu9t5v0__nand3_1
X$4645 \$14870 \$12369 \$14148 \$15045 \$14875 \$14987
+ gf180mcu_fd_sc_mcu9t5v0__nand3_1
X$4646 \$15318 \$12369 \$14148 \$15628 \$15490 \$15489
+ gf180mcu_fd_sc_mcu9t5v0__nand3_1
X$4647 \$14191 \$12369 \$14148 \$14151 \$14034 \$12893
+ gf180mcu_fd_sc_mcu9t5v0__nand3_1
X$4648 \$14988 \$12369 \$14148 \$15045 \$14875 \$15043
+ gf180mcu_fd_sc_mcu9t5v0__nand3_1
X$4649 \$15190 \$12369 \$13196 \$15949 \$15749 \$15800
+ gf180mcu_fd_sc_mcu9t5v0__nand3_1
X$4650 \$16430 \$12369 \$14148 \$15949 \$15749 \$15803
+ gf180mcu_fd_sc_mcu9t5v0__nand3_1
X$4651 \$14142 \$12369 \$14148 \$14454 \$14337 \$14336
+ gf180mcu_fd_sc_mcu9t5v0__nand3_1
X$4652 \$15800 \$13078 \$12370 \$13443 \$15949 \$15749 \$15801
+ gf180mcu_fd_sc_mcu9t5v0__and4_1
X$4653 \$12519 \$12372 \$12486 \$12526 \$12518 gf180mcu_fd_sc_mcu9t5v0__nand2_1
X$4654 \$13078 \$14189 \$12373 \$14454 \$14337 \$14488
+ gf180mcu_fd_sc_mcu9t5v0__nand3_1
X$4655 \$12484 \$12517 \$12486 \$12376 \$12374 gf180mcu_fd_sc_mcu9t5v0__nand2_1
X$4656 \$12487 \$12486 \$12376 \$12483 gf180mcu_fd_sc_mcu9t5v0__clkbuf_8
X$4657 \$12505 \$12503 \$12486 \$12376 \$12504 gf180mcu_fd_sc_mcu9t5v0__nand2_1
X$4658 \$12376 \$12486 gf180mcu_fd_sc_mcu9t5v0__filltie
X$4659 \$12376 \$12486 gf180mcu_fd_sc_mcu9t5v0__filltie
X$4660 \$12376 \$12486 gf180mcu_fd_sc_mcu9t5v0__filltie
X$4661 \$12376 \$12486 gf180mcu_fd_sc_mcu9t5v0__filltie
X$4662 \$12376 \$12486 gf180mcu_fd_sc_mcu9t5v0__filltie
X$4663 \$12376 \$12486 gf180mcu_fd_sc_mcu9t5v0__filltie
X$4664 \$12376 \$12486 gf180mcu_fd_sc_mcu9t5v0__endcap
X$4665 \$12543 \$13222 \$12382 \$13341 \$13083 gf180mcu_fd_sc_mcu9t5v0__dffq_2
X$4666 \$12384 \$12912 \$12786 \$12930 \$12913 gf180mcu_fd_sc_mcu9t5v0__nand2_1
X$4667 \$22278 \$19154 \$22910 \$12388 \$23027 \$22837 \$22916
+ gf180mcu_fd_sc_mcu9t5v0__aoi22_1
X$4668 \$14447 \$12480 \$17944 \$18137 \$17952 \$17810
+ gf180mcu_fd_sc_mcu9t5v0__nor3_1
X$4669 \$12480 \$13070 \$13341 \$13452 \$13030 gf180mcu_fd_sc_mcu9t5v0__nand2_1
X$4670 \$13029 \$12482 \$13341 \$13452 \$13443 gf180mcu_fd_sc_mcu9t5v0__nand2_1
X$4671 \$12484 \$13487 \$13450 \$13486 \$13445 \$13623 \$13452 \$17030
+ gf180mcu_fd_sc_mcu9t5v0__aoi221_1
X$4672 \$14241 \$12918 \$12498 \$13471 \$12486 \$12526
+ gf180mcu_fd_sc_mcu9t5v0__dffrnq_2
X$4673 \$12565 \$12563 \$12486 \$12526 \$12564 gf180mcu_fd_sc_mcu9t5v0__nand2_1
X$4674 \$12656 \$12517 \$12486 \$12526 \$12516 gf180mcu_fd_sc_mcu9t5v0__nand2_1
X$4675 \$12657 \$12517 \$12486 \$12526 \$12523 gf180mcu_fd_sc_mcu9t5v0__nand2_1
X$4676 \$12523 \$12521 \$12486 \$12526 \$12522 gf180mcu_fd_sc_mcu9t5v0__nand2_1
X$4677 \$12520 \$12517 \$12486 \$12526 \$12519 gf180mcu_fd_sc_mcu9t5v0__nand2_1
X$4678 \$12514 \$13197 \$12512 \$12486 \$12526 \$12513
+ gf180mcu_fd_sc_mcu9t5v0__mux2_1
X$4679 \$12526 \$12486 gf180mcu_fd_sc_mcu9t5v0__filltie
X$4680 \$12526 \$12486 gf180mcu_fd_sc_mcu9t5v0__filltie
X$4681 \$12526 \$12486 gf180mcu_fd_sc_mcu9t5v0__filltie
X$4682 \$12526 \$12486 gf180mcu_fd_sc_mcu9t5v0__filltie
X$4683 \$12526 \$12486 gf180mcu_fd_sc_mcu9t5v0__filltie
X$4684 \$12526 \$12486 gf180mcu_fd_sc_mcu9t5v0__filltie
X$4685 \$12533 \$12903 \$12534 \$12794 \$12486 \$12526 \$12669
+ gf180mcu_fd_sc_mcu9t5v0__or4_1
X$4686 \$12526 \$12486 gf180mcu_fd_sc_mcu9t5v0__endcap
X$4687 \$18416 \$18293 \$18403 \$12487 gf180mcu_fd_sc_mcu9t5v0__clkbuf_16
X$4688 \$12487 \$25462 \$25347 \$25460 gf180mcu_fd_sc_mcu9t5v0__clkbuf_8
X$4689 \$12487 \$14748 \$14635 \$12547 gf180mcu_fd_sc_mcu9t5v0__clkbuf_8
X$4690 \$12487 \$26088 \$25918 \$26115 gf180mcu_fd_sc_mcu9t5v0__clkbuf_8
X$4691 \$13045 \$13035 \$13083 \$12494 gf180mcu_fd_sc_mcu9t5v0__buf_8
X$4692 \$12498 \$12912 \$12786 \$12930 \$12919 gf180mcu_fd_sc_mcu9t5v0__nand2_1
X$4693 \$22278 \$19154 \$22910 \$12504 \$23027 \$23139 \$23043
+ gf180mcu_fd_sc_mcu9t5v0__aoi22_1
X$4694 \$13230 \$12797 \$12508 \$12786 \$12930 gf180mcu_fd_sc_mcu9t5v0__dffq_2
X$4695 \$17999 \$13078 \$12512 \$18137 \$17952 \$18000
+ gf180mcu_fd_sc_mcu9t5v0__nor3_1
X$4696 \$16723 \$12512 \$16267 \$16914 \$16728 \$17997
+ gf180mcu_fd_sc_mcu9t5v0__nand3_1
X$4697 \$12512 \$16914 \$16728 \$16427 gf180mcu_fd_sc_mcu9t5v0__clkinv_1
X$4698 \$16836 \$17085 \$17367 \$12512 gf180mcu_fd_sc_mcu9t5v0__buf_8
X$4699 \$14872 \$14870 \$12512 \$14748 \$14875 \$14986
+ gf180mcu_fd_sc_mcu9t5v0__mux2_1
X$4700 \$15197 \$15146 \$12512 \$15045 \$15204 \$15196
+ gf180mcu_fd_sc_mcu9t5v0__mux2_1
X$4701 \$15144 \$15195 \$12512 \$15045 \$15204 \$15312
+ gf180mcu_fd_sc_mcu9t5v0__mux2_1
X$4702 \$17945 \$18289 \$12512 \$17818 \$17952 \$18004
+ gf180mcu_fd_sc_mcu9t5v0__mux2_1
X$4703 \$17943 \$15939 \$12512 \$17818 \$17952 \$17998
+ gf180mcu_fd_sc_mcu9t5v0__mux2_1
X$4704 \$15741 \$14144 \$12512 \$15628 \$15749 \$15740
+ gf180mcu_fd_sc_mcu9t5v0__mux2_1
X$4705 \$17700 \$17814 \$12512 \$17538 \$17703 \$17699
+ gf180mcu_fd_sc_mcu9t5v0__mux2_1
X$4706 \$18292 \$18290 \$12512 \$18403 \$18576 \$18401
+ gf180mcu_fd_sc_mcu9t5v0__mux2_1
X$4707 \$16577 \$16119 \$12512 \$16436 \$16728 \$16576
+ gf180mcu_fd_sc_mcu9t5v0__mux2_1
X$4708 \$15487 \$15736 \$12512 \$15628 \$15749 \$15486
+ gf180mcu_fd_sc_mcu9t5v0__mux2_1
X$4709 \$17025 \$18250 \$12512 \$17085 \$17367 \$17362
+ gf180mcu_fd_sc_mcu9t5v0__mux2_1
X$4710 \$14487 \$14188 \$12512 \$14454 \$14635 \$14632
+ gf180mcu_fd_sc_mcu9t5v0__mux2_1
X$4711 \$15739 \$15735 \$12512 \$15628 \$15749 \$15738
+ gf180mcu_fd_sc_mcu9t5v0__mux2_1
X$4712 \$16909 \$16723 \$12512 \$16914 \$16728 \$16838
+ gf180mcu_fd_sc_mcu9t5v0__mux2_1
X$4713 \$15141 \$15348 \$12512 \$15045 \$14875 \$15039
+ gf180mcu_fd_sc_mcu9t5v0__mux2_1
X$4714 \$16123 \$16062 \$12512 \$16269 \$16070 \$16063
+ gf180mcu_fd_sc_mcu9t5v0__mux2_1
X$4715 \$13829 \$14001 \$12512 \$13881 \$13729 \$13878
+ gf180mcu_fd_sc_mcu9t5v0__mux2_1
X$4716 \$13485 \$13484 \$12512 \$13623 \$13452 \$13483
+ gf180mcu_fd_sc_mcu9t5v0__mux2_1
X$4717 \$14335 \$14449 \$12512 \$14454 \$14337 \$14484
+ gf180mcu_fd_sc_mcu9t5v0__mux2_1
X$4718 \$16433 \$17027 \$12512 \$16436 \$16376 \$16432
+ gf180mcu_fd_sc_mcu9t5v0__mux2_1
X$4719 \$16369 \$17022 \$12512 \$16436 \$16376 \$16368
+ gf180mcu_fd_sc_mcu9t5v0__mux2_1
X$4720 \$12654 \$12513 \$12514 \$12655 \$12786 \$12526
+ gf180mcu_fd_sc_mcu9t5v0__dffrnq_2
X$4721 \$12654 \$12515 \$12656 \$12655 \$12786 \$12526
+ gf180mcu_fd_sc_mcu9t5v0__dffrnq_2
X$4722 \$18528 \$12517 \$18403 \$18576 \$18527 gf180mcu_fd_sc_mcu9t5v0__nand2_1
X$4723 \$13033 \$12517 \$12786 \$12930 \$12891 gf180mcu_fd_sc_mcu9t5v0__nand2_1
X$4724 \$12892 \$12517 \$12786 \$12930 \$12929 gf180mcu_fd_sc_mcu9t5v0__nand2_1
X$4725 \$16066 \$12517 \$15949 \$16070 \$15943 gf180mcu_fd_sc_mcu9t5v0__nand2_1
X$4726 \$17235 \$12517 \$17085 \$17367 \$17234 gf180mcu_fd_sc_mcu9t5v0__nand2_1
X$4727 \$16843 \$12517 \$16436 \$16728 \$16582 gf180mcu_fd_sc_mcu9t5v0__nand2_1
X$4728 \$15358 \$12517 \$15321 \$15490 \$15357 gf180mcu_fd_sc_mcu9t5v0__nand2_1
X$4729 \$15742 \$12517 \$15628 \$15490 \$15624 gf180mcu_fd_sc_mcu9t5v0__nand2_1
X$4730 \$13199 \$12517 \$13341 \$13083 \$13338 gf180mcu_fd_sc_mcu9t5v0__nand2_1
X$4731 \$13725 \$12517 \$13623 \$13452 \$13481 gf180mcu_fd_sc_mcu9t5v0__nand2_1
X$4732 \$12890 \$12517 \$13035 \$12930 \$12927 gf180mcu_fd_sc_mcu9t5v0__nand2_1
X$4733 \$26210 \$26401 \$26220 \$12517 gf180mcu_fd_sc_mcu9t5v0__buf_8
X$4734 \$18987 \$26397 \$12517 \$26401 \$26521 \$26396
+ gf180mcu_fd_sc_mcu9t5v0__mux2_1
X$4735 \$19141 \$25796 \$12517 \$25797 \$25918 \$25740
+ gf180mcu_fd_sc_mcu9t5v0__mux2_1
X$4736 \$18526 \$25581 \$12517 \$25462 \$25632 \$25628
+ gf180mcu_fd_sc_mcu9t5v0__mux2_1
X$4737 \$17695 \$26510 \$12517 \$26401 \$26220 \$26509
+ gf180mcu_fd_sc_mcu9t5v0__mux2_1
X$4738 \$18247 \$24988 \$12517 \$24877 \$24721 \$24987
+ gf180mcu_fd_sc_mcu9t5v0__mux2_1
X$4739 \$18399 \$25624 \$12517 \$25462 \$25347 \$25459
+ gf180mcu_fd_sc_mcu9t5v0__mux2_1
X$4740 \$17359 \$26967 \$12517 \$27015 \$26856 \$27007
+ gf180mcu_fd_sc_mcu9t5v0__mux2_1
X$4741 \$12654 \$12518 \$12520 \$12655 \$12786 \$12526
+ gf180mcu_fd_sc_mcu9t5v0__dffrnq_2
X$4742 \$13486 \$13449 \$13487 \$12520 \$13445 \$13341 \$13452 \$13448
+ gf180mcu_fd_sc_mcu9t5v0__aoi221_1
X$4743 \$12535 \$12900 \$12669 \$12671 \$12786 \$12526 \$12670
+ gf180mcu_fd_sc_mcu9t5v0__oai211_2
X$4744 \$12696 \$12695 \$12786 \$12526 \$12920 gf180mcu_fd_sc_mcu9t5v0__nor2_1
X$4745 \$12926 \$12786 \$12526 \$12653 gf180mcu_fd_sc_mcu9t5v0__clkinv_1
X$4746 \$12526 \$12786 gf180mcu_fd_sc_mcu9t5v0__filltie
X$4747 \$12526 \$12786 gf180mcu_fd_sc_mcu9t5v0__filltie
X$4748 \$12526 \$12786 gf180mcu_fd_sc_mcu9t5v0__filltie
X$4749 \$12526 \$12786 gf180mcu_fd_sc_mcu9t5v0__filltie
X$4750 \$12526 \$12786 gf180mcu_fd_sc_mcu9t5v0__filltie
X$4751 \$12526 \$12786 gf180mcu_fd_sc_mcu9t5v0__filltie
X$4752 \$12659 \$16727 \$13081 \$12786 \$12526 \$12787
+ gf180mcu_fd_sc_mcu9t5v0__mux2_1
X$4753 \$12526 \$12786 gf180mcu_fd_sc_mcu9t5v0__endcap
X$4754 \$15048 \$15327 \$12902 \$15045 \$15204 \$12532
+ gf180mcu_fd_sc_mcu9t5v0__mux2_1
X$4755 \$12533 \$12903 \$13502 \$12794 \$13881 \$13729 \$13841
+ gf180mcu_fd_sc_mcu9t5v0__nor4_1
X$4756 \$12537 \$12671 \$12533 \$13341 \$13083 \$13092
+ gf180mcu_fd_sc_mcu9t5v0__aoi21_4
X$4757 \$12533 \$14156 \$13837 \$14151 \$14034 \$14157
+ gf180mcu_fd_sc_mcu9t5v0__oai21_1
X$4758 \$12533 \$14201 \$15321 \$15204 \$15208 gf180mcu_fd_sc_mcu9t5v0__nor2_1
X$4759 \$12533 \$15949 \$15749 \$16077 gf180mcu_fd_sc_mcu9t5v0__clkinv_1
X$4760 \$15494 \$15628 \$15490 \$12533 gf180mcu_fd_sc_mcu9t5v0__buf_8
X$4761 \$12533 \$15955 \$15328 \$15321 \$15490 \$14756
+ gf180mcu_fd_sc_mcu9t5v0__mux2_1
X$4762 \$12903 \$12534 \$12794 \$12786 \$12930 \$12535
+ gf180mcu_fd_sc_mcu9t5v0__nor3_2
X$4763 \$12903 \$12534 \$12794 \$12786 \$12930 \$12904
+ gf180mcu_fd_sc_mcu9t5v0__or3_2
X$4764 \$12794 \$12534 \$13087 \$13035 \$13083 \$13089
+ gf180mcu_fd_sc_mcu9t5v0__nor3_4
X$4765 \$12794 \$12534 \$13344 \$13035 \$13083 \$13039
+ gf180mcu_fd_sc_mcu9t5v0__nor3_4
X$4766 \$13628 \$13881 \$14034 \$12534 gf180mcu_fd_sc_mcu9t5v0__clkbuf_8
X$4767 \$13502 \$12794 \$13087 \$13623 \$13452 \$12537
+ gf180mcu_fd_sc_mcu9t5v0__or3_4
X$4768 \$12537 \$12671 \$14201 \$13341 \$13452 \$13216
+ gf180mcu_fd_sc_mcu9t5v0__aoi21_2
X$4769 \$13220 \$13092 \$13216 \$13219 \$13035 \$13083 \$12540
+ gf180mcu_fd_sc_mcu9t5v0__oai211_2
X$4770 \$12543 \$14465 \$14352 \$13634 \$14454 \$14635
+ gf180mcu_fd_sc_mcu9t5v0__dffrnq_2
X$4771 \$12543 \$13517 \$13516 \$13634 \$13623 \$13729
+ gf180mcu_fd_sc_mcu9t5v0__dffrnq_2
X$4772 \$12543 \$14454 \$14635 gf180mcu_fd_sc_mcu9t5v0__clkinv_8
X$4773 \$12548 \$12912 \$12786 \$12930 \$12923 gf180mcu_fd_sc_mcu9t5v0__nand2_1
X$4774 \$12548 \$14345 \$14454 \$14337 \$14509 gf180mcu_fd_sc_mcu9t5v0__nand2_1
X$4775 \$25086 \$12558 \$23032 \$24877 \$24997 \$25015
+ gf180mcu_fd_sc_mcu9t5v0__aoi21_1
X$4776 \$25086 \$12558 \$16851 \$25191 \$24997 \$25199
+ gf180mcu_fd_sc_mcu9t5v0__oai21_1
X$4777 \$25086 \$12558 \$25015 \$25191 \$24997 \$25087
+ gf180mcu_fd_sc_mcu9t5v0__oai21_1
X$4778 \$12916 \$12915 \$12917 \$12786 \$12930 \$12563
+ gf180mcu_fd_sc_mcu9t5v0__oai21_1
X$4779 \$12885 \$13029 \$13068 \$12652 \$13035 \$12930 \$12888
+ gf180mcu_fd_sc_mcu9t5v0__nand4_1
X$4780 \$12654 \$13881 \$13729 gf180mcu_fd_sc_mcu9t5v0__clkbuf_4
X$4781 \$12654 \$12889 \$12890 \$12655 \$12786 \$12930
+ gf180mcu_fd_sc_mcu9t5v0__dffrnq_2
X$4782 \$12654 \$13483 \$13485 \$12655 \$13623 \$13729
+ gf180mcu_fd_sc_mcu9t5v0__dffrnq_2
X$4783 \$12654 \$13034 \$12892 \$13634 \$13035 \$12930
+ gf180mcu_fd_sc_mcu9t5v0__dffrnq_2
X$4784 \$12654 \$12928 \$13033 \$12655 \$13035 \$12930
+ gf180mcu_fd_sc_mcu9t5v0__dffrnq_2
X$4785 \$29696 \$29785 \$12655 \$29722 \$29634 \$29720 \$28344
+ gf180mcu_fd_sc_mcu9t5v0__and4_1
X$4786 \$29696 \$30056 \$12655 \$29722 \$29780 \$29720 \$29240
+ gf180mcu_fd_sc_mcu9t5v0__and4_1
X$4787 \$29784 \$29785 \$12655 \$29722 \$29780 \$29720 \$29091
+ gf180mcu_fd_sc_mcu9t5v0__and4_1
X$4788 \$14187 \$15317 \$15318 \$12655 \$15321 \$15490
+ gf180mcu_fd_sc_mcu9t5v0__dffrnq_2
X$4789 \$14187 \$14873 \$14988 \$12655 \$14748 \$14875
+ gf180mcu_fd_sc_mcu9t5v0__dffrnq_2
X$4790 \$17020 \$16371 \$16430 \$12655 \$16269 \$16376
+ gf180mcu_fd_sc_mcu9t5v0__dffrnq_2
X$4791 \$31827 \$32857 \$32792 \$12655 \$32853 \$32934
+ gf180mcu_fd_sc_mcu9t5v0__dffrnq_2
X$4792 \$31089 \$32555 \$32576 \$12655 \$32543 \$32629
+ gf180mcu_fd_sc_mcu9t5v0__dffrnq_2
X$4793 \$28212 \$28048 \$26977 \$12655 \$27913 \$28089
+ gf180mcu_fd_sc_mcu9t5v0__dffrnq_2
X$4794 \$24301 \$26096 \$26097 \$12655 \$26088 \$26220
+ gf180mcu_fd_sc_mcu9t5v0__dffrnq_2
X$4795 \$19026 \$19326 \$19467 \$12655 \$19324 \$19466
+ gf180mcu_fd_sc_mcu9t5v0__dffrnq_2
X$4796 \$19026 \$19325 \$19147 \$12655 \$19324 \$19466
+ gf180mcu_fd_sc_mcu9t5v0__dffrnq_2
X$4797 \$19026 \$19928 \$19929 \$12655 \$19927 \$20087
+ gf180mcu_fd_sc_mcu9t5v0__dffrnq_2
X$4798 \$19026 \$18703 \$18821 \$12655 \$18701 \$18870
+ gf180mcu_fd_sc_mcu9t5v0__dffrnq_2
X$4799 \$18568 \$19323 \$19464 \$12655 \$19324 \$19466
+ gf180mcu_fd_sc_mcu9t5v0__dffrnq_2
X$4800 \$27926 \$29782 \$29784 \$12655 \$29780 \$29847
+ gf180mcu_fd_sc_mcu9t5v0__dffrnq_2
X$4801 \$18568 \$18816 \$18817 \$12655 \$18701 \$18870
+ gf180mcu_fd_sc_mcu9t5v0__dffrnq_2
X$4802 \$28554 \$30317 \$30411 \$12655 \$30251 \$30339
+ gf180mcu_fd_sc_mcu9t5v0__dffrnq_2
X$4803 \$28554 \$30473 \$30474 \$12655 \$30402 \$30485
+ gf180mcu_fd_sc_mcu9t5v0__dffrnq_2
X$4804 \$14187 \$18253 \$18007 \$12655 \$18137 \$18293
+ gf180mcu_fd_sc_mcu9t5v0__dffrnq_2
X$4805 \$28554 \$30766 \$30700 \$12655 \$30696 \$30763
+ gf180mcu_fd_sc_mcu9t5v0__dffrnq_2
X$4806 \$31827 \$32554 \$32772 \$12655 \$32721 \$32765
+ gf180mcu_fd_sc_mcu9t5v0__dffrnq_2
X$4807 \$31381 \$31541 \$31542 \$12655 \$31535 \$31584
+ gf180mcu_fd_sc_mcu9t5v0__dffrnq_2
X$4808 \$28554 \$29854 \$29925 \$12655 \$29954 \$30027
+ gf180mcu_fd_sc_mcu9t5v0__dffrnq_2
X$4809 \$28554 \$29960 \$29961 \$12655 \$29954 \$30027
+ gf180mcu_fd_sc_mcu9t5v0__dffrnq_2
X$4810 \$28554 \$30853 \$30550 \$12655 \$30819 \$30900
+ gf180mcu_fd_sc_mcu9t5v0__dffrnq_2
X$4811 \$25805 \$27641 \$27454 \$12655 \$27637 \$27776
+ gf180mcu_fd_sc_mcu9t5v0__dffrnq_2
X$4812 \$27926 \$29636 \$29637 \$12655 \$29634 \$29720
+ gf180mcu_fd_sc_mcu9t5v0__dffrnq_2
X$4813 \$27926 \$29130 \$28820 \$12655 \$29123 \$29270
+ gf180mcu_fd_sc_mcu9t5v0__dffrnq_2
X$4814 \$24301 \$26680 \$26681 \$12655 \$26675 \$26856
+ gf180mcu_fd_sc_mcu9t5v0__dffrnq_2
X$4815 \$28212 \$28695 \$28340 \$12655 \$28810 \$28971
+ gf180mcu_fd_sc_mcu9t5v0__dffrnq_2
X$4816 \$23323 \$23928 \$23929 \$12655 \$23926 \$24109
+ gf180mcu_fd_sc_mcu9t5v0__dffrnq_2
X$4817 \$21942 \$22444 \$22275 \$12655 \$22387 \$22440
+ gf180mcu_fd_sc_mcu9t5v0__dffrnq_2
X$4818 \$27926 \$28935 \$28502 \$12655 \$28810 \$28971
+ gf180mcu_fd_sc_mcu9t5v0__dffrnq_2
X$4819 \$17020 \$16432 \$16433 \$12655 \$16436 \$16728
+ gf180mcu_fd_sc_mcu9t5v0__dffrnq_2
X$4820 \$21942 \$22131 \$21948 \$12655 \$22074 \$22272
+ gf180mcu_fd_sc_mcu9t5v0__dffrnq_2
X$4821 \$14187 \$14146 \$14147 \$12655 \$14151 \$14337
+ gf180mcu_fd_sc_mcu9t5v0__dffrnq_2
X$4822 \$19026 \$19276 \$19465 \$12655 \$19324 \$19466
+ gf180mcu_fd_sc_mcu9t5v0__dffrnq_2
X$4823 \$25799 \$26525 \$26644 \$12655 \$26401 \$26521
+ gf180mcu_fd_sc_mcu9t5v0__dffrnq_2
X$4824 \$21942 \$22128 \$21803 \$12655 \$22074 \$22272
+ gf180mcu_fd_sc_mcu9t5v0__dffrnq_2
X$4825 \$16439 \$16587 \$16437 \$12655 \$16436 \$16728
+ gf180mcu_fd_sc_mcu9t5v0__dffrnq_2
X$4826 \$14187 \$17028 \$17029 \$12655 \$16914 \$17034
+ gf180mcu_fd_sc_mcu9t5v0__dffrnq_2
X$4827 \$14187 \$16585 \$16727 \$12655 \$16436 \$16728
+ gf180mcu_fd_sc_mcu9t5v0__dffrnq_2
X$4828 \$14187 \$16913 \$16844 \$12655 \$16914 \$17034
+ gf180mcu_fd_sc_mcu9t5v0__dffrnq_2
X$4829 \$14187 \$16068 \$15805 \$12655 \$15949 \$16070
+ gf180mcu_fd_sc_mcu9t5v0__dffrnq_2
X$4830 \$14187 \$15944 \$15804 \$12655 \$15949 \$16070
+ gf180mcu_fd_sc_mcu9t5v0__dffrnq_2
X$4831 \$14187 \$16067 \$15745 \$12655 \$15949 \$16070
+ gf180mcu_fd_sc_mcu9t5v0__dffrnq_2
X$4832 \$14150 \$16069 \$15950 \$12655 \$15949 \$16070
+ gf180mcu_fd_sc_mcu9t5v0__dffrnq_2
X$4833 \$16439 \$17086 \$17087 \$12655 \$17085 \$17367
+ gf180mcu_fd_sc_mcu9t5v0__dffrnq_2
X$4834 \$31089 \$31615 \$31686 \$12655 \$31607 \$31733
+ gf180mcu_fd_sc_mcu9t5v0__dffrnq_2
X$4835 \$19026 \$20576 \$20516 \$12655 \$20515 \$20718
+ gf180mcu_fd_sc_mcu9t5v0__dffrnq_2
X$4836 \$25799 \$25800 \$25923 \$12655 \$25797 \$25918
+ gf180mcu_fd_sc_mcu9t5v0__dffrnq_2
X$4837 \$19775 \$19606 \$19607 \$12655 \$19605 \$19774
+ gf180mcu_fd_sc_mcu9t5v0__dffrnq_2
X$4838 \$23323 \$24998 \$24723 \$12655 \$24877 \$24997
+ gf180mcu_fd_sc_mcu9t5v0__dffrnq_2
X$4839 \$27926 \$30165 \$30056 \$12655 \$30054 \$30185
+ gf180mcu_fd_sc_mcu9t5v0__dffrnq_2
X$4840 \$21942 \$22717 \$22580 \$12655 \$22713 \$22837
+ gf180mcu_fd_sc_mcu9t5v0__dffrnq_2
X$4841 \$19026 \$19880 \$19733 \$12655 \$19927 \$19774
+ gf180mcu_fd_sc_mcu9t5v0__dffrnq_2
X$4842 \$19026 \$18575 \$18820 \$12655 \$18701 \$18576
+ gf180mcu_fd_sc_mcu9t5v0__dffrnq_2
X$4843 \$28554 \$29703 \$29704 \$12655 \$29780 \$29720
+ gf180mcu_fd_sc_mcu9t5v0__dffrnq_2
X$4844 \$27926 \$29432 \$29433 \$12655 \$29634 \$29424
+ gf180mcu_fd_sc_mcu9t5v0__dffrnq_2
X$4845 \$30858 \$31387 \$31263 \$12655 \$31376 \$31310
+ gf180mcu_fd_sc_mcu9t5v0__dffrnq_2
X$4846 \$28554 \$29434 \$29435 \$12655 \$29634 \$29424
+ gf180mcu_fd_sc_mcu9t5v0__dffrnq_2
X$4847 \$27926 \$30057 \$30058 \$12655 \$30054 \$30027
+ gf180mcu_fd_sc_mcu9t5v0__dffrnq_2
X$4848 \$31089 \$31313 \$31322 \$12655 \$31376 \$31310
+ gf180mcu_fd_sc_mcu9t5v0__dffrnq_2
X$4849 \$27926 \$29853 \$29786 \$12655 \$29954 \$29847
+ gf180mcu_fd_sc_mcu9t5v0__dffrnq_2
X$4850 \$31089 \$31593 \$31616 \$12655 \$31607 \$31584
+ gf180mcu_fd_sc_mcu9t5v0__dffrnq_2
X$4851 \$31089 \$32156 \$32158 \$12655 \$32248 \$32171
+ gf180mcu_fd_sc_mcu9t5v0__dffrnq_2
X$4852 \$19026 \$21304 \$21010 \$12655 \$21498 \$21308
+ gf180mcu_fd_sc_mcu9t5v0__dffrnq_2
X$4853 \$21942 \$22578 \$22579 \$12655 \$22713 \$22440
+ gf180mcu_fd_sc_mcu9t5v0__dffrnq_2
X$4854 \$19026 \$20208 \$20210 \$12655 \$20209 \$20087
+ gf180mcu_fd_sc_mcu9t5v0__dffrnq_2
X$4855 \$19026 \$21307 \$21012 \$12655 \$21498 \$21308
+ gf180mcu_fd_sc_mcu9t5v0__dffrnq_2
X$4856 \$19026 \$20717 \$19879 \$12655 \$20881 \$20718
+ gf180mcu_fd_sc_mcu9t5v0__dffrnq_2
X$4857 \$21942 \$21945 \$21804 \$12655 \$22074 \$21946
+ gf180mcu_fd_sc_mcu9t5v0__dffrnq_2
X$4858 \$21942 \$22129 \$22130 \$12655 \$22387 \$22272
+ gf180mcu_fd_sc_mcu9t5v0__dffrnq_2
X$4859 \$19026 \$18869 \$18993 \$12655 \$19027 \$18870
+ gf180mcu_fd_sc_mcu9t5v0__dffrnq_2
X$4860 \$25799 \$26362 \$26222 \$12655 \$26401 \$26220
+ gf180mcu_fd_sc_mcu9t5v0__dffrnq_2
X$4861 \$23323 \$23808 \$23763 \$12655 \$23926 \$23807
+ gf180mcu_fd_sc_mcu9t5v0__dffrnq_2
X$4862 \$25799 \$25349 \$25309 \$12655 \$25462 \$25347
+ gf180mcu_fd_sc_mcu9t5v0__dffrnq_2
X$4863 \$19026 \$20839 \$20882 \$12655 \$20881 \$20718
+ gf180mcu_fd_sc_mcu9t5v0__dffrnq_2
X$4864 \$23321 \$25348 \$25307 \$12655 \$25462 \$25347
+ gf180mcu_fd_sc_mcu9t5v0__dffrnq_2
X$4865 \$23323 \$24850 \$24727 \$12655 \$24877 \$24721
+ gf180mcu_fd_sc_mcu9t5v0__dffrnq_2
X$4866 \$28554 \$30345 \$30316 \$12655 \$30402 \$30339
+ gf180mcu_fd_sc_mcu9t5v0__dffrnq_2
X$4867 \$31381 \$31034 \$30551 \$12655 \$31100 \$31032
+ gf180mcu_fd_sc_mcu9t5v0__dffrnq_2
X$4868 \$31089 \$31037 \$31088 \$12655 \$31100 \$31032
+ gf180mcu_fd_sc_mcu9t5v0__dffrnq_2
X$4869 \$25805 \$27157 \$27030 \$12655 \$27315 \$27153
+ gf180mcu_fd_sc_mcu9t5v0__dffrnq_2
X$4870 \$27926 \$27785 \$26806 \$12655 \$27913 \$27776
+ gf180mcu_fd_sc_mcu9t5v0__dffrnq_2
X$4871 \$31089 \$31259 \$31087 \$12655 \$31376 \$31310
+ gf180mcu_fd_sc_mcu9t5v0__dffrnq_2
X$4872 \$31381 \$31467 \$31386 \$12655 \$31535 \$31465
+ gf180mcu_fd_sc_mcu9t5v0__dffrnq_2
X$4873 \$31381 \$31383 \$31164 \$12655 \$31376 \$31310
+ gf180mcu_fd_sc_mcu9t5v0__dffrnq_2
X$4874 \$27926 \$28815 \$28546 \$12655 \$28810 \$28689
+ gf180mcu_fd_sc_mcu9t5v0__dffrnq_2
X$4875 \$28212 \$21309 \$29955 \$12655 \$29954 \$29847
+ gf180mcu_fd_sc_mcu9t5v0__dffrnq_2
X$4876 \$14187 \$17492 \$17031 \$12655 \$17538 \$17367
+ gf180mcu_fd_sc_mcu9t5v0__dffrnq_2
X$4877 \$16439 \$17365 \$17366 \$12655 \$17538 \$17367
+ gf180mcu_fd_sc_mcu9t5v0__dffrnq_2
X$4878 \$16439 \$17032 \$16853 \$12655 \$17085 \$17034
+ gf180mcu_fd_sc_mcu9t5v0__dffrnq_2
X$4879 \$16439 \$17950 \$17951 \$12655 \$18137 \$17952
+ gf180mcu_fd_sc_mcu9t5v0__dffrnq_2
X$4880 \$16439 \$16440 \$16441 \$12655 \$16436 \$16376
+ gf180mcu_fd_sc_mcu9t5v0__dffrnq_2
X$4881 \$14187 \$16374 \$16434 \$12655 \$16436 \$16376
+ gf180mcu_fd_sc_mcu9t5v0__dffrnq_2
X$4882 \$14150 \$15807 \$15046 \$12655 \$15949 \$15749
+ gf180mcu_fd_sc_mcu9t5v0__dffrnq_2
X$4883 \$16439 \$17948 \$17949 \$12655 \$18137 \$17952
+ gf180mcu_fd_sc_mcu9t5v0__dffrnq_2
X$4884 \$16439 \$16588 \$16589 \$12655 \$16914 \$16728
+ gf180mcu_fd_sc_mcu9t5v0__dffrnq_2
X$4885 \$19026 \$20384 \$20385 \$12655 \$20515 \$20383
+ gf180mcu_fd_sc_mcu9t5v0__dffrnq_2
X$4886 \$23323 \$23590 \$23621 \$12655 \$23620 \$23454
+ gf180mcu_fd_sc_mcu9t5v0__dffrnq_2
X$4887 \$23321 \$25760 \$25761 \$12655 \$25797 \$25632
+ gf180mcu_fd_sc_mcu9t5v0__dffrnq_2
X$4888 \$25799 \$26357 \$26359 \$12655 \$26401 \$26220
+ gf180mcu_fd_sc_mcu9t5v0__dffrnq_2
X$4889 \$14187 \$14986 \$14872 \$12655 \$15045 \$14875
+ gf180mcu_fd_sc_mcu9t5v0__dffrnq_2
X$4890 \$14187 \$15488 \$15358 \$12655 \$15628 \$15490
+ gf180mcu_fd_sc_mcu9t5v0__dffrnq_2
X$4891 \$31089 \$31877 \$31878 \$12655 \$32100 \$32034
+ gf180mcu_fd_sc_mcu9t5v0__dffrnq_2
X$4892 \$25799 \$26801 \$26092 \$12655 \$27015 \$26856
+ gf180mcu_fd_sc_mcu9t5v0__dffrnq_2
X$4893 \$28212 \$27925 \$26408 \$12655 \$27913 \$27776
+ gf180mcu_fd_sc_mcu9t5v0__dffrnq_2
X$4894 \$34300 \$I24314 \$34215 \$12655 gf180mcu_fd_sc_mcu9t5v0__buf_20
X$4895 \$12655 \$33071 \$33184 \$13471 gf180mcu_fd_sc_mcu9t5v0__buf_20
X$4896 \$12655 \$31376 \$31465 \$13634 gf180mcu_fd_sc_mcu9t5v0__buf_20
X$4897 \$12655 \$31967 \$32034 \$19307 gf180mcu_fd_sc_mcu9t5v0__buf_20
X$4898 \$12656 \$13487 \$14031 \$13486 \$13445 \$14151 \$14034 \$14149
+ gf180mcu_fd_sc_mcu9t5v0__aoi221_1
X$4899 \$12657 \$13487 \$13726 \$13486 \$13445 \$13881 \$14034 \$14032
+ gf180mcu_fd_sc_mcu9t5v0__aoi221_1
X$4900 \$12659 \$12901 \$12902 \$12786 \$12930 \$12793
+ gf180mcu_fd_sc_mcu9t5v0__mux2_1
X$4901 \$12898 \$12661 \$13035 \$12930 \$13210 gf180mcu_fd_sc_mcu9t5v0__nand2_1
X$4902 \$13502 \$12794 \$13344 \$13341 \$13452 \$12671
+ gf180mcu_fd_sc_mcu9t5v0__or3_4
X$4903 \$12688 \$12786 \$12930 \$12940 gf180mcu_fd_sc_mcu9t5v0__clkinv_1
X$4904 \$13230 \$12798 \$12689 \$13035 \$12930 gf180mcu_fd_sc_mcu9t5v0__dffq_2
X$4905 \$20101 \$19042 \$18885 \$12690 \$20209 \$20087 \$20064
+ gf180mcu_fd_sc_mcu9t5v0__aoi22_1
X$4906 \$13051 \$12914 \$13056 \$12913 \$12786 \$12930 \$12694
+ gf180mcu_fd_sc_mcu9t5v0__oai31_1
X$4907 \$12696 \$12695 \$12786 \$12930 \$12921 gf180mcu_fd_sc_mcu9t5v0__and2_1
X$4908 \$13062 \$13061 \$13252 \$13035 \$13083 \$12695
+ gf180mcu_fd_sc_mcu9t5v0__aoi21_1
X$4909 \$12696 \$12695 \$13060 \$13035 \$12930 \$12915
+ gf180mcu_fd_sc_mcu9t5v0__oai21_1
X$4910 \$13477 \$13532 \$12696 \$13341 \$13452 \$13478
+ gf180mcu_fd_sc_mcu9t5v0__or3_1
X$4911 \$13250 \$13251 \$13341 \$13452 \$12696 gf180mcu_fd_sc_mcu9t5v0__xnor2_1
X$4912 \$13477 \$13532 \$12696 \$13341 \$13452 \$13246
+ gf180mcu_fd_sc_mcu9t5v0__oai21_1
X$4913 \$12923 \$12922 \$12786 \$12930 \$12697 gf180mcu_fd_sc_mcu9t5v0__nand2_1
X$4914 \$15796 \$12783 \$15949 \$15749 \$15795 gf180mcu_fd_sc_mcu9t5v0__nand2_1
X$4915 \$13078 \$14987 \$12784 \$15045 \$14875 \$15042
+ gf180mcu_fd_sc_mcu9t5v0__nand3_1
X$4916 \$18292 \$13078 \$13486 \$12785 \$18137 \$17952 \$18529
+ gf180mcu_fd_sc_mcu9t5v0__oai211_1
X$4917 \$12916 \$12915 \$13051 \$12786 \$12930 \$12917
+ gf180mcu_fd_sc_mcu9t5v0__aoi21_1
X$4918 \$13051 \$12920 \$12921 \$12919 \$12786 \$12930 \$12918
+ gf180mcu_fd_sc_mcu9t5v0__oai31_1
X$4919 \$12885 \$12886 \$12786 \$12930 \$12884 gf180mcu_fd_sc_mcu9t5v0__nor2_1
X$4920 \$12930 \$12786 gf180mcu_fd_sc_mcu9t5v0__filltie
X$4921 \$12930 \$12786 gf180mcu_fd_sc_mcu9t5v0__filltie
X$4922 \$12930 \$12786 gf180mcu_fd_sc_mcu9t5v0__filltie
X$4923 \$12930 \$12786 gf180mcu_fd_sc_mcu9t5v0__filltie
X$4924 \$12930 \$12786 gf180mcu_fd_sc_mcu9t5v0__filltie
X$4925 \$12930 \$12786 gf180mcu_fd_sc_mcu9t5v0__filltie
X$4926 \$12930 \$12786 gf180mcu_fd_sc_mcu9t5v0__endcap
X$4927 \$13502 \$12794 \$13883 \$14151 \$14034 \$14041
+ gf180mcu_fd_sc_mcu9t5v0__nor3_2
X$4928 \$14161 \$13883 \$13502 \$12794 \$14151 \$14034 \$13459
+ gf180mcu_fd_sc_mcu9t5v0__aoi211_4
X$4929 \$13502 \$12794 \$14161 \$14151 \$14337 \$13884
+ gf180mcu_fd_sc_mcu9t5v0__nor3_1
X$4930 \$12794 \$16381 \$16133 \$19781 \$19605 \$19774 \$19736
+ gf180mcu_fd_sc_mcu9t5v0__oai211_1
X$4931 \$12794 \$17037 \$19027 \$19149 \$18825 gf180mcu_fd_sc_mcu9t5v0__nor2_1
X$4932 \$12794 \$16381 \$16914 \$16728 \$16593 gf180mcu_fd_sc_mcu9t5v0__nor2_1
X$4933 \$26363 \$26401 \$26220 \$12794 gf180mcu_fd_sc_mcu9t5v0__buf_8
X$4934 \$13068 \$13067 \$13035 \$13083 \$12886 gf180mcu_fd_sc_mcu9t5v0__and2_1
X$4935 \$12890 \$13487 \$13202 \$13486 \$13445 \$13341 \$13083 \$13204
+ gf180mcu_fd_sc_mcu9t5v0__aoi221_1
X$4936 \$12892 \$13487 \$14029 \$13486 \$13445 \$13881 \$14034 \$14030
+ gf180mcu_fd_sc_mcu9t5v0__aoi221_1
X$4937 \$16853 \$17955 \$12902 \$13035 \$12930 \$12900
+ gf180mcu_fd_sc_mcu9t5v0__mux2_1
X$4938 \$17955 \$12901 \$17818 \$17952 \$17956 gf180mcu_fd_sc_mcu9t5v0__xnor2_1
X$4939 \$16439 \$17654 \$12901 \$13634 \$17538 \$17703
+ gf180mcu_fd_sc_mcu9t5v0__dffrnq_2
X$4940 \$17955 \$18406 \$12901 \$18403 \$18293 \$18408
+ gf180mcu_fd_sc_mcu9t5v0__and3_1
X$4941 \$17955 \$12901 \$18406 \$18403 \$18293 \$18407
+ gf180mcu_fd_sc_mcu9t5v0__aoi21_1
X$4942 \$17955 \$18259 \$12901 \$18403 \$18293 \$18296
+ gf180mcu_fd_sc_mcu9t5v0__nand3_1
X$4943 \$12901 \$18009 \$18137 \$18293 \$17957 gf180mcu_fd_sc_mcu9t5v0__nand2_1
X$4944 \$15492 \$15321 \$15204 \$12902 gf180mcu_fd_sc_mcu9t5v0__buf_8
X$4945 \$12902 \$14748 \$14875 \$13493 gf180mcu_fd_sc_mcu9t5v0__buf_8
X$4946 \$15046 \$18406 \$12902 \$15045 \$15204 \$13037
+ gf180mcu_fd_sc_mcu9t5v0__mux2_1
X$4947 \$14991 \$13499 \$12902 \$13623 \$13452 \$13503
+ gf180mcu_fd_sc_mcu9t5v0__mux2_1
X$4948 \$13213 \$13211 \$12902 \$13341 \$13083 \$13212
+ gf180mcu_fd_sc_mcu9t5v0__mux2_1
X$4949 \$14992 \$14748 \$14875 \$12903 gf180mcu_fd_sc_mcu9t5v0__clkinv_1
X$4950 \$14993 \$12903 \$14748 \$14635 \$13344 gf180mcu_fd_sc_mcu9t5v0__nand2_1
X$4951 \$12904 \$13212 \$13841 \$13039 \$13341 \$13083 \$13088
+ gf180mcu_fd_sc_mcu9t5v0__aoi211_1
X$4952 \$13218 \$13341 \$13083 \$12905 gf180mcu_fd_sc_mcu9t5v0__clkinv_1
X$4953 \$13054 \$13053 \$13052 \$13035 \$12930 \$12911
+ gf180mcu_fd_sc_mcu9t5v0__oai21_1
X$4954 \$20097 \$20058 \$12912 \$19927 \$20087 \$19614
+ gf180mcu_fd_sc_mcu9t5v0__aoi21_1
X$4955 \$21822 \$21682 \$12912 \$21498 \$21622 \$20526
+ gf180mcu_fd_sc_mcu9t5v0__aoi21_1
X$4956 \$19761 \$19760 \$12912 \$19605 \$19774 \$19759
+ gf180mcu_fd_sc_mcu9t5v0__aoi21_1
X$4957 \$20528 \$20060 \$12912 \$19927 \$20087 \$19750
+ gf180mcu_fd_sc_mcu9t5v0__aoi21_1
X$4958 \$16881 \$16880 \$12912 \$16914 \$16728 \$16878
+ gf180mcu_fd_sc_mcu9t5v0__aoi21_1
X$4959 \$15024 \$15023 \$12912 \$15045 \$14875 \$14895
+ gf180mcu_fd_sc_mcu9t5v0__aoi21_1
X$4960 \$21160 \$21159 \$12912 \$21184 \$21011 \$20349
+ gf180mcu_fd_sc_mcu9t5v0__aoi21_1
X$4961 \$16888 \$16886 \$12912 \$16914 \$16728 \$16887
+ gf180mcu_fd_sc_mcu9t5v0__aoi21_1
X$4962 \$15024 \$13871 \$12912 \$13881 \$13729 \$13528
+ gf180mcu_fd_sc_mcu9t5v0__aoi21_1
X$4963 \$12912 \$17671 \$17672 \$17538 \$17703 \$17843
+ gf180mcu_fd_sc_mcu9t5v0__oai21_1
X$4964 \$12912 \$24602 \$24251 \$24231 \$24109 \$24119
+ gf180mcu_fd_sc_mcu9t5v0__oai21_1
X$4965 \$12912 \$22156 \$23159 \$23158 \$23027 \$23139 \$23207
+ gf180mcu_fd_sc_mcu9t5v0__oai31_1
X$4966 \$12912 \$24604 \$25069 \$24854 \$24877 \$24721 \$24883
+ gf180mcu_fd_sc_mcu9t5v0__oai31_1
X$4967 \$12912 \$15024 \$15045 \$14875 \$14237 gf180mcu_fd_sc_mcu9t5v0__nor2_1
X$4968 \$12912 \$16893 \$16914 \$16728 \$16616 gf180mcu_fd_sc_mcu9t5v0__nor2_1
X$4969 \$16739 \$12912 \$19751 \$19750 \$19605 \$19774 \$19043
+ gf180mcu_fd_sc_mcu9t5v0__aoi22_1
X$4970 \$20221 \$12912 \$20405 \$20349 \$20209 \$20383 \$20056
+ gf180mcu_fd_sc_mcu9t5v0__aoi22_1
X$4971 \$19619 \$12912 \$19789 \$19759 \$19605 \$19774 \$19618
+ gf180mcu_fd_sc_mcu9t5v0__aoi22_1
X$4972 \$16618 \$12912 \$16617 \$16616 \$16436 \$16728 \$16476
+ gf180mcu_fd_sc_mcu9t5v0__aoi22_1
X$4973 \$13512 \$12912 \$19476 \$19614 \$19605 \$19466 \$18597
+ gf180mcu_fd_sc_mcu9t5v0__aoi22_1
X$4974 \$20403 \$12912 \$20527 \$20526 \$20515 \$20383 \$20347
+ gf180mcu_fd_sc_mcu9t5v0__aoi22_1
X$4975 \$13865 \$12912 \$13876 \$13875 \$13881 \$13729 \$13245
+ gf180mcu_fd_sc_mcu9t5v0__aoi22_1
X$4976 \$16614 \$12912 \$16889 \$16887 \$16914 \$16728 \$16475
+ gf180mcu_fd_sc_mcu9t5v0__aoi22_1
X$4977 \$16742 \$12912 \$16879 \$16878 \$16914 \$16728 \$16613
+ gf180mcu_fd_sc_mcu9t5v0__aoi22_1
X$4978 \$15832 \$12912 \$16436 \$16728 \$16612 gf180mcu_fd_sc_mcu9t5v0__nand2_1
X$4979 \$13899 \$12912 \$15949 \$16070 \$16095 gf180mcu_fd_sc_mcu9t5v0__nand2_1
X$4980 \$16392 \$12912 \$23027 \$23139 \$23158 gf180mcu_fd_sc_mcu9t5v0__nand2_1
X$4981 \$15821 \$12912 \$17818 \$17952 \$17672 gf180mcu_fd_sc_mcu9t5v0__nand2_1
X$4982 \$13866 \$12912 \$13881 \$14034 \$14014 gf180mcu_fd_sc_mcu9t5v0__nand2_1
X$4983 \$13351 \$12912 \$15045 \$15204 \$15171 gf180mcu_fd_sc_mcu9t5v0__nand2_1
X$4984 \$13345 \$12912 \$15949 \$16070 \$16088 gf180mcu_fd_sc_mcu9t5v0__nand2_1
X$4985 \$19038 \$12912 \$24877 \$24997 \$24854 gf180mcu_fd_sc_mcu9t5v0__nand2_1
X$4986 \$17115 \$12912 \$17538 \$17367 \$17121 gf180mcu_fd_sc_mcu9t5v0__nand2_1
X$4987 \$19161 \$12912 \$24593 \$24428 \$24251 gf180mcu_fd_sc_mcu9t5v0__nand2_1
X$4988 \$28057 \$27913 \$28089 \$12912 gf180mcu_fd_sc_mcu9t5v0__buf_8
X$4989 \$13058 \$13057 \$13035 \$12930 \$12914 gf180mcu_fd_sc_mcu9t5v0__and2_1
X$4990 \$12916 \$12915 \$13059 \$13035 \$12930 \$13057
+ gf180mcu_fd_sc_mcu9t5v0__aoi21_1
X$4991 \$13476 \$13243 \$13341 \$13452 \$12916 gf180mcu_fd_sc_mcu9t5v0__xnor2_1
X$4992 \$13105 \$13246 \$12916 \$13341 \$13083 \$13248
+ gf180mcu_fd_sc_mcu9t5v0__and3_1
X$4993 \$13105 \$13246 \$12916 \$13035 \$13083 \$13241
+ gf180mcu_fd_sc_mcu9t5v0__aoi21_1
X$4994 \$13062 \$13061 \$13063 \$13035 \$12930 \$12922
+ gf180mcu_fd_sc_mcu9t5v0__oai21_1
X$4995 \$13030 \$12925 \$13035 \$12930 \$13067 gf180mcu_fd_sc_mcu9t5v0__nor2_1
X$4996 \$13104 \$13056 \$13055 \$13035 \$12930 \$13054
+ gf180mcu_fd_sc_mcu9t5v0__nor3_1
X$4997 \$13062 \$13061 \$13051 \$13035 \$12930 \$13063
+ gf180mcu_fd_sc_mcu9t5v0__aoi21_1
X$4998 \$13058 \$13057 \$13035 \$12930 \$13056 gf180mcu_fd_sc_mcu9t5v0__nor2_1
X$4999 \$14511 \$13035 \$12930 \$12937 gf180mcu_fd_sc_mcu9t5v0__clkinv_1
X$5000 \$12930 \$13035 gf180mcu_fd_sc_mcu9t5v0__filltie
X$5001 \$12930 \$13035 gf180mcu_fd_sc_mcu9t5v0__filltie
X$5002 \$12930 \$13035 gf180mcu_fd_sc_mcu9t5v0__filltie
X$5003 \$12930 \$13035 gf180mcu_fd_sc_mcu9t5v0__filltie
X$5004 \$12930 \$13035 gf180mcu_fd_sc_mcu9t5v0__filltie
X$5005 \$12930 \$13035 gf180mcu_fd_sc_mcu9t5v0__filltie
X$5006 \$12930 \$13035 gf180mcu_fd_sc_mcu9t5v0__endcap
X$5007 \$25199 \$12938 \$25200 \$25191 \$25347 \$25323
+ gf180mcu_fd_sc_mcu9t5v0__aoi21_1
X$5008 \$16851 \$12942 \$24324 \$24593 \$24721 \$24861
+ gf180mcu_fd_sc_mcu9t5v0__aoi21_1
X$5009 \$12942 \$24324 \$23032 \$24593 \$24428 \$24555
+ gf180mcu_fd_sc_mcu9t5v0__aoi21_1
X$5010 \$12942 \$24324 \$24555 \$24593 \$24428 \$24554
+ gf180mcu_fd_sc_mcu9t5v0__oai21_1
X$5011 \$13030 \$13069 \$13341 \$13083 \$13195 gf180mcu_fd_sc_mcu9t5v0__nor2_1
X$5012 \$15812 \$16840 \$16724 \$13030 \$16914 \$16728 \$16841
+ gf180mcu_fd_sc_mcu9t5v0__oai211_1
X$5013 \$13033 \$13487 \$13447 \$13486 \$13445 \$13623 \$13452 \$13833
+ gf180mcu_fd_sc_mcu9t5v0__aoi221_1
X$5014 \$13104 \$13056 \$13055 \$13035 \$13083 \$13103
+ gf180mcu_fd_sc_mcu9t5v0__oai21_1
X$5015 \$13068 \$13067 \$13035 \$13083 \$13066 gf180mcu_fd_sc_mcu9t5v0__nor2_1
X$5016 \$14237 \$13103 \$13035 \$13083 \$13053 gf180mcu_fd_sc_mcu9t5v0__nand2_1
X$5017 \$13080 \$13206 \$13081 \$13035 \$13083 \$13036
+ gf180mcu_fd_sc_mcu9t5v0__mux2_1
X$5018 \$13084 \$13207 \$13081 \$13035 \$13083 \$13082
+ gf180mcu_fd_sc_mcu9t5v0__mux2_1
X$5019 \$13083 \$13035 gf180mcu_fd_sc_mcu9t5v0__filltie
X$5020 \$13083 \$13035 gf180mcu_fd_sc_mcu9t5v0__filltie
X$5021 \$13083 \$13035 gf180mcu_fd_sc_mcu9t5v0__filltie
X$5022 \$13083 \$13035 gf180mcu_fd_sc_mcu9t5v0__filltie
X$5023 \$13083 \$13035 gf180mcu_fd_sc_mcu9t5v0__filltie
X$5024 \$13083 \$13035 gf180mcu_fd_sc_mcu9t5v0__filltie
X$5025 \$13083 \$13035 gf180mcu_fd_sc_mcu9t5v0__endcap
X$5026 \$13506 \$13503 \$13623 \$13452 \$13040 gf180mcu_fd_sc_mcu9t5v0__or2_1
X$5027 \$14231 \$14454 \$14337 \$13046 gf180mcu_fd_sc_mcu9t5v0__clkinv_1
X$5028 \$13046 \$13862 \$14151 \$14337 \$15163 gf180mcu_fd_sc_mcu9t5v0__nor2_1
X$5029 \$13738 \$13341 \$13083 \$13047 gf180mcu_fd_sc_mcu9t5v0__clkinv_1
X$5030 \$13354 \$13475 \$13051 \$13341 \$13452 \$13240
+ gf180mcu_fd_sc_mcu9t5v0__aoi21_1
X$5031 \$13246 \$13478 \$13051 \$13341 \$13452 \$13479
+ gf180mcu_fd_sc_mcu9t5v0__aoi21_1
X$5032 \$13051 \$14168 \$14169 \$14151 \$14034 \$14048
+ gf180mcu_fd_sc_mcu9t5v0__oai21_1
X$5033 \$13051 \$13524 \$13525 \$13623 \$13452 \$13470
+ gf180mcu_fd_sc_mcu9t5v0__oai21_1
X$5034 \$13241 \$13051 \$13248 \$13245 \$13341 \$13083 \$13247
+ gf180mcu_fd_sc_mcu9t5v0__oai31_1
X$5035 \$13874 \$14536 \$14748 \$14875 \$13051 gf180mcu_fd_sc_mcu9t5v0__nand2_1
X$5036 \$13051 \$14748 \$14875 \$14652 gf180mcu_fd_sc_mcu9t5v0__buf_8
X$5037 \$13051 \$14454 \$14337 \$14643 gf180mcu_fd_sc_mcu9t5v0__buf_8
X$5038 \$14172 \$14174 \$14151 \$14034 \$14173 \$13055
+ gf180mcu_fd_sc_mcu9t5v0__xor3_1
X$5039 \$13355 \$13354 \$13055 \$13341 \$13452 \$13530
+ gf180mcu_fd_sc_mcu9t5v0__and3_1
X$5040 \$13355 \$13354 \$13055 \$13341 \$13452 \$13473
+ gf180mcu_fd_sc_mcu9t5v0__aoi21_1
X$5041 \$13238 \$13239 \$13341 \$13083 \$13058 gf180mcu_fd_sc_mcu9t5v0__xnor2_1
X$5042 \$13242 \$13241 \$13058 \$13341 \$13083 \$13475
+ gf180mcu_fd_sc_mcu9t5v0__or3_1
X$5043 \$13242 \$13241 \$13058 \$13341 \$13083 \$13354
+ gf180mcu_fd_sc_mcu9t5v0__oai21_1
X$5044 \$13244 \$13243 \$13341 \$13083 \$13059 gf180mcu_fd_sc_mcu9t5v0__and2_1
X$5045 \$13250 \$13251 \$13341 \$13083 \$13060 gf180mcu_fd_sc_mcu9t5v0__or2_1
X$5046 \$15180 \$15179 \$15181 \$15045 \$15204 \$13061
+ gf180mcu_fd_sc_mcu9t5v0__oai21_1
X$5047 \$13740 \$13062 \$13881 \$13729 \$13904 gf180mcu_fd_sc_mcu9t5v0__xnor2_1
X$5048 \$13877 \$13623 \$13452 \$13062 gf180mcu_fd_sc_mcu9t5v0__buf_8
X$5049 \$16428 \$13070 \$16365 \$16427 \$16436 \$16376 \$16839
+ gf180mcu_fd_sc_mcu9t5v0__oai31_1
X$5050 \$15621 \$13070 \$18809 \$19312 \$18701 \$18870 \$18700
+ gf180mcu_fd_sc_mcu9t5v0__oai211_1
X$5051 \$17646 \$13070 \$19027 \$19149 \$19143 gf180mcu_fd_sc_mcu9t5v0__nand2_1
X$5052 \$17018 \$13070 \$16914 \$16728 \$16724 gf180mcu_fd_sc_mcu9t5v0__nand2_1
X$5053 \$18811 \$18701 \$18870 \$13070 gf180mcu_fd_sc_mcu9t5v0__buf_8
X$5054 \$13481 \$13071 \$13623 \$13452 \$13621 gf180mcu_fd_sc_mcu9t5v0__nand2_1
X$5055 \$13339 \$13074 \$13341 \$13083 \$13200 gf180mcu_fd_sc_mcu9t5v0__nand2_1
X$5056 \$13999 \$13881 \$14034 \$13075 gf180mcu_fd_sc_mcu9t5v0__buf_8
X$5057 \$13339 \$13076 \$13341 \$13083 \$13202 gf180mcu_fd_sc_mcu9t5v0__nand2_1
X$5058 \$13339 \$13077 \$13341 \$13083 \$13203 gf180mcu_fd_sc_mcu9t5v0__nand2_1
X$5059 \$16123 \$13078 \$15621 \$17085 \$17367 \$17233
+ gf180mcu_fd_sc_mcu9t5v0__oai21_1
X$5060 \$17025 \$13078 \$13486 \$16268 \$16914 \$17034 \$17083
+ gf180mcu_fd_sc_mcu9t5v0__oai211_1
X$5061 \$15141 \$13078 \$15192 \$15621 \$15321 \$15490 \$15352
+ gf180mcu_fd_sc_mcu9t5v0__oai211_1
X$5062 \$15487 \$13078 \$15350 \$15621 \$15321 \$15490 \$15351
+ gf180mcu_fd_sc_mcu9t5v0__oai211_1
X$5063 \$17945 \$13078 \$13486 \$14452 \$17818 \$17952 \$17697
+ gf180mcu_fd_sc_mcu9t5v0__oai211_1
X$5064 \$17700 \$13078 \$13486 \$15627 \$17538 \$17703 \$17537
+ gf180mcu_fd_sc_mcu9t5v0__oai211_1
X$5065 \$16433 \$13078 \$13486 \$15945 \$16269 \$16376 \$16373
+ gf180mcu_fd_sc_mcu9t5v0__oai211_1
X$5066 \$16369 \$13078 \$13486 \$14745 \$16269 \$16376 \$16370
+ gf180mcu_fd_sc_mcu9t5v0__oai211_1
X$5067 \$15739 \$13078 \$15795 \$15621 \$15949 \$15749 \$15942
+ gf180mcu_fd_sc_mcu9t5v0__oai211_1
X$5068 \$15197 \$13078 \$13486 \$15148 \$15321 \$15204 \$15314
+ gf180mcu_fd_sc_mcu9t5v0__oai211_1
X$5069 \$17943 \$13078 \$18137 \$18293 \$18245 gf180mcu_fd_sc_mcu9t5v0__nor2_1
X$5070 \$16577 \$13078 \$16914 \$17034 \$16910 gf180mcu_fd_sc_mcu9t5v0__nor2_1
X$5071 \$16909 \$13078 \$17085 \$17367 \$17360 gf180mcu_fd_sc_mcu9t5v0__nor2_1
X$5072 \$16724 \$16436 \$16376 \$13078 gf180mcu_fd_sc_mcu9t5v0__buf_8
X$5073 \$13339 \$13079 \$13341 \$13452 \$13450 gf180mcu_fd_sc_mcu9t5v0__nand2_1
X$5074 \$13080 \$13454 \$13493 \$13341 \$13083 \$13085
+ gf180mcu_fd_sc_mcu9t5v0__mux2_1
X$5075 \$15329 \$13081 \$16130 \$13634 \$16269 \$16376
+ gf180mcu_fd_sc_mcu9t5v0__dffrnq_2
X$5076 \$16131 \$18574 \$13081 \$18701 \$18576 \$18703
+ gf180mcu_fd_sc_mcu9t5v0__nor3_1
X$5077 \$13081 \$15748 \$17947 \$18137 \$18293 \$18253
+ gf180mcu_fd_sc_mcu9t5v0__nor3_1
X$5078 \$16131 \$13081 \$18993 \$18701 \$18576 \$18819
+ gf180mcu_fd_sc_mcu9t5v0__oai21_1
X$5079 \$13081 \$18530 \$18403 \$18576 \$18571 gf180mcu_fd_sc_mcu9t5v0__nand2_1
X$5080 \$17241 \$17818 \$17703 \$13081 gf180mcu_fd_sc_mcu9t5v0__buf_8
X$5081 \$14495 \$14491 \$13081 \$14454 \$14635 \$14494
+ gf180mcu_fd_sc_mcu9t5v0__mux2_1
X$5082 \$16853 \$17031 \$13081 \$16914 \$17034 \$17032
+ gf180mcu_fd_sc_mcu9t5v0__mux2_1
X$5083 \$14152 \$14193 \$13081 \$13881 \$14034 \$14033
+ gf180mcu_fd_sc_mcu9t5v0__mux2_1
X$5084 \$14035 \$14188 \$13081 \$13881 \$14034 \$14153
+ gf180mcu_fd_sc_mcu9t5v0__mux2_1
X$5085 \$15046 \$16437 \$13081 \$15949 \$16070 \$15807
+ gf180mcu_fd_sc_mcu9t5v0__mux2_1
X$5086 \$13456 \$13197 \$13081 \$13341 \$13452 \$13455
+ gf180mcu_fd_sc_mcu9t5v0__mux2_1
X$5087 \$15151 \$15150 \$13081 \$15045 \$15204 \$15205
+ gf180mcu_fd_sc_mcu9t5v0__mux2_1
X$5088 \$14502 \$14870 \$13081 \$14748 \$14875 \$14755
+ gf180mcu_fd_sc_mcu9t5v0__mux2_1
X$5089 \$14752 \$14449 \$13081 \$14748 \$14875 \$14751
+ gf180mcu_fd_sc_mcu9t5v0__mux2_1
X$5090 \$14002 \$14001 \$13081 \$13881 \$14034 \$14038
+ gf180mcu_fd_sc_mcu9t5v0__mux2_1
X$5091 \$15363 \$15195 \$13081 \$15321 \$15490 \$15325
+ gf180mcu_fd_sc_mcu9t5v0__mux2_1
X$5092 \$14155 \$14144 \$13081 \$14454 \$14337 \$14198
+ gf180mcu_fd_sc_mcu9t5v0__mux2_1
X$5093 \$15362 \$15950 \$13081 \$15628 \$15490 \$15361
+ gf180mcu_fd_sc_mcu9t5v0__mux2_1
X$5094 \$13624 \$13488 \$13081 \$13623 \$13452 \$13489
+ gf180mcu_fd_sc_mcu9t5v0__mux2_1
X$5095 \$14633 \$15149 \$13081 \$15045 \$14875 \$14874
+ gf180mcu_fd_sc_mcu9t5v0__mux2_1
X$5096 \$15360 \$15320 \$13081 \$15321 \$15204 \$15322
+ gf180mcu_fd_sc_mcu9t5v0__mux2_1
X$5097 \$13238 \$13239 \$13341 \$13083 \$13104 gf180mcu_fd_sc_mcu9t5v0__and2_1
X$5098 \$13240 \$13873 \$13341 \$13083 \$13356 gf180mcu_fd_sc_mcu9t5v0__nor2_1
X$5099 \$13251 \$13341 \$13083 \$13249 gf180mcu_fd_sc_mcu9t5v0__clkinv_1
X$5100 \$17955 \$13341 \$13083 \$13211 gf180mcu_fd_sc_mcu9t5v0__clkinv_1
X$5101 \$16853 \$13341 \$13083 \$13213 gf180mcu_fd_sc_mcu9t5v0__clkinv_1
X$5102 \$13250 \$13249 \$13341 \$13083 \$13105 gf180mcu_fd_sc_mcu9t5v0__nand2_1
X$5103 \$13083 \$13341 gf180mcu_fd_sc_mcu9t5v0__filltie
X$5104 \$13083 \$13341 gf180mcu_fd_sc_mcu9t5v0__filltie
X$5105 \$13083 \$13341 gf180mcu_fd_sc_mcu9t5v0__filltie
X$5106 \$13083 \$13341 gf180mcu_fd_sc_mcu9t5v0__filltie
X$5107 \$13083 \$13341 gf180mcu_fd_sc_mcu9t5v0__filltie
X$5108 \$13083 \$13341 gf180mcu_fd_sc_mcu9t5v0__filltie
X$5109 \$13490 \$13207 \$13342 \$13341 \$13083 \$13343
+ gf180mcu_fd_sc_mcu9t5v0__mux2_1
X$5110 \$13083 \$13341 gf180mcu_fd_sc_mcu9t5v0__endcap
X$5111 \$13084 \$13491 \$13493 \$13623 \$13452 \$13492
+ gf180mcu_fd_sc_mcu9t5v0__mux2_1
X$5112 \$14995 \$14994 \$15045 \$14875 \$13087 gf180mcu_fd_sc_mcu9t5v0__nand2_1
X$5113 \$13502 \$13459 \$13623 \$13452 \$13091 gf180mcu_fd_sc_mcu9t5v0__nor2_2
X$5114 \$15011 \$15006 \$13226 \$15045 \$14875 \$13095
+ gf180mcu_fd_sc_mcu9t5v0__mux2_1
X$5115 \$20600 \$19042 \$18885 \$13097 \$20515 \$20718 \$20599
+ gf180mcu_fd_sc_mcu9t5v0__aoi22_1
X$5116 \$13624 \$13626 \$13493 \$13623 \$13452 \$13098
+ gf180mcu_fd_sc_mcu9t5v0__mux2_1
X$5117 \$19171 \$19042 \$18885 \$13102 \$19027 \$19149 \$19172
+ gf180mcu_fd_sc_mcu9t5v0__aoi22_1
X$5118 \$18997 \$16380 \$18701 \$18870 \$13193 gf180mcu_fd_sc_mcu9t5v0__nand2_1
X$5119 \$13193 \$18581 \$18701 \$18576 \$18582 gf180mcu_fd_sc_mcu9t5v0__nand2_1
X$5120 \$13196 \$14481 \$14454 \$14635 \$14478 gf180mcu_fd_sc_mcu9t5v0__and2_1
X$5121 \$13997 \$13996 \$14334 \$13196 \$14151 \$14034 \$14185
+ gf180mcu_fd_sc_mcu9t5v0__oai211_1
X$5122 \$13196 \$15194 \$15321 \$15490 \$15353 gf180mcu_fd_sc_mcu9t5v0__nand2_1
X$5123 \$19321 \$19324 \$19466 \$13196 gf180mcu_fd_sc_mcu9t5v0__buf_8
X$5124 \$13196 \$15628 \$15749 \$14148 gf180mcu_fd_sc_mcu9t5v0__buf_8
X$5125 \$13196 \$15797 \$15142 \$15949 \$15749 \$16064
+ gf180mcu_fd_sc_mcu9t5v0__mux2_1
X$5126 \$18133 \$18137 \$18293 \$13197 gf180mcu_fd_sc_mcu9t5v0__clkbuf_1
X$5127 \$13197 \$20209 \$20383 \$15806 gf180mcu_fd_sc_mcu9t5v0__clkbuf_1
X$5128 \$13197 \$14001 \$19925 \$20209 \$20087 \$20203
+ gf180mcu_fd_sc_mcu9t5v0__oai21_1
X$5129 \$13197 \$21620 \$24112 \$23926 \$24109 \$24113
+ gf180mcu_fd_sc_mcu9t5v0__nand3_1
X$5130 \$13197 \$20083 \$23926 \$24109 \$24115 gf180mcu_fd_sc_mcu9t5v0__nand2_1
X$5131 \$13197 \$24231 \$24109 \$24241 gf180mcu_fd_sc_mcu9t5v0__clkinv_1
X$5132 \$13197 \$23754 \$22270 \$23183 \$23454 \$23447
+ gf180mcu_fd_sc_mcu9t5v0__mux2_1
X$5133 \$13199 \$13487 \$13203 \$13486 \$13445 \$13341 \$13452 \$13451
+ gf180mcu_fd_sc_mcu9t5v0__aoi221_1
X$5134 \$13201 \$13339 \$13341 \$13452 \$13449 gf180mcu_fd_sc_mcu9t5v0__nand2_1
X$5135 \$15751 \$13204 \$15628 \$15749 \$15750 gf180mcu_fd_sc_mcu9t5v0__nor2_1
X$5136 \$18291 \$13206 \$13342 \$13341 \$13452 \$13205
+ gf180mcu_fd_sc_mcu9t5v0__mux2_1
X$5137 \$22716 \$19154 \$21663 \$13210 \$23027 \$22837 \$22893
+ gf180mcu_fd_sc_mcu9t5v0__aoi22_1
X$5138 \$13459 \$13503 \$13623 \$13729 \$13214 gf180mcu_fd_sc_mcu9t5v0__nor2_2
X$5139 \$14521 \$25921 \$17038 \$13215 \$17818 \$17952 \$17825
+ gf180mcu_fd_sc_mcu9t5v0__aoi22_1
X$5140 \$14521 \$20885 \$17038 \$13215 \$18137 \$17952 \$18014
+ gf180mcu_fd_sc_mcu9t5v0__aoi22_1
X$5141 \$17709 \$17818 \$17703 \$13215 gf180mcu_fd_sc_mcu9t5v0__buf_8
X$5142 \$13218 \$15499 \$14999 \$14521 \$14638 \$15045 \$14875 \$14880
+ gf180mcu_fd_sc_mcu9t5v0__aoi221_1
X$5143 \$14344 \$14871 \$14218 \$14881 \$14454 \$14337 \$13221
+ gf180mcu_fd_sc_mcu9t5v0__aoi22_1
X$5144 \$13345 \$13350 \$13341 \$13452 \$13224 gf180mcu_fd_sc_mcu9t5v0__and2_1
X$5145 \$14521 \$13225 \$13852 \$16914 \$17034 \$17050
+ gf180mcu_fd_sc_mcu9t5v0__oai21_1
X$5146 \$15764 \$15765 \$13226 \$15949 \$15749 \$13225
+ gf180mcu_fd_sc_mcu9t5v0__mux2_1
X$5147 \$16739 \$13226 \$16914 \$16728 \$16738 gf180mcu_fd_sc_mcu9t5v0__nor2_1
X$5148 \$26528 \$26401 \$26521 \$13226 gf180mcu_fd_sc_mcu9t5v0__buf_8
X$5149 \$15167 \$15011 \$13226 \$15045 \$15204 \$14163
+ gf180mcu_fd_sc_mcu9t5v0__mux2_1
X$5150 \$14513 \$14512 \$13226 \$14454 \$14635 \$13497
+ gf180mcu_fd_sc_mcu9t5v0__mux2_1
X$5151 \$15757 \$15764 \$13226 \$15628 \$15749 \$15636
+ gf180mcu_fd_sc_mcu9t5v0__mux2_1
X$5152 \$15765 \$15167 \$13226 \$15628 \$15749 \$13633
+ gf180mcu_fd_sc_mcu9t5v0__mux2_1
X$5153 \$14514 \$14513 \$13226 \$14454 \$14635 \$13838
+ gf180mcu_fd_sc_mcu9t5v0__mux2_1
X$5154 \$15006 \$14882 \$13226 \$14748 \$14875 \$14042
+ gf180mcu_fd_sc_mcu9t5v0__mux2_1
X$5155 \$15000 \$18998 \$13226 \$19027 \$19149 \$14203
+ gf180mcu_fd_sc_mcu9t5v0__mux2_1
X$5156 \$13861 \$14640 \$13226 \$13881 \$14034 \$13859
+ gf180mcu_fd_sc_mcu9t5v0__mux2_1
X$5157 \$15821 \$16392 \$13226 \$16269 \$16376 \$14160
+ gf180mcu_fd_sc_mcu9t5v0__mux2_1
X$5158 \$19161 \$19038 \$13226 \$19027 \$19149 \$14990
+ gf180mcu_fd_sc_mcu9t5v0__mux2_1
X$5159 \$14761 \$15000 \$13226 \$15045 \$14875 \$14637
+ gf180mcu_fd_sc_mcu9t5v0__mux2_1
X$5160 \$18998 \$19161 \$13226 \$19027 \$18870 \$14507
+ gf180mcu_fd_sc_mcu9t5v0__mux2_1
X$5161 \$14512 \$14761 \$13226 \$14748 \$14635 \$14158
+ gf180mcu_fd_sc_mcu9t5v0__mux2_1
X$5162 \$15756 \$16148 \$13226 \$16269 \$16070 \$14228
+ gf180mcu_fd_sc_mcu9t5v0__mux2_1
X$5163 \$16392 \$17120 \$13226 \$17085 \$17034 \$14996
+ gf180mcu_fd_sc_mcu9t5v0__mux2_1
X$5164 \$14764 \$15007 \$13226 \$14748 \$14635 \$13738
+ gf180mcu_fd_sc_mcu9t5v0__mux2_1
X$5165 \$15005 \$15757 \$13226 \$15628 \$15490 \$13347
+ gf180mcu_fd_sc_mcu9t5v0__mux2_1
X$5166 \$15004 \$15821 \$13226 \$15949 \$15749 \$13500
+ gf180mcu_fd_sc_mcu9t5v0__mux2_1
X$5167 \$15007 \$15005 \$13226 \$15045 \$14875 \$14511
+ gf180mcu_fd_sc_mcu9t5v0__mux2_1
X$5168 \$14882 \$15004 \$13226 \$15045 \$14875 \$14340
+ gf180mcu_fd_sc_mcu9t5v0__mux2_1
X$5169 \$13349 \$13350 \$13341 \$13452 \$13227 gf180mcu_fd_sc_mcu9t5v0__and2_1
X$5170 \$13519 \$13350 \$13341 \$13452 \$13228 gf180mcu_fd_sc_mcu9t5v0__and2_1
X$5171 \$13351 \$13350 \$13341 \$13452 \$13229 gf180mcu_fd_sc_mcu9t5v0__and2_1
X$5172 \$13230 \$13901 \$14006 \$13471 \$13881 \$14034
+ gf180mcu_fd_sc_mcu9t5v0__dffrnq_2
X$5173 \$13230 \$14238 \$13897 \$13471 \$14151 \$14034
+ gf180mcu_fd_sc_mcu9t5v0__dffrnq_2
X$5174 \$13230 \$13869 \$13866 \$13471 \$13881 \$13729
+ gf180mcu_fd_sc_mcu9t5v0__dffrnq_2
X$5175 \$13230 \$15020 \$13351 \$13471 \$15045 \$14875
+ gf180mcu_fd_sc_mcu9t5v0__dffrnq_2
X$5176 \$13230 \$15019 \$13349 \$13471 \$15045 \$14875
+ gf180mcu_fd_sc_mcu9t5v0__dffrnq_2
X$5177 \$13230 \$13881 \$13729 \$I54515 gf180mcu_fd_sc_mcu9t5v0__clkinv_1
X$5178 \$13230 \$13352 \$13232 \$13341 \$13452 gf180mcu_fd_sc_mcu9t5v0__dffq_2
X$5179 \$13234 \$24262 \$24231 \$24428 \$24325 gf180mcu_fd_sc_mcu9t5v0__xnor2_1
X$5180 \$16851 \$13234 \$24231 \$24428 \$24323 gf180mcu_fd_sc_mcu9t5v0__nand2_1
X$5181 \$14049 \$14052 \$13881 \$14034 \$13872 \$13238
+ gf180mcu_fd_sc_mcu9t5v0__xnor3_1
X$5182 \$13238 \$15223 \$15520 \$14748 \$14875 \$14774
+ gf180mcu_fd_sc_mcu9t5v0__aoi21_1
X$5183 \$13531 \$14454 \$14635 \$13238 gf180mcu_fd_sc_mcu9t5v0__clkinv_1
X$5184 \$14049 \$13238 \$14151 \$14034 \$14175 gf180mcu_fd_sc_mcu9t5v0__nor2_1
X$5185 \$14049 \$13238 \$14151 \$14034 \$14176 gf180mcu_fd_sc_mcu9t5v0__nand2_1
X$5186 \$14049 \$14050 \$13881 \$14034 \$13239 \$14243
+ gf180mcu_fd_sc_mcu9t5v0__xnor3_1
X$5187 \$13531 \$13239 \$13623 \$13452 \$13355 gf180mcu_fd_sc_mcu9t5v0__nand2_1
X$5188 \$13476 \$13243 \$13341 \$13452 \$13242 gf180mcu_fd_sc_mcu9t5v0__and2_1
X$5189 \$14019 \$14177 \$14151 \$14034 \$13243 \$14017
+ gf180mcu_fd_sc_mcu9t5v0__xnor3_1
X$5190 \$13476 \$13623 \$13452 \$13244 gf180mcu_fd_sc_mcu9t5v0__clkinv_1
X$5191 \$14019 \$13244 \$13881 \$13729 \$13903 gf180mcu_fd_sc_mcu9t5v0__nor2_1
X$5192 \$14241 \$13247 \$13865 \$13471 \$13341 \$13452
+ gf180mcu_fd_sc_mcu9t5v0__dffrnq_2
X$5193 \$13250 \$14540 \$14454 \$14337 \$14476 gf180mcu_fd_sc_mcu9t5v0__xnor2_1
X$5194 \$15036 \$15346 \$13250 \$15037 \$15321 \$15490
+ gf180mcu_fd_sc_mcu9t5v0__dffrnq_2
X$5195 \$13250 \$14358 \$14246 \$14151 \$14337 \$14179
+ gf180mcu_fd_sc_mcu9t5v0__oai21_1
X$5196 \$15224 \$13250 \$15223 \$15321 \$15204 \$15346
+ gf180mcu_fd_sc_mcu9t5v0__mux2_1
X$5197 \$13250 \$14657 \$14536 \$14748 \$14635 \$14779
+ gf180mcu_fd_sc_mcu9t5v0__mux2_1
X$5198 \$14541 \$14454 \$14635 \$14542 \$13251 gf180mcu_fd_sc_mcu9t5v0__xor2_1
X$5199 \$14055 \$14023 \$13881 \$14034 \$13252 gf180mcu_fd_sc_mcu9t5v0__nor2_1
X$5200 \$13339 \$13834 \$13881 \$14034 \$14031 gf180mcu_fd_sc_mcu9t5v0__nand2_1
X$5201 \$13339 \$13340 \$13341 \$13452 \$13447 gf180mcu_fd_sc_mcu9t5v0__nand2_1
X$5202 \$13339 \$13622 \$13623 \$13729 \$13726 gf180mcu_fd_sc_mcu9t5v0__nand2_1
X$5203 \$13339 \$13832 \$13881 \$13729 \$14029 gf180mcu_fd_sc_mcu9t5v0__nand2_1
X$5204 \$13465 \$13350 \$13341 \$13452 \$13466 gf180mcu_fd_sc_mcu9t5v0__and2_1
X$5205 \$13498 \$13835 \$13341 \$13452 \$13458 gf180mcu_fd_sc_mcu9t5v0__or2_1
X$5206 \$13498 \$13492 \$13341 \$13452 \$13501 gf180mcu_fd_sc_mcu9t5v0__or2_1
X$5207 \$13512 \$13350 \$13341 \$13452 \$13464 gf180mcu_fd_sc_mcu9t5v0__nor2_1
X$5208 \$13459 \$13341 \$13452 \$13506 gf180mcu_fd_sc_mcu9t5v0__clkbuf_8
X$5209 \$18291 \$13454 \$13625 \$13341 \$13452 \$13453
+ gf180mcu_fd_sc_mcu9t5v0__mux2_1
X$5210 \$13452 \$13341 gf180mcu_fd_sc_mcu9t5v0__filltie
X$5211 \$13452 \$13341 gf180mcu_fd_sc_mcu9t5v0__filltie
X$5212 \$13452 \$13341 gf180mcu_fd_sc_mcu9t5v0__filltie
X$5213 \$13452 \$13341 gf180mcu_fd_sc_mcu9t5v0__filltie
X$5214 \$13452 \$13341 gf180mcu_fd_sc_mcu9t5v0__filltie
X$5215 \$13452 \$13341 gf180mcu_fd_sc_mcu9t5v0__filltie
X$5216 \$13452 \$13341 gf180mcu_fd_sc_mcu9t5v0__endcap
X$5217 \$15748 \$14493 \$15628 \$15749 \$13342 gf180mcu_fd_sc_mcu9t5v0__nor2_1
X$5218 \$14492 \$14493 \$13342 \$14491 \$14454 \$14635 \$14490
+ gf180mcu_fd_sc_mcu9t5v0__aoi22_1
X$5219 \$15201 \$14493 \$13342 \$15320 \$15321 \$15204 \$15200
+ gf180mcu_fd_sc_mcu9t5v0__aoi22_1
X$5220 \$15147 \$14493 \$13342 \$15149 \$15045 \$14875 \$14989
+ gf180mcu_fd_sc_mcu9t5v0__aoi22_1
X$5221 \$15806 \$13488 \$13342 \$13623 \$13729 \$13727
+ gf180mcu_fd_sc_mcu9t5v0__mux2_1
X$5222 \$14194 \$14193 \$13342 \$14151 \$14337 \$14192
+ gf180mcu_fd_sc_mcu9t5v0__mux2_1
X$5223 \$15203 \$15150 \$13342 \$15045 \$15204 \$15202
+ gf180mcu_fd_sc_mcu9t5v0__mux2_1
X$5224 \$14010 \$16153 \$13345 \$13471 \$16269 \$16070
+ gf180mcu_fd_sc_mcu9t5v0__dffrnq_2
X$5225 \$13345 \$13862 \$15819 \$15949 \$16070 \$16081
+ gf180mcu_fd_sc_mcu9t5v0__aoi21_1
X$5226 \$13345 \$14459 \$13862 \$16436 \$16376 \$16449
+ gf180mcu_fd_sc_mcu9t5v0__mux2_1
X$5227 \$16457 \$13347 \$14217 \$16436 \$16376 \$16455
+ gf180mcu_fd_sc_mcu9t5v0__mux2_1
X$5228 \$13349 \$13862 \$15819 \$17538 \$17703 \$17659
+ gf180mcu_fd_sc_mcu9t5v0__aoi21_1
X$5229 \$13349 \$13874 \$13902 \$15963 \$15321 \$15490 \$15337
+ gf180mcu_fd_sc_mcu9t5v0__oai22_1
X$5230 \$13349 \$14458 \$13862 \$18137 \$17952 \$18263
+ gf180mcu_fd_sc_mcu9t5v0__mux2_1
X$5231 \$26526 \$26527 \$26675 \$26856 \$13350 gf180mcu_fd_sc_mcu9t5v0__and2_1
X$5232 \$13893 \$13350 \$14151 \$14034 \$13864 gf180mcu_fd_sc_mcu9t5v0__and2_1
X$5233 \$16739 \$13350 \$16914 \$16728 \$16603 gf180mcu_fd_sc_mcu9t5v0__nor2_1
X$5234 \$14354 \$14231 \$13350 \$14151 \$14337 \$13514
+ gf180mcu_fd_sc_mcu9t5v0__mux2_1
X$5235 \$13861 \$13860 \$13350 \$13881 \$13729 \$13736
+ gf180mcu_fd_sc_mcu9t5v0__mux2_1
X$5236 \$13860 \$13897 \$13350 \$13881 \$13729 \$13855
+ gf180mcu_fd_sc_mcu9t5v0__mux2_1
X$5237 \$14764 \$14354 \$13350 \$14454 \$14337 \$13853
+ gf180mcu_fd_sc_mcu9t5v0__mux2_1
X$5238 \$13351 \$13862 \$15819 \$17818 \$17703 \$17837
+ gf180mcu_fd_sc_mcu9t5v0__aoi21_1
X$5239 \$13351 \$14044 \$13862 \$18403 \$18293 \$18300
+ gf180mcu_fd_sc_mcu9t5v0__mux2_1
X$5240 \$13442 \$14184 \$14151 \$14034 \$13996 gf180mcu_fd_sc_mcu9t5v0__and2_1
X$5241 \$13442 \$14184 \$14151 \$14337 \$13995 gf180mcu_fd_sc_mcu9t5v0__nor2_1
X$5242 \$13442 \$14479 \$14151 \$14034 \$14140 gf180mcu_fd_sc_mcu9t5v0__nand2_1
X$5243 \$13486 \$13445 \$25743 \$26088 \$25918 \$25965
+ gf180mcu_fd_sc_mcu9t5v0__nor3_1
X$5244 \$18528 \$13487 \$13445 \$18701 \$18870 \$18815
+ gf180mcu_fd_sc_mcu9t5v0__aoi21_1
X$5245 \$16066 \$13487 \$13445 \$16914 \$17034 \$17024
+ gf180mcu_fd_sc_mcu9t5v0__aoi21_1
X$5246 \$17235 \$13487 \$13445 \$17538 \$17703 \$17648
+ gf180mcu_fd_sc_mcu9t5v0__aoi21_1
X$5247 \$16843 \$13487 \$13445 \$17538 \$17703 \$17535
+ gf180mcu_fd_sc_mcu9t5v0__aoi21_1
X$5248 \$15358 \$13487 \$13445 \$15321 \$15490 \$15356
+ gf180mcu_fd_sc_mcu9t5v0__aoi21_1
X$5249 \$13725 \$13487 \$13445 \$16269 \$16070 \$16125
+ gf180mcu_fd_sc_mcu9t5v0__aoi21_1
X$5250 \$15742 \$13487 \$13445 \$16436 \$16376 \$16429
+ gf180mcu_fd_sc_mcu9t5v0__aoi21_1
X$5251 \$26399 \$13445 \$27015 \$27153 \$27309 gf180mcu_fd_sc_mcu9t5v0__nor2_1
X$5252 \$16370 \$16429 \$16583 \$13445 \$16436 \$16728 \$16580
+ gf180mcu_fd_sc_mcu9t5v0__aoi22_1
X$5253 \$16373 \$16125 \$16372 \$13445 \$16269 \$16376 \$17236
+ gf180mcu_fd_sc_mcu9t5v0__aoi22_1
X$5254 \$15314 \$15356 \$15743 \$13445 \$15628 \$15749 \$16126
+ gf180mcu_fd_sc_mcu9t5v0__aoi22_1
X$5255 \$17537 \$17535 \$17701 \$13445 \$17818 \$17703 \$17815
+ gf180mcu_fd_sc_mcu9t5v0__aoi22_1
X$5256 \$18529 \$18815 \$18868 \$13445 \$19027 \$18870 \$18992
+ gf180mcu_fd_sc_mcu9t5v0__aoi22_1
X$5257 \$25741 \$18526 \$25742 \$13445 \$25797 \$25632 \$25583
+ gf180mcu_fd_sc_mcu9t5v0__aoi22_1
X$5258 \$17083 \$17024 \$17082 \$13445 \$17085 \$17034 \$17534
+ gf180mcu_fd_sc_mcu9t5v0__aoi22_1
X$5259 \$17697 \$17648 \$17696 \$13445 \$17818 \$17703 \$17813
+ gf180mcu_fd_sc_mcu9t5v0__aoi22_1
X$5260 \$26849 \$27015 \$26856 \$13445 gf180mcu_fd_sc_mcu9t5v0__buf_8
X$5261 \$15946 \$13446 \$15949 \$15749 \$15947 gf180mcu_fd_sc_mcu9t5v0__nor2_1
X$5262 \$17539 \$13448 \$17818 \$17703 \$17821 gf180mcu_fd_sc_mcu9t5v0__nor2_1
X$5263 \$16446 \$13451 \$16436 \$16728 \$16848 gf180mcu_fd_sc_mcu9t5v0__nor2_1
X$5264 \$13623 \$13452 \$13533 gf180mcu_fd_sc_mcu9t5v0__tieh
X$5265 \$13623 \$13452 \$13618 gf180mcu_fd_sc_mcu9t5v0__tiel
X$5266 \$15024 \$13473 \$13530 \$13623 \$13452 \$13529
+ gf180mcu_fd_sc_mcu9t5v0__or3_1
X$5267 \$15629 \$13509 \$14216 \$13634 \$13623 \$13452
+ gf180mcu_fd_sc_mcu9t5v0__dffrnq_2
X$5268 \$13527 \$13526 \$13623 \$13452 \$13472 gf180mcu_fd_sc_mcu9t5v0__nand2_1
X$5269 \$13452 \$13623 gf180mcu_fd_sc_mcu9t5v0__filltie
X$5270 \$13452 \$13623 gf180mcu_fd_sc_mcu9t5v0__filltie
X$5271 \$13452 \$13623 gf180mcu_fd_sc_mcu9t5v0__filltie
X$5272 \$13452 \$13623 gf180mcu_fd_sc_mcu9t5v0__filltie
X$5273 \$13452 \$13623 gf180mcu_fd_sc_mcu9t5v0__filltie
X$5274 \$13452 \$13623 gf180mcu_fd_sc_mcu9t5v0__filltie
X$5275 \$13452 \$13623 gf180mcu_fd_sc_mcu9t5v0__endcap
X$5276 \$13459 \$13881 \$14034 \$14456 gf180mcu_fd_sc_mcu9t5v0__buf_8
X$5277 \$14010 \$16870 \$13460 \$13471 \$16914 \$16728
+ gf180mcu_fd_sc_mcu9t5v0__dffrnq_2
X$5278 \$13460 \$13862 \$15819 \$16436 \$16728 \$16735
+ gf180mcu_fd_sc_mcu9t5v0__aoi21_1
X$5279 \$13460 \$13874 \$13902 \$16604 \$16436 \$16728 \$16605
+ gf180mcu_fd_sc_mcu9t5v0__oai22_1
X$5280 \$13460 \$14212 \$13862 \$13881 \$14034 \$13843
+ gf180mcu_fd_sc_mcu9t5v0__mux2_1
X$5281 \$18596 \$19041 \$13461 \$13634 \$19027 \$19149
+ gf180mcu_fd_sc_mcu9t5v0__dffrnq_2
X$5282 \$13461 \$13862 \$15819 \$17538 \$17367 \$17827
+ gf180mcu_fd_sc_mcu9t5v0__aoi21_1
X$5283 \$13461 \$19477 \$13874 \$19027 \$18870 \$19041
+ gf180mcu_fd_sc_mcu9t5v0__mux2_1
X$5284 \$13461 \$16458 \$13862 \$16914 \$16728 \$16737
+ gf180mcu_fd_sc_mcu9t5v0__mux2_1
X$5285 \$15016 \$19043 \$13462 \$13634 \$18403 \$18293
+ gf180mcu_fd_sc_mcu9t5v0__dffrnq_2
X$5286 \$13462 \$13862 \$15819 \$15628 \$15749 \$15758
+ gf180mcu_fd_sc_mcu9t5v0__aoi21_1
X$5287 \$13462 \$18137 \$18293 \$16739 gf180mcu_fd_sc_mcu9t5v0__clkinv_1
X$5288 \$13462 \$14220 \$13862 \$18137 \$17952 \$17963
+ gf180mcu_fd_sc_mcu9t5v0__mux2_1
X$5289 \$14650 \$15389 \$13465 \$13471 \$15321 \$15490
+ gf180mcu_fd_sc_mcu9t5v0__dffrnq_2
X$5290 \$13465 \$13862 \$15819 \$15628 \$15749 \$16467
+ gf180mcu_fd_sc_mcu9t5v0__aoi21_1
X$5291 \$13465 \$13874 \$13902 \$15642 \$15628 \$15490 \$15388
+ gf180mcu_fd_sc_mcu9t5v0__oai22_1
X$5292 \$13465 \$14007 \$13862 \$15045 \$15204 \$15218
+ gf180mcu_fd_sc_mcu9t5v0__mux2_1
X$5293 \$31089 \$32025 \$13471 \$32034 \$31264 \$31967
+ gf180mcu_fd_sc_mcu9t5v0__dffrnq_4
X$5294 \$18545 \$20601 \$20602 \$13471 \$20515 \$20718
+ gf180mcu_fd_sc_mcu9t5v0__dffrnq_2
X$5295 \$30838 \$30623 \$30354 \$13471 \$30564 \$30625
+ gf180mcu_fd_sc_mcu9t5v0__dffrnq_2
X$5296 \$23781 \$25359 \$25614 \$13471 \$25462 \$25632
+ gf180mcu_fd_sc_mcu9t5v0__dffrnq_2
X$5297 \$22152 \$24611 \$24329 \$13471 \$24593 \$24721
+ gf180mcu_fd_sc_mcu9t5v0__dffrnq_2
X$5298 \$30858 \$30760 \$29934 \$13471 \$30696 \$30763
+ gf180mcu_fd_sc_mcu9t5v0__dffrnq_2
X$5299 \$18596 \$22091 \$21824 \$13471 \$22074 \$22272
+ gf180mcu_fd_sc_mcu9t5v0__dffrnq_2
X$5300 \$28566 \$30761 \$30710 \$13471 \$30696 \$30763
+ gf180mcu_fd_sc_mcu9t5v0__dffrnq_2
X$5301 \$30838 \$31023 \$31025 \$13471 \$30971 \$31032
+ gf180mcu_fd_sc_mcu9t5v0__dffrnq_2
X$5302 \$31089 \$32417 \$32163 \$13471 \$32339 \$32467
+ gf180mcu_fd_sc_mcu9t5v0__dffrnq_2
X$5303 \$30838 \$30270 \$30265 \$13471 \$30251 \$30339
+ gf180mcu_fd_sc_mcu9t5v0__dffrnq_2
X$5304 \$30838 \$31020 \$29248 \$13471 \$30696 \$30763
+ gf180mcu_fd_sc_mcu9t5v0__dffrnq_2
X$5305 \$22152 \$24123 \$24326 \$13471 \$24231 \$24428
+ gf180mcu_fd_sc_mcu9t5v0__dffrnq_2
X$5306 \$24612 \$25327 \$25202 \$13471 \$25191 \$25347
+ gf180mcu_fd_sc_mcu9t5v0__dffrnq_2
X$5307 \$28566 \$30331 \$28712 \$13471 \$30251 \$30339
+ gf180mcu_fd_sc_mcu9t5v0__dffrnq_2
X$5308 \$18838 \$18882 \$17715 \$13471 \$18701 \$18870
+ gf180mcu_fd_sc_mcu9t5v0__dffrnq_2
X$5309 \$18545 \$18424 \$16401 \$13471 \$18403 \$18576
+ gf180mcu_fd_sc_mcu9t5v0__dffrnq_2
X$5310 \$18838 \$19616 \$19481 \$13471 \$19605 \$19774
+ gf180mcu_fd_sc_mcu9t5v0__dffrnq_2
X$5311 \$18838 \$19617 \$19756 \$13471 \$19605 \$19774
+ gf180mcu_fd_sc_mcu9t5v0__dffrnq_2
X$5312 \$31827 \$32348 \$32421 \$13471 \$32339 \$32467
+ gf180mcu_fd_sc_mcu9t5v0__dffrnq_2
X$5313 \$31827 \$31409 \$32179 \$13471 \$32100 \$32171
+ gf180mcu_fd_sc_mcu9t5v0__dffrnq_2
X$5314 \$18838 \$19004 \$18844 \$13471 \$19027 \$19149
+ gf180mcu_fd_sc_mcu9t5v0__dffrnq_2
X$5315 \$14650 \$16613 \$14219 \$13471 \$16436 \$16728
+ gf180mcu_fd_sc_mcu9t5v0__dffrnq_2
X$5316 \$14650 \$14470 \$14231 \$13471 \$14454 \$14635
+ gf180mcu_fd_sc_mcu9t5v0__dffrnq_2
X$5317 \$14650 \$15176 \$15005 \$13471 \$15045 \$15204
+ gf180mcu_fd_sc_mcu9t5v0__dffrnq_2
X$5318 \$30858 \$30620 \$30557 \$13471 \$30564 \$30625
+ gf180mcu_fd_sc_mcu9t5v0__dffrnq_2
X$5319 \$14650 \$16097 \$15764 \$13471 \$15949 \$16070
+ gf180mcu_fd_sc_mcu9t5v0__dffrnq_2
X$5320 \$14241 \$14242 \$14354 \$13471 \$14151 \$14337
+ gf180mcu_fd_sc_mcu9t5v0__dffrnq_2
X$5321 \$24612 \$25616 \$21171 \$13471 \$25462 \$25632
+ gf180mcu_fd_sc_mcu9t5v0__dffrnq_2
X$5322 \$30858 \$31021 \$31038 \$13471 \$30971 \$31032
+ gf180mcu_fd_sc_mcu9t5v0__dffrnq_2
X$5323 \$28566 \$30069 \$30071 \$13471 \$30054 \$30185
+ gf180mcu_fd_sc_mcu9t5v0__dffrnq_2
X$5324 \$14650 \$16275 \$15765 \$13471 \$16269 \$16376
+ gf180mcu_fd_sc_mcu9t5v0__dffrnq_2
X$5325 \$31827 \$32998 \$32999 \$13471 \$32992 \$33062
+ gf180mcu_fd_sc_mcu9t5v0__dffrnq_2
X$5326 \$18545 \$18546 \$14009 \$13471 \$18403 \$18576
+ gf180mcu_fd_sc_mcu9t5v0__dffrnq_2
X$5327 \$14010 \$17057 \$13861 \$13471 \$16914 \$17034
+ gf180mcu_fd_sc_mcu9t5v0__dffrnq_2
X$5328 \$18545 \$19939 \$19905 \$13471 \$19927 \$20087
+ gf180mcu_fd_sc_mcu9t5v0__dffrnq_2
X$5329 \$31827 \$31529 \$32102 \$13471 \$32100 \$32171
+ gf180mcu_fd_sc_mcu9t5v0__dffrnq_2
X$5330 \$14010 \$17978 \$13860 \$13471 \$17818 \$17952
+ gf180mcu_fd_sc_mcu9t5v0__dffrnq_2
X$5331 \$18545 \$19348 \$19297 \$13471 \$19324 \$19466
+ gf180mcu_fd_sc_mcu9t5v0__dffrnq_2
X$5332 \$18545 \$19006 \$18886 \$13471 \$19027 \$19149
+ gf180mcu_fd_sc_mcu9t5v0__dffrnq_2
X$5333 \$31827 \$32997 \$32985 \$13471 \$32992 \$33062
+ gf180mcu_fd_sc_mcu9t5v0__dffrnq_2
X$5334 \$31827 \$32637 \$32638 \$13471 \$32721 \$32765
+ gf180mcu_fd_sc_mcu9t5v0__dffrnq_2
X$5335 \$31089 \$32159 \$31617 \$13471 \$32248 \$32307
+ gf180mcu_fd_sc_mcu9t5v0__dffrnq_2
X$5336 \$30838 \$31413 \$31595 \$13471 \$31535 \$31584
+ gf180mcu_fd_sc_mcu9t5v0__dffrnq_2
X$5337 \$28566 \$29970 \$30037 \$13471 \$29954 \$30027
+ gf180mcu_fd_sc_mcu9t5v0__dffrnq_2
X$5338 \$18545 \$21512 \$21390 \$13471 \$21498 \$21622
+ gf180mcu_fd_sc_mcu9t5v0__dffrnq_2
X$5339 \$28062 \$26113 \$25983 \$13471 \$26088 \$26220
+ gf180mcu_fd_sc_mcu9t5v0__dffrnq_2
X$5340 \$18545 \$20229 \$20230 \$13471 \$20209 \$20383
+ gf180mcu_fd_sc_mcu9t5v0__dffrnq_2
X$5341 \$28566 \$28834 \$27807 \$13471 \$28810 \$28971
+ gf180mcu_fd_sc_mcu9t5v0__dffrnq_2
X$5342 \$28062 \$28228 \$28509 \$13471 \$28211 \$28381
+ gf180mcu_fd_sc_mcu9t5v0__dffrnq_2
X$5343 \$28566 \$29318 \$29319 \$13471 \$29290 \$29424
+ gf180mcu_fd_sc_mcu9t5v0__dffrnq_2
X$5344 \$27935 \$28058 \$28101 \$13471 \$27913 \$28089
+ gf180mcu_fd_sc_mcu9t5v0__dffrnq_2
X$5345 \$24320 \$27591 \$27461 \$13471 \$27315 \$27449
+ gf180mcu_fd_sc_mcu9t5v0__dffrnq_2
X$5346 \$24320 \$26106 \$25981 \$13471 \$26088 \$26220
+ gf180mcu_fd_sc_mcu9t5v0__dffrnq_2
X$5347 \$27935 \$28220 \$26231 \$13471 \$28211 \$28381
+ gf180mcu_fd_sc_mcu9t5v0__dffrnq_2
X$5348 \$24320 \$25470 \$25471 \$13471 \$25462 \$25632
+ gf180mcu_fd_sc_mcu9t5v0__dffrnq_2
X$5349 \$24320 \$26816 \$26817 \$13471 \$26675 \$26856
+ gf180mcu_fd_sc_mcu9t5v0__dffrnq_2
X$5350 \$27935 \$28223 \$28059 \$13471 \$28211 \$28381
+ gf180mcu_fd_sc_mcu9t5v0__dffrnq_2
X$5351 \$24742 \$26101 \$26102 \$13471 \$26088 \$26220
+ gf180mcu_fd_sc_mcu9t5v0__dffrnq_2
X$5352 \$30858 \$31543 \$31594 \$13471 \$31535 \$31584
+ gf180mcu_fd_sc_mcu9t5v0__dffrnq_2
X$5353 \$24742 \$25005 \$24856 \$13471 \$24877 \$24997
+ gf180mcu_fd_sc_mcu9t5v0__dffrnq_2
X$5354 \$24742 \$24608 \$24548 \$13471 \$24593 \$24721
+ gf180mcu_fd_sc_mcu9t5v0__dffrnq_2
X$5355 \$28566 \$28567 \$28568 \$13471 \$28534 \$28689
+ gf180mcu_fd_sc_mcu9t5v0__dffrnq_2
X$5356 \$30858 \$31620 \$31621 \$13471 \$31607 \$31733
+ gf180mcu_fd_sc_mcu9t5v0__dffrnq_2
X$5357 \$28062 \$29102 \$29312 \$13471 \$29123 \$29270
+ gf180mcu_fd_sc_mcu9t5v0__dffrnq_2
X$5358 \$24320 \$25474 \$25007 \$13471 \$25462 \$25632
+ gf180mcu_fd_sc_mcu9t5v0__dffrnq_2
X$5359 \$24742 \$26988 \$26990 \$13471 \$27015 \$27153
+ gf180mcu_fd_sc_mcu9t5v0__dffrnq_2
X$5360 \$30858 \$30854 \$25939 \$13471 \$30971 \$31032
+ gf180mcu_fd_sc_mcu9t5v0__dffrnq_2
X$5361 \$20845 \$23937 \$24260 \$13471 \$23926 \$24109
+ gf180mcu_fd_sc_mcu9t5v0__dffrnq_2
X$5362 \$30858 \$31169 \$31109 \$13471 \$31100 \$31175
+ gf180mcu_fd_sc_mcu9t5v0__dffrnq_2
X$5363 \$20845 \$22594 \$22457 \$13471 \$22387 \$22440
+ gf180mcu_fd_sc_mcu9t5v0__dffrnq_2
X$5364 \$23781 \$24610 \$24744 \$13471 \$24593 \$24721
+ gf180mcu_fd_sc_mcu9t5v0__dffrnq_2
X$5365 \$23781 \$24261 \$24322 \$13471 \$24231 \$24428
+ gf180mcu_fd_sc_mcu9t5v0__dffrnq_2
X$5366 \$22152 \$23342 \$23203 \$13471 \$23183 \$23454
+ gf180mcu_fd_sc_mcu9t5v0__dffrnq_2
X$5367 \$24320 \$26107 \$26233 \$13471 \$26088 \$26220
+ gf180mcu_fd_sc_mcu9t5v0__dffrnq_2
X$5368 \$28062 \$28716 \$28115 \$13471 \$28534 \$28689
+ gf180mcu_fd_sc_mcu9t5v0__dffrnq_2
X$5369 \$23781 \$26111 \$26112 \$13471 \$26088 \$26220
+ gf180mcu_fd_sc_mcu9t5v0__dffrnq_2
X$5370 \$22152 \$24891 \$16876 \$13471 \$24877 \$24997
+ gf180mcu_fd_sc_mcu9t5v0__dffrnq_2
X$5371 \$22152 \$24557 \$24746 \$13471 \$24593 \$24721
+ gf180mcu_fd_sc_mcu9t5v0__dffrnq_2
X$5372 \$18596 \$22401 \$22402 \$13471 \$22387 \$22440
+ gf180mcu_fd_sc_mcu9t5v0__dffrnq_2
X$5373 \$27935 \$28356 \$28383 \$13471 \$28211 \$28381
+ gf180mcu_fd_sc_mcu9t5v0__dffrnq_2
X$5374 \$18596 \$22459 \$21162 \$13471 \$22387 \$22440
+ gf180mcu_fd_sc_mcu9t5v0__dffrnq_2
X$5375 \$27935 \$28225 \$28507 \$13471 \$28211 \$28381
+ gf180mcu_fd_sc_mcu9t5v0__dffrnq_2
X$5376 \$27935 \$28831 \$29100 \$13471 \$28810 \$28971
+ gf180mcu_fd_sc_mcu9t5v0__dffrnq_2
X$5377 \$22152 \$23942 \$22460 \$13471 \$23926 \$24109
+ gf180mcu_fd_sc_mcu9t5v0__dffrnq_2
X$5378 \$28566 \$29973 \$30038 \$13471 \$29954 \$30027
+ gf180mcu_fd_sc_mcu9t5v0__dffrnq_2
X$5379 \$20845 \$22089 \$22090 \$13471 \$22074 \$22272
+ gf180mcu_fd_sc_mcu9t5v0__dffrnq_2
X$5380 \$24320 \$23938 \$23939 \$13471 \$23926 \$24109
+ gf180mcu_fd_sc_mcu9t5v0__dffrnq_2
X$5381 \$23781 \$26825 \$26994 \$13471 \$26675 \$26856
+ gf180mcu_fd_sc_mcu9t5v0__dffrnq_2
X$5382 \$24320 \$24321 \$22283 \$13471 \$24231 \$24428
+ gf180mcu_fd_sc_mcu9t5v0__dffrnq_2
X$5383 \$23781 \$23642 \$23940 \$13471 \$23620 \$23807
+ gf180mcu_fd_sc_mcu9t5v0__dffrnq_2
X$5384 \$20845 \$22861 \$22862 \$13471 \$22713 \$22837
+ gf180mcu_fd_sc_mcu9t5v0__dffrnq_2
X$5385 \$28062 \$27661 \$29309 \$13471 \$27637 \$27776
+ gf180mcu_fd_sc_mcu9t5v0__dffrnq_2
X$5386 \$31827 \$31828 \$31751 \$13471 \$31810 \$31886
+ gf180mcu_fd_sc_mcu9t5v0__dffrnq_2
X$5387 \$28350 \$29968 \$29930 \$13471 \$29954 \$30027
+ gf180mcu_fd_sc_mcu9t5v0__dffrnq_2
X$5388 \$18545 \$18425 \$17979 \$13471 \$18403 \$18576
+ gf180mcu_fd_sc_mcu9t5v0__dffrnq_2
X$5389 \$28350 \$29640 \$29708 \$13471 \$29634 \$29720
+ gf180mcu_fd_sc_mcu9t5v0__dffrnq_2
X$5390 \$18545 \$19347 \$17517 \$13471 \$19324 \$19466
+ gf180mcu_fd_sc_mcu9t5v0__dffrnq_2
X$5391 \$30858 \$30835 \$30859 \$13471 \$30819 \$30900
+ gf180mcu_fd_sc_mcu9t5v0__dffrnq_2
X$5392 \$31089 \$31687 \$31618 \$13471 \$31607 \$31733
+ gf180mcu_fd_sc_mcu9t5v0__dffrnq_2
X$5393 \$18838 \$21641 \$21388 \$13471 \$21498 \$21622
+ gf180mcu_fd_sc_mcu9t5v0__dffrnq_2
X$5394 \$18838 \$20895 \$20853 \$13471 \$20881 \$21011
+ gf180mcu_fd_sc_mcu9t5v0__dffrnq_2
X$5395 \$18838 \$20228 \$20063 \$13471 \$20209 \$20383
+ gf180mcu_fd_sc_mcu9t5v0__dffrnq_2
X$5396 \$18545 \$19936 \$19937 \$13471 \$19927 \$20087
+ gf180mcu_fd_sc_mcu9t5v0__dffrnq_2
X$5397 \$22152 \$21685 \$21686 \$13471 \$21661 \$21946
+ gf180mcu_fd_sc_mcu9t5v0__dffrnq_2
X$5398 \$22152 \$23647 \$23648 \$13471 \$23620 \$23807
+ gf180mcu_fd_sc_mcu9t5v0__dffrnq_2
X$5399 \$30858 \$31265 \$31240 \$13471 \$31232 \$31310
+ gf180mcu_fd_sc_mcu9t5v0__dffrnq_2
X$5400 \$18545 \$21165 \$21166 \$13471 \$21184 \$21308
+ gf180mcu_fd_sc_mcu9t5v0__dffrnq_2
X$5401 \$30858 \$31389 \$31408 \$13471 \$31376 \$31465
+ gf180mcu_fd_sc_mcu9t5v0__dffrnq_2
X$5402 \$30858 \$30243 \$30322 \$13471 \$30251 \$30339
+ gf180mcu_fd_sc_mcu9t5v0__dffrnq_2
X$5403 \$22152 \$22092 \$22093 \$13471 \$22074 \$22272
+ gf180mcu_fd_sc_mcu9t5v0__dffrnq_2
X$5404 \$18838 \$18708 \$18839 \$13471 \$18701 \$18870
+ gf180mcu_fd_sc_mcu9t5v0__dffrnq_2
X$5405 \$18838 \$19346 \$16399 \$13471 \$19324 \$19466
+ gf180mcu_fd_sc_mcu9t5v0__dffrnq_2
X$5406 \$24742 \$26815 \$26532 \$13471 \$26675 \$26856
+ gf180mcu_fd_sc_mcu9t5v0__dffrnq_2
X$5407 \$30838 \$30839 \$30634 \$13471 \$30819 \$30900
+ gf180mcu_fd_sc_mcu9t5v0__dffrnq_2
X$5408 \$27935 \$29793 \$29931 \$13471 \$29780 \$29847
+ gf180mcu_fd_sc_mcu9t5v0__dffrnq_2
X$5409 \$27935 \$28828 \$28829 \$13471 \$28810 \$28971
+ gf180mcu_fd_sc_mcu9t5v0__dffrnq_2
X$5410 \$27935 \$28826 \$28706 \$13471 \$28810 \$28971
+ gf180mcu_fd_sc_mcu9t5v0__dffrnq_2
X$5411 \$27935 \$29133 \$28978 \$13471 \$29123 \$29270
+ gf180mcu_fd_sc_mcu9t5v0__dffrnq_2
X$5412 \$27935 \$29642 \$29643 \$13471 \$29634 \$29720
+ gf180mcu_fd_sc_mcu9t5v0__dffrnq_2
X$5413 \$27935 \$28943 \$28707 \$13471 \$28810 \$28971
+ gf180mcu_fd_sc_mcu9t5v0__dffrnq_2
X$5414 \$30858 \$31107 \$31168 \$13471 \$31100 \$31175
+ gf180mcu_fd_sc_mcu9t5v0__dffrnq_2
X$5415 \$20845 \$22458 \$21386 \$13471 \$22713 \$22440
+ gf180mcu_fd_sc_mcu9t5v0__dffrnq_2
X$5416 \$18545 \$22154 \$15766 \$13471 \$22387 \$22272
+ gf180mcu_fd_sc_mcu9t5v0__dffrnq_2
X$5417 \$24320 \$24549 \$24434 \$13471 \$24593 \$24428
+ gf180mcu_fd_sc_mcu9t5v0__dffrnq_2
X$5418 \$22152 \$22153 \$22096 \$13471 \$22387 \$22272
+ gf180mcu_fd_sc_mcu9t5v0__dffrnq_2
X$5419 \$22152 \$22403 \$16874 \$13471 \$22387 \$22272
+ gf180mcu_fd_sc_mcu9t5v0__dffrnq_2
X$5420 \$24320 \$25641 \$25321 \$13471 \$25797 \$25632
+ gf180mcu_fd_sc_mcu9t5v0__dffrnq_2
X$5421 \$18596 \$22151 \$18033 \$13471 \$22387 \$22272
+ gf180mcu_fd_sc_mcu9t5v0__dffrnq_2
X$5422 \$18596 \$21637 \$21028 \$13471 \$21661 \$21622
+ gf180mcu_fd_sc_mcu9t5v0__dffrnq_2
X$5423 \$30838 \$30769 \$30691 \$13471 \$30819 \$30763
+ gf180mcu_fd_sc_mcu9t5v0__dffrnq_2
X$5424 \$30838 \$30770 \$30712 \$13471 \$30819 \$30763
+ gf180mcu_fd_sc_mcu9t5v0__dffrnq_2
X$5425 \$18545 \$20733 \$19938 \$13471 \$20881 \$20718
+ gf180mcu_fd_sc_mcu9t5v0__dffrnq_2
X$5426 \$18545 \$21329 \$21169 \$13471 \$21498 \$21308
+ gf180mcu_fd_sc_mcu9t5v0__dffrnq_2
X$5427 \$27935 \$29437 \$29438 \$13471 \$29634 \$29424
+ gf180mcu_fd_sc_mcu9t5v0__dffrnq_2
X$5428 \$30838 \$30713 \$29867 \$13471 \$30819 \$30763
+ gf180mcu_fd_sc_mcu9t5v0__dffrnq_2
X$5429 \$23781 \$27170 \$26827 \$13471 \$27015 \$26856
+ gf180mcu_fd_sc_mcu9t5v0__dffrnq_2
X$5430 \$23781 \$27466 \$27340 \$13471 \$27637 \$27449
+ gf180mcu_fd_sc_mcu9t5v0__dffrnq_2
X$5431 \$14241 \$16476 \$14011 \$13471 \$16436 \$16376
+ gf180mcu_fd_sc_mcu9t5v0__dffrnq_2
X$5432 \$28062 \$28106 \$28107 \$13471 \$28211 \$28089
+ gf180mcu_fd_sc_mcu9t5v0__dffrnq_2
X$5433 \$30838 \$30693 \$28838 \$13471 \$30696 \$30625
+ gf180mcu_fd_sc_mcu9t5v0__dffrnq_2
X$5434 \$28566 \$30496 \$30494 \$13471 \$30564 \$30485
+ gf180mcu_fd_sc_mcu9t5v0__dffrnq_2
X$5435 \$31827 \$32986 \$31391 \$13471 \$32992 \$32934
+ gf180mcu_fd_sc_mcu9t5v0__dffrnq_2
X$5436 \$30858 \$31110 \$31111 \$13471 \$31100 \$31032
+ gf180mcu_fd_sc_mcu9t5v0__dffrnq_2
X$5437 \$27935 \$29275 \$29303 \$13471 \$29290 \$29270
+ gf180mcu_fd_sc_mcu9t5v0__dffrnq_2
X$5438 \$30838 \$31315 \$31415 \$13471 \$31376 \$31310
+ gf180mcu_fd_sc_mcu9t5v0__dffrnq_2
X$5439 \$28566 \$29971 \$29709 \$13471 \$29954 \$29847
+ gf180mcu_fd_sc_mcu9t5v0__dffrnq_2
X$5440 \$31089 \$31953 \$32090 \$13471 \$31967 \$31886
+ gf180mcu_fd_sc_mcu9t5v0__dffrnq_2
X$5441 \$23781 \$24860 \$23205 \$13471 \$24877 \$24721
+ gf180mcu_fd_sc_mcu9t5v0__dffrnq_2
X$5442 \$22152 \$22863 \$22865 \$13471 \$23027 \$22837
+ gf180mcu_fd_sc_mcu9t5v0__dffrnq_2
X$5443 \$28062 \$27804 \$27936 \$13471 \$27913 \$27776
+ gf180mcu_fd_sc_mcu9t5v0__dffrnq_2
X$5444 \$31089 \$32556 \$32530 \$13471 \$32721 \$32629
+ gf180mcu_fd_sc_mcu9t5v0__dffrnq_2
X$5445 \$24320 \$27165 \$27166 \$13471 \$27315 \$27153
+ gf180mcu_fd_sc_mcu9t5v0__dffrnq_2
X$5446 \$31089 \$32256 \$32178 \$13471 \$32248 \$32171
+ gf180mcu_fd_sc_mcu9t5v0__dffrnq_2
X$5447 \$23781 \$27168 \$26691 \$13471 \$27315 \$27153
+ gf180mcu_fd_sc_mcu9t5v0__dffrnq_2
X$5448 \$28566 \$29443 \$28946 \$13471 \$29634 \$29424
+ gf180mcu_fd_sc_mcu9t5v0__dffrnq_2
X$5449 \$28062 \$28835 \$28833 \$13471 \$28810 \$28689
+ gf180mcu_fd_sc_mcu9t5v0__dffrnq_2
X$5450 \$31089 \$32160 \$32101 \$13471 \$32248 \$32171
+ gf180mcu_fd_sc_mcu9t5v0__dffrnq_2
X$5451 \$31827 \$32773 \$32774 \$13471 \$32853 \$32765
+ gf180mcu_fd_sc_mcu9t5v0__dffrnq_2
X$5452 \$30858 \$31815 \$31747 \$13471 \$31810 \$31733
+ gf180mcu_fd_sc_mcu9t5v0__dffrnq_2
X$5453 \$24742 \$27162 \$27037 \$13471 \$27315 \$27153
+ gf180mcu_fd_sc_mcu9t5v0__dffrnq_2
X$5454 \$30838 \$31817 \$31689 \$13471 \$31810 \$31733
+ gf180mcu_fd_sc_mcu9t5v0__dffrnq_2
X$5455 \$27935 \$28832 \$28981 \$13471 \$29123 \$28971
+ gf180mcu_fd_sc_mcu9t5v0__dffrnq_2
X$5456 \$28566 \$29936 \$29797 \$13471 \$29954 \$29847
+ gf180mcu_fd_sc_mcu9t5v0__dffrnq_2
X$5457 \$14650 \$18426 \$18427 \$13471 \$18403 \$18293
+ gf180mcu_fd_sc_mcu9t5v0__dffrnq_2
X$5458 \$28566 \$29727 \$29646 \$13471 \$29780 \$29720
+ gf180mcu_fd_sc_mcu9t5v0__dffrnq_2
X$5459 \$28566 \$29647 \$29315 \$13471 \$29634 \$29424
+ gf180mcu_fd_sc_mcu9t5v0__dffrnq_2
X$5460 \$18545 \$19618 \$14208 \$13471 \$19605 \$19466
+ gf180mcu_fd_sc_mcu9t5v0__dffrnq_2
X$5461 \$24320 \$26868 \$26690 \$13471 \$27015 \$26856
+ gf180mcu_fd_sc_mcu9t5v0__dffrnq_2
X$5462 \$14010 \$18035 \$16164 \$13471 \$18137 \$17952
+ gf180mcu_fd_sc_mcu9t5v0__dffrnq_2
X$5463 \$27935 \$27800 \$27801 \$13471 \$27913 \$27776
+ gf180mcu_fd_sc_mcu9t5v0__dffrnq_2
X$5464 \$27935 \$28097 \$27336 \$13471 \$28211 \$28089
+ gf180mcu_fd_sc_mcu9t5v0__dffrnq_2
X$5465 \$28566 \$30179 \$30039 \$13471 \$30054 \$30027
+ gf180mcu_fd_sc_mcu9t5v0__dffrnq_2
X$5466 \$31827 \$32724 \$32532 \$13471 \$32721 \$32629
+ gf180mcu_fd_sc_mcu9t5v0__dffrnq_2
X$5467 \$28566 \$29800 \$29715 \$13471 \$29954 \$29847
+ gf180mcu_fd_sc_mcu9t5v0__dffrnq_2
X$5468 \$28062 \$29322 \$29278 \$13471 \$29290 \$29270
+ gf180mcu_fd_sc_mcu9t5v0__dffrnq_2
X$5469 \$31827 \$33065 \$32935 \$13471 \$33071 \$33062
+ gf180mcu_fd_sc_mcu9t5v0__dffrnq_2
X$5470 \$31827 \$33064 \$31826 \$13471 \$33071 \$33062
+ gf180mcu_fd_sc_mcu9t5v0__dffrnq_2
X$5471 \$31827 \$32319 \$32347 \$13471 \$32339 \$32307
+ gf180mcu_fd_sc_mcu9t5v0__dffrnq_2
X$5472 \$24742 \$24257 \$24259 \$13471 \$24231 \$24109
+ gf180mcu_fd_sc_mcu9t5v0__dffrnq_2
X$5473 \$18545 \$21964 \$21826 \$13471 \$22074 \$21946
+ gf180mcu_fd_sc_mcu9t5v0__dffrnq_2
X$5474 \$14010 \$15336 \$14763 \$13471 \$15321 \$15204
+ gf180mcu_fd_sc_mcu9t5v0__dffrnq_2
X$5475 \$20845 \$24120 \$24068 \$13471 \$24231 \$24109
+ gf180mcu_fd_sc_mcu9t5v0__dffrnq_2
X$5476 \$20845 \$22859 \$22860 \$13471 \$23027 \$22837
+ gf180mcu_fd_sc_mcu9t5v0__dffrnq_2
X$5477 \$20845 \$23466 \$23467 \$13471 \$23620 \$23454
+ gf180mcu_fd_sc_mcu9t5v0__dffrnq_2
X$5478 \$24742 \$26533 \$21960 \$13471 \$26675 \$26521
+ gf180mcu_fd_sc_mcu9t5v0__dffrnq_2
X$5479 \$31089 \$31814 \$31746 \$13471 \$31810 \$31733
+ gf180mcu_fd_sc_mcu9t5v0__dffrnq_2
X$5480 \$22152 \$23603 \$23784 \$13471 \$23620 \$23454
+ gf180mcu_fd_sc_mcu9t5v0__dffrnq_2
X$5481 \$24320 \$26410 \$26687 \$13471 \$26675 \$26521
+ gf180mcu_fd_sc_mcu9t5v0__dffrnq_2
X$5482 \$22152 \$24122 \$24073 \$13471 \$24231 \$24109
+ gf180mcu_fd_sc_mcu9t5v0__dffrnq_2
X$5483 \$22152 \$22915 \$16607 \$13471 \$23027 \$22837
+ gf180mcu_fd_sc_mcu9t5v0__dffrnq_2
X$5484 \$24742 \$25640 \$25931 \$13471 \$25797 \$25632
+ gf180mcu_fd_sc_mcu9t5v0__dffrnq_2
X$5485 \$23781 \$26657 \$26689 \$13471 \$26675 \$26521
+ gf180mcu_fd_sc_mcu9t5v0__dffrnq_2
X$5486 \$30858 \$31181 \$31167 \$13471 \$31232 \$31175
+ gf180mcu_fd_sc_mcu9t5v0__dffrnq_2
X$5487 \$30858 \$30478 \$30631 \$13471 \$30564 \$30485
+ gf180mcu_fd_sc_mcu9t5v0__dffrnq_2
X$5488 \$18596 \$18599 \$18836 \$13471 \$18701 \$18576
+ gf180mcu_fd_sc_mcu9t5v0__dffrnq_2
X$5489 \$18545 \$21167 \$21168 \$13471 \$21184 \$21011
+ gf180mcu_fd_sc_mcu9t5v0__dffrnq_2
X$5490 \$22152 \$23207 \$16392 \$13471 \$23183 \$23139
+ gf180mcu_fd_sc_mcu9t5v0__dffrnq_2
X$5491 \$18545 \$22596 \$17058 \$13471 \$22713 \$22440
+ gf180mcu_fd_sc_mcu9t5v0__dffrnq_2
X$5492 \$18838 \$20412 \$20413 \$13471 \$20515 \$20383
+ gf180mcu_fd_sc_mcu9t5v0__dffrnq_2
X$5493 \$18545 \$21326 \$21327 \$13471 \$21498 \$21308
+ gf180mcu_fd_sc_mcu9t5v0__dffrnq_2
X$5494 \$18838 \$20596 \$20597 \$13471 \$20881 \$20718
+ gf180mcu_fd_sc_mcu9t5v0__dffrnq_2
X$5495 \$18838 \$20854 \$20732 \$13471 \$20881 \$20718
+ gf180mcu_fd_sc_mcu9t5v0__dffrnq_2
X$5496 \$22152 \$21684 \$21825 \$13471 \$21661 \$21622
+ gf180mcu_fd_sc_mcu9t5v0__dffrnq_2
X$5497 \$18838 \$21324 \$21325 \$13471 \$21498 \$21308
+ gf180mcu_fd_sc_mcu9t5v0__dffrnq_2
X$5498 \$18596 \$21962 \$21963 \$13471 \$22074 \$21946
+ gf180mcu_fd_sc_mcu9t5v0__dffrnq_2
X$5499 \$18838 \$19754 \$19755 \$13471 \$19927 \$19774
+ gf180mcu_fd_sc_mcu9t5v0__dffrnq_2
X$5500 \$14010 \$18271 \$14640 \$13471 \$18403 \$18293
+ gf180mcu_fd_sc_mcu9t5v0__dffrnq_2
X$5501 \$18596 \$21683 \$19615 \$13471 \$21661 \$21622
+ gf180mcu_fd_sc_mcu9t5v0__dffrnq_2
X$5502 \$18838 \$21639 \$20894 \$13471 \$21661 \$21622
+ gf180mcu_fd_sc_mcu9t5v0__dffrnq_2
X$5503 \$18838 \$20227 \$20414 \$13471 \$20209 \$20087
+ gf180mcu_fd_sc_mcu9t5v0__dffrnq_2
X$5504 \$18545 \$18884 \$18845 \$13471 \$19027 \$18870
+ gf180mcu_fd_sc_mcu9t5v0__dffrnq_2
X$5505 \$31827 \$32093 \$32027 \$13471 \$32100 \$32034
+ gf180mcu_fd_sc_mcu9t5v0__dffrnq_2
X$5506 \$14010 \$18034 \$16092 \$13471 \$18137 \$17952
+ gf180mcu_fd_sc_mcu9t5v0__dffrnq_2
X$5507 \$31089 \$32091 \$32161 \$13471 \$32100 \$32034
+ gf180mcu_fd_sc_mcu9t5v0__dffrnq_2
X$5508 \$14010 \$18422 \$18423 \$13471 \$18403 \$18293
+ gf180mcu_fd_sc_mcu9t5v0__dffrnq_2
X$5509 \$31827 \$31390 \$32092 \$13471 \$32100 \$32034
+ gf180mcu_fd_sc_mcu9t5v0__dffrnq_2
X$5510 \$18838 \$18843 \$18305 \$13471 \$18701 \$18576
+ gf180mcu_fd_sc_mcu9t5v0__dffrnq_2
X$5511 \$18838 \$18840 \$18841 \$13471 \$18701 \$18576
+ gf180mcu_fd_sc_mcu9t5v0__dffrnq_2
X$5512 \$18838 \$19169 \$19170 \$13471 \$19324 \$19149
+ gf180mcu_fd_sc_mcu9t5v0__dffrnq_2
X$5513 \$24320 \$27339 \$27593 \$13471 \$27637 \$27449
+ gf180mcu_fd_sc_mcu9t5v0__dffrnq_2
X$5514 \$22152 \$24328 \$24330 \$13471 \$24593 \$24428
+ gf180mcu_fd_sc_mcu9t5v0__dffrnq_2
X$5515 \$14241 \$16475 \$13867 \$13471 \$16436 \$16376
+ gf180mcu_fd_sc_mcu9t5v0__dffrnq_2
X$5516 \$24612 \$24331 \$23162 \$13471 \$24593 \$24428
+ gf180mcu_fd_sc_mcu9t5v0__dffrnq_2
X$5517 \$14241 \$15518 \$15757 \$13471 \$15628 \$15490
+ gf180mcu_fd_sc_mcu9t5v0__dffrnq_2
X$5518 \$14241 \$15221 \$15007 \$13471 \$15321 \$15204
+ gf180mcu_fd_sc_mcu9t5v0__dffrnq_2
X$5519 \$20845 \$23154 \$23341 \$13471 \$23183 \$23139
+ gf180mcu_fd_sc_mcu9t5v0__dffrnq_2
X$5520 \$24612 \$25985 \$25986 \$13471 \$26088 \$25918
+ gf180mcu_fd_sc_mcu9t5v0__dffrnq_2
X$5521 \$14241 \$14774 \$13531 \$13471 \$14748 \$14635
+ gf180mcu_fd_sc_mcu9t5v0__dffrnq_2
X$5522 \$24612 \$25773 \$25615 \$13471 \$25797 \$25632
+ gf180mcu_fd_sc_mcu9t5v0__dffrnq_2
X$5523 \$24612 \$26243 \$26114 \$13471 \$26401 \$26220
+ gf180mcu_fd_sc_mcu9t5v0__dffrnq_2
X$5524 \$14650 \$17980 \$17120 \$13471 \$18137 \$17952
+ gf180mcu_fd_sc_mcu9t5v0__dffrnq_2
X$5525 \$14650 \$17721 \$15006 \$13471 \$17818 \$17703
+ gf180mcu_fd_sc_mcu9t5v0__dffrnq_2
X$5526 \$14650 \$17062 \$15167 \$13471 \$17085 \$17034
+ gf180mcu_fd_sc_mcu9t5v0__dffrnq_2
X$5527 \$14650 \$15968 \$13899 \$13471 \$15949 \$15749
+ gf180mcu_fd_sc_mcu9t5v0__dffrnq_2
X$5528 \$28566 \$30263 \$30176 \$13471 \$30251 \$30185
+ gf180mcu_fd_sc_mcu9t5v0__dffrnq_2
X$5529 \$14650 \$14649 \$14764 \$13471 \$14748 \$14635
+ gf180mcu_fd_sc_mcu9t5v0__dffrnq_2
X$5530 \$30858 \$30836 \$29307 \$13471 \$30819 \$30763
+ gf180mcu_fd_sc_mcu9t5v0__dffrnq_2
X$5531 \$14650 \$16927 \$15832 \$13471 \$16914 \$16728
+ gf180mcu_fd_sc_mcu9t5v0__dffrnq_2
X$5532 \$23781 \$23780 \$23782 \$13471 \$23926 \$23807
+ gf180mcu_fd_sc_mcu9t5v0__dffrnq_2
X$5533 \$14650 \$17843 \$15821 \$13471 \$17818 \$17703
+ gf180mcu_fd_sc_mcu9t5v0__dffrnq_2
X$5534 \$14650 \$15338 \$14882 \$13471 \$15321 \$15204
+ gf180mcu_fd_sc_mcu9t5v0__dffrnq_2
X$5535 \$14650 \$16402 \$14043 \$13471 \$16436 \$16376
+ gf180mcu_fd_sc_mcu9t5v0__dffrnq_2
X$5536 \$30858 \$31244 \$29795 \$13471 \$31232 \$31175
+ gf180mcu_fd_sc_mcu9t5v0__dffrnq_2
X$5537 \$14650 \$15339 \$15011 \$13471 \$15321 \$15204
+ gf180mcu_fd_sc_mcu9t5v0__dffrnq_2
X$5538 \$14650 \$15770 \$15004 \$13471 \$15949 \$15749
+ gf180mcu_fd_sc_mcu9t5v0__dffrnq_2
X$5539 \$24320 \$25934 \$26372 \$13471 \$26401 \$26220
+ gf180mcu_fd_sc_mcu9t5v0__dffrnq_2
X$5540 \$18596 \$22914 \$21640 \$13471 \$23027 \$22837
+ gf180mcu_fd_sc_mcu9t5v0__dffrnq_2
X$5541 \$24320 \$26867 \$25083 \$13471 \$27015 \$26856
+ gf180mcu_fd_sc_mcu9t5v0__dffrnq_2
X$5542 \$24612 \$25020 \$25088 \$13471 \$25191 \$24997
+ gf180mcu_fd_sc_mcu9t5v0__dffrnq_2
X$5543 \$23781 \$25325 \$25326 \$13471 \$25462 \$25347
+ gf180mcu_fd_sc_mcu9t5v0__dffrnq_2
X$5544 \$23781 \$25771 \$25772 \$13471 \$25797 \$25632
+ gf180mcu_fd_sc_mcu9t5v0__dffrnq_2
X$5545 \$24612 \$25984 \$25643 \$13471 \$26088 \$25918
+ gf180mcu_fd_sc_mcu9t5v0__dffrnq_2
X$5546 \$22152 \$23943 \$23785 \$13471 \$23926 \$23807
+ gf180mcu_fd_sc_mcu9t5v0__dffrnq_2
X$5547 \$24612 \$25016 \$25017 \$13471 \$25191 \$24997
+ gf180mcu_fd_sc_mcu9t5v0__dffrnq_2
X$5548 \$23781 \$25982 \$25770 \$13471 \$26088 \$25918
+ gf180mcu_fd_sc_mcu9t5v0__dffrnq_2
X$5549 \$23781 \$25478 \$25479 \$13471 \$25462 \$25347
+ gf180mcu_fd_sc_mcu9t5v0__dffrnq_2
X$5550 \$23781 \$25201 \$16472 \$13471 \$25191 \$24997
+ gf180mcu_fd_sc_mcu9t5v0__dffrnq_2
X$5551 \$23781 \$26240 \$26539 \$13471 \$26401 \$26220
+ gf180mcu_fd_sc_mcu9t5v0__dffrnq_2
X$5552 \$22152 \$23602 \$23343 \$13471 \$23620 \$23454
+ gf180mcu_fd_sc_mcu9t5v0__dffrnq_2
X$5553 \$13471 \$28810 \$28689 \$15037 gf180mcu_fd_sc_mcu9t5v0__buf_20
X$5554 \$15395 \$15038 \$13476 \$15037 \$14748 \$14875
+ gf180mcu_fd_sc_mcu9t5v0__dffrnq_2
X$5555 \$14018 \$13476 \$13881 \$14034 \$14054 gf180mcu_fd_sc_mcu9t5v0__nor2_1
X$5556 \$14018 \$13476 \$14151 \$14337 \$14180 gf180mcu_fd_sc_mcu9t5v0__nand2_1
X$5557 \$15397 \$13476 \$15223 \$15045 \$14875 \$15038
+ gf180mcu_fd_sc_mcu9t5v0__mux2_1
X$5558 \$13476 \$14539 \$14536 \$14454 \$14635 \$14538
+ gf180mcu_fd_sc_mcu9t5v0__mux2_1
X$5559 \$14183 \$14023 \$14151 \$14034 \$13477 gf180mcu_fd_sc_mcu9t5v0__nor2_1
X$5560 \$13479 \$13639 \$13623 \$13729 \$13741 gf180mcu_fd_sc_mcu9t5v0__nor2_1
X$5561 \$15806 \$13484 \$15041 \$13881 \$14034 \$13998
+ gf180mcu_fd_sc_mcu9t5v0__mux2_1
X$5562 \$26513 \$26640 \$13486 \$26675 \$26521 \$26791
+ gf180mcu_fd_sc_mcu9t5v0__aoi21_1
X$5563 \$16912 \$19027 \$18870 \$13486 gf180mcu_fd_sc_mcu9t5v0__buf_8
X$5564 \$25743 \$25797 \$25632 \$13487 gf180mcu_fd_sc_mcu9t5v0__buf_8
X$5565 \$14150 \$13727 \$13488 \$13634 \$13881 \$13729
+ gf180mcu_fd_sc_mcu9t5v0__dffrnq_2
X$5566 \$14144 \$17538 \$17703 \$13490 gf180mcu_fd_sc_mcu9t5v0__clkbuf_1
X$5567 \$13490 \$17490 \$15041 \$18289 \$18403 \$18293 \$18288
+ gf180mcu_fd_sc_mcu9t5v0__aoi22_1
X$5568 \$13490 \$13491 \$13625 \$13623 \$13729 \$13728
+ gf180mcu_fd_sc_mcu9t5v0__mux2_1
X$5569 \$13490 \$19733 \$19278 \$19605 \$19774 \$19880
+ gf180mcu_fd_sc_mcu9t5v0__mux2_1
X$5570 \$13490 \$17366 \$16438 \$17085 \$17367 \$17365
+ gf180mcu_fd_sc_mcu9t5v0__mux2_1
X$5571 \$13490 \$21804 \$20716 \$21661 \$21946 \$21945
+ gf180mcu_fd_sc_mcu9t5v0__mux2_1
X$5572 \$13490 \$21010 \$19776 \$21184 \$21308 \$21304
+ gf180mcu_fd_sc_mcu9t5v0__mux2_1
X$5573 \$13490 \$21798 \$22270 \$21661 \$21946 \$21940
+ gf180mcu_fd_sc_mcu9t5v0__mux2_1
X$5574 \$13490 \$18005 \$16845 \$18137 \$17952 \$18136
+ gf180mcu_fd_sc_mcu9t5v0__mux2_1
X$5575 \$13490 \$21802 \$21496 \$21661 \$21622 \$21659
+ gf180mcu_fd_sc_mcu9t5v0__mux2_1
X$5576 \$14150 \$13728 \$13491 \$13634 \$13881 \$13729
+ gf180mcu_fd_sc_mcu9t5v0__dffrnq_2
X$5577 \$15360 \$15324 \$13493 \$15045 \$15204 \$14997
+ gf180mcu_fd_sc_mcu9t5v0__mux2_1
X$5578 \$14502 \$14870 \$13493 \$14454 \$14635 \$14501
+ gf180mcu_fd_sc_mcu9t5v0__mux2_1
X$5579 \$14002 \$14001 \$13493 \$13881 \$14034 \$13839
+ gf180mcu_fd_sc_mcu9t5v0__mux2_1
X$5580 \$14152 \$14196 \$13493 \$14151 \$14337 \$14197
+ gf180mcu_fd_sc_mcu9t5v0__mux2_1
X$5581 \$14495 \$14634 \$13493 \$14454 \$14635 \$14209
+ gf180mcu_fd_sc_mcu9t5v0__mux2_1
X$5582 \$14633 \$14754 \$13493 \$14454 \$14635 \$14498
+ gf180mcu_fd_sc_mcu9t5v0__mux2_1
X$5583 \$15151 \$15326 \$13493 \$15321 \$15204 \$14341
+ gf180mcu_fd_sc_mcu9t5v0__mux2_1
X$5584 \$14155 \$14144 \$13493 \$14151 \$14034 \$14154
+ gf180mcu_fd_sc_mcu9t5v0__mux2_1
X$5585 \$14035 \$13620 \$13493 \$13881 \$13729 \$13835
+ gf180mcu_fd_sc_mcu9t5v0__mux2_1
X$5586 \$13627 \$13837 \$13881 \$13729 \$13494 gf180mcu_fd_sc_mcu9t5v0__and2_1
X$5587 \$15493 \$13495 \$19280 \$18873 \$19027 \$18870 \$18996
+ gf180mcu_fd_sc_mcu9t5v0__oai211_1
X$5588 \$13627 \$13837 \$13623 \$13729 \$13496 gf180mcu_fd_sc_mcu9t5v0__nand2_1
X$5589 \$13734 \$13736 \$13497 \$13632 \$13623 \$13729 \$13735
+ gf180mcu_fd_sc_mcu9t5v0__aoi22_1
X$5590 \$13498 \$14154 \$14151 \$14337 \$14205 gf180mcu_fd_sc_mcu9t5v0__or2_1
X$5591 \$13498 \$14036 \$13881 \$14034 \$14040 gf180mcu_fd_sc_mcu9t5v0__or2_1
X$5592 \$13498 \$14197 \$14151 \$14337 \$14202 gf180mcu_fd_sc_mcu9t5v0__or2_1
X$5593 \$13498 \$14501 \$14454 \$14635 \$14503 gf180mcu_fd_sc_mcu9t5v0__or2_1
X$5594 \$13498 \$14497 \$14454 \$14635 \$14504 gf180mcu_fd_sc_mcu9t5v0__or2_1
X$5595 \$13498 \$13839 \$13881 \$13729 \$13840 gf180mcu_fd_sc_mcu9t5v0__or2_1
X$5596 \$13498 \$14997 \$15045 \$14875 \$14877 gf180mcu_fd_sc_mcu9t5v0__or2_1
X$5597 \$14456 \$14454 \$14337 \$13498 gf180mcu_fd_sc_mcu9t5v0__buf_8
X$5598 \$18259 \$18137 \$17952 \$13499 gf180mcu_fd_sc_mcu9t5v0__clkinv_1
X$5599 \$13628 \$13623 \$13729 \$13502 gf180mcu_fd_sc_mcu9t5v0__buf_8
X$5600 \$14216 \$13845 \$13518 \$13881 \$13729 \$13509
+ gf180mcu_fd_sc_mcu9t5v0__mux2_1
X$5601 \$18415 \$13510 \$13849 \$18588 \$16919 \$23925 \$18701 \$18576 \$18538
+ gf180mcu_fd_sc_mcu9t5v0__aoi222_1
X$5602 \$14217 \$15507 \$13510 \$15506 \$15628 \$15490 \$15635
+ gf180mcu_fd_sc_mcu9t5v0__oai211_1
X$5603 \$13892 \$17053 \$16600 \$13510 \$16914 \$17034 \$17114
+ gf180mcu_fd_sc_mcu9t5v0__aoi22_1
X$5604 \$16456 \$13510 \$13849 \$15831 \$16598 \$16914 \$17034 \$16921
+ gf180mcu_fd_sc_mcu9t5v0__aoi221_1
X$5605 \$16597 \$13510 \$13887 \$15817 \$14217 \$16436 \$16728 \$16596
+ gf180mcu_fd_sc_mcu9t5v0__aoi221_1
X$5606 \$17970 \$13510 \$13892 \$17966 \$18142 \$18137 \$17952 \$17967
+ gf180mcu_fd_sc_mcu9t5v0__aoi221_1
X$5607 \$18828 \$18701 \$18870 \$13510 gf180mcu_fd_sc_mcu9t5v0__buf_8
X$5608 \$13511 \$13850 \$13735 \$13851 \$13881 \$13729 \$13891
+ gf180mcu_fd_sc_mcu9t5v0__nand4_1
X$5609 \$14007 \$13881 \$14034 \$13512 gf180mcu_fd_sc_mcu9t5v0__clkinv_1
X$5610 \$13513 \$13854 \$13894 \$13881 \$13729 \$13895
+ gf180mcu_fd_sc_mcu9t5v0__nand3_1
X$5611 \$18413 \$13515 \$13734 \$18591 \$18299 \$13887 \$18403 \$18293 \$18412
+ gf180mcu_fd_sc_mcu9t5v0__aoi222_1
X$5612 \$14217 \$15755 \$13515 \$15949 \$15749 \$14510
+ gf180mcu_fd_sc_mcu9t5v0__oai21_1
X$5613 \$14217 \$17243 \$13515 \$17103 \$17085 \$17367 \$17380
+ gf180mcu_fd_sc_mcu9t5v0__oai211_1
X$5614 \$14217 \$15761 \$13515 \$15762 \$15949 \$15749 \$15960
+ gf180mcu_fd_sc_mcu9t5v0__oai211_1
X$5615 \$14887 \$13515 \$13734 \$14355 \$14748 \$14875 \$14886
+ gf180mcu_fd_sc_mcu9t5v0__aoi22_1
X$5616 \$17101 \$13515 \$13852 \$17100 \$17085 \$17034 \$17045
+ gf180mcu_fd_sc_mcu9t5v0__aoi22_1
X$5617 \$16864 \$13515 \$13734 \$16388 \$16914 \$16728 \$16866
+ gf180mcu_fd_sc_mcu9t5v0__aoi22_1
X$5618 \$17664 \$13515 \$13852 \$17714 \$17818 \$17703 \$17832
+ gf180mcu_fd_sc_mcu9t5v0__aoi22_1
X$5619 \$18141 \$18137 \$17952 \$13515 gf180mcu_fd_sc_mcu9t5v0__buf_8
X$5620 \$14352 \$16452 \$15216 \$13516 \$15045 \$15204 \$15217
+ gf180mcu_fd_sc_mcu9t5v0__aoi22_1
X$5621 \$13518 \$28481 \$28930 \$28810 \$28971 \$28931
+ gf180mcu_fd_sc_mcu9t5v0__aoi21_1
X$5622 \$13518 \$28485 \$26400 \$28211 \$28381 \$28378
+ gf180mcu_fd_sc_mcu9t5v0__nand3_1
X$5623 \$13518 \$28481 \$28810 \$28971 \$28969 gf180mcu_fd_sc_mcu9t5v0__nand2_1
X$5624 \$13518 \$26797 \$26675 \$26856 \$26799 gf180mcu_fd_sc_mcu9t5v0__nand2_1
X$5625 \$27781 \$27637 \$27776 \$13518 gf180mcu_fd_sc_mcu9t5v0__buf_8
X$5626 \$15154 \$15370 \$13518 \$15321 \$15490 \$15504
+ gf180mcu_fd_sc_mcu9t5v0__mux2_1
X$5627 \$16271 \$16273 \$13518 \$16269 \$16376 \$16152
+ gf180mcu_fd_sc_mcu9t5v0__mux2_1
X$5628 \$14760 \$15209 \$13518 \$15045 \$15204 \$15332
+ gf180mcu_fd_sc_mcu9t5v0__mux2_1
X$5629 \$25761 \$25922 \$13518 \$25797 \$25918 \$25760
+ gf180mcu_fd_sc_mcu9t5v0__mux2_1
X$5630 \$25921 \$25920 \$13518 \$25797 \$25918 \$25919
+ gf180mcu_fd_sc_mcu9t5v0__mux2_1
X$5631 \$18297 \$18263 \$13518 \$18137 \$18293 \$18298
+ gf180mcu_fd_sc_mcu9t5v0__mux2_1
X$5632 \$20344 \$24296 \$13518 \$24231 \$24428 \$24054
+ gf180mcu_fd_sc_mcu9t5v0__mux2_1
X$5633 \$15013 \$15218 \$13518 \$15321 \$15490 \$15335
+ gf180mcu_fd_sc_mcu9t5v0__mux2_1
X$5634 \$14765 \$14889 \$13518 \$14748 \$14875 \$14888
+ gf180mcu_fd_sc_mcu9t5v0__mux2_1
X$5635 \$15053 \$15052 \$13518 \$15045 \$15204 \$15213
+ gf180mcu_fd_sc_mcu9t5v0__mux2_1
X$5636 \$23806 \$23761 \$13518 \$23620 \$23807 \$23760
+ gf180mcu_fd_sc_mcu9t5v0__mux2_1
X$5637 \$18024 \$19160 \$13518 \$19027 \$19149 \$19159
+ gf180mcu_fd_sc_mcu9t5v0__mux2_1
X$5638 \$18877 \$18829 \$13518 \$18701 \$18870 \$18878
+ gf180mcu_fd_sc_mcu9t5v0__mux2_1
X$5639 \$18023 \$17963 \$13518 \$17818 \$17952 \$18025
+ gf180mcu_fd_sc_mcu9t5v0__mux2_1
X$5640 \$15215 \$15168 \$13518 \$15045 \$15204 \$15017
+ gf180mcu_fd_sc_mcu9t5v0__mux2_1
X$5641 \$18299 \$17828 \$13518 \$17818 \$17952 \$18022
+ gf180mcu_fd_sc_mcu9t5v0__mux2_1
X$5642 \$16464 \$16393 \$13518 \$16436 \$16728 \$16466
+ gf180mcu_fd_sc_mcu9t5v0__mux2_1
X$5643 \$23927 \$24232 \$13518 \$24231 \$24109 \$24108
+ gf180mcu_fd_sc_mcu9t5v0__mux2_1
X$5644 \$18027 \$18268 \$13518 \$18403 \$18293 \$18417
+ gf180mcu_fd_sc_mcu9t5v0__mux2_1
X$5645 \$17384 \$19037 \$13518 \$19324 \$19149 \$19036
+ gf180mcu_fd_sc_mcu9t5v0__mux2_1
X$5646 \$17966 \$18300 \$13518 \$18403 \$18293 \$18418
+ gf180mcu_fd_sc_mcu9t5v0__mux2_1
X$5647 \$18145 \$19292 \$13518 \$19324 \$19149 \$19000
+ gf180mcu_fd_sc_mcu9t5v0__mux2_1
X$5648 \$18015 \$24849 \$13518 \$24877 \$24721 \$24595
+ gf180mcu_fd_sc_mcu9t5v0__mux2_1
X$5649 \$20885 \$27280 \$13518 \$25191 \$24997 \$25057
+ gf180mcu_fd_sc_mcu9t5v0__mux2_1
X$5650 \$17707 \$25798 \$13518 \$25462 \$25347 \$25306
+ gf180mcu_fd_sc_mcu9t5v0__mux2_1
X$5651 \$24107 \$24530 \$13518 \$24593 \$24428 \$24594
+ gf180mcu_fd_sc_mcu9t5v0__mux2_1
X$5652 \$23925 \$24529 \$13518 \$24593 \$24428 \$24295
+ gf180mcu_fd_sc_mcu9t5v0__mux2_1
X$5653 \$17049 \$17055 \$13518 \$17085 \$17034 \$17054
+ gf180mcu_fd_sc_mcu9t5v0__mux2_1
X$5654 \$18588 \$18020 \$13518 \$19027 \$18870 \$19034
+ gf180mcu_fd_sc_mcu9t5v0__mux2_1
X$5655 \$14352 \$14231 \$13518 \$14454 \$14337 \$14465
+ gf180mcu_fd_sc_mcu9t5v0__mux2_1
X$5656 \$15831 \$15962 \$13518 \$15949 \$15749 \$15830
+ gf180mcu_fd_sc_mcu9t5v0__mux2_1
X$5657 \$17502 \$17383 \$13518 \$17538 \$17367 \$17660
+ gf180mcu_fd_sc_mcu9t5v0__mux2_1
X$5658 \$15505 \$15634 \$13518 \$15628 \$15490 \$15633
+ gf180mcu_fd_sc_mcu9t5v0__mux2_1
X$5659 \$16450 \$16449 \$13518 \$16436 \$16376 \$16448
+ gf180mcu_fd_sc_mcu9t5v0__mux2_1
X$5660 \$15817 \$15498 \$13518 \$15949 \$15749 \$15957
+ gf180mcu_fd_sc_mcu9t5v0__mux2_1
X$5661 \$16080 \$15818 \$13518 \$15949 \$15749 \$15958
+ gf180mcu_fd_sc_mcu9t5v0__mux2_1
X$5662 \$15014 \$13863 \$13518 \$13881 \$13729 \$13898
+ gf180mcu_fd_sc_mcu9t5v0__mux2_1
X$5663 \$16462 \$16737 \$13518 \$16436 \$16376 \$16461
+ gf180mcu_fd_sc_mcu9t5v0__mux2_1
X$5664 \$17111 \$17116 \$13518 \$17538 \$17367 \$17247
+ gf180mcu_fd_sc_mcu9t5v0__mux2_1
X$5665 \$17246 \$17119 \$13518 \$17538 \$17367 \$17249
+ gf180mcu_fd_sc_mcu9t5v0__mux2_1
X$5666 \$18026 \$16460 \$13518 \$18137 \$17952 \$18143
+ gf180mcu_fd_sc_mcu9t5v0__mux2_1
X$5667 \$14355 \$13897 \$13518 \$14454 \$14337 \$14466
+ gf180mcu_fd_sc_mcu9t5v0__mux2_1
X$5668 \$13731 \$13843 \$13518 \$13881 \$13729 \$13631
+ gf180mcu_fd_sc_mcu9t5v0__mux2_1
X$5669 \$13519 \$13862 \$15502 \$14151 \$14034 \$14233
+ gf180mcu_fd_sc_mcu9t5v0__aoi21_1
X$5670 \$13519 \$13874 \$13872 \$13902 \$13881 \$13729 \$13873
+ gf180mcu_fd_sc_mcu9t5v0__oai22_1
X$5671 \$13519 \$13867 \$13862 \$13881 \$13729 \$13863
+ gf180mcu_fd_sc_mcu9t5v0__mux2_1
X$5672 \$19005 \$19042 \$18885 \$13522 \$19027 \$18870 \$18600
+ gf180mcu_fd_sc_mcu9t5v0__aoi22_1
X$5673 \$19299 \$19352 \$19324 \$19149 \$13524 gf180mcu_fd_sc_mcu9t5v0__xnor2_1
X$5674 \$16168 \$15969 \$16098 \$15949 \$16070 \$13526
+ gf180mcu_fd_sc_mcu9t5v0__oai21_1
X$5675 \$13531 \$14017 \$14536 \$14748 \$14635 \$14654
+ gf180mcu_fd_sc_mcu9t5v0__mux2_1
X$5676 \$13638 \$13637 \$13877 \$13881 \$13729 \$13532
+ gf180mcu_fd_sc_mcu9t5v0__aoi21_1
X$5677 \$15185 pad_din[5] \$I20747 \$I20765 \$I20756 \$I20774 \$I20783 \$I20801
+ \$I20792 \$I20810 \$I20819 \$I20837 \$I20828 \$I20846 \$I20855 \$I20864
+ \$I20873 \$I20882 \$I20891 \$I20900 \$I20909 \$I20918 \$I20927 \$I20936
+ \$I20945 \$I20954 \$I20963 \$I20981 \$I20972 \$I20990 \$I20999 \$I21017
+ \$I21008 \$I21026 \$I21044 \$I21035 \$I21053 \$I21062 \$I21071 \$I21089
+ \$I21080 \$I21098 \$I21107 \$I21116 \$I21125 \$I21134 \$I21143 \$I21161
+ \$I21152 \$I21170 \$I21179 \$I21197 \$I21188 \$I21206 \$I21215 \$I21233
+ \$I21224 \$I21242 \$I21251 \$I21269 \$I21260 \$I21278 \$I21287 \$I21296
+ \$I21305 \$I21314 \$I21323 \$I21332 \$I21341 \$I21350 \$I21368 \$I21377
+ \$I21404 \$I21413 \$I21359 \$I21395 \$I21386 \$I21431 \$I21422 \$I21458
+ \$I21449 \$I21467 \$I21440 \$I21485 \$I21476 \$I21494 \$I21512 \$I21539
+ \$I21548 \$I21557 \$I21503 \$I21530 \$I21521 \$I21575 \$I21566 \$I21584
+ \$I21593 \$I21602 \$I21611 \$I21620 \$I21629 \$I21638 \$13618 \$I21647
+ \$I21665 \$I21656 \$I21674 \$13618 \$14866 gf180mcu_fd_io__in_c
X$5678 \$13619 \$13729 \$13623 \$13620 gf180mcu_fd_sc_mcu9t5v0__buf_8
X$5679 \$14744 \$13729 \$13623 \$13619 gf180mcu_fd_sc_mcu9t5v0__buf_1
X$5680 \$13620 \$14454 \$14635 \$14188 gf180mcu_fd_sc_mcu9t5v0__buf_1
X$5681 \$15629 \$13631 \$13731 \$13634 \$13623 \$13729
+ gf180mcu_fd_sc_mcu9t5v0__dffrnq_2
X$5682 \$13638 \$13637 \$13623 \$13729 \$13740 gf180mcu_fd_sc_mcu9t5v0__nand2_1
X$5683 \$15806 \$13626 \$13625 \$13623 \$13729 \$13730
+ gf180mcu_fd_sc_mcu9t5v0__mux2_1
X$5684 \$13729 \$13623 gf180mcu_fd_sc_mcu9t5v0__filltie
X$5685 \$13729 \$13623 gf180mcu_fd_sc_mcu9t5v0__filltie
X$5686 \$13729 \$13623 gf180mcu_fd_sc_mcu9t5v0__filltie
X$5687 \$13729 \$13623 gf180mcu_fd_sc_mcu9t5v0__filltie
X$5688 \$13729 \$13623 gf180mcu_fd_sc_mcu9t5v0__filltie
X$5689 \$13729 \$13623 gf180mcu_fd_sc_mcu9t5v0__filltie
X$5690 \$13729 \$13623 gf180mcu_fd_sc_mcu9t5v0__endcap
X$5691 \$16073 \$18405 \$13625 \$18137 \$18293 \$18255
+ gf180mcu_fd_sc_mcu9t5v0__oai21_1
X$5692 \$18820 \$18405 \$18403 \$18576 \$13625 gf180mcu_fd_sc_mcu9t5v0__nand2_1
X$5693 \$14194 \$14196 \$13625 \$14151 \$14337 \$14195
+ gf180mcu_fd_sc_mcu9t5v0__mux2_1
X$5694 \$15147 \$14754 \$13625 \$14748 \$14875 \$14753
+ gf180mcu_fd_sc_mcu9t5v0__mux2_1
X$5695 \$15203 \$15326 \$13625 \$15628 \$15490 \$15364
+ gf180mcu_fd_sc_mcu9t5v0__mux2_1
X$5696 \$15201 \$15324 \$13625 \$15321 \$15204 \$15323
+ gf180mcu_fd_sc_mcu9t5v0__mux2_1
X$5697 \$14492 \$14634 \$13625 \$14748 \$14635 \$14749
+ gf180mcu_fd_sc_mcu9t5v0__mux2_1
X$5698 \$17371 \$13627 \$17085 \$17367 \$15330 gf180mcu_fd_sc_mcu9t5v0__and2_1
X$5699 \$17097 \$16854 \$17085 \$17034 \$13627 gf180mcu_fd_sc_mcu9t5v0__nor2_1
X$5700 \$16073 \$16072 \$15812 \$16131 \$15949 \$15749 \$13628
+ gf180mcu_fd_sc_mcu9t5v0__oai31_4
X$5701 \$14217 \$17384 \$13632 \$17085 \$17367 \$17107
+ gf180mcu_fd_sc_mcu9t5v0__oai21_1
X$5702 \$14217 \$14760 \$13632 \$16269 \$16376 \$16385
+ gf180mcu_fd_sc_mcu9t5v0__oai21_1
X$5703 \$14217 \$15154 \$13632 \$15045 \$15204 \$15155
+ gf180mcu_fd_sc_mcu9t5v0__oai21_1
X$5704 \$14217 \$15154 \$13632 \$14637 \$15045 \$14875 \$14879
+ gf180mcu_fd_sc_mcu9t5v0__oai211_1
X$5705 \$14217 \$14760 \$13632 \$14158 \$14748 \$14635 \$14506
+ gf180mcu_fd_sc_mcu9t5v0__oai211_1
X$5706 \$18590 \$13852 \$13632 \$18877 \$18701 \$18576 \$18539
+ gf180mcu_fd_sc_mcu9t5v0__aoi22_1
X$5707 \$14765 \$13632 \$13887 \$15215 \$15045 \$14875 \$14884
+ gf180mcu_fd_sc_mcu9t5v0__aoi22_1
X$5708 \$13855 \$13734 \$13838 \$13632 \$13881 \$13729 \$13894
+ gf180mcu_fd_sc_mcu9t5v0__aoi22_1
X$5709 \$13734 \$14228 \$14507 \$13632 \$15949 \$15749 \$15822
+ gf180mcu_fd_sc_mcu9t5v0__aoi22_1
X$5710 \$18264 \$18403 \$18293 \$13632 gf180mcu_fd_sc_mcu9t5v0__buf_8
X$5711 \$15329 \$15366 \$14992 \$13634 \$15204 \$15045
+ gf180mcu_fd_sc_mcu9t5v0__dffsnq_2
X$5712 \$14150 \$15323 \$15324 \$13634 \$15321 \$15490
+ gf180mcu_fd_sc_mcu9t5v0__dffrnq_2
X$5713 \$14462 \$16461 \$16462 \$13634 \$16436 \$16728
+ gf180mcu_fd_sc_mcu9t5v0__dffrnq_2
X$5714 \$14150 \$14749 \$14634 \$13634 \$14748 \$14875
+ gf180mcu_fd_sc_mcu9t5v0__dffrnq_2
X$5715 \$15016 \$17838 \$17970 \$13634 \$17818 \$17952
+ gf180mcu_fd_sc_mcu9t5v0__dffrnq_2
X$5716 \$14150 \$15322 \$15360 \$13634 \$15321 \$15490
+ gf180mcu_fd_sc_mcu9t5v0__dffrnq_2
X$5717 \$14150 \$14874 \$14633 \$13634 \$14748 \$14875
+ gf180mcu_fd_sc_mcu9t5v0__dffrnq_2
X$5718 \$18592 \$17247 \$17111 \$13634 \$17085 \$17367
+ gf180mcu_fd_sc_mcu9t5v0__dffrnq_2
X$5719 \$15016 \$17834 \$17714 \$13634 \$17818 \$17952
+ gf180mcu_fd_sc_mcu9t5v0__dffrnq_2
X$5720 \$14187 \$14190 \$14191 \$13634 \$14151 \$14337
+ gf180mcu_fd_sc_mcu9t5v0__dffrnq_2
X$5721 \$15016 \$17248 \$17382 \$13634 \$17085 \$17367
+ gf180mcu_fd_sc_mcu9t5v0__dffrnq_2
X$5722 \$15016 \$17249 \$17246 \$13634 \$17085 \$17367
+ gf180mcu_fd_sc_mcu9t5v0__dffrnq_2
X$5723 \$14010 \$14466 \$14355 \$13634 \$14454 \$14635
+ gf180mcu_fd_sc_mcu9t5v0__dffrnq_2
X$5724 \$15016 \$16087 \$16086 \$13634 \$15949 \$16070
+ gf180mcu_fd_sc_mcu9t5v0__dffrnq_2
X$5725 \$15016 \$14766 \$14887 \$13634 \$14748 \$14875
+ gf180mcu_fd_sc_mcu9t5v0__dffrnq_2
X$5726 \$14462 \$16145 \$16457 \$13634 \$16269 \$16376
+ gf180mcu_fd_sc_mcu9t5v0__dffrnq_2
X$5727 \$15016 \$15830 \$15831 \$13634 \$15949 \$16070
+ gf180mcu_fd_sc_mcu9t5v0__dffrnq_2
X$5728 \$15016 \$17836 \$17664 \$13634 \$17818 \$17952
+ gf180mcu_fd_sc_mcu9t5v0__dffrnq_2
X$5729 \$14010 \$13898 \$15014 \$13634 \$13881 \$14034
+ gf180mcu_fd_sc_mcu9t5v0__dffrnq_2
X$5730 \$15016 \$17250 \$17115 \$13634 \$17085 \$17367
+ gf180mcu_fd_sc_mcu9t5v0__dffrnq_2
X$5731 \$24742 \$26365 \$26366 \$13634 \$26401 \$26521
+ gf180mcu_fd_sc_mcu9t5v0__dffrnq_2
X$5732 \$15016 \$17054 \$17049 \$13634 \$16914 \$17034
+ gf180mcu_fd_sc_mcu9t5v0__dffrnq_2
X$5733 \$28350 \$30062 \$30173 \$13634 \$30054 \$30185
+ gf180mcu_fd_sc_mcu9t5v0__dffrnq_2
X$5734 \$14462 \$17660 \$17502 \$13634 \$17538 \$17703
+ gf180mcu_fd_sc_mcu9t5v0__dffrnq_2
X$5735 \$21369 \$22392 \$22391 \$13634 \$22387 \$22440
+ gf180mcu_fd_sc_mcu9t5v0__dffrnq_2
X$5736 \$15016 \$18028 \$18269 \$13634 \$18137 \$18293
+ gf180mcu_fd_sc_mcu9t5v0__dffrnq_2
X$5737 \$24742 \$25929 \$25930 \$13634 \$25797 \$25918
+ gf180mcu_fd_sc_mcu9t5v0__dffrnq_2
X$5738 \$24301 \$25635 \$25599 \$13634 \$25797 \$25918
+ gf180mcu_fd_sc_mcu9t5v0__dffrnq_2
X$5739 \$24301 \$25193 \$25063 \$13634 \$25191 \$25347
+ gf180mcu_fd_sc_mcu9t5v0__dffrnq_2
X$5740 \$23765 \$25313 \$24738 \$13634 \$25191 \$25347
+ gf180mcu_fd_sc_mcu9t5v0__dffrnq_2
X$5741 \$25805 \$26100 \$25975 \$13634 \$26088 \$26220
+ gf180mcu_fd_sc_mcu9t5v0__dffrnq_2
X$5742 \$15629 \$16141 \$16456 \$13634 \$16269 \$16376
+ gf180mcu_fd_sc_mcu9t5v0__dffrnq_2
X$5743 \$28554 \$29789 \$29927 \$13634 \$29780 \$29847
+ gf180mcu_fd_sc_mcu9t5v0__dffrnq_2
X$5744 \$28350 \$29299 \$28941 \$13634 \$29290 \$29424
+ gf180mcu_fd_sc_mcu9t5v0__dffrnq_2
X$5745 \$23765 \$24880 \$24881 \$13634 \$24877 \$24997
+ gf180mcu_fd_sc_mcu9t5v0__dffrnq_2
X$5746 \$15329 \$16857 \$17097 \$13634 \$17538 \$17703
+ gf180mcu_fd_sc_mcu9t5v0__dffrnq_2
X$5747 \$17658 \$17710 \$17243 \$13634 \$17538 \$17703
+ gf180mcu_fd_sc_mcu9t5v0__dffrnq_2
X$5748 \$23323 \$23624 \$23591 \$13634 \$23620 \$23807
+ gf180mcu_fd_sc_mcu9t5v0__dffrnq_2
X$5749 \$15329 \$17657 \$17242 \$13634 \$17538 \$17703
+ gf180mcu_fd_sc_mcu9t5v0__dffrnq_2
X$5750 \$23765 \$23634 \$23596 \$13634 \$23620 \$23807
+ gf180mcu_fd_sc_mcu9t5v0__dffrnq_2
X$5751 \$19740 \$22587 \$15000 \$13634 \$22713 \$22837
+ gf180mcu_fd_sc_mcu9t5v0__dffrnq_2
X$5752 \$15329 \$16448 \$16450 \$13634 \$16436 \$16728
+ gf180mcu_fd_sc_mcu9t5v0__dffrnq_2
X$5753 \$23765 \$23331 \$23462 \$13634 \$23183 \$23454
+ gf180mcu_fd_sc_mcu9t5v0__dffrnq_2
X$5754 \$28350 \$29639 \$29726 \$13634 \$29634 \$29720
+ gf180mcu_fd_sc_mcu9t5v0__dffrnq_2
X$5755 \$28350 \$29705 \$29706 \$13634 \$29634 \$29720
+ gf180mcu_fd_sc_mcu9t5v0__dffrnq_2
X$5756 \$28350 \$28824 \$28705 \$13634 \$28810 \$28971
+ gf180mcu_fd_sc_mcu9t5v0__dffrnq_2
X$5757 \$23765 \$25312 \$24064 \$13634 \$25191 \$25347
+ gf180mcu_fd_sc_mcu9t5v0__dffrnq_2
X$5758 \$21369 \$22452 \$22585 \$13634 \$22387 \$22440
+ gf180mcu_fd_sc_mcu9t5v0__dffrnq_2
X$5759 \$15329 \$16377 \$16132 \$13634 \$16269 \$16376
+ gf180mcu_fd_sc_mcu9t5v0__dffrnq_2
X$5760 \$16439 \$18010 \$17955 \$13634 \$17538 \$17703
+ gf180mcu_fd_sc_mcu9t5v0__dffrnq_2
X$5761 \$24742 \$26230 \$25074 \$13634 \$26088 \$26220
+ gf180mcu_fd_sc_mcu9t5v0__dffrnq_2
X$5762 \$23765 \$24116 \$24117 \$13634 \$24231 \$24428
+ gf180mcu_fd_sc_mcu9t5v0__dffrnq_2
X$5763 \$16439 \$17652 \$17653 \$13634 \$17538 \$17703
+ gf180mcu_fd_sc_mcu9t5v0__dffrnq_2
X$5764 \$25805 \$25927 \$25806 \$13634 \$25797 \$25918
+ gf180mcu_fd_sc_mcu9t5v0__dffrnq_2
X$5765 \$21369 \$24061 \$24114 \$13634 \$23926 \$24109
+ gf180mcu_fd_sc_mcu9t5v0__dffrnq_2
X$5766 \$14150 \$15364 \$15326 \$13634 \$15321 \$15490
+ gf180mcu_fd_sc_mcu9t5v0__dffrnq_2
X$5767 \$17658 \$18584 \$18535 \$13634 \$18403 \$18576
+ gf180mcu_fd_sc_mcu9t5v0__dffrnq_2
X$5768 \$20342 \$21148 \$21186 \$13634 \$21184 \$21308
+ gf180mcu_fd_sc_mcu9t5v0__dffrnq_2
X$5769 \$17658 \$19932 \$19888 \$13634 \$19927 \$20087
+ gf180mcu_fd_sc_mcu9t5v0__dffrnq_2
X$5770 \$21369 \$23031 \$22897 \$13634 \$23027 \$23139
+ gf180mcu_fd_sc_mcu9t5v0__dffrnq_2
X$5771 \$20342 \$20582 \$20583 \$13634 \$20515 \$20718
+ gf180mcu_fd_sc_mcu9t5v0__dffrnq_2
X$5772 \$23765 \$23631 \$23594 \$13634 \$23620 \$23807
+ gf180mcu_fd_sc_mcu9t5v0__dffrnq_2
X$5773 \$17658 \$19034 \$18588 \$13634 \$19027 \$19149
+ gf180mcu_fd_sc_mcu9t5v0__dffrnq_2
X$5774 \$17658 \$19289 \$19290 \$13634 \$19324 \$19466
+ gf180mcu_fd_sc_mcu9t5v0__dffrnq_2
X$5775 \$19740 \$21506 \$21507 \$13634 \$21498 \$21622
+ gf180mcu_fd_sc_mcu9t5v0__dffrnq_2
X$5776 \$17658 \$19934 \$19893 \$13634 \$19927 \$20087
+ gf180mcu_fd_sc_mcu9t5v0__dffrnq_2
X$5777 \$21369 \$21673 \$21674 \$13634 \$21661 \$21946
+ gf180mcu_fd_sc_mcu9t5v0__dffrnq_2
X$5778 \$19740 \$19610 \$19473 \$13634 \$19605 \$19774
+ gf180mcu_fd_sc_mcu9t5v0__dffrnq_2
X$5779 \$17658 \$20217 \$20393 \$13634 \$20209 \$20383
+ gf180mcu_fd_sc_mcu9t5v0__dffrnq_2
X$5780 \$23765 \$24119 \$19161 \$13634 \$24231 \$24428
+ gf180mcu_fd_sc_mcu9t5v0__dffrnq_2
X$5781 \$19740 \$20887 \$20844 \$13634 \$20881 \$21011
+ gf180mcu_fd_sc_mcu9t5v0__dffrnq_2
X$5782 \$24742 \$24883 \$19038 \$13634 \$24877 \$24997
+ gf180mcu_fd_sc_mcu9t5v0__dffrnq_2
X$5783 \$19740 \$19741 \$19895 \$13634 \$19605 \$19774
+ gf180mcu_fd_sc_mcu9t5v0__dffrnq_2
X$5784 \$19775 \$18582 \$17708 \$13634 \$18403 \$18576
+ gf180mcu_fd_sc_mcu9t5v0__dffrnq_2
X$5785 \$16439 \$18138 \$18008 \$13634 \$18137 \$18293
+ gf180mcu_fd_sc_mcu9t5v0__dffrnq_2
X$5786 \$17658 \$19332 \$19156 \$13634 \$19324 \$19466
+ gf180mcu_fd_sc_mcu9t5v0__dffrnq_2
X$5787 \$21369 \$22080 \$21957 \$13634 \$22074 \$22272
+ gf180mcu_fd_sc_mcu9t5v0__dffrnq_2
X$5788 \$20342 \$21022 \$21150 \$13634 \$21184 \$21308
+ gf180mcu_fd_sc_mcu9t5v0__dffrnq_2
X$5789 \$21369 \$21671 \$21813 \$13634 \$21661 \$21946
+ gf180mcu_fd_sc_mcu9t5v0__dffrnq_2
X$5790 \$28554 \$28555 \$28556 \$13634 \$28534 \$28689
+ gf180mcu_fd_sc_mcu9t5v0__dffrnq_2
X$5791 \$25805 \$27458 \$27330 \$13634 \$27315 \$27449
+ gf180mcu_fd_sc_mcu9t5v0__dffrnq_2
X$5792 \$20342 \$20584 \$20391 \$13634 \$20515 \$20718
+ gf180mcu_fd_sc_mcu9t5v0__dffrnq_2
X$5793 \$25805 \$26684 \$26652 \$13634 \$26675 \$26856
+ gf180mcu_fd_sc_mcu9t5v0__dffrnq_2
X$5794 \$21369 \$20886 \$21023 \$13634 \$20881 \$21011
+ gf180mcu_fd_sc_mcu9t5v0__dffrnq_2
X$5795 \$20342 \$21149 \$21187 \$13634 \$21184 \$21308
+ gf180mcu_fd_sc_mcu9t5v0__dffrnq_2
X$5796 \$28350 \$28218 \$27652 \$13634 \$28211 \$28381
+ gf180mcu_fd_sc_mcu9t5v0__dffrnq_2
X$5797 \$17658 \$19784 \$19892 \$13634 \$19605 \$19774
+ gf180mcu_fd_sc_mcu9t5v0__dffrnq_2
X$5798 \$27926 \$28550 \$28382 \$13634 \$28534 \$28689
+ gf180mcu_fd_sc_mcu9t5v0__dffrnq_2
X$5799 \$21369 \$22081 \$22144 \$13634 \$22074 \$22272
+ gf180mcu_fd_sc_mcu9t5v0__dffrnq_2
X$5800 \$19740 \$20586 \$20522 \$13634 \$20515 \$20718
+ gf180mcu_fd_sc_mcu9t5v0__dffrnq_2
X$5801 \$19740 \$21817 \$21958 \$13634 \$21661 \$21946
+ gf180mcu_fd_sc_mcu9t5v0__dffrnq_2
X$5802 \$20342 \$20049 \$19157 \$13634 \$19927 \$20087
+ gf180mcu_fd_sc_mcu9t5v0__dffrnq_2
X$5803 \$19775 \$19780 \$19931 \$13634 \$19927 \$20087
+ gf180mcu_fd_sc_mcu9t5v0__dffrnq_2
X$5804 \$19775 \$22078 \$22079 \$13634 \$22074 \$22272
+ gf180mcu_fd_sc_mcu9t5v0__dffrnq_2
X$5805 \$20342 \$22840 \$22841 \$13634 \$22713 \$22837
+ gf180mcu_fd_sc_mcu9t5v0__dffrnq_2
X$5806 \$24301 \$23764 \$23626 \$13634 \$23620 \$23807
+ gf180mcu_fd_sc_mcu9t5v0__dffrnq_2
X$5807 \$19775 \$19930 \$19734 \$13634 \$19927 \$20087
+ gf180mcu_fd_sc_mcu9t5v0__dffrnq_2
X$5808 \$15329 \$15958 \$16080 \$13634 \$15949 \$16070
+ gf180mcu_fd_sc_mcu9t5v0__dffrnq_2
X$5809 \$15329 \$15957 \$15817 \$13634 \$15949 \$16070
+ gf180mcu_fd_sc_mcu9t5v0__dffrnq_2
X$5810 \$15629 \$15630 \$15754 \$13634 \$15628 \$15749
+ gf180mcu_fd_sc_mcu9t5v0__dffrnq_2
X$5811 \$15629 \$16920 \$17100 \$13634 \$16914 \$17034
+ gf180mcu_fd_sc_mcu9t5v0__dffrnq_2
X$5812 \$15629 \$16138 \$16388 \$13634 \$16269 \$16376
+ gf180mcu_fd_sc_mcu9t5v0__dffrnq_2
X$5813 \$17658 \$17543 \$17101 \$13634 \$17538 \$17703
+ gf180mcu_fd_sc_mcu9t5v0__dffrnq_2
X$5814 \$25805 \$26807 \$26682 \$13634 \$26675 \$26856
+ gf180mcu_fd_sc_mcu9t5v0__dffrnq_2
X$5815 \$16439 \$15953 \$15809 \$13634 \$15949 \$16070
+ gf180mcu_fd_sc_mcu9t5v0__dffrnq_2
X$5816 \$16439 \$16444 \$16445 \$13634 \$16436 \$16728
+ gf180mcu_fd_sc_mcu9t5v0__dffrnq_2
X$5817 \$14150 \$14198 \$14155 \$13634 \$14151 \$14337
+ gf180mcu_fd_sc_mcu9t5v0__dffrnq_2
X$5818 \$19775 \$20579 \$20518 \$13634 \$20515 \$20718
+ gf180mcu_fd_sc_mcu9t5v0__dffrnq_2
X$5819 \$18596 \$18419 \$18413 \$13634 \$18403 \$18576
+ gf180mcu_fd_sc_mcu9t5v0__dffrnq_2
X$5820 \$25805 \$27643 \$26981 \$13634 \$27637 \$27776
+ gf180mcu_fd_sc_mcu9t5v0__dffrnq_2
X$5821 \$14150 \$15361 \$15362 \$13634 \$15321 \$15490
+ gf180mcu_fd_sc_mcu9t5v0__dffrnq_2
X$5822 \$20845 \$20888 \$14459 \$13634 \$20881 \$21011
+ gf180mcu_fd_sc_mcu9t5v0__dffrnq_2
X$5823 \$20845 \$21818 \$14212 \$13634 \$21661 \$21946
+ gf180mcu_fd_sc_mcu9t5v0__dffrnq_2
X$5824 \$19775 \$20884 \$20842 \$13634 \$20881 \$21011
+ gf180mcu_fd_sc_mcu9t5v0__dffrnq_2
X$5825 \$19775 \$19281 \$19608 \$13634 \$19324 \$19466
+ gf180mcu_fd_sc_mcu9t5v0__dffrnq_2
X$5826 \$20342 \$21502 \$21503 \$13634 \$21498 \$21622
+ gf180mcu_fd_sc_mcu9t5v0__dffrnq_2
X$5827 \$19740 \$21508 \$21509 \$13634 \$21498 \$21622
+ gf180mcu_fd_sc_mcu9t5v0__dffrnq_2
X$5828 \$20342 \$20581 \$20721 \$13634 \$20515 \$20718
+ gf180mcu_fd_sc_mcu9t5v0__dffrnq_2
X$5829 \$14462 \$15002 \$15212 \$13634 \$15045 \$15204
+ gf180mcu_fd_sc_mcu9t5v0__dffrnq_2
X$5830 \$19775 \$20340 \$20214 \$13634 \$20209 \$20383
+ gf180mcu_fd_sc_mcu9t5v0__dffrnq_2
X$5831 \$14462 \$15633 \$15505 \$13634 \$15628 \$15749
+ gf180mcu_fd_sc_mcu9t5v0__dffrnq_2
X$5832 \$19740 \$19036 \$17384 \$13634 \$19027 \$19149
+ gf180mcu_fd_sc_mcu9t5v0__dffrnq_2
X$5833 \$18592 \$18594 \$16149 \$13634 \$18701 \$18870
+ gf180mcu_fd_sc_mcu9t5v0__dffrnq_2
X$5834 \$18592 \$18831 \$14514 \$13634 \$18701 \$18870
+ gf180mcu_fd_sc_mcu9t5v0__dffrnq_2
X$5835 \$18592 \$20056 \$14044 \$13634 \$19927 \$20087
+ gf180mcu_fd_sc_mcu9t5v0__dffrnq_2
X$5836 \$28350 \$28704 \$28558 \$13634 \$28534 \$28689
+ gf180mcu_fd_sc_mcu9t5v0__dffrnq_2
X$5837 \$25805 \$26223 \$26409 \$13634 \$26401 \$26521
+ gf180mcu_fd_sc_mcu9t5v0__dffrnq_2
X$5838 \$18592 \$18830 \$18590 \$13634 \$18701 \$18870
+ gf180mcu_fd_sc_mcu9t5v0__dffrnq_2
X$5839 \$19740 \$20524 \$14513 \$13634 \$20515 \$20718
+ gf180mcu_fd_sc_mcu9t5v0__dffrnq_2
X$5840 \$18592 \$17663 \$17503 \$13634 \$17538 \$17703
+ gf180mcu_fd_sc_mcu9t5v0__dffrnq_2
X$5841 \$14187 \$15319 \$15320 \$13634 \$15321 \$15490
+ gf180mcu_fd_sc_mcu9t5v0__dffrnq_2
X$5842 \$16439 \$16071 \$15952 \$13634 \$15949 \$16070
+ gf180mcu_fd_sc_mcu9t5v0__dffrnq_2
X$5843 \$14187 \$15044 \$15149 \$13634 \$15045 \$15204
+ gf180mcu_fd_sc_mcu9t5v0__dffrnq_2
X$5844 \$16439 \$16442 \$16443 \$13634 \$16436 \$16728
+ gf180mcu_fd_sc_mcu9t5v0__dffrnq_2
X$5845 \$28350 \$30703 \$30687 \$13634 \$30696 \$30763
+ gf180mcu_fd_sc_mcu9t5v0__dffrnq_2
X$5846 \$28350 \$30414 \$30349 \$13634 \$30402 \$30485
+ gf180mcu_fd_sc_mcu9t5v0__dffrnq_2
X$5847 \$18592 \$18418 \$17966 \$13634 \$18403 \$18576
+ gf180mcu_fd_sc_mcu9t5v0__dffrnq_2
X$5848 \$18592 \$19611 \$15010 \$13634 \$19605 \$19774
+ gf180mcu_fd_sc_mcu9t5v0__dffrnq_2
X$5849 \$18592 \$18417 \$18027 \$13634 \$18403 \$18576
+ gf180mcu_fd_sc_mcu9t5v0__dffrnq_2
X$5850 \$31089 \$31090 \$31091 \$13634 \$31100 \$31175
+ gf180mcu_fd_sc_mcu9t5v0__dffrnq_2
X$5851 \$19026 \$18822 \$18871 \$13634 \$18701 \$18870
+ gf180mcu_fd_sc_mcu9t5v0__dffrnq_2
X$5852 \$19740 \$20219 \$20346 \$13634 \$20209 \$20383
+ gf180mcu_fd_sc_mcu9t5v0__dffrnq_2
X$5853 \$20845 \$20347 \$14458 \$13634 \$20209 \$20383
+ gf180mcu_fd_sc_mcu9t5v0__dffrnq_2
X$5854 \$18592 \$18143 \$18026 \$13634 \$18137 \$18293
+ gf180mcu_fd_sc_mcu9t5v0__dffrnq_2
X$5855 \$25805 \$27159 \$27031 \$13634 \$27315 \$27153
+ gf180mcu_fd_sc_mcu9t5v0__dffrnq_2
X$5856 \$16439 \$18255 \$18294 \$13634 \$18403 \$18293
+ gf180mcu_fd_sc_mcu9t5v0__dffrnq_2
X$5857 \$19775 \$18579 \$18406 \$13634 \$18701 \$18576
+ gf180mcu_fd_sc_mcu9t5v0__dffrnq_2
X$5858 \$19775 \$19153 \$19279 \$13634 \$19324 \$19149
+ gf180mcu_fd_sc_mcu9t5v0__dffrnq_2
X$5859 \$25805 \$27582 \$27324 \$13634 \$27637 \$27449
+ gf180mcu_fd_sc_mcu9t5v0__dffrnq_2
X$5860 \$27926 \$28093 \$28055 \$13634 \$28211 \$28089
+ gf180mcu_fd_sc_mcu9t5v0__dffrnq_2
X$5861 \$19775 \$20840 \$20580 \$13634 \$20881 \$20718
+ gf180mcu_fd_sc_mcu9t5v0__dffrnq_2
X$5862 \$15329 \$18409 \$18259 \$13634 \$18403 \$18293
+ gf180mcu_fd_sc_mcu9t5v0__dffrnq_2
X$5863 \$23323 \$22839 \$23030 \$13634 \$23027 \$22837
+ gf180mcu_fd_sc_mcu9t5v0__dffrnq_2
X$5864 \$28554 \$28348 \$27588 \$13634 \$28534 \$28381
+ gf180mcu_fd_sc_mcu9t5v0__dffrnq_2
X$5865 \$24742 \$23198 \$14220 \$13634 \$23183 \$23139
+ gf180mcu_fd_sc_mcu9t5v0__dffrnq_2
X$5866 \$20342 \$21365 \$21367 \$13634 \$21184 \$21011
+ gf180mcu_fd_sc_mcu9t5v0__dffrnq_2
X$5867 \$20342 \$21954 \$21810 \$13634 \$22074 \$21946
+ gf180mcu_fd_sc_mcu9t5v0__dffrnq_2
X$5868 \$20342 \$20389 \$20341 \$13634 \$20515 \$20383
+ gf180mcu_fd_sc_mcu9t5v0__dffrnq_2
X$5869 \$24742 \$25637 \$25638 \$13634 \$25797 \$25632
+ gf180mcu_fd_sc_mcu9t5v0__dffrnq_2
X$5870 \$19740 \$22082 \$14761 \$13634 \$22074 \$21946
+ gf180mcu_fd_sc_mcu9t5v0__dffrnq_2
X$5871 \$19740 \$21314 \$21315 \$13634 \$21498 \$21308
+ gf180mcu_fd_sc_mcu9t5v0__dffrnq_2
X$5872 \$28350 \$29857 \$29964 \$13634 \$29954 \$29847
+ gf180mcu_fd_sc_mcu9t5v0__dffrnq_2
X$5873 \$19740 \$21371 \$21313 \$13634 \$21498 \$21308
+ gf180mcu_fd_sc_mcu9t5v0__dffrnq_2
X$5874 \$24742 \$26228 \$22848 \$13634 \$26401 \$26220
+ gf180mcu_fd_sc_mcu9t5v0__dffrnq_2
X$5875 \$19740 \$21152 \$21153 \$13634 \$21184 \$21011
+ gf180mcu_fd_sc_mcu9t5v0__dffrnq_2
X$5876 \$19740 \$20399 \$20401 \$13634 \$20515 \$20383
+ gf180mcu_fd_sc_mcu9t5v0__dffrnq_2
X$5877 \$28350 \$29966 \$29967 \$13634 \$30054 \$30027
+ gf180mcu_fd_sc_mcu9t5v0__dffrnq_2
X$5878 \$28350 \$29097 \$27654 \$13634 \$29123 \$28971
+ gf180mcu_fd_sc_mcu9t5v0__dffrnq_2
X$5879 \$21369 \$21310 \$21151 \$13634 \$21498 \$21308
+ gf180mcu_fd_sc_mcu9t5v0__dffrnq_2
X$5880 \$21369 \$21956 \$21814 \$13634 \$22074 \$21946
+ gf180mcu_fd_sc_mcu9t5v0__dffrnq_2
X$5881 \$28554 \$29298 \$28940 \$13634 \$29290 \$29270
+ gf180mcu_fd_sc_mcu9t5v0__dffrnq_2
X$5882 \$28350 \$30491 \$30756 \$13634 \$30564 \$30485
+ gf180mcu_fd_sc_mcu9t5v0__dffrnq_2
X$5883 \$28350 \$29301 \$29274 \$13634 \$29290 \$29270
+ gf180mcu_fd_sc_mcu9t5v0__dffrnq_2
X$5884 \$28350 \$29302 \$28506 \$13634 \$29290 \$29270
+ gf180mcu_fd_sc_mcu9t5v0__dffrnq_2
X$5885 \$28350 \$29725 \$29707 \$13634 \$29780 \$29720
+ gf180mcu_fd_sc_mcu9t5v0__dffrnq_2
X$5886 \$28350 \$30413 \$30477 \$13634 \$30402 \$30339
+ gf180mcu_fd_sc_mcu9t5v0__dffrnq_2
X$5887 \$17658 \$18583 \$18874 \$13634 \$18701 \$18576
+ gf180mcu_fd_sc_mcu9t5v0__dffrnq_2
X$5888 \$17658 \$19471 \$19470 \$13634 \$19605 \$19466
+ gf180mcu_fd_sc_mcu9t5v0__dffrnq_2
X$5889 \$20342 \$19736 \$19886 \$13634 \$19927 \$19774
+ gf180mcu_fd_sc_mcu9t5v0__dffrnq_2
X$5890 \$18596 \$18880 \$18832 \$13634 \$19027 \$18870
+ gf180mcu_fd_sc_mcu9t5v0__dffrnq_2
X$5891 \$17658 \$18826 \$18997 \$13634 \$19027 \$18870
+ gf180mcu_fd_sc_mcu9t5v0__dffrnq_2
X$5892 \$17658 \$18298 \$18297 \$13634 \$18403 \$18293
+ gf180mcu_fd_sc_mcu9t5v0__dffrnq_2
X$5893 \$21369 \$21311 \$21370 \$13634 \$21498 \$21308
+ gf180mcu_fd_sc_mcu9t5v0__dffrnq_2
X$5894 \$19740 \$20218 \$19472 \$13634 \$20209 \$20087
+ gf180mcu_fd_sc_mcu9t5v0__dffrnq_2
X$5895 \$31089 \$31312 \$31261 \$13634 \$31376 \$31310
+ gf180mcu_fd_sc_mcu9t5v0__dffrnq_2
X$5896 \$23765 \$23811 \$23812 \$13634 \$23926 \$23807
+ gf180mcu_fd_sc_mcu9t5v0__dffrnq_2
X$5897 \$23765 \$23148 \$23149 \$13634 \$23183 \$23139
+ gf180mcu_fd_sc_mcu9t5v0__dffrnq_2
X$5898 \$24301 \$24733 \$24734 \$13634 \$24877 \$24721
+ gf180mcu_fd_sc_mcu9t5v0__dffrnq_2
X$5899 \$25805 \$25925 \$25926 \$13634 \$26088 \$25918
+ gf180mcu_fd_sc_mcu9t5v0__dffrnq_2
X$5900 \$23765 \$23197 \$18998 \$13634 \$23183 \$23139
+ gf180mcu_fd_sc_mcu9t5v0__dffrnq_2
X$5901 \$21369 \$22453 \$22455 \$13634 \$22713 \$22440
+ gf180mcu_fd_sc_mcu9t5v0__dffrnq_2
X$5902 \$23765 \$24118 \$22903 \$13634 \$24231 \$24109
+ gf180mcu_fd_sc_mcu9t5v0__dffrnq_2
X$5903 \$21369 \$22900 \$22844 \$13634 \$23027 \$22837
+ gf180mcu_fd_sc_mcu9t5v0__dffrnq_2
X$5904 \$23765 \$23810 \$23931 \$13634 \$23926 \$23807
+ gf180mcu_fd_sc_mcu9t5v0__dffrnq_2
X$5905 \$25805 \$25764 \$25600 \$13634 \$25797 \$25632
+ gf180mcu_fd_sc_mcu9t5v0__dffrnq_2
X$5906 \$25805 \$26226 \$26227 \$13634 \$26401 \$26220
+ gf180mcu_fd_sc_mcu9t5v0__dffrnq_2
X$5907 \$25805 \$25807 \$25602 \$13634 \$25797 \$25632
+ gf180mcu_fd_sc_mcu9t5v0__dffrnq_2
X$5908 \$25805 \$25636 \$25314 \$13634 \$25797 \$25632
+ gf180mcu_fd_sc_mcu9t5v0__dffrnq_2
X$5909 \$15629 \$18025 \$18023 \$13634 \$18137 \$17952
+ gf180mcu_fd_sc_mcu9t5v0__dffrnq_2
X$5910 \$23765 \$24308 \$24309 \$13634 \$24593 \$24428
+ gf180mcu_fd_sc_mcu9t5v0__dffrnq_2
X$5911 \$24301 \$25972 \$25973 \$13634 \$26088 \$25918
+ gf180mcu_fd_sc_mcu9t5v0__dffrnq_2
X$5912 \$18592 \$18265 \$18591 \$13634 \$18701 \$18576
+ gf180mcu_fd_sc_mcu9t5v0__dffrnq_2
X$5913 \$25805 \$25974 \$25601 \$13634 \$26088 \$25918
+ gf180mcu_fd_sc_mcu9t5v0__dffrnq_2
X$5914 \$23765 \$24540 \$24601 \$13634 \$24593 \$24428
+ gf180mcu_fd_sc_mcu9t5v0__dffrnq_2
X$5915 \$21369 \$22393 \$22394 \$13634 \$22387 \$22272
+ gf180mcu_fd_sc_mcu9t5v0__dffrnq_2
X$5916 \$24301 \$24243 \$24060 \$13634 \$24231 \$24109
+ gf180mcu_fd_sc_mcu9t5v0__dffrnq_2
X$5917 \$20342 \$22584 \$22449 \$13634 \$22713 \$22440
+ gf180mcu_fd_sc_mcu9t5v0__dffrnq_2
X$5918 \$24301 \$24731 \$24732 \$13634 \$24877 \$24721
+ gf180mcu_fd_sc_mcu9t5v0__dffrnq_2
X$5919 \$24301 \$25463 \$25311 \$13634 \$25462 \$25347
+ gf180mcu_fd_sc_mcu9t5v0__dffrnq_2
X$5920 \$24301 \$24729 \$24730 \$13634 \$24877 \$24721
+ gf180mcu_fd_sc_mcu9t5v0__dffrnq_2
X$5921 \$14150 \$14753 \$14754 \$13634 \$14748 \$14635
+ gf180mcu_fd_sc_mcu9t5v0__dffrnq_2
X$5922 \$14150 \$15325 \$15363 \$13634 \$15321 \$15204
+ gf180mcu_fd_sc_mcu9t5v0__dffrnq_2
X$5923 \$15329 \$15330 \$14993 \$13634 \$15321 \$15204
+ gf180mcu_fd_sc_mcu9t5v0__dffrnq_2
X$5924 \$24742 \$26530 \$26531 \$13634 \$26675 \$26521
+ gf180mcu_fd_sc_mcu9t5v0__dffrnq_2
X$5925 \$15016 \$15335 \$15013 \$13634 \$15321 \$15204
+ gf180mcu_fd_sc_mcu9t5v0__dffrnq_2
X$5926 \$15329 \$17095 \$17371 \$13634 \$17538 \$17367
+ gf180mcu_fd_sc_mcu9t5v0__dffrnq_2
X$5927 \$24742 \$23465 \$16458 \$13634 \$23620 \$23454
+ gf180mcu_fd_sc_mcu9t5v0__dffrnq_2
X$5928 \$14150 \$14755 \$14502 \$13634 \$14748 \$14635
+ gf180mcu_fd_sc_mcu9t5v0__dffrnq_2
X$5929 \$18592 \$19000 \$18145 \$13634 \$19027 \$18870
+ gf180mcu_fd_sc_mcu9t5v0__dffrnq_2
X$5930 \$15329 \$16453 \$16597 \$13634 \$16436 \$16376
+ gf180mcu_fd_sc_mcu9t5v0__dffrnq_2
X$5931 \$15629 \$16136 \$15755 \$13634 \$16269 \$16070
+ gf180mcu_fd_sc_mcu9t5v0__dffrnq_2
X$5932 \$17658 \$18022 \$18299 \$13634 \$18137 \$17952
+ gf180mcu_fd_sc_mcu9t5v0__dffrnq_2
X$5933 \$15629 \$16863 \$16864 \$13634 \$16914 \$16728
+ gf180mcu_fd_sc_mcu9t5v0__dffrnq_2
X$5934 \$15629 \$15504 \$15154 \$13634 \$15628 \$15490
+ gf180mcu_fd_sc_mcu9t5v0__dffrnq_2
X$5935 \$15629 \$15001 \$15160 \$13634 \$15045 \$14875
+ gf180mcu_fd_sc_mcu9t5v0__dffrnq_2
X$5936 \$24742 \$25639 \$22083 \$13634 \$25797 \$25632
+ gf180mcu_fd_sc_mcu9t5v0__dffrnq_2
X$5937 \$15329 \$16852 \$16854 \$13634 \$16914 \$16728
+ gf180mcu_fd_sc_mcu9t5v0__dffrnq_2
X$5938 \$15329 \$15813 \$15494 \$13634 \$15949 \$15749
+ gf180mcu_fd_sc_mcu9t5v0__dffrnq_2
X$5939 \$15629 \$15332 \$14760 \$13634 \$15321 \$15204
+ gf180mcu_fd_sc_mcu9t5v0__dffrnq_2
X$5940 \$14150 \$14192 \$14193 \$13634 \$14151 \$14034
+ gf180mcu_fd_sc_mcu9t5v0__dffrnq_2
X$5941 \$18596 \$18597 \$14007 \$13634 \$18701 \$18576
+ gf180mcu_fd_sc_mcu9t5v0__dffrnq_2
X$5942 \$18596 \$18881 \$18835 \$13634 \$19027 \$18870
+ gf180mcu_fd_sc_mcu9t5v0__dffrnq_2
X$5943 \$18596 \$19479 \$19749 \$13634 \$19605 \$19466
+ gf180mcu_fd_sc_mcu9t5v0__dffrnq_2
X$5944 \$18592 \$19162 \$16148 \$13634 \$19324 \$19149
+ gf180mcu_fd_sc_mcu9t5v0__dffrnq_2
X$5945 \$14462 \$15213 \$15053 \$13634 \$15321 \$15204
+ gf180mcu_fd_sc_mcu9t5v0__dffrnq_2
X$5946 \$14150 \$14494 \$14495 \$13634 \$14748 \$14635
+ gf180mcu_fd_sc_mcu9t5v0__dffrnq_2
X$5947 \$14187 \$14632 \$14487 \$13634 \$14748 \$14635
+ gf180mcu_fd_sc_mcu9t5v0__dffrnq_2
X$5948 \$14150 \$15202 \$15150 \$13634 \$15321 \$15204
+ gf180mcu_fd_sc_mcu9t5v0__dffrnq_2
X$5949 \$14462 \$15759 \$15761 \$13634 \$15949 \$15749
+ gf180mcu_fd_sc_mcu9t5v0__dffrnq_2
X$5950 \$14187 \$14489 \$14491 \$13634 \$14748 \$14635
+ gf180mcu_fd_sc_mcu9t5v0__dffrnq_2
X$5951 \$14150 \$14153 \$14035 \$13634 \$14151 \$14034
+ gf180mcu_fd_sc_mcu9t5v0__dffrnq_2
X$5952 \$14150 \$14033 \$14152 \$13634 \$14151 \$14034
+ gf180mcu_fd_sc_mcu9t5v0__dffrnq_2
X$5953 \$14150 \$14195 \$14196 \$13634 \$14454 \$14337
+ gf180mcu_fd_sc_mcu9t5v0__dffrnq_2
X$5954 \$15016 \$16466 \$16464 \$13634 \$16436 \$16376
+ gf180mcu_fd_sc_mcu9t5v0__dffrnq_2
X$5955 \$14150 \$14751 \$14752 \$13634 \$14748 \$14635
+ gf180mcu_fd_sc_mcu9t5v0__dffrnq_2
X$5956 \$14010 \$18032 \$15756 \$13634 \$18137 \$17952
+ gf180mcu_fd_sc_mcu9t5v0__dffrnq_2
X$5957 \$20845 \$20726 \$20587 \$13634 \$20881 \$20718
+ gf180mcu_fd_sc_mcu9t5v0__dffrnq_2
X$5958 \$20845 \$20723 \$20725 \$13634 \$20881 \$20718
+ gf180mcu_fd_sc_mcu9t5v0__dffrnq_2
X$5959 \$15016 \$16152 \$16271 \$13634 \$16269 \$16070
+ gf180mcu_fd_sc_mcu9t5v0__dffrnq_2
X$5960 \$15016 \$16869 \$16924 \$13634 \$16914 \$16728
+ gf180mcu_fd_sc_mcu9t5v0__dffrnq_2
X$5961 \$15016 \$15508 \$15507 \$13634 \$15628 \$15490
+ gf180mcu_fd_sc_mcu9t5v0__dffrnq_2
X$5962 \$25805 \$26649 \$26650 \$13634 \$26675 \$26521
+ gf180mcu_fd_sc_mcu9t5v0__dffrnq_2
X$5963 \$19775 \$18872 \$18823 \$13634 \$19027 \$18870
+ gf180mcu_fd_sc_mcu9t5v0__dffrnq_2
X$5964 \$19740 \$19474 \$14512 \$13634 \$19605 \$19466
+ gf180mcu_fd_sc_mcu9t5v0__dffrnq_2
X$5965 \$14010 \$15017 \$15215 \$13634 \$15045 \$14875
+ gf180mcu_fd_sc_mcu9t5v0__dffrnq_2
X$5966 \$15016 \$14888 \$14765 \$13634 \$15045 \$14875
+ gf180mcu_fd_sc_mcu9t5v0__dffrnq_2
X$5967 \$15329 \$15331 \$14995 \$13634 \$15321 \$15204
+ gf180mcu_fd_sc_mcu9t5v0__dffrnq_2
X$5968 \$15629 \$18414 \$18415 \$13634 \$18403 \$18293
+ gf180mcu_fd_sc_mcu9t5v0__dffrnq_2
X$5969 \$17658 \$19338 \$19158 \$13634 \$19324 \$19149
+ gf180mcu_fd_sc_mcu9t5v0__dffrnq_2
X$5970 \$19740 \$19159 \$18024 \$13634 \$19324 \$19149
+ gf180mcu_fd_sc_mcu9t5v0__dffrnq_2
X$5971 \$16439 \$17954 \$17369 \$13634 \$18137 \$17952
+ gf180mcu_fd_sc_mcu9t5v0__dffrnq_2
X$5972 \$16439 \$17494 \$17651 \$13634 \$17538 \$17367
+ gf180mcu_fd_sc_mcu9t5v0__dffrnq_2
X$5973 \$14150 \$15205 \$15151 \$13634 \$15321 \$15204
+ gf180mcu_fd_sc_mcu9t5v0__dffrnq_2
X$5974 \$24742 \$26866 \$26986 \$13634 \$27015 \$26856
+ gf180mcu_fd_sc_mcu9t5v0__dffrnq_2
X$5975 \$25805 \$27329 \$27286 \$13634 \$27637 \$27449
+ gf180mcu_fd_sc_mcu9t5v0__dffrnq_2
X$5976 \$27926 \$28503 \$28094 \$13634 \$28534 \$28381
+ gf180mcu_fd_sc_mcu9t5v0__dffrnq_2
X$5977 \$17658 \$19738 \$19891 \$13634 \$19927 \$19774
+ gf180mcu_fd_sc_mcu9t5v0__dffrnq_2
X$5978 \$24742 \$26656 \$25604 \$13634 \$26675 \$26521
+ gf180mcu_fd_sc_mcu9t5v0__dffrnq_2
X$5979 \$17658 \$18878 \$18877 \$13634 \$19027 \$18870
+ gf180mcu_fd_sc_mcu9t5v0__dffrnq_2
X$5980 \$19740 \$19894 \$19935 \$13634 \$19927 \$19774
+ gf180mcu_fd_sc_mcu9t5v0__dffrnq_2
X$5981 \$28554 \$29856 \$29926 \$13634 \$29954 \$29847
+ gf180mcu_fd_sc_mcu9t5v0__dffrnq_2
X$5982 \$13634 \$21009 \$21498 \$21308 \$21364 gf180mcu_fd_sc_mcu9t5v0__nand2_1
X$5983 \$15527 \$15645 \$15180 \$15628 \$15490 \$13637
+ gf180mcu_fd_sc_mcu9t5v0__oai21_1
X$5984 \$14182 \$14151 \$14034 \$13638 gf180mcu_fd_sc_mcu9t5v0__clkinv_1
X$5985 \$13900 \$13874 \$13902 \$14248 \$14151 \$14034 \$13639
+ gf180mcu_fd_sc_mcu9t5v0__oai22_1
X$5986 \$17488 \$15621 \$13724 \$17233 \$17538 \$17367 \$17359
+ gf180mcu_fd_sc_mcu9t5v0__oai22_1
X$5987 \$14241 \$13741 \$13900 \$15037 \$13881 \$13729
+ gf180mcu_fd_sc_mcu9t5v0__dffrnq_2
X$5988 \$13848 \$13733 \$13732 \$13881 \$13729 \$13889
+ gf180mcu_fd_sc_mcu9t5v0__nand3_1
X$5989 \$13734 \$13859 \$13738 \$13852 \$13881 \$13729 \$13847
+ gf180mcu_fd_sc_mcu9t5v0__aoi22_1
X$5990 \$13888 \$13847 \$13881 \$13729 \$13842 gf180mcu_fd_sc_mcu9t5v0__nand2_1
X$5991 \$13729 \$13881 gf180mcu_fd_sc_mcu9t5v0__filltie
X$5992 \$13729 \$13881 gf180mcu_fd_sc_mcu9t5v0__filltie
X$5993 \$13729 \$13881 gf180mcu_fd_sc_mcu9t5v0__filltie
X$5994 \$13729 \$13881 gf180mcu_fd_sc_mcu9t5v0__filltie
X$5995 \$13729 \$13881 gf180mcu_fd_sc_mcu9t5v0__filltie
X$5996 \$13729 \$13881 gf180mcu_fd_sc_mcu9t5v0__filltie
X$5997 \$14006 \$13870 \$13874 \$13881 \$13729 \$13901
+ gf180mcu_fd_sc_mcu9t5v0__mux2_1
X$5998 \$13729 \$13881 gf180mcu_fd_sc_mcu9t5v0__endcap
X$5999 \$15212 \$13852 \$13892 \$13731 \$15045 \$15204 \$15049
+ gf180mcu_fd_sc_mcu9t5v0__aoi22_1
X$6000 \$14216 \$15216 \$17244 \$13731 \$15045 \$15204 \$15156
+ gf180mcu_fd_sc_mcu9t5v0__aoi22_1
X$6001 \$13734 \$14762 \$14639 \$14748 \$14635 \$14343
+ gf180mcu_fd_sc_mcu9t5v0__aoi21_1
X$6002 \$18269 \$13734 \$18264 \$18027 \$18137 \$18293 \$17968
+ gf180mcu_fd_sc_mcu9t5v0__aoi22_1
X$6003 \$16149 \$13734 \$18264 \$18145 \$18137 \$17952 \$17958
+ gf180mcu_fd_sc_mcu9t5v0__aoi22_1
X$6004 \$17242 \$13734 \$17085 \$17367 \$17042 gf180mcu_fd_sc_mcu9t5v0__nand2_1
X$6005 \$18019 \$18137 \$17952 \$13734 gf180mcu_fd_sc_mcu9t5v0__buf_8
X$6006 \$17713 \$17818 \$17703 \$13737 gf180mcu_fd_sc_mcu9t5v0__buf_8
X$6007 \$14027 \$14140 \$14026 \$14477 \$14151 \$14034 \$13826
+ gf180mcu_fd_sc_mcu9t5v0__aoi22_1
X$6008 \$14028 \$14185 \$14151 \$14337 \$13828 gf180mcu_fd_sc_mcu9t5v0__nand2_1
X$6009 \$15811 \$13833 \$15949 \$15749 \$15954 gf180mcu_fd_sc_mcu9t5v0__nor2_1
X$6010 \$14201 \$13837 \$14156 \$14151 \$14337 \$14200
+ gf180mcu_fd_sc_mcu9t5v0__aoi21_1
X$6011 \$15494 \$15328 \$15321 \$15204 \$13837 gf180mcu_fd_sc_mcu9t5v0__nand2_1
X$6012 \$13893 \$14006 \$13862 \$13881 \$14034 \$13845
+ gf180mcu_fd_sc_mcu9t5v0__mux2_1
X$6013 \$14344 \$15050 \$14343 \$14342 \$14454 \$14337 \$13846
+ gf180mcu_fd_sc_mcu9t5v0__aoi22_1
X$6014 \$18026 \$13849 \$16919 \$20344 \$18140 \$24107 \$18403 \$18576 \$18262
+ gf180mcu_fd_sc_mcu9t5v0__aoi222_1
X$6015 \$14217 \$17049 \$13849 \$16734 \$16914 \$17034 \$16923
+ gf180mcu_fd_sc_mcu9t5v0__oai211_1
X$6016 \$15014 \$13849 \$13892 \$15013 \$15045 \$14875 \$14885
+ gf180mcu_fd_sc_mcu9t5v0__aoi22_1
X$6017 \$16080 \$13849 \$18140 \$17099 \$17043 \$17085 \$17034 \$17044
+ gf180mcu_fd_sc_mcu9t5v0__aoi221_1
X$6018 \$13887 \$14460 \$14215 \$13849 \$14214 \$14454 \$14337 \$14342
+ gf180mcu_fd_sc_mcu9t5v0__aoi221_1
X$6019 \$19286 \$19027 \$18870 \$13849 gf180mcu_fd_sc_mcu9t5v0__buf_8
X$6020 \$14521 \$15636 \$13852 \$15628 \$15749 \$15763
+ gf180mcu_fd_sc_mcu9t5v0__oai21_1
X$6021 \$13852 \$16455 \$16598 \$14203 \$16736 \$16436 \$16728 \$14881
+ gf180mcu_fd_sc_mcu9t5v0__aoi221_1
X$6022 \$19033 \$19027 \$19149 \$13852 gf180mcu_fd_sc_mcu9t5v0__buf_8
X$6023 \$13858 \$13896 \$13881 \$14034 \$14008 gf180mcu_fd_sc_mcu9t5v0__nand2_1
X$6024 \$13860 \$13862 \$16140 \$18137 \$17952 \$18029
+ gf180mcu_fd_sc_mcu9t5v0__aoi21_1
X$6025 \$13860 \$14514 \$13862 \$14748 \$14875 \$14889
+ gf180mcu_fd_sc_mcu9t5v0__mux2_1
X$6026 \$13860 \$17720 \$13874 \$17818 \$17703 \$17978
+ gf180mcu_fd_sc_mcu9t5v0__mux2_1
X$6027 \$13861 \$13862 \$16140 \$18137 \$18293 \$18266
+ gf180mcu_fd_sc_mcu9t5v0__aoi21_1
X$6028 \$13861 \$14513 \$13862 \$18137 \$18293 \$18268
+ gf180mcu_fd_sc_mcu9t5v0__mux2_1
X$6029 \$13861 \$17122 \$13874 \$17085 \$17034 \$17057
+ gf180mcu_fd_sc_mcu9t5v0__mux2_1
X$6030 \$14763 \$13862 \$16140 \$15045 \$15204 \$15157
+ gf180mcu_fd_sc_mcu9t5v0__aoi21_1
X$6031 \$16148 \$13862 \$16140 \$18403 \$18576 \$18543
+ gf180mcu_fd_sc_mcu9t5v0__aoi21_1
X$6032 \$15005 \$13862 \$15163 \$15045 \$15204 \$15161
+ gf180mcu_fd_sc_mcu9t5v0__aoi21_1
X$6033 \$15007 \$13862 \$15163 \$16914 \$17034 \$16861
+ gf180mcu_fd_sc_mcu9t5v0__aoi21_1
X$6034 \$13865 \$13862 \$15502 \$16269 \$16376 \$16389
+ gf180mcu_fd_sc_mcu9t5v0__aoi21_1
X$6035 \$14640 \$13862 \$16140 \$17538 \$17703 \$17499
+ gf180mcu_fd_sc_mcu9t5v0__aoi21_1
X$6036 \$13900 \$13862 \$15502 \$16269 \$16376 \$16386
+ gf180mcu_fd_sc_mcu9t5v0__aoi21_1
X$6037 \$13899 \$13862 \$15502 \$15321 \$15490 \$15372
+ gf180mcu_fd_sc_mcu9t5v0__aoi21_1
X$6038 \$15764 \$13862 \$15163 \$16269 \$16070 \$16151
+ gf180mcu_fd_sc_mcu9t5v0__aoi21_1
X$6039 \$14011 \$13862 \$15502 \$16436 \$16376 \$16469
+ gf180mcu_fd_sc_mcu9t5v0__aoi21_1
X$6040 \$15765 \$13862 \$15163 \$16914 \$16728 \$17117
+ gf180mcu_fd_sc_mcu9t5v0__aoi21_1
X$6041 \$15010 \$13862 \$16140 \$17818 \$17703 \$17662
+ gf180mcu_fd_sc_mcu9t5v0__aoi21_1
X$6042 \$14764 \$13862 \$15163 \$15321 \$15204 \$17385
+ gf180mcu_fd_sc_mcu9t5v0__aoi21_1
X$6043 \$13866 \$13862 \$15502 \$15628 \$15490 \$15500
+ gf180mcu_fd_sc_mcu9t5v0__aoi21_1
X$6044 \$13893 \$13862 \$15502 \$15949 \$15749 \$15820
+ gf180mcu_fd_sc_mcu9t5v0__aoi21_1
X$6045 \$15757 \$13862 \$15163 \$15949 \$15749 \$16144
+ gf180mcu_fd_sc_mcu9t5v0__aoi21_1
X$6046 \$14354 \$13862 \$15163 \$15628 \$15490 \$16150
+ gf180mcu_fd_sc_mcu9t5v0__aoi21_1
X$6047 \$15756 \$13862 \$16140 \$16269 \$16070 \$16139
+ gf180mcu_fd_sc_mcu9t5v0__aoi21_1
X$6048 \$28975 \$28810 \$28971 \$13862 gf180mcu_fd_sc_mcu9t5v0__buf_8
X$6049 \$13899 \$14009 \$13862 \$15949 \$16070 \$15962
+ gf180mcu_fd_sc_mcu9t5v0__mux2_1
X$6050 \$15010 \$19161 \$13862 \$19027 \$19149 \$19292
+ gf180mcu_fd_sc_mcu9t5v0__mux2_1
X$6051 \$15756 \$15000 \$13862 \$15628 \$15749 \$15370
+ gf180mcu_fd_sc_mcu9t5v0__mux2_1
X$6052 \$15757 \$15004 \$13862 \$15628 \$15749 \$15634
+ gf180mcu_fd_sc_mcu9t5v0__mux2_1
X$6053 \$14354 \$15167 \$13862 \$15045 \$15204 \$15168
+ gf180mcu_fd_sc_mcu9t5v0__mux2_1
X$6054 \$13900 \$14219 \$13862 \$16269 \$16376 \$18020
+ gf180mcu_fd_sc_mcu9t5v0__mux2_1
X$6055 \$15765 \$16392 \$13862 \$16269 \$16376 \$16393
+ gf180mcu_fd_sc_mcu9t5v0__mux2_1
X$6056 \$14011 \$15766 \$13862 \$15949 \$16070 \$16273
+ gf180mcu_fd_sc_mcu9t5v0__mux2_1
X$6057 \$14640 \$14512 \$13862 \$18701 \$18870 \$18829
+ gf180mcu_fd_sc_mcu9t5v0__mux2_1
X$6058 \$14514 \$19038 \$13862 \$19027 \$18870 \$19037
+ gf180mcu_fd_sc_mcu9t5v0__mux2_1
X$6059 \$13867 \$15832 \$13862 \$16914 \$16728 \$17055
+ gf180mcu_fd_sc_mcu9t5v0__mux2_1
X$6060 \$16148 \$18998 \$13862 \$19324 \$19149 \$19160
+ gf180mcu_fd_sc_mcu9t5v0__mux2_1
X$6061 \$14763 \$14761 \$13862 \$15321 \$15204 \$15209
+ gf180mcu_fd_sc_mcu9t5v0__mux2_1
X$6062 \$13866 \$14208 \$13862 \$15949 \$15749 \$15818
+ gf180mcu_fd_sc_mcu9t5v0__mux2_1
X$6063 \$15764 \$15821 \$13862 \$17085 \$17034 \$17383
+ gf180mcu_fd_sc_mcu9t5v0__mux2_1
X$6064 \$15007 \$15006 \$13862 \$17818 \$17703 \$17828
+ gf180mcu_fd_sc_mcu9t5v0__mux2_1
X$6065 \$14007 \$17115 \$13862 \$17085 \$17034 \$17116
+ gf180mcu_fd_sc_mcu9t5v0__mux2_1
X$6066 \$15167 \$17120 \$13862 \$17085 \$17034 \$17119
+ gf180mcu_fd_sc_mcu9t5v0__mux2_1
X$6067 \$13865 \$14043 \$13862 \$16436 \$16376 \$16460
+ gf180mcu_fd_sc_mcu9t5v0__mux2_1
X$6068 \$15005 \$14882 \$13862 \$15628 \$15490 \$15498
+ gf180mcu_fd_sc_mcu9t5v0__mux2_1
X$6069 \$14764 \$15011 \$13862 \$15045 \$14875 \$15052
+ gf180mcu_fd_sc_mcu9t5v0__mux2_1
X$6070 \$13867 \$16436 \$16728 \$16614 gf180mcu_fd_sc_mcu9t5v0__clkinv_1
X$6071 \$14012 \$14045 \$13881 \$14034 \$13868 gf180mcu_fd_sc_mcu9t5v0__nand2_1
X$6072 \$14014 \$14013 \$13881 \$14034 \$13869 gf180mcu_fd_sc_mcu9t5v0__nand2_1
X$6073 \$15024 \$20541 \$20605 \$20540 \$20515 \$20718 \$13870
+ gf180mcu_fd_sc_mcu9t5v0__oai31_1
X$6074 \$14174 \$14051 \$13881 \$14034 \$13871 gf180mcu_fd_sc_mcu9t5v0__xnor2_1
X$6075 \$13893 \$13874 \$14652 \$15528 \$15628 \$15490 \$15529
+ gf180mcu_fd_sc_mcu9t5v0__oai22_1
X$6076 \$15024 \$13904 \$14022 \$13874 \$13881 \$14034 \$14013
+ gf180mcu_fd_sc_mcu9t5v0__oai211_1
X$6077 \$15024 \$16274 \$16398 \$13874 \$16269 \$16376 \$16395
+ gf180mcu_fd_sc_mcu9t5v0__oai211_1
X$6078 \$15024 \$16276 \$16174 \$13874 \$16269 \$16070 \$16096
+ gf180mcu_fd_sc_mcu9t5v0__oai211_1
X$6079 \$13874 \$15024 \$13881 \$14034 \$13902 gf180mcu_fd_sc_mcu9t5v0__nand2_1
X$6080 \$28095 \$28211 \$28089 \$13874 gf180mcu_fd_sc_mcu9t5v0__buf_8
X$6081 \$15007 \$15178 \$13874 \$15045 \$15204 \$15221
+ gf180mcu_fd_sc_mcu9t5v0__mux2_1
X$6082 \$18998 \$23635 \$13874 \$23183 \$23454 \$23197
+ gf180mcu_fd_sc_mcu9t5v0__mux2_1
X$6083 \$15757 \$15519 \$13874 \$15321 \$15490 \$15518
+ gf180mcu_fd_sc_mcu9t5v0__mux2_1
X$6084 \$13897 \$14239 \$13874 \$14151 \$14337 \$14238
+ gf180mcu_fd_sc_mcu9t5v0__mux2_1
X$6085 \$15004 \$15771 \$13874 \$15628 \$15749 \$15770
+ gf180mcu_fd_sc_mcu9t5v0__mux2_1
X$6086 \$15756 \$17972 \$13874 \$17818 \$17952 \$18032
+ gf180mcu_fd_sc_mcu9t5v0__mux2_1
X$6087 \$15766 \$22155 \$13874 \$22074 \$22272 \$22154
+ gf180mcu_fd_sc_mcu9t5v0__mux2_1
X$6088 \$16148 \$19163 \$13874 \$19027 \$19149 \$19162
+ gf180mcu_fd_sc_mcu9t5v0__mux2_1
X$6089 \$14512 \$19475 \$13874 \$19324 \$19466 \$19474
+ gf180mcu_fd_sc_mcu9t5v0__mux2_1
X$6090 \$14514 \$19164 \$13874 \$19027 \$19149 \$18831
+ gf180mcu_fd_sc_mcu9t5v0__mux2_1
X$6091 \$14761 \$22139 \$13874 \$22074 \$22272 \$22082
+ gf180mcu_fd_sc_mcu9t5v0__mux2_1
X$6092 \$14763 \$15511 \$13874 \$15045 \$15204 \$15336
+ gf180mcu_fd_sc_mcu9t5v0__mux2_1
X$6093 \$14220 \$23150 \$13874 \$23027 \$23139 \$23198
+ gf180mcu_fd_sc_mcu9t5v0__mux2_1
X$6094 \$16458 \$23815 \$13874 \$23183 \$23454 \$23465
+ gf180mcu_fd_sc_mcu9t5v0__mux2_1
X$6095 \$14640 \$17842 \$13874 \$18137 \$18293 \$18271
+ gf180mcu_fd_sc_mcu9t5v0__mux2_1
X$6096 \$15006 \$17844 \$13874 \$17538 \$17703 \$17721
+ gf180mcu_fd_sc_mcu9t5v0__mux2_1
X$6097 \$14043 \$16403 \$13874 \$16269 \$16376 \$16402
+ gf180mcu_fd_sc_mcu9t5v0__mux2_1
X$6098 \$15167 \$17063 \$13874 \$16914 \$17034 \$17062
+ gf180mcu_fd_sc_mcu9t5v0__mux2_1
X$6099 \$14764 \$14534 \$13874 \$14454 \$14635 \$14649
+ gf180mcu_fd_sc_mcu9t5v0__mux2_1
X$6100 \$14882 \$15390 \$13874 \$15321 \$15490 \$15338
+ gf180mcu_fd_sc_mcu9t5v0__mux2_1
X$6101 \$17120 \$18846 \$13874 \$17818 \$17952 \$17980
+ gf180mcu_fd_sc_mcu9t5v0__mux2_1
X$6102 \$15011 \$15391 \$13874 \$15321 \$15490 \$15339
+ gf180mcu_fd_sc_mcu9t5v0__mux2_1
X$6103 \$14009 \$18601 \$13874 \$18701 \$18576 \$18546
+ gf180mcu_fd_sc_mcu9t5v0__mux2_1
X$6104 \$14212 \$21675 \$13874 \$21661 \$21622 \$21818
+ gf180mcu_fd_sc_mcu9t5v0__mux2_1
X$6105 \$14513 \$20525 \$13874 \$20515 \$20383 \$20524
+ gf180mcu_fd_sc_mcu9t5v0__mux2_1
X$6106 \$15010 \$19612 \$13874 \$19605 \$19466 \$19611
+ gf180mcu_fd_sc_mcu9t5v0__mux2_1
X$6107 \$15000 \$22588 \$13874 \$22713 \$22440 \$22587
+ gf180mcu_fd_sc_mcu9t5v0__mux2_1
X$6108 \$14459 \$20722 \$13874 \$20881 \$20718 \$20888
+ gf180mcu_fd_sc_mcu9t5v0__mux2_1
X$6109 \$14354 \$14170 \$13874 \$14151 \$14034 \$14242
+ gf180mcu_fd_sc_mcu9t5v0__mux2_1
X$6110 \$15764 \$16167 \$13874 \$16269 \$16070 \$16097
+ gf180mcu_fd_sc_mcu9t5v0__mux2_1
X$6111 \$15765 \$16166 \$13874 \$16269 \$16070 \$16275
+ gf180mcu_fd_sc_mcu9t5v0__mux2_1
X$6112 \$15005 \$15220 \$13874 \$15321 \$15204 \$15176
+ gf180mcu_fd_sc_mcu9t5v0__mux2_1
X$6113 \$14231 \$14357 \$13874 \$14454 \$14337 \$14470
+ gf180mcu_fd_sc_mcu9t5v0__mux2_1
X$6114 \$13902 \$14021 \$13881 \$14034 \$13875 gf180mcu_fd_sc_mcu9t5v0__nor2_1
X$6115 \$14179 \$14020 \$14151 \$14034 \$13876 gf180mcu_fd_sc_mcu9t5v0__nand2_1
X$6116 \$14183 \$14023 \$13881 \$14034 \$13877 gf180mcu_fd_sc_mcu9t5v0__xnor2_1
X$6117 \$13997 \$14027 \$14479 \$13881 \$14034 \$14028
+ gf180mcu_fd_sc_mcu9t5v0__nand3_1
X$6118 \$14018 \$14017 \$13881 \$14034 \$14053 gf180mcu_fd_sc_mcu9t5v0__nor2_1
X$6119 \$14054 \$13903 \$13881 \$14034 \$14020 gf180mcu_fd_sc_mcu9t5v0__nor2_1
X$6120 \$14179 \$14020 \$13881 \$14034 \$14021 gf180mcu_fd_sc_mcu9t5v0__nor2_1
X$6121 \$14027 \$13994 \$13881 \$14034 \$14026 gf180mcu_fd_sc_mcu9t5v0__nor2_1
X$6122 \$13996 \$13995 \$13881 \$14034 \$13994 gf180mcu_fd_sc_mcu9t5v0__nor2_1
X$6123 \$14019 \$13881 \$14034 \$14018 gf180mcu_fd_sc_mcu9t5v0__clkinv_1
X$6124 \$14034 \$13881 gf180mcu_fd_sc_mcu9t5v0__filltie
X$6125 \$14034 \$13881 gf180mcu_fd_sc_mcu9t5v0__filltie
X$6126 \$14034 \$13881 gf180mcu_fd_sc_mcu9t5v0__filltie
X$6127 \$14034 \$13881 gf180mcu_fd_sc_mcu9t5v0__filltie
X$6128 \$14034 \$13881 gf180mcu_fd_sc_mcu9t5v0__filltie
X$6129 \$14034 \$13881 gf180mcu_fd_sc_mcu9t5v0__filltie
X$6130 \$14034 \$13881 gf180mcu_fd_sc_mcu9t5v0__endcap
X$6131 \$17708 \$14161 \$14748 \$14635 \$13883 gf180mcu_fd_sc_mcu9t5v0__nand2_1
X$6132 \$14206 \$14506 \$13885 \$14454 \$14635 \$14998
+ gf180mcu_fd_sc_mcu9t5v0__nand3_1
X$6133 \$13886 \$14510 \$14213 \$14521 \$14151 \$14337 \$14214
+ gf180mcu_fd_sc_mcu9t5v0__oai22_1
X$6134 \$14217 \$17246 \$13887 \$17052 \$17085 \$17034 \$17112
+ gf180mcu_fd_sc_mcu9t5v0__oai211_1
X$6135 \$18023 \$13892 \$13887 \$17502 \$17538 \$17703 \$16867
+ gf180mcu_fd_sc_mcu9t5v0__aoi22_1
X$6136 \$13887 \$16391 \$16463 \$13892 \$16269 \$16376 \$16390
+ gf180mcu_fd_sc_mcu9t5v0__aoi22_1
X$6137 \$13887 \$15012 \$14641 \$14521 \$14642 \$14748 \$14635 \$14517
+ gf180mcu_fd_sc_mcu9t5v0__aoi221_1
X$6138 \$18536 \$18403 \$18576 \$13887 gf180mcu_fd_sc_mcu9t5v0__buf_8
X$6139 \$14217 \$13889 \$14151 \$14337 \$14218 gf180mcu_fd_sc_mcu9t5v0__nand2_1
X$6140 \$14217 \$13891 \$14151 \$14337 \$14222 gf180mcu_fd_sc_mcu9t5v0__nand2_1
X$6141 \$18297 \$13892 \$18140 \$23806 \$18403 \$18576 \$18537
+ gf180mcu_fd_sc_mcu9t5v0__aoi22_1
X$6142 \$16450 \$13892 \$16919 \$17040 \$16914 \$17034 \$17041
+ gf180mcu_fd_sc_mcu9t5v0__aoi22_1
X$6143 \$19336 \$19324 \$19466 \$13892 gf180mcu_fd_sc_mcu9t5v0__buf_8
X$6144 \$15036 \$15646 \$13893 \$15037 \$15628 \$15490
+ gf180mcu_fd_sc_mcu9t5v0__dffrnq_2
X$6145 \$14217 \$13895 \$14454 \$14635 \$14518 gf180mcu_fd_sc_mcu9t5v0__nand2_1
X$6146 \$14643 \$15172 \$15170 \$13902 \$15171 \$15045 \$15204 \$15020
+ gf180mcu_fd_sc_mcu9t5v0__oai221_1
X$6147 \$13902 \$17059 \$16612 \$17060 \$16914 \$17034 \$16927
+ gf180mcu_fd_sc_mcu9t5v0__oai211_1
X$6148 \$13902 \$18598 \$17121 \$17386 \$17085 \$17034 \$17250
+ gf180mcu_fd_sc_mcu9t5v0__oai211_1
X$6149 \$13902 \$15849 \$15949 \$15749 \$15781 gf180mcu_fd_sc_mcu9t5v0__nor2_1
X$6150 \$15186 pad_dout[6] \$I20746 \$I20755 \$I20764 \$I20773 \$I20782
+ \$I20791 \$I20800 \$I20809 \$I20818 \$I20827 \$I20836 \$I20845 \$I20854
+ \$I20863 \$I20872 \$I20881 \$I20890 \$I20899 \$I20908 \$I20917 \$I20926
+ \$I20935 \$I20944 \$I20953 \$I20962 \$I20971 \$I20980 \$I20989 \$I20998
+ \$I21007 \$I21016 \$I21025 \$I21034 \$I21043 \$I21052 \$I21061 \$I21070
+ \$I21079 \$I21088 \$I21097 \$I21106 \$I21115 \$I21124 \$I21133 \$I21142
+ \$I21151 \$I21160 \$I21169 \$I21178 \$I21187 \$I21196 \$I21205 \$I21214
+ \$I21223 \$I21232 \$I21241 \$I21250 \$I21259 \$I21268 \$I21277 \$I21286
+ \$I21295 \$I21304 \$I21313 \$13906 \$I21322 \$I21331 \$I21340 \$I21349
+ \$I21358 \$I21367 \$I21376 \$I21385 \$I21394 \$I21403 \$I21412 \$I21421
+ \$I21430 \$I21439 \$I21448 \$I21457 \$I21466 \$I21475 \$I21484 \$I21493
+ \$I21502 \$I21511 \$I21520 \$I21529 \$I21538 \$I21547 \$I21556 \$I21565
+ \$I21574 \$I21583 \$I21592 \$I21601 \$13905 \$I21610 \$I21619 \$I21628
+ \$I21637 \$I21646 \$I21655 \$I21664 \$I21673 \$13905 \$13905 \$13906 \$13905
+ \$13905 \$15625 \$13906 gf180mcu_fd_io__bi_t
X$6151 \$15628 \$15749 \$13905 gf180mcu_fd_sc_mcu9t5v0__tiel
X$6152 \$15628 \$15749 \$13906 gf180mcu_fd_sc_mcu9t5v0__tieh
X$6153 \$13997 \$13996 \$14151 \$14034 \$14141 gf180mcu_fd_sc_mcu9t5v0__and2_1
X$6154 \$14001 \$21184 \$21011 \$14492 gf180mcu_fd_sc_mcu9t5v0__clkbuf_1
X$6155 \$14188 \$14001 \$24531 \$24231 \$24109 \$24112
+ gf180mcu_fd_sc_mcu9t5v0__nor3_1
X$6156 \$14188 \$24531 \$14001 \$24231 \$24109 \$24236
+ gf180mcu_fd_sc_mcu9t5v0__oai21_1
X$6157 \$20083 \$14001 \$23926 \$24109 \$23930 gf180mcu_fd_sc_mcu9t5v0__nand2_1
X$6158 \$15789 \$15949 \$16070 \$14001 gf180mcu_fd_sc_mcu9t5v0__buf_1
X$6159 \$14001 \$15318 \$14143 \$15321 \$15204 \$15317
+ gf180mcu_fd_sc_mcu9t5v0__mux2_1
X$6160 \$14217 \$14008 \$18701 \$18870 \$18879 gf180mcu_fd_sc_mcu9t5v0__nand2_1
X$6161 \$14010 \$16436 \$16376 gf180mcu_fd_sc_mcu9t5v0__inv_4
X$6162 \$14011 \$16436 \$16728 \$16618 gf180mcu_fd_sc_mcu9t5v0__clkinv_1
X$6163 \$25022 \$24267 \$14017 \$15037 \$24231 \$24428
+ gf180mcu_fd_sc_mcu9t5v0__dffrnq_2
X$6164 \$14018 \$14017 \$14151 \$14337 \$14178 gf180mcu_fd_sc_mcu9t5v0__nand2_1
X$6165 \$25025 \$14017 \$15223 \$24231 \$24109 \$24267
+ gf180mcu_fd_sc_mcu9t5v0__mux2_1
X$6166 \$14019 \$14776 \$14748 \$14635 \$14534 \$14538
+ gf180mcu_fd_sc_mcu9t5v0__xnor3_1
X$6167 \$19300 \$19354 \$14019 \$15037 \$19324 \$19466
+ gf180mcu_fd_sc_mcu9t5v0__dffrnq_2
X$6168 \$14019 \$14538 \$14454 \$14635 \$14896 gf180mcu_fd_sc_mcu9t5v0__nor2_1
X$6169 \$14019 \$14538 \$14748 \$14875 \$14775 gf180mcu_fd_sc_mcu9t5v0__nand2_1
X$6170 \$19911 \$14019 \$15223 \$19324 \$19149 \$19354
+ gf180mcu_fd_sc_mcu9t5v0__mux2_1
X$6171 \$15024 \$14181 \$14151 \$14034 \$14022 gf180mcu_fd_sc_mcu9t5v0__nand2_1
X$6172 \$14360 \$14472 \$14748 \$14635 \$14023 \$14657
+ gf180mcu_fd_sc_mcu9t5v0__xnor3_1
X$6173 \$14027 \$15194 \$15321 \$15204 \$15193 gf180mcu_fd_sc_mcu9t5v0__or2_1
X$6174 \$15311 \$15191 \$14027 \$15321 \$15204 \$15188
+ gf180mcu_fd_sc_mcu9t5v0__aoi21_1
X$6175 \$14984 \$14983 \$14027 \$15045 \$14875 \$14868
+ gf180mcu_fd_sc_mcu9t5v0__aoi21_1
X$6176 \$14027 \$14480 \$14478 \$14477 \$14454 \$14635 \$14445
+ gf180mcu_fd_sc_mcu9t5v0__aoi22_1
X$6177 \$14027 \$14869 \$14868 \$14477 \$14748 \$14875 \$14867
+ gf180mcu_fd_sc_mcu9t5v0__aoi22_1
X$6178 \$14027 \$15189 \$15188 \$14477 \$15321 \$15204 \$15310
+ gf180mcu_fd_sc_mcu9t5v0__aoi22_1
X$6179 \$17944 \$17818 \$17952 \$14027 gf180mcu_fd_sc_mcu9t5v0__buf_8
X$6180 \$17705 \$14030 \$17818 \$17703 \$17819 gf180mcu_fd_sc_mcu9t5v0__nor2_1
X$6181 \$17088 \$14032 \$17085 \$17034 \$17089 gf180mcu_fd_sc_mcu9t5v0__nor2_1
X$6182 \$15343 \$14474 \$14151 \$14034 \$14181 \$14183
+ gf180mcu_fd_sc_mcu9t5v0__xnor3_1
X$6183 \$14166 \$14235 \$14047 \$14151 \$14034 \$14046
+ gf180mcu_fd_sc_mcu9t5v0__oai21_1
X$6184 \$14177 \$14053 \$14178 \$14151 \$14034 \$14050
+ gf180mcu_fd_sc_mcu9t5v0__oai21_1
X$6185 \$14054 \$14179 \$14180 \$14151 \$14034 \$14052
+ gf180mcu_fd_sc_mcu9t5v0__oai21_1
X$6186 \$14175 \$14052 \$14176 \$14151 \$14034 \$14051
+ gf180mcu_fd_sc_mcu9t5v0__oai21_1
X$6187 \$14049 \$14243 \$14151 \$14034 \$14171 gf180mcu_fd_sc_mcu9t5v0__nor2_1
X$6188 \$14034 \$14151 gf180mcu_fd_sc_mcu9t5v0__filltie
X$6189 \$14034 \$14151 gf180mcu_fd_sc_mcu9t5v0__filltie
X$6190 \$14034 \$14151 gf180mcu_fd_sc_mcu9t5v0__filltie
X$6191 \$14034 \$14151 gf180mcu_fd_sc_mcu9t5v0__filltie
X$6192 \$14034 \$14151 gf180mcu_fd_sc_mcu9t5v0__filltie
X$6193 \$14034 \$14151 gf180mcu_fd_sc_mcu9t5v0__filltie
X$6194 \$14144 \$14142 \$14143 \$14151 \$14034 \$14186
+ gf180mcu_fd_sc_mcu9t5v0__mux2_1
X$6195 \$15806 \$14147 \$14143 \$14151 \$14034 \$14146
+ gf180mcu_fd_sc_mcu9t5v0__mux2_1
X$6196 \$14034 \$14151 gf180mcu_fd_sc_mcu9t5v0__endcap
X$6197 \$14037 \$14748 \$14635 \$14636 gf180mcu_fd_sc_mcu9t5v0__buf_8
X$6198 \$17093 \$14039 \$15752 \$17091 \$17085 \$17034 \$17094
+ gf180mcu_fd_sc_mcu9t5v0__oai31_1
X$6199 \$14039 \$15752 \$16914 \$17034 \$17090 gf180mcu_fd_sc_mcu9t5v0__nor2_1
X$6200 \$14044 \$20209 \$20087 \$20221 gf180mcu_fd_sc_mcu9t5v0__clkinv_1
X$6201 \$14527 \$14647 \$14528 \$14454 \$14635 \$14045
+ gf180mcu_fd_sc_mcu9t5v0__oai21_1
X$6202 \$14049 \$14655 \$14454 \$14635 \$14654 \$14170
+ gf180mcu_fd_sc_mcu9t5v0__xor3_1
X$6203 \$20065 \$21967 \$14049 \$15037 \$22074 \$21946
+ gf180mcu_fd_sc_mcu9t5v0__dffrnq_2
X$6204 \$14049 \$14654 \$14748 \$14635 \$14653 gf180mcu_fd_sc_mcu9t5v0__and2_1
X$6205 \$14049 \$14654 \$14748 \$14875 \$14773 gf180mcu_fd_sc_mcu9t5v0__or2_1
X$6206 \$14049 \$14243 \$14151 \$14337 \$14244 gf180mcu_fd_sc_mcu9t5v0__nand2_1
X$6207 \$21838 \$14049 \$15223 \$21661 \$21946 \$21967
+ gf180mcu_fd_sc_mcu9t5v0__mux2_1
X$6208 \$14171 \$14050 \$14244 \$14151 \$14337 \$14173
+ gf180mcu_fd_sc_mcu9t5v0__oai21_1
X$6209 \$15395 \$17688 \$14055 \$15037 \$17538 \$17367
+ gf180mcu_fd_sc_mcu9t5v0__dffrnq_2
X$6210 \$14360 \$14055 \$14454 \$14337 \$14475 gf180mcu_fd_sc_mcu9t5v0__nor2_1
X$6211 \$14055 \$15223 \$17085 \$17367 \$17396 gf180mcu_fd_sc_mcu9t5v0__nand2_1
X$6212 \$14360 \$14055 \$14151 \$14337 \$14247 gf180mcu_fd_sc_mcu9t5v0__nand2_1
X$6213 \$14055 \$14151 \$14337 \$14183 gf180mcu_fd_sc_mcu9t5v0__clkinv_1
X$6214 \$14055 \$15344 \$14536 \$15321 \$15204 \$15222
+ gf180mcu_fd_sc_mcu9t5v0__mux2_1
X$6215 \$14483 \$14141 \$14454 \$14635 \$15194 gf180mcu_fd_sc_mcu9t5v0__and2_1
X$6216 \$14483 \$14141 \$14454 \$14635 \$14628 gf180mcu_fd_sc_mcu9t5v0__nor2_1
X$6217 \$14483 \$14141 \$14482 \$14454 \$14635 \$14477
+ gf180mcu_fd_sc_mcu9t5v0__nand3_1
X$6218 \$14141 \$14448 \$14454 \$14337 \$14334 gf180mcu_fd_sc_mcu9t5v0__nand2_1
X$6219 \$18864 \$19023 \$14143 \$19027 \$18870 \$18812
+ gf180mcu_fd_sc_mcu9t5v0__oai21_1
X$6220 \$18866 \$19023 \$19027 \$19149 \$14143 gf180mcu_fd_sc_mcu9t5v0__nand2_1
X$6221 \$14449 \$14631 \$14143 \$14454 \$14635 \$14630
+ gf180mcu_fd_sc_mcu9t5v0__mux2_1
X$6222 \$15195 \$16430 \$14143 \$16436 \$16376 \$16371
+ gf180mcu_fd_sc_mcu9t5v0__mux2_1
X$6223 \$14188 \$14191 \$14143 \$14454 \$14337 \$14190
+ gf180mcu_fd_sc_mcu9t5v0__mux2_1
X$6224 \$14870 \$14988 \$14143 \$15045 \$14875 \$14873
+ gf180mcu_fd_sc_mcu9t5v0__mux2_1
X$6225 \$14144 \$14870 \$19597 \$20881 \$20718 \$21006
+ gf180mcu_fd_sc_mcu9t5v0__nand3_1
X$6226 \$14144 \$20041 \$20515 \$20718 \$20565 gf180mcu_fd_sc_mcu9t5v0__nor2_1
X$6227 \$14144 \$20042 \$20881 \$21011 \$20512 gf180mcu_fd_sc_mcu9t5v0__nand2_1
X$6228 \$20083 \$14144 \$21498 \$21308 \$21359 gf180mcu_fd_sc_mcu9t5v0__nand2_1
X$6229 \$18578 \$14149 \$18701 \$18576 \$18577 gf180mcu_fd_sc_mcu9t5v0__nor2_1
X$6230 \$14476 \$14249 \$14151 \$14337 \$14248 gf180mcu_fd_sc_mcu9t5v0__xnor2_1
X$6231 \$14226 \$14225 \$14223 \$14151 \$14337 \$14224
+ gf180mcu_fd_sc_mcu9t5v0__nand3_1
X$6232 \$14245 \$14151 \$14337 \$14243 gf180mcu_fd_sc_mcu9t5v0__clkinv_1
X$6233 \$14237 \$14236 \$14151 \$14337 \$14235 gf180mcu_fd_sc_mcu9t5v0__nand2_1
X$6234 \$14337 \$14151 gf180mcu_fd_sc_mcu9t5v0__filltie
X$6235 \$14337 \$14151 gf180mcu_fd_sc_mcu9t5v0__filltie
X$6236 \$14337 \$14151 gf180mcu_fd_sc_mcu9t5v0__filltie
X$6237 \$14337 \$14151 gf180mcu_fd_sc_mcu9t5v0__filltie
X$6238 \$14337 \$14151 gf180mcu_fd_sc_mcu9t5v0__filltie
X$6239 \$14337 \$14151 gf180mcu_fd_sc_mcu9t5v0__filltie
X$6240 \$14337 \$14151 gf180mcu_fd_sc_mcu9t5v0__endcap
X$6241 \$14201 \$15956 \$15949 \$16070 \$14156 gf180mcu_fd_sc_mcu9t5v0__nor2_1
X$6242 \$16854 \$14156 \$16436 \$16728 \$14876 gf180mcu_fd_sc_mcu9t5v0__nor2_1
X$6243 \$16464 \$14160 \$14217 \$16436 \$16376 \$16391
+ gf180mcu_fd_sc_mcu9t5v0__mux2_1
X$6244 \$14993 \$14992 \$14995 \$15045 \$14875 \$14161
+ gf180mcu_fd_sc_mcu9t5v0__nor3_1
X$6245 \$14878 \$14162 \$14879 \$14880 \$14748 \$14875 \$14639
+ gf180mcu_fd_sc_mcu9t5v0__oai211_1
X$6246 \$15053 \$14163 \$14217 \$15045 \$14875 \$15012
+ gf180mcu_fd_sc_mcu9t5v0__mux2_1
X$6247 \$14164 \$14347 \$14454 \$14337 \$14642 gf180mcu_fd_sc_mcu9t5v0__nand2_1
X$6248 \$14643 \$14530 \$14356 \$14165 \$14454 \$14337 \$14234
+ gf180mcu_fd_sc_mcu9t5v0__oai31_1
X$6249 \$14533 \$14356 \$14532 \$14454 \$14635 \$14166
+ gf180mcu_fd_sc_mcu9t5v0__nor3_1
X$6250 \$22920 \$22919 \$23027 \$22837 \$14168 gf180mcu_fd_sc_mcu9t5v0__xnor2_1
X$6251 \$25022 \$24863 \$14172 \$15037 \$24877 \$24721
+ gf180mcu_fd_sc_mcu9t5v0__dffrnq_2
X$6252 \$25360 \$14172 \$15223 \$24877 \$24997 \$24863
+ gf180mcu_fd_sc_mcu9t5v0__mux2_1
X$6253 \$15027 \$15321 \$15204 \$15183 \$14174 gf180mcu_fd_sc_mcu9t5v0__xor2_1
X$6254 \$14358 \$14539 \$14471 \$14454 \$14337 \$14177
+ gf180mcu_fd_sc_mcu9t5v0__oai21_1
X$6255 \$15778 \$15393 \$15321 \$15490 \$14182 gf180mcu_fd_sc_mcu9t5v0__and2_1
X$6256 \$14447 \$14984 \$14454 \$14635 \$14184 gf180mcu_fd_sc_mcu9t5v0__nor2_1
X$6257 \$14187 \$15628 \$15749 gf180mcu_fd_sc_mcu9t5v0__clkbuf_4
X$6258 \$14188 \$21498 \$21308 \$18291 gf180mcu_fd_sc_mcu9t5v0__clkbuf_1
X$6259 \$14188 \$24531 \$20083 \$24593 \$24428 \$24535
+ gf180mcu_fd_sc_mcu9t5v0__aoi21_1
X$6260 \$14188 \$24531 \$24535 \$24593 \$24428 \$24597
+ gf180mcu_fd_sc_mcu9t5v0__oai21_1
X$6261 \$20083 \$14188 \$24593 \$24428 \$24300 gf180mcu_fd_sc_mcu9t5v0__nand2_1
X$6262 \$14449 \$19324 \$19149 \$14194 gf180mcu_fd_sc_mcu9t5v0__clkbuf_1
X$6263 \$14194 \$20834 \$20709 \$20833 \$20881 \$20718 \$20832
+ gf180mcu_fd_sc_mcu9t5v0__oai211_1
X$6264 \$14194 \$17490 \$15041 \$17022 \$16914 \$17034 \$17021
+ gf180mcu_fd_sc_mcu9t5v0__aoi22_1
X$6265 \$14194 \$16589 \$16438 \$16436 \$16728 \$16588
+ gf180mcu_fd_sc_mcu9t5v0__mux2_1
X$6266 \$14194 \$22828 \$22270 \$22713 \$22837 \$22890
+ gf180mcu_fd_sc_mcu9t5v0__mux2_1
X$6267 \$14194 \$23136 \$21496 \$23027 \$22837 \$23026
+ gf180mcu_fd_sc_mcu9t5v0__mux2_1
X$6268 \$14194 \$19147 \$19278 \$19324 \$19149 \$19325
+ gf180mcu_fd_sc_mcu9t5v0__mux2_1
X$6269 \$14194 \$21803 \$19776 \$22074 \$21946 \$22128
+ gf180mcu_fd_sc_mcu9t5v0__mux2_1
X$6270 \$14194 \$16844 \$16845 \$16914 \$16728 \$16913
+ gf180mcu_fd_sc_mcu9t5v0__mux2_1
X$6271 \$15494 \$14201 \$16729 \$16269 \$16376 \$16381
+ gf180mcu_fd_sc_mcu9t5v0__nor3_1
X$6272 \$14208 \$19605 \$19466 \$19619 gf180mcu_fd_sc_mcu9t5v0__clkinv_1
X$6273 \$18016 \$17961 \$17818 \$17952 \$14211 gf180mcu_fd_sc_mcu9t5v0__nor2_1
X$6274 \$17540 \$17959 \$18014 \$17541 \$14217 \$17958 \$17818 \$17952 \$16594
+ gf180mcu_fd_sc_mcu9t5v0__oai222_1
X$6275 \$14217 \$17960 \$17826 \$17818 \$17952 \$17542
+ gf180mcu_fd_sc_mcu9t5v0__nor3_1
X$6276 \$28489 \$27778 \$14217 \$27913 \$27776 \$27918
+ gf180mcu_fd_sc_mcu9t5v0__aoi21_1
X$6277 \$14217 \$26645 \$26407 \$26406 \$26401 \$26521 \$25763
+ gf180mcu_fd_sc_mcu9t5v0__oai22_1
X$6278 \$18015 \$14217 \$16919 \$18137 \$17952 \$17959
+ gf180mcu_fd_sc_mcu9t5v0__oai21_1
X$6279 \$14217 \$16086 \$15949 \$16070 \$16085 gf180mcu_fd_sc_mcu9t5v0__nor2_1
X$6280 \$14217 \$17503 \$17085 \$17367 \$17113 gf180mcu_fd_sc_mcu9t5v0__nor2_1
X$6281 \$14217 \$18024 \$18137 \$18293 \$18021 gf180mcu_fd_sc_mcu9t5v0__nor2_1
X$6282 \$14217 \$15754 \$15045 \$15204 \$14878 gf180mcu_fd_sc_mcu9t5v0__nor2_1
X$6283 \$14217 \$17382 \$17085 \$17034 \$17108 gf180mcu_fd_sc_mcu9t5v0__nor2_1
X$6284 \$14217 \$28489 \$27913 \$27776 \$27782 gf180mcu_fd_sc_mcu9t5v0__nor2_1
X$6285 \$14217 \$24229 \$24293 \$15746 \$24231 \$24428 \$24294
+ gf180mcu_fd_sc_mcu9t5v0__aoi22_1
X$6286 \$15746 \$24055 \$23805 \$14217 \$23926 \$24109 \$24110
+ gf180mcu_fd_sc_mcu9t5v0__aoi22_1
X$6287 \$15746 \$24592 \$24591 \$14217 \$24593 \$24721 \$24720
+ gf180mcu_fd_sc_mcu9t5v0__aoi22_1
X$6288 \$15746 \$25594 \$24230 \$14217 \$25462 \$25632 \$25593
+ gf180mcu_fd_sc_mcu9t5v0__aoi22_1
X$6289 \$15746 \$24053 \$24052 \$14217 \$23926 \$24109 \$24105
+ gf180mcu_fd_sc_mcu9t5v0__aoi22_1
X$6290 \$15746 \$24051 \$23924 \$14217 \$23926 \$24109 \$24104
+ gf180mcu_fd_sc_mcu9t5v0__aoi22_1
X$6291 \$25192 \$15746 \$24590 \$14217 \$27910 \$27015 \$26856 \$26853
+ gf180mcu_fd_sc_mcu9t5v0__aoi221_1
X$6292 \$27322 \$27315 \$27449 \$14217 gf180mcu_fd_sc_mcu9t5v0__buf_8
X$6293 \$15505 \$14340 \$14217 \$14454 \$14635 \$14460
+ gf180mcu_fd_sc_mcu9t5v0__mux2_1
X$6294 \$14219 \$16436 \$16728 \$16742 gf180mcu_fd_sc_mcu9t5v0__clkinv_1
X$6295 \$14226 \$14221 \$14461 \$14454 \$14337 \$16447
+ gf180mcu_fd_sc_mcu9t5v0__nand3_1
X$6296 \$14344 \$19463 \$14222 \$17661 \$17538 \$17703 \$17713
+ gf180mcu_fd_sc_mcu9t5v0__aoi22_1
X$6297 \$14226 \$14509 \$14508 \$14759 \$14748 \$14635 \$14638
+ gf180mcu_fd_sc_mcu9t5v0__nand4_1
X$6298 \$14226 \$18523 \$18402 \$17953 \$18403 \$18576 \$18573
+ gf180mcu_fd_sc_mcu9t5v0__oai31_2
X$6299 \$14226 \$21493 \$21617 \$14747 \$21498 \$21622 \$21619
+ gf180mcu_fd_sc_mcu9t5v0__oai31_2
X$6300 \$14226 \$22448 \$21295 \$25191 \$25347 \$25310
+ gf180mcu_fd_sc_mcu9t5v0__aoi21_1
X$6301 \$22268 \$21939 \$22113 \$14226 \$22074 \$22272 \$16142
+ gf180mcu_fd_sc_mcu9t5v0__aoi211_1
X$6302 \$22065 \$25040 \$25042 \$14226 \$24877 \$24997 \$18989
+ gf180mcu_fd_sc_mcu9t5v0__aoi211_1
X$6303 \$17104 \$17381 \$17377 \$14226 \$17085 \$17367 \$17953
+ gf180mcu_fd_sc_mcu9t5v0__oai31_1
X$6304 \$14226 \$14464 \$14230 \$14454 \$14337 \$14348
+ gf180mcu_fd_sc_mcu9t5v0__nand3_1
X$6305 \$14226 \$20877 \$20881 \$21011 \$15315 gf180mcu_fd_sc_mcu9t5v0__nor2_1
X$6306 \$19157 \$19156 \$14226 \$19027 \$19149 \$18586
+ gf180mcu_fd_sc_mcu9t5v0__nand3_1
X$6307 \$14226 \$15164 \$15045 \$15204 \$15214 gf180mcu_fd_sc_mcu9t5v0__nand2_1
X$6308 \$14226 \$14515 \$14748 \$14875 \$14747 gf180mcu_fd_sc_mcu9t5v0__nand2_1
X$6309 \$14226 \$22448 \$25462 \$25347 \$25350 gf180mcu_fd_sc_mcu9t5v0__nand2_1
X$6310 \$25311 \$25191 \$25347 \$14226 gf180mcu_fd_sc_mcu9t5v0__buf_8
X$6311 \$14643 \$15009 \$14227 \$14454 \$14635 \$14516
+ gf180mcu_fd_sc_mcu9t5v0__oai21_1
X$6312 \$17960 \$17961 \$17818 \$17952 \$14229 gf180mcu_fd_sc_mcu9t5v0__nor2_1
X$6313 \$14231 \$14352 \$14521 \$14454 \$14337 \$14353
+ gf180mcu_fd_sc_mcu9t5v0__mux2_1
X$6314 \$15159 \$14233 \$17839 \$17818 \$17703 \$17838
+ gf180mcu_fd_sc_mcu9t5v0__oai21_1
X$6315 \$14533 \$14356 \$14532 \$14454 \$14635 \$14236
+ gf180mcu_fd_sc_mcu9t5v0__oai21_1
X$6316 \$14237 \$17391 \$17085 \$17367 \$17060 gf180mcu_fd_sc_mcu9t5v0__nand2_1
X$6317 \$14237 \$17504 \$17538 \$17367 \$17386 gf180mcu_fd_sc_mcu9t5v0__nand2_1
X$6318 \$17517 \$17518 \$17538 \$17367 \$14239 \$17516
+ gf180mcu_fd_sc_mcu9t5v0__xnor3_1
X$6319 \$14241 \$15045 \$14875 gf180mcu_fd_sc_mcu9t5v0__inv_4
X$6320 \$25022 \$25483 \$14245 \$15037 \$25462 \$25632
+ gf180mcu_fd_sc_mcu9t5v0__dffrnq_2
X$6321 \$25361 \$14245 \$15223 \$25462 \$25347 \$25483
+ gf180mcu_fd_sc_mcu9t5v0__mux2_1
X$6322 \$14245 \$15183 \$15024 \$15045 \$15204 \$15028
+ gf180mcu_fd_sc_mcu9t5v0__mux2_1
X$6323 \$14475 \$14474 \$14247 \$14476 \$14454 \$14337 \$14246
+ gf180mcu_fd_sc_mcu9t5v0__oai211_1
X$6324 \$14475 \$14474 \$14247 \$14454 \$14635 \$14249
+ gf180mcu_fd_sc_mcu9t5v0__oai21_1
X$6325 \$14519 \$14351 \$14349 \$14350 \$14454 \$14337 \$14463
+ gf180mcu_fd_sc_mcu9t5v0__and4_1
X$6326 \$14359 \$14472 \$14473 \$14454 \$14337 \$14542
+ gf180mcu_fd_sc_mcu9t5v0__oai21_1
X$6327 \$14446 \$14454 \$14337 \$14447 gf180mcu_fd_sc_mcu9t5v0__clkinv_1
X$6328 \$14540 \$14454 \$14337 \$14358 gf180mcu_fd_sc_mcu9t5v0__clkinv_1
X$6329 \$14337 \$14454 gf180mcu_fd_sc_mcu9t5v0__filltie
X$6330 \$14337 \$14454 gf180mcu_fd_sc_mcu9t5v0__filltie
X$6331 \$14337 \$14454 gf180mcu_fd_sc_mcu9t5v0__filltie
X$6332 \$14337 \$14454 gf180mcu_fd_sc_mcu9t5v0__filltie
X$6333 \$14337 \$14454 gf180mcu_fd_sc_mcu9t5v0__filltie
X$6334 \$14337 \$14454 gf180mcu_fd_sc_mcu9t5v0__filltie
X$6335 \$14337 \$14454 gf180mcu_fd_sc_mcu9t5v0__endcap
X$6336 \$14344 \$22268 \$22068 \$22385 \$22387 \$22440 \$22438
+ gf180mcu_fd_sc_mcu9t5v0__nand4_1
X$6337 \$14344 \$22448 \$19927 \$20087 \$19283 gf180mcu_fd_sc_mcu9t5v0__nor2_1
X$6338 \$14344 \$25597 \$25462 \$25632 \$20048 gf180mcu_fd_sc_mcu9t5v0__nand2_1
X$6339 \$25464 \$25462 \$25347 \$14344 gf180mcu_fd_sc_mcu9t5v0__buf_8
X$6340 \$18875 \$18018 \$18137 \$17952 \$14345 gf180mcu_fd_sc_mcu9t5v0__nor2_1
X$6341 \$14355 \$15166 \$17244 \$14887 \$15045 \$15204 \$15165
+ gf180mcu_fd_sc_mcu9t5v0__aoi22_1
X$6342 \$14531 \$14529 \$14454 \$14635 \$14356 gf180mcu_fd_sc_mcu9t5v0__nor2_1
X$6343 \$15027 \$15028 \$15045 \$14875 \$14357 \$14772
+ gf180mcu_fd_sc_mcu9t5v0__xnor3_1
X$6344 \$14359 \$14472 \$14473 \$14541 \$14454 \$14635 \$14471
+ gf180mcu_fd_sc_mcu9t5v0__oai211_1
X$6345 \$14360 \$14657 \$14748 \$14635 \$14359 gf180mcu_fd_sc_mcu9t5v0__nor2_1
X$6346 \$15343 \$14454 \$14635 \$14360 gf180mcu_fd_sc_mcu9t5v0__clkinv_1
X$6347 \$14360 \$14657 \$14748 \$14875 \$14473 gf180mcu_fd_sc_mcu9t5v0__nand2_1
X$6348 \$14446 \$14479 \$14454 \$14635 \$14480 gf180mcu_fd_sc_mcu9t5v0__nand2_1
X$6349 \$14447 \$14984 \$14454 \$14635 \$14481 gf180mcu_fd_sc_mcu9t5v0__xnor2_1
X$6350 \$15193 \$14628 \$14448 \$14748 \$14635 \$14629
+ gf180mcu_fd_sc_mcu9t5v0__oai21_1
X$6351 \$14483 \$14482 \$14748 \$14875 \$14448 gf180mcu_fd_sc_mcu9t5v0__nand2_1
X$6352 \$14449 \$20835 \$20563 \$20881 \$20718 \$20709
+ gf180mcu_fd_sc_mcu9t5v0__aoi21_1
X$6353 \$20083 \$14449 \$22713 \$22440 \$22714 gf180mcu_fd_sc_mcu9t5v0__nand2_1
X$6354 \$19769 \$14449 \$20515 \$20383 \$20376 gf180mcu_fd_sc_mcu9t5v0__nand2_1
X$6355 \$14449 \$22579 \$20716 \$22713 \$22837 \$22578
+ gf180mcu_fd_sc_mcu9t5v0__mux2_1
X$6356 \$15624 \$14450 \$15628 \$15490 \$15623 gf180mcu_fd_sc_mcu9t5v0__nand2_1
X$6357 \$14540 \$14539 \$14454 \$14635 \$14541 gf180mcu_fd_sc_mcu9t5v0__xnor2_1
X$6358 \$14531 \$14529 \$14454 \$14635 \$14530 gf180mcu_fd_sc_mcu9t5v0__and2_1
X$6359 \$14643 \$14525 \$14526 \$14468 \$14454 \$14635 \$14469
+ gf180mcu_fd_sc_mcu9t5v0__oai31_1
X$6360 \$14490 \$14454 \$14635 \$14489 gf180mcu_fd_sc_mcu9t5v0__clkinv_1
X$6361 \$14521 \$14520 \$14454 \$14635 \$14519 gf180mcu_fd_sc_mcu9t5v0__nand2_1
X$6362 \$14518 \$14517 \$14454 \$14635 \$14515 gf180mcu_fd_sc_mcu9t5v0__nand2_1
X$6363 \$14635 \$14454 gf180mcu_fd_sc_mcu9t5v0__filltie
X$6364 \$14635 \$14454 gf180mcu_fd_sc_mcu9t5v0__filltie
X$6365 \$14635 \$14454 gf180mcu_fd_sc_mcu9t5v0__filltie
X$6366 \$14635 \$14454 gf180mcu_fd_sc_mcu9t5v0__filltie
X$6367 \$14635 \$14454 gf180mcu_fd_sc_mcu9t5v0__filltie
X$6368 \$14635 \$14454 gf180mcu_fd_sc_mcu9t5v0__filltie
X$6369 \$14635 \$14454 gf180mcu_fd_sc_mcu9t5v0__endcap
X$6370 \$14458 \$20209 \$20383 \$20403 gf180mcu_fd_sc_mcu9t5v0__clkinv_1
X$6371 \$18879 \$14463 \$18989 \$19027 \$18870 \$19001
+ gf180mcu_fd_sc_mcu9t5v0__aoi21_1
X$6372 \$14643 \$14645 \$14646 \$14467 \$14748 \$14635 \$14523
+ gf180mcu_fd_sc_mcu9t5v0__oai31_1
X$6373 \$17259 \$17394 \$17130 \$17256 \$17085 \$17367 \$14472
+ gf180mcu_fd_sc_mcu9t5v0__oai31_1
X$6374 \$16106 \$16480 \$16410 \$15848 \$15949 \$16070 \$14474
+ gf180mcu_fd_sc_mcu9t5v0__oai31_1
X$6375 \$15190 \$14479 \$15045 \$15204 \$15189 gf180mcu_fd_sc_mcu9t5v0__nand2_1
X$6376 \$15040 \$14479 \$15045 \$14875 \$14869 gf180mcu_fd_sc_mcu9t5v0__nand2_1
X$6377 \$14482 \$15321 \$15204 \$14479 gf180mcu_fd_sc_mcu9t5v0__buf_8
X$6378 \$14482 \$15193 \$15949 \$16070 \$15797 gf180mcu_fd_sc_mcu9t5v0__and2_1
X$6379 \$20039 \$19875 \$20037 \$19927 \$20087 \$14482
+ gf180mcu_fd_sc_mcu9t5v0__nand3_1
X$6380 \$14482 \$20209 \$20087 \$20202 gf180mcu_fd_sc_mcu9t5v0__buf_8
X$6381 \$16582 \$14485 \$16436 \$16728 \$16842 gf180mcu_fd_sc_mcu9t5v0__nand2_1
X$6382 \$14492 \$17490 \$15041 \$17814 \$17818 \$17952 \$17649
+ gf180mcu_fd_sc_mcu9t5v0__aoi22_1
X$6383 \$14492 \$17651 \$16438 \$17538 \$17703 \$17494
+ gf180mcu_fd_sc_mcu9t5v0__mux2_1
X$6384 \$14492 \$22120 \$22270 \$22074 \$22272 \$22271
+ gf180mcu_fd_sc_mcu9t5v0__mux2_1
X$6385 \$14492 \$19607 \$19776 \$19605 \$19466 \$19606
+ gf180mcu_fd_sc_mcu9t5v0__mux2_1
X$6386 \$14492 \$20721 \$19278 \$20881 \$20718 \$20581
+ gf180mcu_fd_sc_mcu9t5v0__mux2_1
X$6387 \$14492 \$21503 \$20716 \$21498 \$21308 \$21502
+ gf180mcu_fd_sc_mcu9t5v0__mux2_1
X$6388 \$14492 \$17650 \$16845 \$17538 \$17367 \$17536
+ gf180mcu_fd_sc_mcu9t5v0__mux2_1
X$6389 \$14492 \$22071 \$21496 \$22074 \$21946 \$22127
+ gf180mcu_fd_sc_mcu9t5v0__mux2_1
X$6390 \$18007 \$15812 \$19275 \$18137 \$17952 \$14493
+ gf180mcu_fd_sc_mcu9t5v0__nor3_1
X$6391 \$14884 \$14886 \$14885 \$14748 \$14875 \$14520
+ gf180mcu_fd_sc_mcu9t5v0__nand3_1
X$6392 \$14521 \$26805 \$18013 \$26804 \$26675 \$26856 \$26979
+ gf180mcu_fd_sc_mcu9t5v0__oai31_2
X$6393 \$14521 \$14996 \$16914 \$17034 \$17052 gf180mcu_fd_sc_mcu9t5v0__or2_1
X$6394 \$15827 \$15822 \$14521 \$15949 \$15749 \$15826
+ gf180mcu_fd_sc_mcu9t5v0__aoi21_1
X$6395 \$14521 \$26805 \$26860 \$27015 \$26856 \$27027
+ gf180mcu_fd_sc_mcu9t5v0__oai21_1
X$6396 \$14521 \$26977 \$25310 \$27015 \$26856 \$27024
+ gf180mcu_fd_sc_mcu9t5v0__nand3_1
X$6397 \$14521 \$19032 \$25797 \$25918 \$25804 gf180mcu_fd_sc_mcu9t5v0__nor2_1
X$6398 \$14521 \$14990 \$17085 \$17034 \$17106 gf180mcu_fd_sc_mcu9t5v0__nor2_1
X$6399 \$14521 \$16922 \$17085 \$17034 \$17105 gf180mcu_fd_sc_mcu9t5v0__nand2_1
X$6400 \$27282 \$25797 \$25632 \$14521 gf180mcu_fd_sc_mcu9t5v0__buf_8
X$6401 \$14643 \$14890 \$14522 \$14748 \$14875 \$14644
+ gf180mcu_fd_sc_mcu9t5v0__oai21_1
X$6402 \$15377 \$14767 \$14748 \$14635 \$14525 gf180mcu_fd_sc_mcu9t5v0__nor2_1
X$6403 \$15377 \$14767 \$14748 \$14635 \$14526 gf180mcu_fd_sc_mcu9t5v0__and2_1
X$6404 \$15383 \$15321 \$15204 \$14527 \$15172 gf180mcu_fd_sc_mcu9t5v0__xor2_1
X$6405 \$15515 \$15641 \$15628 \$15490 \$14527 gf180mcu_fd_sc_mcu9t5v0__xnor2_1
X$6406 \$14527 \$14647 \$14648 \$14748 \$14635 \$14529
+ gf180mcu_fd_sc_mcu9t5v0__aoi21_1
X$6407 \$14527 \$14647 \$14643 \$14748 \$14635 \$14528
+ gf180mcu_fd_sc_mcu9t5v0__aoi21_1
X$6408 \$15382 \$15378 \$14527 \$15321 \$15490 \$15384
+ gf180mcu_fd_sc_mcu9t5v0__aoi21_1
X$6409 \$15385 \$15384 \$14531 \$15321 \$15490 \$15386
+ gf180mcu_fd_sc_mcu9t5v0__or3_1
X$6410 \$15769 \$15768 \$15628 \$15749 \$14531 gf180mcu_fd_sc_mcu9t5v0__xnor2_1
X$6411 \$15385 \$15384 \$14531 \$15321 \$15490 \$15175
+ gf180mcu_fd_sc_mcu9t5v0__oai21_1
X$6412 \$16876 \$16165 \$16914 \$16728 \$14532 \$16877
+ gf180mcu_fd_sc_mcu9t5v0__xnor3_1
X$6413 \$15173 \$15175 \$14532 \$15045 \$15204 \$15021
+ gf180mcu_fd_sc_mcu9t5v0__and3_1
X$6414 \$15173 \$15175 \$14532 \$15045 \$15204 \$15022
+ gf180mcu_fd_sc_mcu9t5v0__aoi21_1
X$6415 \$15769 \$15768 \$15628 \$15749 \$14533 gf180mcu_fd_sc_mcu9t5v0__and2_1
X$6416 \$14536 \$17065 \$19927 \$19774 \$19908 gf180mcu_fd_sc_mcu9t5v0__and2_1
X$6417 \$14536 \$16894 \$17126 \$16914 \$17034 \$16893
+ gf180mcu_fd_sc_mcu9t5v0__nor3_1
X$6418 \$16884 \$16743 \$16883 \$14536 \$16914 \$16728 \$16403
+ gf180mcu_fd_sc_mcu9t5v0__oai22_1
X$6419 \$14536 \$16615 \$16892 \$16914 \$16728 \$16617
+ gf180mcu_fd_sc_mcu9t5v0__nand3_1
X$6420 \$14536 \$19762 \$19605 \$19774 \$19760 gf180mcu_fd_sc_mcu9t5v0__nor2_1
X$6421 \$14536 \$16885 \$16914 \$16728 \$16743 gf180mcu_fd_sc_mcu9t5v0__nand2_1
X$6422 \$20528 \$20209 \$20087 \$14536 gf180mcu_fd_sc_mcu9t5v0__buf_8
X$6423 \$15381 \$16607 \$14536 \$17538 \$17703 \$17512
+ gf180mcu_fd_sc_mcu9t5v0__mux2_1
X$6424 \$15835 \$18033 \$14536 \$17818 \$17952 \$17841
+ gf180mcu_fd_sc_mcu9t5v0__mux2_1
X$6425 \$16479 \$17393 \$14536 \$17085 \$17367 \$16405
+ gf180mcu_fd_sc_mcu9t5v0__mux2_1
X$6426 \$17392 \$18274 \$14536 \$18137 \$18293 \$18149
+ gf180mcu_fd_sc_mcu9t5v0__mux2_1
X$6427 \$17677 \$18548 \$14536 \$18403 \$18576 \$18432
+ gf180mcu_fd_sc_mcu9t5v0__mux2_1
X$6428 \$17673 \$18887 \$14536 \$18701 \$18576 \$18428
+ gf180mcu_fd_sc_mcu9t5v0__mux2_1
X$6429 \$17666 \$20894 \$14536 \$19605 \$19466 \$19345
+ gf180mcu_fd_sc_mcu9t5v0__mux2_1
X$6430 \$15778 \$15847 \$14536 \$15949 \$15749 \$15775
+ gf180mcu_fd_sc_mcu9t5v0__mux2_1
X$6431 \$16619 \$17679 \$14536 \$18137 \$17952 \$17984
+ gf180mcu_fd_sc_mcu9t5v0__mux2_1
X$6432 \$25022 \$25815 \$14539 \$15037 \$25797 \$25918
+ gf180mcu_fd_sc_mcu9t5v0__dffrnq_2
X$6433 \$25774 \$14539 \$15223 \$25797 \$25632 \$25815
+ gf180mcu_fd_sc_mcu9t5v0__mux2_1
X$6434 \$14540 \$14779 \$14748 \$14875 \$14898 gf180mcu_fd_sc_mcu9t5v0__xnor2_1
X$6435 \$15036 \$15182 \$14540 \$15037 \$15045 \$15204
+ gf180mcu_fd_sc_mcu9t5v0__dffrnq_2
X$6436 \$14540 \$14779 \$14748 \$14635 \$14778 gf180mcu_fd_sc_mcu9t5v0__nand2_1
X$6437 \$18552 \$14540 \$15223 \$15321 \$15204 \$15182
+ gf180mcu_fd_sc_mcu9t5v0__mux2_1
X$6438 \$14773 \$14655 \$14653 \$14748 \$14635 \$14772
+ gf180mcu_fd_sc_mcu9t5v0__aoi21_1
X$6439 \$14652 \$14771 \$14770 \$14748 \$14635 \$14651
+ gf180mcu_fd_sc_mcu9t5v0__oai21_1
X$6440 \$14635 \$14748 gf180mcu_fd_sc_mcu9t5v0__filltie
X$6441 \$14635 \$14748 gf180mcu_fd_sc_mcu9t5v0__filltie
X$6442 \$14635 \$14748 gf180mcu_fd_sc_mcu9t5v0__filltie
X$6443 \$14635 \$14748 gf180mcu_fd_sc_mcu9t5v0__filltie
X$6444 \$14635 \$14748 gf180mcu_fd_sc_mcu9t5v0__filltie
X$6445 \$14635 \$14748 gf180mcu_fd_sc_mcu9t5v0__filltie
X$6446 \$14635 \$14748 gf180mcu_fd_sc_mcu9t5v0__endcap
X$6447 \$14636 \$22719 \$22713 \$22837 \$22845 gf180mcu_fd_sc_mcu9t5v0__xnor2_1
X$6448 \$22901 \$22846 \$14636 \$22713 \$22837 \$22445 \$22912
+ gf180mcu_fd_sc_mcu9t5v0__nand4_2
X$6449 \$14636 \$22445 \$17093 \$22713 \$22440 \$22586
+ gf180mcu_fd_sc_mcu9t5v0__aoi21_1
X$6450 \$17968 \$17832 \$17967 \$17818 \$17952 \$14641
+ gf180mcu_fd_sc_mcu9t5v0__nand3_1
X$6451 \$15386 \$15175 \$14643 \$15321 \$15490 \$15387
+ gf180mcu_fd_sc_mcu9t5v0__aoi21_1
X$6452 \$15378 \$15379 \$14643 \$15321 \$15490 \$15380
+ gf180mcu_fd_sc_mcu9t5v0__aoi21_1
X$6453 \$16089 \$17056 \$14643 \$16914 \$17034 \$16606
+ gf180mcu_fd_sc_mcu9t5v0__aoi21_1
X$6454 \$20094 \$20054 \$14643 \$20209 \$20087 \$20055
+ gf180mcu_fd_sc_mcu9t5v0__aoi21_1
X$6455 \$14643 \$20052 \$20053 \$19927 \$20087 \$20220
+ gf180mcu_fd_sc_mcu9t5v0__oai21_1
X$6456 \$14643 \$19785 \$19340 \$19324 \$19466 \$19339
+ gf180mcu_fd_sc_mcu9t5v0__oai21_1
X$6457 \$14643 \$19291 \$18999 \$19324 \$19149 \$19039
+ gf180mcu_fd_sc_mcu9t5v0__oai21_1
X$6458 \$14643 \$20057 \$19746 \$19745 \$19605 \$19774 \$19744
+ gf180mcu_fd_sc_mcu9t5v0__oai31_1
X$6459 \$14643 \$15375 \$15376 \$15219 \$15321 \$15490 \$15374
+ gf180mcu_fd_sc_mcu9t5v0__oai31_1
X$6460 \$14643 \$19748 \$19786 \$19478 \$19605 \$19774 \$19747
+ gf180mcu_fd_sc_mcu9t5v0__oai31_1
X$6461 \$14643 \$19897 \$20096 \$19613 \$19927 \$19774 \$19743
+ gf180mcu_fd_sc_mcu9t5v0__oai31_1
X$6462 \$14892 \$14891 \$14748 \$14875 \$14645 gf180mcu_fd_sc_mcu9t5v0__and2_1
X$6463 \$14892 \$14891 \$14748 \$14875 \$14646 gf180mcu_fd_sc_mcu9t5v0__nor2_1
X$6464 \$15377 \$14767 \$14893 \$14748 \$14875 \$14647
+ gf180mcu_fd_sc_mcu9t5v0__oai21_1
X$6465 \$15767 \$15641 \$15628 \$15749 \$14648 gf180mcu_fd_sc_mcu9t5v0__and2_1
X$6466 \$16168 \$15969 \$14652 \$16269 \$16070 \$16098
+ gf180mcu_fd_sc_mcu9t5v0__aoi21_1
X$6467 \$14652 \$15025 \$15026 \$15045 \$14875 \$15177
+ gf180mcu_fd_sc_mcu9t5v0__oai21_1
X$6468 \$14652 \$15773 \$15774 \$15643 \$15628 \$15749 \$15392
+ gf180mcu_fd_sc_mcu9t5v0__oai31_1
X$6469 \$14652 \$15034 \$15035 \$15033 \$15045 \$14875 \$15056
+ gf180mcu_fd_sc_mcu9t5v0__oai31_1
X$6470 \$14652 \$15843 \$15844 \$15841 \$15949 \$15749 \$15842
+ gf180mcu_fd_sc_mcu9t5v0__oai31_1
X$6471 \$14652 \$15523 \$15522 \$15340 \$15628 \$15490 \$15521
+ gf180mcu_fd_sc_mcu9t5v0__oai31_1
X$6472 \$14652 \$15840 \$15970 \$15517 \$15949 \$15749 \$15839
+ gf180mcu_fd_sc_mcu9t5v0__oai31_1
X$6473 \$14775 \$14776 \$14896 \$14748 \$14875 \$14655
+ gf180mcu_fd_sc_mcu9t5v0__aoi21_1
X$6474 \$25022 \$26245 \$14657 \$15037 \$26401 \$26220
+ gf180mcu_fd_sc_mcu9t5v0__dffrnq_2
X$6475 \$27176 \$14657 \$15223 \$26088 \$26220 \$26245
+ gf180mcu_fd_sc_mcu9t5v0__mux2_1
X$6476 \$14866 \$14748 \$14875 \$14744 gf180mcu_fd_sc_mcu9t5v0__dlyc_1
X$6477 \$14778 \$14897 \$14748 \$14875 \$14776 gf180mcu_fd_sc_mcu9t5v0__and2_1
X$6478 \$14875 \$14748 gf180mcu_fd_sc_mcu9t5v0__filltie
X$6479 \$14875 \$14748 gf180mcu_fd_sc_mcu9t5v0__filltie
X$6480 \$14875 \$14748 gf180mcu_fd_sc_mcu9t5v0__filltie
X$6481 \$14875 \$14748 gf180mcu_fd_sc_mcu9t5v0__filltie
X$6482 \$14875 \$14748 gf180mcu_fd_sc_mcu9t5v0__filltie
X$6483 \$14875 \$14748 gf180mcu_fd_sc_mcu9t5v0__filltie
X$6484 \$14875 \$14748 gf180mcu_fd_sc_mcu9t5v0__endcap
X$6485 \$16591 \$16076 \$16436 \$16728 \$14757 gf180mcu_fd_sc_mcu9t5v0__nand2_1
X$6486 \$14760 \$15166 \$15216 \$16080 \$16269 \$16376 \$16384
+ gf180mcu_fd_sc_mcu9t5v0__aoi22_1
X$6487 \$14765 \$15166 \$17244 \$15013 \$15321 \$15204 \$15334
+ gf180mcu_fd_sc_mcu9t5v0__aoi22_1
X$6488 \$14892 \$14891 \$15018 \$15045 \$14875 \$14767
+ gf180mcu_fd_sc_mcu9t5v0__aoi21_1
X$6489 \$20543 \$20544 \$20515 \$20383 \$14771 gf180mcu_fd_sc_mcu9t5v0__xnor2_1
X$6490 \$14870 \$19027 \$18870 \$15147 gf180mcu_fd_sc_mcu9t5v0__clkbuf_1
X$6491 \$14870 \$20333 \$21498 \$21308 \$21357 gf180mcu_fd_sc_mcu9t5v0__or2_1
X$6492 \$20083 \$14870 \$21184 \$21308 \$21145 gf180mcu_fd_sc_mcu9t5v0__nand2_1
X$6493 \$22268 \$22382 \$22380 \$22387 \$22272 \$14871
+ gf180mcu_fd_sc_mcu9t5v0__aoi21_1
X$6494 \$15024 \$15021 \$15022 \$15045 \$14875 \$14894
+ gf180mcu_fd_sc_mcu9t5v0__or3_1
X$6495 \$15031 \$15029 \$15032 \$15045 \$14875 \$15030
+ gf180mcu_fd_sc_mcu9t5v0__oai21_1
X$6496 \$15159 \$15161 \$15003 \$15045 \$14875 \$15002
+ gf180mcu_fd_sc_mcu9t5v0__oai21_1
X$6497 \$14993 \$14992 \$15045 \$14875 \$14994 gf180mcu_fd_sc_mcu9t5v0__nor2_1
X$6498 \$15046 \$15045 \$14875 \$15048 gf180mcu_fd_sc_mcu9t5v0__clkinv_1
X$6499 \$15362 \$15045 \$14875 \$14991 gf180mcu_fd_sc_mcu9t5v0__clkinv_1
X$6500 \$14989 \$15045 \$14875 \$15044 gf180mcu_fd_sc_mcu9t5v0__clkinv_1
X$6501 \$14898 \$15045 \$14875 \$15055 gf180mcu_fd_sc_mcu9t5v0__clkinv_1
X$6502 \$15155 \$15049 \$15045 \$14875 \$14999 gf180mcu_fd_sc_mcu9t5v0__nand2_1
X$6503 \$14875 \$15045 gf180mcu_fd_sc_mcu9t5v0__filltie
X$6504 \$14875 \$15045 gf180mcu_fd_sc_mcu9t5v0__filltie
X$6505 \$14875 \$15045 gf180mcu_fd_sc_mcu9t5v0__filltie
X$6506 \$14875 \$15045 gf180mcu_fd_sc_mcu9t5v0__filltie
X$6507 \$14875 \$15045 gf180mcu_fd_sc_mcu9t5v0__filltie
X$6508 \$14875 \$15045 gf180mcu_fd_sc_mcu9t5v0__filltie
X$6509 \$14875 \$15045 gf180mcu_fd_sc_mcu9t5v0__endcap
X$6510 \$20357 \$20408 \$20209 \$20087 \$14890 gf180mcu_fd_sc_mcu9t5v0__xnor2_1
X$6511 \$15510 \$15509 \$15639 \$15628 \$15749 \$14891
+ gf180mcu_fd_sc_mcu9t5v0__oai21_1
X$6512 \$15834 \$15833 \$15949 \$16070 \$14892 gf180mcu_fd_sc_mcu9t5v0__xnor2_1
X$6513 \$16397 \$14892 \$16269 \$16070 \$16274 gf180mcu_fd_sc_mcu9t5v0__xnor2_1
X$6514 \$16396 \$16089 \$14892 \$15949 \$16070 \$15640
+ gf180mcu_fd_sc_mcu9t5v0__aoi21_1
X$6515 \$15381 \$15513 \$15321 \$15490 \$14893 gf180mcu_fd_sc_mcu9t5v0__or2_1
X$6516 \$15031 \$15029 \$15032 \$15055 \$15045 \$15204 \$14897
+ gf180mcu_fd_sc_mcu9t5v0__oai211_1
X$6517 \$15143 \$15311 \$15045 \$15204 \$14983 gf180mcu_fd_sc_mcu9t5v0__nand2_1
X$6518 \$15040 \$15190 \$15142 \$15045 \$15204 \$14984
+ gf180mcu_fd_sc_mcu9t5v0__nand3_1
X$6519 \$15159 \$15157 \$15158 \$15045 \$15204 \$15001
+ gf180mcu_fd_sc_mcu9t5v0__oai21_1
X$6520 \$15212 \$15159 \$15321 \$15204 \$15003 gf180mcu_fd_sc_mcu9t5v0__nand2_1
X$6521 \$24315 \$24314 \$24231 \$24428 \$15009 gf180mcu_fd_sc_mcu9t5v0__xnor2_1
X$6522 \$15215 \$16452 \$15216 \$15014 \$15321 \$15490 \$15371
+ gf180mcu_fd_sc_mcu9t5v0__aoi22_1
X$6523 \$16142 \$15828 \$15949 \$15749 \$15015 gf180mcu_fd_sc_mcu9t5v0__nor2_1
X$6524 \$15016 \$16914 \$16728 \$I71626 gf180mcu_fd_sc_mcu9t5v0__inv_2
X$6525 \$15835 \$15833 \$15949 \$15749 \$15018 gf180mcu_fd_sc_mcu9t5v0__nor2_1
X$6526 \$15380 \$15337 \$15321 \$15204 \$15019 gf180mcu_fd_sc_mcu9t5v0__nor2_1
X$6527 \$16165 \$16269 \$16070 \$15967 \$15023 gf180mcu_fd_sc_mcu9t5v0__xor2_1
X$6528 \$15024 \$21689 \$21830 \$21688 \$21661 \$21622 \$18601
+ gf180mcu_fd_sc_mcu9t5v0__oai22_1
X$6529 \$15024 \$20588 \$20515 \$20718 \$20589 gf180mcu_fd_sc_mcu9t5v0__nor2_1
X$6530 \$15024 \$20353 \$20209 \$20087 \$20058 gf180mcu_fd_sc_mcu9t5v0__nor2_1
X$6531 \$15024 \$16882 \$16914 \$16728 \$16880 gf180mcu_fd_sc_mcu9t5v0__nor2_1
X$6532 \$15024 \$16890 \$16914 \$16728 \$16886 gf180mcu_fd_sc_mcu9t5v0__nor2_1
X$6533 \$15024 \$16477 \$16436 \$16376 \$16174 gf180mcu_fd_sc_mcu9t5v0__nand2_1
X$6534 \$15024 \$21687 \$21661 \$21622 \$21688 gf180mcu_fd_sc_mcu9t5v0__nand2_1
X$6535 \$15024 \$20539 \$20515 \$20383 \$20540 gf180mcu_fd_sc_mcu9t5v0__nand2_1
X$6536 \$15024 \$17522 \$17538 \$17367 \$16889 gf180mcu_fd_sc_mcu9t5v0__nand2_1
X$6537 \$15024 \$17519 \$17538 \$17367 \$16879 gf180mcu_fd_sc_mcu9t5v0__nand2_1
X$6538 \$15024 \$16154 \$16269 \$16070 \$16398 gf180mcu_fd_sc_mcu9t5v0__nand2_1
X$6539 \$21822 \$21661 \$21946 \$15024 gf180mcu_fd_sc_mcu9t5v0__buf_8
X$6540 \$16472 \$16094 \$15024 \$17085 \$17367 \$17389
+ gf180mcu_fd_sc_mcu9t5v0__mux2_1
X$6541 \$20098 \$20222 \$15024 \$20209 \$20087 \$19477
+ gf180mcu_fd_sc_mcu9t5v0__mux2_1
X$6542 \$16874 \$15515 \$15024 \$17085 \$17034 \$17123
+ gf180mcu_fd_sc_mcu9t5v0__mux2_1
X$6543 \$17058 \$17252 \$15024 \$17538 \$17367 \$17518
+ gf180mcu_fd_sc_mcu9t5v0__mux2_1
X$6544 \$21835 \$21837 \$21661 \$21622 \$15025 gf180mcu_fd_sc_mcu9t5v0__xnor2_1
X$6545 \$20065 \$20735 \$15027 \$15037 \$20881 \$20718
+ gf180mcu_fd_sc_mcu9t5v0__dffrnq_2
X$6546 \$20608 \$15027 \$15223 \$20515 \$20718 \$20735
+ gf180mcu_fd_sc_mcu9t5v0__mux2_1
X$6547 \$15029 \$15341 \$15321 \$15204 \$15220 gf180mcu_fd_sc_mcu9t5v0__xnor2_1
X$6548 \$15524 \$15526 \$15777 \$15525 \$15628 \$15490 \$15029
+ gf180mcu_fd_sc_mcu9t5v0__oai31_1
X$6549 \$15055 \$15030 \$15045 \$15204 \$15178 gf180mcu_fd_sc_mcu9t5v0__xnor2_1
X$6550 \$15342 \$15321 \$15490 \$15031 gf180mcu_fd_sc_mcu9t5v0__clkinv_1
X$6551 \$15343 \$15222 \$15321 \$15204 \$15032 gf180mcu_fd_sc_mcu9t5v0__or2_1
X$6552 \$15342 \$15032 \$15321 \$15204 \$15341 gf180mcu_fd_sc_mcu9t5v0__nand2_1
X$6553 \$15180 \$15179 \$15321 \$15204 \$15034 gf180mcu_fd_sc_mcu9t5v0__nor2_1
X$6554 \$15180 \$15179 \$15045 \$15204 \$15035 gf180mcu_fd_sc_mcu9t5v0__and2_1
X$6555 \$15036 \$17085 \$17367 gf180mcu_fd_sc_mcu9t5v0__clkbuf_4
X$6556 \$15036 \$17849 \$15776 \$15037 \$17818 \$17952
+ gf180mcu_fd_sc_mcu9t5v0__dffrnq_2
X$6557 \$15036 \$17260 \$15381 \$15037 \$17085 \$17367
+ gf180mcu_fd_sc_mcu9t5v0__dffrnq_2
X$6558 \$15036 \$17131 \$16897 \$15037 \$16914 \$17034
+ gf180mcu_fd_sc_mcu9t5v0__dffrnq_2
X$6559 \$15036 \$16412 \$15778 \$15037 \$16269 \$16376
+ gf180mcu_fd_sc_mcu9t5v0__dffrnq_2
X$6560 \$15036 \$17850 \$15835 \$15037 \$17818 \$17703
+ gf180mcu_fd_sc_mcu9t5v0__dffrnq_2
X$6561 \$15036 \$16896 \$15515 \$15037 \$16914 \$16728
+ gf180mcu_fd_sc_mcu9t5v0__dffrnq_2
X$6562 \$15036 \$18277 \$18278 \$15037 \$18403 \$18293
+ gf180mcu_fd_sc_mcu9t5v0__dffrnq_2
X$6563 \$15036 \$17985 \$15343 \$15037 \$18137 \$17952
+ gf180mcu_fd_sc_mcu9t5v0__dffrnq_2
X$6564 \$15036 \$17395 \$16899 \$15037 \$17538 \$17367
+ gf180mcu_fd_sc_mcu9t5v0__dffrnq_2
X$6565 \$15036 \$18042 \$16094 \$15037 \$18137 \$17952
+ gf180mcu_fd_sc_mcu9t5v0__dffrnq_2
X$6566 \$15036 \$18043 \$17986 \$15037 \$18137 \$17952
+ gf180mcu_fd_sc_mcu9t5v0__dffrnq_2
X$6567 \$15036 \$17527 \$17252 \$15037 \$17538 \$17367
+ gf180mcu_fd_sc_mcu9t5v0__dffrnq_2
X$6568 \$15036 \$18551 \$18435 \$15037 \$18403 \$18293
+ gf180mcu_fd_sc_mcu9t5v0__dffrnq_2
X$6569 \$15036 \$15971 \$15850 \$15037 \$15949 \$15749
+ gf180mcu_fd_sc_mcu9t5v0__dffrnq_2
X$6570 \$21519 \$22176 \$22104 \$15037 \$22074 \$22272
+ gf180mcu_fd_sc_mcu9t5v0__dffrnq_2
X$6571 \$27942 \$29142 \$29113 \$15037 \$29123 \$29270
+ gf180mcu_fd_sc_mcu9t5v0__dffrnq_2
X$6572 \$27942 \$28238 \$28073 \$15037 \$28211 \$28381
+ gf180mcu_fd_sc_mcu9t5v0__dffrnq_2
X$6573 \$18609 \$20237 \$20109 \$15037 \$20209 \$20383
+ gf180mcu_fd_sc_mcu9t5v0__dffrnq_2
X$6574 \$23609 \$24894 \$24868 \$15037 \$24877 \$24997
+ gf180mcu_fd_sc_mcu9t5v0__dffrnq_2
X$6575 \$25951 \$25819 \$25789 \$15037 \$25797 \$25918
+ gf180mcu_fd_sc_mcu9t5v0__dffrnq_2
X$6576 \$21519 \$22729 \$22613 \$15037 \$22713 \$22837
+ gf180mcu_fd_sc_mcu9t5v0__dffrnq_2
X$6577 \$18609 \$20619 \$20552 \$15037 \$20515 \$20718
+ gf180mcu_fd_sc_mcu9t5v0__dffrnq_2
X$6578 \$25491 \$27058 \$27302 \$15037 \$27015 \$27153
+ gf180mcu_fd_sc_mcu9t5v0__dffrnq_2
X$6579 \$21519 \$21846 \$21706 \$15037 \$21661 \$21946
+ gf180mcu_fd_sc_mcu9t5v0__dffrnq_2
X$6580 \$25951 \$27675 \$27945 \$15037 \$27637 \$27776
+ gf180mcu_fd_sc_mcu9t5v0__dffrnq_2
X$6581 \$15395 \$17072 \$16902 \$15037 \$16914 \$17034
+ gf180mcu_fd_sc_mcu9t5v0__dffrnq_2
X$6582 \$18609 \$21178 \$21179 \$15037 \$21184 \$21308
+ gf180mcu_fd_sc_mcu9t5v0__dffrnq_2
X$6583 \$21519 \$22174 \$22103 \$15037 \$22074 \$22272
+ gf180mcu_fd_sc_mcu9t5v0__dffrnq_2
X$6584 \$25022 \$25816 \$25644 \$15037 \$25797 \$25918
+ gf180mcu_fd_sc_mcu9t5v0__dffrnq_2
X$6585 \$15395 \$16114 \$16178 \$15037 \$15949 \$16070
+ gf180mcu_fd_sc_mcu9t5v0__dffrnq_2
X$6586 \$15395 \$17263 \$17073 \$15037 \$17085 \$17367
+ gf180mcu_fd_sc_mcu9t5v0__dffrnq_2
X$6587 \$27942 \$28958 \$28842 \$15037 \$28810 \$28971
+ gf180mcu_fd_sc_mcu9t5v0__dffrnq_2
X$6588 \$25951 \$26698 \$26118 \$15037 \$26675 \$26856
+ gf180mcu_fd_sc_mcu9t5v0__dffrnq_2
X$6589 \$19300 \$19355 \$19356 \$15037 \$19324 \$19466
+ gf180mcu_fd_sc_mcu9t5v0__dffrnq_2
X$6590 \$27942 \$28369 \$28395 \$15037 \$28211 \$28381
+ gf180mcu_fd_sc_mcu9t5v0__dffrnq_2
X$6591 \$25022 \$24613 \$24563 \$15037 \$24593 \$24721
+ gf180mcu_fd_sc_mcu9t5v0__dffrnq_2
X$6592 \$23214 \$21842 \$19913 \$15037 \$21661 \$21946
+ gf180mcu_fd_sc_mcu9t5v0__dffrnq_2
X$6593 \$25491 \$27676 \$27621 \$15037 \$27637 \$27776
+ gf180mcu_fd_sc_mcu9t5v0__dffrnq_2
X$6594 \$20233 \$20609 \$20535 \$15037 \$20515 \$20718
+ gf180mcu_fd_sc_mcu9t5v0__dffrnq_2
X$6595 \$21519 \$21180 \$20912 \$15037 \$21184 \$21308
+ gf180mcu_fd_sc_mcu9t5v0__dffrnq_2
X$6596 \$27942 \$28368 \$28393 \$15037 \$28211 \$28381
+ gf180mcu_fd_sc_mcu9t5v0__dffrnq_2
X$6597 \$25491 \$26550 \$25955 \$15037 \$26401 \$26521
+ gf180mcu_fd_sc_mcu9t5v0__dffrnq_2
X$6598 \$21519 \$22728 \$22608 \$15037 \$22713 \$22837
+ gf180mcu_fd_sc_mcu9t5v0__dffrnq_2
X$6599 \$25951 \$26120 \$25788 \$15037 \$26088 \$26220
+ gf180mcu_fd_sc_mcu9t5v0__dffrnq_2
X$6600 \$28948 \$28592 \$28517 \$15037 \$28534 \$28689
+ gf180mcu_fd_sc_mcu9t5v0__dffrnq_2
X$6601 \$21519 \$23350 \$23219 \$15037 \$23183 \$23454
+ gf180mcu_fd_sc_mcu9t5v0__dffrnq_2
X$6602 \$19300 \$18851 \$18608 \$15037 \$18701 \$18870
+ gf180mcu_fd_sc_mcu9t5v0__dffrnq_2
X$6603 \$18609 \$19361 \$19491 \$15037 \$19324 \$19466
+ gf180mcu_fd_sc_mcu9t5v0__dffrnq_2
X$6604 \$19300 \$18553 \$18606 \$15037 \$18403 \$18576
+ gf180mcu_fd_sc_mcu9t5v0__dffrnq_2
X$6605 \$21519 \$22418 \$20896 \$15037 \$22387 \$22440
+ gf180mcu_fd_sc_mcu9t5v0__dffrnq_2
X$6606 \$15395 \$17134 \$16900 \$15037 \$17085 \$17367
+ gf180mcu_fd_sc_mcu9t5v0__dffrnq_2
X$6607 \$25491 \$26837 \$26879 \$15037 \$26675 \$26856
+ gf180mcu_fd_sc_mcu9t5v0__dffrnq_2
X$6608 \$23609 \$25337 \$24577 \$15037 \$25191 \$25347
+ gf180mcu_fd_sc_mcu9t5v0__dffrnq_2
X$6609 \$25491 \$27677 \$27678 \$15037 \$27637 \$27776
+ gf180mcu_fd_sc_mcu9t5v0__dffrnq_2
X$6610 \$28511 \$28363 \$28581 \$15037 \$28211 \$28381
+ gf180mcu_fd_sc_mcu9t5v0__dffrnq_2
X$6611 \$25491 \$26699 \$26668 \$15037 \$26675 \$26856
+ gf180mcu_fd_sc_mcu9t5v0__dffrnq_2
X$6612 \$28948 \$29258 \$29284 \$15037 \$29123 \$29270
+ gf180mcu_fd_sc_mcu9t5v0__dffrnq_2
X$6613 \$28511 \$16108 \$21199 \$15037 \$29123 \$29270
+ gf180mcu_fd_sc_mcu9t5v0__dffrnq_2
X$6614 \$28511 \$28236 \$28067 \$15037 \$28211 \$28381
+ gf180mcu_fd_sc_mcu9t5v0__dffrnq_2
X$6615 \$25951 \$26390 \$25790 \$15037 \$26401 \$26521
+ gf180mcu_fd_sc_mcu9t5v0__dffrnq_2
X$6616 \$21519 \$21652 \$17673 \$15037 \$21498 \$21622
+ gf180mcu_fd_sc_mcu9t5v0__dffrnq_2
X$6617 \$24127 \$25620 \$24892 \$15037 \$25462 \$25632
+ gf180mcu_fd_sc_mcu9t5v0__dffrnq_2
X$6618 \$27942 \$28593 \$28518 \$15037 \$28534 \$28689
+ gf180mcu_fd_sc_mcu9t5v0__dffrnq_2
X$6619 \$28511 \$28584 \$28514 \$15037 \$28534 \$28689
+ gf180mcu_fd_sc_mcu9t5v0__dffrnq_2
X$6620 \$24127 \$25032 \$24754 \$15037 \$24877 \$24997
+ gf180mcu_fd_sc_mcu9t5v0__dffrnq_2
X$6621 \$20233 \$19764 \$19626 \$15037 \$19605 \$19774
+ gf180mcu_fd_sc_mcu9t5v0__dffrnq_2
X$6622 \$25491 \$24896 \$24870 \$15037 \$24877 \$24997
+ gf180mcu_fd_sc_mcu9t5v0__dffrnq_2
X$6623 \$25951 \$27300 \$27185 \$15037 \$27015 \$27153
+ gf180mcu_fd_sc_mcu9t5v0__dffrnq_2
X$6624 \$21519 \$22731 \$22615 \$15037 \$22713 \$22837
+ gf180mcu_fd_sc_mcu9t5v0__dffrnq_2
X$6625 \$23609 \$24090 \$24130 \$15037 \$23926 \$24109
+ gf180mcu_fd_sc_mcu9t5v0__dffrnq_2
X$6626 \$19300 \$19621 \$19486 \$15037 \$19605 \$19774
+ gf180mcu_fd_sc_mcu9t5v0__dffrnq_2
X$6627 \$25491 \$25821 \$25793 \$15037 \$25797 \$25918
+ gf180mcu_fd_sc_mcu9t5v0__dffrnq_2
X$6628 \$23609 \$24277 \$24278 \$15037 \$24231 \$24428
+ gf180mcu_fd_sc_mcu9t5v0__dffrnq_2
X$6629 \$20233 \$19942 \$17666 \$15037 \$19927 \$20087
+ gf180mcu_fd_sc_mcu9t5v0__dffrnq_2
X$6630 \$27942 \$28957 \$28986 \$15037 \$28810 \$28971
+ gf180mcu_fd_sc_mcu9t5v0__dffrnq_2
X$6631 \$15395 \$16277 \$16177 \$15037 \$16269 \$16376
+ gf180mcu_fd_sc_mcu9t5v0__dffrnq_2
X$6632 \$26417 \$27669 \$27295 \$15037 \$27637 \$27776
+ gf180mcu_fd_sc_mcu9t5v0__dffrnq_2
X$6633 \$25951 \$27674 \$27618 \$15037 \$27637 \$27776
+ gf180mcu_fd_sc_mcu9t5v0__dffrnq_2
X$6634 \$23609 \$23658 \$23351 \$15037 \$23620 \$23807
+ gf180mcu_fd_sc_mcu9t5v0__dffrnq_2
X$6635 \$25491 \$24895 \$24756 \$15037 \$24877 \$24997
+ gf180mcu_fd_sc_mcu9t5v0__dffrnq_2
X$6636 \$21519 \$22727 \$22606 \$15037 \$22713 \$22837
+ gf180mcu_fd_sc_mcu9t5v0__dffrnq_2
X$6637 \$27942 \$29141 \$29112 \$15037 \$29123 \$29270
+ gf180mcu_fd_sc_mcu9t5v0__dffrnq_2
X$6638 \$23609 \$23356 \$23222 \$15037 \$23183 \$23454
+ gf180mcu_fd_sc_mcu9t5v0__dffrnq_2
X$6639 \$18609 \$19943 \$19944 \$15037 \$19927 \$20087
+ gf180mcu_fd_sc_mcu9t5v0__dffrnq_2
X$6640 \$21519 \$22422 \$22289 \$15037 \$22387 \$22440
+ gf180mcu_fd_sc_mcu9t5v0__dffrnq_2
X$6641 \$25022 \$25944 \$25361 \$15037 \$26088 \$26220
+ gf180mcu_fd_sc_mcu9t5v0__dffrnq_2
X$6642 \$25951 \$25818 \$25783 \$15037 \$25797 \$25918
+ gf180mcu_fd_sc_mcu9t5v0__dffrnq_2
X$6643 \$18609 \$18555 \$18152 \$15037 \$18403 \$18576
+ gf180mcu_fd_sc_mcu9t5v0__dffrnq_2
X$6644 \$18609 \$21696 \$17677 \$15037 \$21498 \$21622
+ gf180mcu_fd_sc_mcu9t5v0__dffrnq_2
X$6645 \$20233 \$22472 \$20908 \$15037 \$22387 \$22440
+ gf180mcu_fd_sc_mcu9t5v0__dffrnq_2
X$6646 \$21519 \$23656 \$23608 \$15037 \$23620 \$23807
+ gf180mcu_fd_sc_mcu9t5v0__dffrnq_2
X$6647 \$25022 \$25024 \$25025 \$15037 \$24877 \$24997
+ gf180mcu_fd_sc_mcu9t5v0__dffrnq_2
X$6648 \$25022 \$25204 \$25091 \$15037 \$25191 \$25347
+ gf180mcu_fd_sc_mcu9t5v0__dffrnq_2
X$6649 \$24127 \$24273 \$24128 \$15037 \$24231 \$24428
+ gf180mcu_fd_sc_mcu9t5v0__dffrnq_2
X$6650 \$21519 \$23480 \$22598 \$15037 \$23183 \$23454
+ gf180mcu_fd_sc_mcu9t5v0__dffrnq_2
X$6651 \$15395 \$15396 \$15782 \$15037 \$15321 \$15490
+ gf180mcu_fd_sc_mcu9t5v0__dffrnq_2
X$6652 \$25022 \$24560 \$21320 \$15037 \$24593 \$24721
+ gf180mcu_fd_sc_mcu9t5v0__dffrnq_2
X$6653 \$25022 \$25203 \$21680 \$15037 \$25191 \$25347
+ gf180mcu_fd_sc_mcu9t5v0__dffrnq_2
X$6654 \$25951 \$27671 \$27614 \$15037 \$27637 \$27776
+ gf180mcu_fd_sc_mcu9t5v0__dffrnq_2
X$6655 \$27942 \$28720 \$28721 \$15037 \$28534 \$28689
+ gf180mcu_fd_sc_mcu9t5v0__dffrnq_2
X$6656 \$23214 \$22412 \$20903 \$15037 \$22387 \$22440
+ gf180mcu_fd_sc_mcu9t5v0__dffrnq_2
X$6657 \$23214 \$23477 \$23217 \$15037 \$23620 \$23807
+ gf180mcu_fd_sc_mcu9t5v0__dffrnq_2
X$6658 \$24127 \$25205 \$25096 \$15037 \$25191 \$25347
+ gf180mcu_fd_sc_mcu9t5v0__dffrnq_2
X$6659 \$23214 \$24618 \$24567 \$15037 \$24593 \$24721
+ gf180mcu_fd_sc_mcu9t5v0__dffrnq_2
X$6660 \$28511 \$29257 \$28956 \$15037 \$29123 \$29270
+ gf180mcu_fd_sc_mcu9t5v0__dffrnq_2
X$6661 \$25022 \$25023 \$25089 \$15037 \$24877 \$24997
+ gf180mcu_fd_sc_mcu9t5v0__dffrnq_2
X$6662 \$24612 \$25482 \$25360 \$15037 \$25462 \$25632
+ gf180mcu_fd_sc_mcu9t5v0__dffrnq_2
X$6663 \$24612 \$24558 \$22464 \$15037 \$24593 \$24721
+ gf180mcu_fd_sc_mcu9t5v0__dffrnq_2
X$6664 \$24612 \$24075 \$24124 \$15037 \$23926 \$24109
+ gf180mcu_fd_sc_mcu9t5v0__dffrnq_2
X$6665 \$26417 \$26382 \$26381 \$15037 \$26401 \$26521
+ gf180mcu_fd_sc_mcu9t5v0__dffrnq_2
X$6666 \$24127 \$25031 \$24751 \$15037 \$24877 \$24997
+ gf180mcu_fd_sc_mcu9t5v0__dffrnq_2
X$6667 \$23214 \$23606 \$19628 \$15037 \$23620 \$23807
+ gf180mcu_fd_sc_mcu9t5v0__dffrnq_2
X$6668 \$23214 \$23046 \$16636 \$15037 \$23027 \$23139
+ gf180mcu_fd_sc_mcu9t5v0__dffrnq_2
X$6669 \$24127 \$24269 \$24271 \$15037 \$24231 \$24428
+ gf180mcu_fd_sc_mcu9t5v0__dffrnq_2
X$6670 \$20065 \$19940 \$19910 \$15037 \$19927 \$20087
+ gf180mcu_fd_sc_mcu9t5v0__dffrnq_2
X$6671 \$20065 \$22726 \$22603 \$15037 \$22713 \$22837
+ gf180mcu_fd_sc_mcu9t5v0__dffrnq_2
X$6672 \$15395 \$17993 \$17855 \$15037 \$17818 \$17952
+ gf180mcu_fd_sc_mcu9t5v0__dffrnq_2
X$6673 \$15395 \$16417 \$16112 \$15037 \$16269 \$16376
+ gf180mcu_fd_sc_mcu9t5v0__dffrnq_2
X$6674 \$15395 \$17265 \$16637 \$15037 \$17085 \$17367
+ gf180mcu_fd_sc_mcu9t5v0__dffrnq_2
X$6675 \$20065 \$22407 \$22286 \$15037 \$22387 \$22440
+ gf180mcu_fd_sc_mcu9t5v0__dffrnq_2
X$6676 \$20233 \$21177 \$21046 \$15037 \$21184 \$21308
+ gf180mcu_fd_sc_mcu9t5v0__dffrnq_2
X$6677 \$18609 \$19630 \$19496 \$15037 \$19605 \$19774
+ gf180mcu_fd_sc_mcu9t5v0__dffrnq_2
X$6678 \$18609 \$18614 \$18558 \$15037 \$18701 \$18870
+ gf180mcu_fd_sc_mcu9t5v0__dffrnq_2
X$6679 \$19300 \$19353 \$19485 \$15037 \$19324 \$19466
+ gf180mcu_fd_sc_mcu9t5v0__dffrnq_2
X$6680 \$20233 \$21516 \$21041 \$15037 \$21498 \$21622
+ gf180mcu_fd_sc_mcu9t5v0__dffrnq_2
X$6681 \$18609 \$19052 \$19016 \$15037 \$19027 \$19149
+ gf180mcu_fd_sc_mcu9t5v0__dffrnq_2
X$6682 \$18609 \$20073 \$19921 \$15037 \$19927 \$20087
+ gf180mcu_fd_sc_mcu9t5v0__dffrnq_2
X$6683 \$19300 \$20232 \$20103 \$15037 \$20209 \$20383
+ gf180mcu_fd_sc_mcu9t5v0__dffrnq_2
X$6684 \$20233 \$20362 \$20363 \$15037 \$20209 \$20383
+ gf180mcu_fd_sc_mcu9t5v0__dffrnq_2
X$6685 \$20233 \$20904 \$20859 \$15037 \$20881 \$21011
+ gf180mcu_fd_sc_mcu9t5v0__dffrnq_2
X$6686 \$24127 \$25332 \$25097 \$15037 \$25191 \$25347
+ gf180mcu_fd_sc_mcu9t5v0__dffrnq_2
X$6687 \$20065 \$23044 \$20592 \$15037 \$23027 \$23139
+ gf180mcu_fd_sc_mcu9t5v0__dffrnq_2
X$6688 \$24127 \$24268 \$22416 \$15037 \$24231 \$24428
+ gf180mcu_fd_sc_mcu9t5v0__dffrnq_2
X$6689 \$24612 \$26416 \$26244 \$15037 \$26401 \$26521
+ gf180mcu_fd_sc_mcu9t5v0__dffrnq_2
X$6690 \$26417 \$26421 \$26380 \$15037 \$26401 \$26521
+ gf180mcu_fd_sc_mcu9t5v0__dffrnq_2
X$6691 \$23214 \$23787 \$20728 \$15037 \$23620 \$23807
+ gf180mcu_fd_sc_mcu9t5v0__dffrnq_2
X$6692 \$23214 \$23346 \$23210 \$15037 \$23183 \$23454
+ gf180mcu_fd_sc_mcu9t5v0__dffrnq_2
X$6693 \$26417 \$26418 \$26419 \$15037 \$26401 \$26521
+ gf180mcu_fd_sc_mcu9t5v0__dffrnq_2
X$6694 \$23214 \$23949 \$23824 \$15037 \$23926 \$24109
+ gf180mcu_fd_sc_mcu9t5v0__dffrnq_2
X$6695 \$20065 \$19941 \$19911 \$15037 \$19927 \$20087
+ gf180mcu_fd_sc_mcu9t5v0__dffrnq_2
X$6696 \$26417 \$26385 \$26386 \$15037 \$26401 \$26521
+ gf180mcu_fd_sc_mcu9t5v0__dffrnq_2
X$6697 \$25022 \$24266 \$24125 \$15037 \$24231 \$24428
+ gf180mcu_fd_sc_mcu9t5v0__dffrnq_2
X$6698 \$20065 \$21333 \$21393 \$15037 \$21184 \$21308
+ gf180mcu_fd_sc_mcu9t5v0__dffrnq_2
X$6699 \$20065 \$20607 \$20856 \$15037 \$20515 \$20718
+ gf180mcu_fd_sc_mcu9t5v0__dffrnq_2
X$6700 \$15395 \$16111 \$15972 \$15037 \$15949 \$16070
+ gf180mcu_fd_sc_mcu9t5v0__dffrnq_2
X$6701 \$19300 \$18709 \$18603 \$15037 \$18701 \$18870
+ gf180mcu_fd_sc_mcu9t5v0__dffrnq_2
X$6702 \$19300 \$18549 \$18276 \$15037 \$18403 \$18576
+ gf180mcu_fd_sc_mcu9t5v0__dffrnq_2
X$6703 \$20065 \$22162 \$21838 \$15037 \$22074 \$22272
+ gf180mcu_fd_sc_mcu9t5v0__dffrnq_2
X$6704 \$23214 \$22927 \$16898 \$15037 \$23027 \$23139
+ gf180mcu_fd_sc_mcu9t5v0__dffrnq_2
X$6705 \$23214 \$23478 \$20616 \$15037 \$23620 \$23807
+ gf180mcu_fd_sc_mcu9t5v0__dffrnq_2
X$6706 \$20065 \$20545 \$20546 \$15037 \$20515 \$20718
+ gf180mcu_fd_sc_mcu9t5v0__dffrnq_2
X$6707 \$24127 \$25948 \$25619 \$15037 \$25797 \$25918
+ gf180mcu_fd_sc_mcu9t5v0__dffrnq_2
X$6708 \$28948 \$28362 \$27345 \$15037 \$28211 \$28381
+ gf180mcu_fd_sc_mcu9t5v0__dffrnq_2
X$6709 \$28062 \$28064 \$27609 \$15037 \$27913 \$28089
+ gf180mcu_fd_sc_mcu9t5v0__dffrnq_2
X$6710 \$26417 \$27667 \$23769 \$15037 \$27637 \$27776
+ gf180mcu_fd_sc_mcu9t5v0__dffrnq_2
X$6711 \$26417 \$27665 \$27666 \$15037 \$27637 \$27776
+ gf180mcu_fd_sc_mcu9t5v0__dffrnq_2
X$6712 \$24612 \$27664 \$27610 \$15037 \$27637 \$27776
+ gf180mcu_fd_sc_mcu9t5v0__dffrnq_2
X$6713 \$28948 \$28577 \$28578 \$15037 \$28534 \$28689
+ gf180mcu_fd_sc_mcu9t5v0__dffrnq_2
X$6714 \$15395 \$18155 \$16619 \$15037 \$18137 \$18293
+ gf180mcu_fd_sc_mcu9t5v0__dffrnq_2
X$6715 \$28948 \$28361 \$28387 \$15037 \$28211 \$28381
+ gf180mcu_fd_sc_mcu9t5v0__dffrnq_2
X$6716 \$28062 \$27607 \$27608 \$15037 \$27637 \$27776
+ gf180mcu_fd_sc_mcu9t5v0__dffrnq_2
X$6717 \$28948 \$28951 \$28952 \$15037 \$28810 \$28971
+ gf180mcu_fd_sc_mcu9t5v0__dffrnq_2
X$6718 \$25022 \$27046 \$26996 \$15037 \$27015 \$27153
+ gf180mcu_fd_sc_mcu9t5v0__dffrnq_2
X$6719 \$24612 \$26834 \$21330 \$15037 \$26675 \$26856
+ gf180mcu_fd_sc_mcu9t5v0__dffrnq_2
X$6720 \$28511 \$28579 \$28718 \$15037 \$28534 \$28689
+ gf180mcu_fd_sc_mcu9t5v0__dffrnq_2
X$6721 \$28511 \$28583 \$28068 \$15037 \$28534 \$28689
+ gf180mcu_fd_sc_mcu9t5v0__dffrnq_2
X$6722 \$26417 \$27054 \$27052 \$15037 \$27015 \$27153
+ gf180mcu_fd_sc_mcu9t5v0__dffrnq_2
X$6723 \$25951 \$26388 \$26422 \$15037 \$26401 \$26521
+ gf180mcu_fd_sc_mcu9t5v0__dffrnq_2
X$6724 \$28948 \$28949 \$29104 \$15037 \$28810 \$28971
+ gf180mcu_fd_sc_mcu9t5v0__dffrnq_2
X$6725 \$28062 \$27663 \$27173 \$15037 \$27637 \$27776
+ gf180mcu_fd_sc_mcu9t5v0__dffrnq_2
X$6726 \$25491 \$27475 \$27476 \$15037 \$27637 \$27449
+ gf180mcu_fd_sc_mcu9t5v0__dffrnq_2
X$6727 \$23609 \$23610 \$23957 \$15037 \$23620 \$23454
+ gf180mcu_fd_sc_mcu9t5v0__dffrnq_2
X$6728 \$28062 \$27174 \$18887 \$15037 \$27315 \$27153
+ gf180mcu_fd_sc_mcu9t5v0__dffrnq_2
X$6729 \$25491 \$27477 \$27305 \$15037 \$27637 \$27449
+ gf180mcu_fd_sc_mcu9t5v0__dffrnq_2
X$6730 \$25491 \$26880 \$26838 \$15037 \$27015 \$26856
+ gf180mcu_fd_sc_mcu9t5v0__dffrnq_2
X$6731 \$28062 \$28114 \$28063 \$15037 \$28211 \$28089
+ gf180mcu_fd_sc_mcu9t5v0__dffrnq_2
X$6732 \$28062 \$27471 \$23945 \$15037 \$27637 \$27449
+ gf180mcu_fd_sc_mcu9t5v0__dffrnq_2
X$6733 \$27942 \$28985 \$28367 \$15037 \$29123 \$28971
+ gf180mcu_fd_sc_mcu9t5v0__dffrnq_2
X$6734 \$23609 \$24275 \$24089 \$15037 \$24231 \$24109
+ gf180mcu_fd_sc_mcu9t5v0__dffrnq_2
X$6735 \$27942 \$28121 \$28079 \$15037 \$28211 \$28089
+ gf180mcu_fd_sc_mcu9t5v0__dffrnq_2
X$6736 \$25491 \$27059 \$27060 \$15037 \$27015 \$26856
+ gf180mcu_fd_sc_mcu9t5v0__dffrnq_2
X$6737 \$23609 \$23490 \$23491 \$15037 \$23620 \$23454
+ gf180mcu_fd_sc_mcu9t5v0__dffrnq_2
X$6738 \$23609 \$23483 \$23484 \$15037 \$23620 \$23454
+ gf180mcu_fd_sc_mcu9t5v0__dffrnq_2
X$6739 \$27942 \$28119 \$28077 \$15037 \$28211 \$28089
+ gf180mcu_fd_sc_mcu9t5v0__dffrnq_2
X$6740 \$24612 \$26697 \$25481 \$15037 \$26675 \$26521
+ gf180mcu_fd_sc_mcu9t5v0__dffrnq_2
X$6741 \$23609 \$23487 \$23353 \$15037 \$23620 \$23454
+ gf180mcu_fd_sc_mcu9t5v0__dffrnq_2
X$6742 \$21519 \$22879 \$22614 \$15037 \$23027 \$22837
+ gf180mcu_fd_sc_mcu9t5v0__dffrnq_2
X$6743 \$23609 \$24279 \$24095 \$15037 \$24231 \$24109
+ gf180mcu_fd_sc_mcu9t5v0__dffrnq_2
X$6744 \$18609 \$18610 \$17988 \$15037 \$18701 \$18576
+ gf180mcu_fd_sc_mcu9t5v0__dffrnq_2
X$6745 \$15395 \$17990 \$17991 \$15037 \$18137 \$17952
+ gf180mcu_fd_sc_mcu9t5v0__dffrnq_2
X$6746 \$20065 \$22872 \$22873 \$15037 \$23027 \$22837
+ gf180mcu_fd_sc_mcu9t5v0__dffrnq_2
X$6747 \$23609 \$24871 \$24758 \$15037 \$24877 \$24721
+ gf180mcu_fd_sc_mcu9t5v0__dffrnq_2
X$6748 \$25951 \$26549 \$25787 \$15037 \$26675 \$26521
+ gf180mcu_fd_sc_mcu9t5v0__dffrnq_2
X$6749 \$18609 \$22616 \$22880 \$15037 \$22713 \$22440
+ gf180mcu_fd_sc_mcu9t5v0__dffrnq_2
X$6750 \$23609 \$24129 \$24085 \$15037 \$24231 \$24109
+ gf180mcu_fd_sc_mcu9t5v0__dffrnq_2
X$6751 \$20065 \$22602 \$22285 \$15037 \$22713 \$22440
+ gf180mcu_fd_sc_mcu9t5v0__dffrnq_2
X$6752 \$26417 \$26542 \$26543 \$15037 \$26675 \$26521
+ gf180mcu_fd_sc_mcu9t5v0__dffrnq_2
X$6753 \$23609 \$25493 \$25341 \$15037 \$25462 \$25347
+ gf180mcu_fd_sc_mcu9t5v0__dffrnq_2
X$6754 \$25022 \$23947 \$23948 \$15037 \$23926 \$23807
+ gf180mcu_fd_sc_mcu9t5v0__dffrnq_2
X$6755 \$20065 \$21394 \$20608 \$15037 \$21498 \$21308
+ gf180mcu_fd_sc_mcu9t5v0__dffrnq_2
X$6756 \$23609 \$23489 \$23357 \$15037 \$23620 \$23454
+ gf180mcu_fd_sc_mcu9t5v0__dffrnq_2
X$6757 \$25951 \$27301 \$27186 \$15037 \$27315 \$27153
+ gf180mcu_fd_sc_mcu9t5v0__dffrnq_2
X$6758 \$20233 \$19177 \$19051 \$15037 \$19324 \$19149
+ gf180mcu_fd_sc_mcu9t5v0__dffrnq_2
X$6759 \$25491 \$26252 \$26253 \$15037 \$26401 \$26220
+ gf180mcu_fd_sc_mcu9t5v0__dffrnq_2
X$6760 \$20065 \$20102 \$19909 \$15037 \$20209 \$20087
+ gf180mcu_fd_sc_mcu9t5v0__dffrnq_2
X$6761 \$25491 \$25957 \$25958 \$15037 \$26088 \$25918
+ gf180mcu_fd_sc_mcu9t5v0__dffrnq_2
X$6762 \$25951 \$26878 \$26836 \$15037 \$27015 \$26856
+ gf180mcu_fd_sc_mcu9t5v0__dffrnq_2
X$6763 \$28062 \$27045 \$26833 \$15037 \$27015 \$26856
+ gf180mcu_fd_sc_mcu9t5v0__dffrnq_2
X$6764 \$20065 \$21968 \$21839 \$15037 \$22074 \$21946
+ gf180mcu_fd_sc_mcu9t5v0__dffrnq_2
X$6765 \$25491 \$27303 \$27349 \$15037 \$27315 \$27153
+ gf180mcu_fd_sc_mcu9t5v0__dffrnq_2
X$6766 \$20233 \$21176 \$19050 \$15037 \$21184 \$21011
+ gf180mcu_fd_sc_mcu9t5v0__dffrnq_2
X$6767 \$18609 \$19302 \$16479 \$15037 \$19324 \$19149
+ gf180mcu_fd_sc_mcu9t5v0__dffrnq_2
X$6768 \$28948 \$28953 \$29137 \$15037 \$29123 \$28971
+ gf180mcu_fd_sc_mcu9t5v0__dffrnq_2
X$6769 \$20233 \$21648 \$18893 \$15037 \$21661 \$21622
+ gf180mcu_fd_sc_mcu9t5v0__dffrnq_2
X$6770 \$25491 \$25338 \$25339 \$15037 \$25462 \$25347
+ gf180mcu_fd_sc_mcu9t5v0__dffrnq_2
X$6771 \$25491 \$25364 \$25340 \$15037 \$25462 \$25347
+ gf180mcu_fd_sc_mcu9t5v0__dffrnq_2
X$6772 \$20233 \$20857 \$20858 \$15037 \$20881 \$20718
+ gf180mcu_fd_sc_mcu9t5v0__dffrnq_2
X$6773 \$24127 \$25363 \$25336 \$15037 \$25462 \$25347
+ gf180mcu_fd_sc_mcu9t5v0__dffrnq_2
X$6774 \$21519 \$21521 \$20911 \$15037 \$21661 \$21622
+ gf180mcu_fd_sc_mcu9t5v0__dffrnq_2
X$6775 \$15395 \$17397 \$16904 \$15037 \$17538 \$17367
+ gf180mcu_fd_sc_mcu9t5v0__dffrnq_2
X$6776 \$18609 \$20736 \$20614 \$15037 \$20881 \$20718
+ gf180mcu_fd_sc_mcu9t5v0__dffrnq_2
X$6777 \$15395 \$18284 \$18154 \$15037 \$18403 \$18293
+ gf180mcu_fd_sc_mcu9t5v0__dffrnq_2
X$6778 \$20233 \$20105 \$20106 \$15037 \$20209 \$20087
+ gf180mcu_fd_sc_mcu9t5v0__dffrnq_2
X$6779 \$28948 \$28987 \$28590 \$15037 \$29123 \$28971
+ gf180mcu_fd_sc_mcu9t5v0__dffrnq_2
X$6780 \$19300 \$18605 \$18552 \$15037 \$18701 \$18576
+ gf180mcu_fd_sc_mcu9t5v0__dffrnq_2
X$6781 \$18609 \$19017 \$17392 \$15037 \$19027 \$18870
+ gf180mcu_fd_sc_mcu9t5v0__dffrnq_2
X$6782 \$23609 \$24755 \$24274 \$15037 \$24877 \$24721
+ gf180mcu_fd_sc_mcu9t5v0__dffrnq_2
X$6783 \$25491 \$25956 \$25822 \$15037 \$26088 \$25918
+ gf180mcu_fd_sc_mcu9t5v0__dffrnq_2
X$6784 \$20233 \$21647 \$20356 \$15037 \$21661 \$21622
+ gf180mcu_fd_sc_mcu9t5v0__dffrnq_2
X$6785 \$28948 \$28235 \$18548 \$15037 \$28211 \$28089
+ gf180mcu_fd_sc_mcu9t5v0__dffrnq_2
X$6786 \$18609 \$20861 \$20907 \$15037 \$20881 \$20718
+ gf180mcu_fd_sc_mcu9t5v0__dffrnq_2
X$6787 \$18609 \$20737 \$20550 \$15037 \$20881 \$20718
+ gf180mcu_fd_sc_mcu9t5v0__dffrnq_2
X$6788 \$25491 \$27304 \$27350 \$15037 \$27315 \$27153
+ gf180mcu_fd_sc_mcu9t5v0__dffrnq_2
X$6789 \$27942 \$28118 \$28074 \$15037 \$28211 \$28089
+ gf180mcu_fd_sc_mcu9t5v0__dffrnq_2
X$6790 \$27942 \$28588 \$28515 \$15037 \$28810 \$28689
+ gf180mcu_fd_sc_mcu9t5v0__dffrnq_2
X$6791 \$15395 \$17398 \$16907 \$15037 \$17538 \$17367
+ gf180mcu_fd_sc_mcu9t5v0__dffrnq_2
X$6792 \$15395 \$15785 \$15647 \$15037 \$15949 \$15749
+ gf180mcu_fd_sc_mcu9t5v0__dffrnq_2
X$6793 \$20065 \$21339 \$19627 \$15037 \$21498 \$21308
+ gf180mcu_fd_sc_mcu9t5v0__dffrnq_2
X$6794 \$15395 \$16414 \$16416 \$15037 \$16436 \$16376
+ gf180mcu_fd_sc_mcu9t5v0__dffrnq_2
X$6795 \$27942 \$28120 \$28078 \$15037 \$28211 \$28089
+ gf180mcu_fd_sc_mcu9t5v0__dffrnq_2
X$6796 \$25951 \$26249 \$26119 \$15037 \$26401 \$26220
+ gf180mcu_fd_sc_mcu9t5v0__dffrnq_2
X$6797 \$25491 \$25492 \$24579 \$15037 \$25462 \$25347
+ gf180mcu_fd_sc_mcu9t5v0__dffrnq_2
X$6798 \$19300 \$20104 \$16406 \$15037 \$20209 \$20087
+ gf180mcu_fd_sc_mcu9t5v0__dffrnq_2
X$6799 \$27942 \$28722 \$28587 \$15037 \$28810 \$28689
+ gf180mcu_fd_sc_mcu9t5v0__dffrnq_2
X$6800 \$23609 \$24276 \$24091 \$15037 \$24231 \$24109
+ gf180mcu_fd_sc_mcu9t5v0__dffrnq_2
X$6801 \$19300 \$18604 \$18550 \$15037 \$18701 \$18576
+ gf180mcu_fd_sc_mcu9t5v0__dffrnq_2
X$6802 \$19300 \$19176 \$17129 \$15037 \$19324 \$19149
+ gf180mcu_fd_sc_mcu9t5v0__dffrnq_2
X$6803 \$19300 \$18890 \$18849 \$15037 \$19027 \$18870
+ gf180mcu_fd_sc_mcu9t5v0__dffrnq_2
X$6804 \$18609 \$19945 \$19918 \$15037 \$20209 \$20087
+ gf180mcu_fd_sc_mcu9t5v0__dffrnq_2
X$6805 \$19300 \$19483 \$19484 \$15037 \$19605 \$19466
+ gf180mcu_fd_sc_mcu9t5v0__dffrnq_2
X$6806 \$19300 \$18602 \$17524 \$15037 \$18701 \$18576
+ gf180mcu_fd_sc_mcu9t5v0__dffrnq_2
X$6807 \$19300 \$19010 \$19011 \$15037 \$19027 \$18870
+ gf180mcu_fd_sc_mcu9t5v0__dffrnq_2
X$6808 \$18609 \$20108 \$19495 \$15037 \$20209 \$20087
+ gf180mcu_fd_sc_mcu9t5v0__dffrnq_2
X$6809 \$21519 \$21404 \$21341 \$15037 \$21498 \$21308
+ gf180mcu_fd_sc_mcu9t5v0__dffrnq_2
X$6810 \$19300 \$18889 \$17847 \$15037 \$19027 \$18870
+ gf180mcu_fd_sc_mcu9t5v0__dffrnq_2
X$6811 \$19300 \$19012 \$18891 \$15037 \$19027 \$18870
+ gf180mcu_fd_sc_mcu9t5v0__dffrnq_2
X$6812 \$27942 \$29283 \$29111 \$15037 \$29290 \$29270
+ gf180mcu_fd_sc_mcu9t5v0__dffrnq_2
X$6813 \$25491 \$26392 \$26251 \$15037 \$26401 \$26220
+ gf180mcu_fd_sc_mcu9t5v0__dffrnq_2
X$6814 \$25951 \$26250 \$25954 \$15037 \$26401 \$26220
+ gf180mcu_fd_sc_mcu9t5v0__dffrnq_2
X$6815 \$24127 \$25100 \$25335 \$15037 \$25191 \$24997
+ gf180mcu_fd_sc_mcu9t5v0__dffrnq_2
X$6816 \$24127 \$24333 \$24332 \$15037 \$24593 \$24428
+ gf180mcu_fd_sc_mcu9t5v0__dffrnq_2
X$6817 \$24127 \$24570 \$24568 \$15037 \$24593 \$24428
+ gf180mcu_fd_sc_mcu9t5v0__dffrnq_2
X$6818 \$20233 \$22172 \$21699 \$15037 \$22387 \$22272
+ gf180mcu_fd_sc_mcu9t5v0__dffrnq_2
X$6819 \$19300 \$19175 \$19048 \$15037 \$19324 \$19149
+ gf180mcu_fd_sc_mcu9t5v0__dffrnq_2
X$6820 \$19300 \$19790 \$19620 \$15037 \$19927 \$19774
+ gf180mcu_fd_sc_mcu9t5v0__dffrnq_2
X$6821 \$27942 \$28391 \$28365 \$15037 \$28534 \$28381
+ gf180mcu_fd_sc_mcu9t5v0__dffrnq_2
X$6822 \$24127 \$25781 \$25782 \$15037 \$25797 \$25632
+ gf180mcu_fd_sc_mcu9t5v0__dffrnq_2
X$6823 \$24127 \$25028 \$25030 \$15037 \$25191 \$24997
+ gf180mcu_fd_sc_mcu9t5v0__dffrnq_2
X$6824 \$20233 \$21972 \$21701 \$15037 \$22074 \$21946
+ gf180mcu_fd_sc_mcu9t5v0__dffrnq_2
X$6825 \$25951 \$27182 \$27055 \$15037 \$27315 \$27153
+ gf180mcu_fd_sc_mcu9t5v0__dffrnq_2
X$6826 \$23214 \$23788 \$23789 \$15037 \$23926 \$23807
+ gf180mcu_fd_sc_mcu9t5v0__dffrnq_2
X$6827 \$25951 \$27183 \$27184 \$15037 \$27315 \$27153
+ gf180mcu_fd_sc_mcu9t5v0__dffrnq_2
X$6828 \$25951 \$26389 \$24316 \$15037 \$26401 \$26220
+ gf180mcu_fd_sc_mcu9t5v0__dffrnq_2
X$6829 \$26417 \$26997 \$24542 \$15037 \$27015 \$26856
+ gf180mcu_fd_sc_mcu9t5v0__dffrnq_2
X$6830 \$26417 \$27473 \$15847 \$15037 \$27637 \$27449
+ gf180mcu_fd_sc_mcu9t5v0__dffrnq_2
X$6831 \$23214 \$23166 \$23215 \$15037 \$23183 \$23139
+ gf180mcu_fd_sc_mcu9t5v0__dffrnq_2
X$6832 \$26417 \$27175 \$27176 \$15037 \$27315 \$27153
+ gf180mcu_fd_sc_mcu9t5v0__dffrnq_2
X$6833 \$21519 \$22933 \$19351 \$15037 \$23027 \$22837
+ gf180mcu_fd_sc_mcu9t5v0__dffrnq_2
X$6834 \$24127 \$23954 \$22926 \$15037 \$23926 \$23807
+ gf180mcu_fd_sc_mcu9t5v0__dffrnq_2
X$6835 \$24127 \$23955 \$23163 \$15037 \$23926 \$23807
+ gf180mcu_fd_sc_mcu9t5v0__dffrnq_2
X$6836 \$26417 \$26998 \$27051 \$15037 \$27015 \$26856
+ gf180mcu_fd_sc_mcu9t5v0__dffrnq_2
X$6837 \$26417 \$27178 \$27179 \$15037 \$27315 \$27153
+ gf180mcu_fd_sc_mcu9t5v0__dffrnq_2
X$6838 \$23214 \$23605 \$19915 \$15037 \$23620 \$23454
+ gf180mcu_fd_sc_mcu9t5v0__dffrnq_2
X$6839 \$28511 \$27808 \$21644 \$15037 \$27913 \$27776
+ gf180mcu_fd_sc_mcu9t5v0__dffrnq_2
X$6840 \$24127 \$25778 \$25779 \$15037 \$25797 \$25632
+ gf180mcu_fd_sc_mcu9t5v0__dffrnq_2
X$6841 \$27942 \$27943 \$28069 \$15037 \$27913 \$27776
+ gf180mcu_fd_sc_mcu9t5v0__dffrnq_2
X$6842 \$26417 \$25987 \$25776 \$15037 \$26088 \$25918
+ gf180mcu_fd_sc_mcu9t5v0__dffrnq_2
X$6843 \$28511 \$28983 \$29136 \$15037 \$29123 \$28971
+ gf180mcu_fd_sc_mcu9t5v0__dffrnq_2
X$6844 \$25951 \$26877 \$26835 \$15037 \$27015 \$26856
+ gf180mcu_fd_sc_mcu9t5v0__dffrnq_2
X$6845 \$25022 \$26874 \$18274 \$15037 \$27015 \$26856
+ gf180mcu_fd_sc_mcu9t5v0__dffrnq_2
X$6846 \$23214 \$23045 \$22604 \$15037 \$23027 \$22837
+ gf180mcu_fd_sc_mcu9t5v0__dffrnq_2
X$6847 \$27942 \$28392 \$28366 \$15037 \$28534 \$28381
+ gf180mcu_fd_sc_mcu9t5v0__dffrnq_2
X$6848 \$26417 \$26875 \$15344 \$15037 \$27015 \$26856
+ gf180mcu_fd_sc_mcu9t5v0__dffrnq_2
X$6849 \$23214 \$24126 \$24078 \$15037 \$24231 \$24109
+ gf180mcu_fd_sc_mcu9t5v0__dffrnq_2
X$6850 \$28511 \$28388 \$17679 \$15037 \$28534 \$28381
+ gf180mcu_fd_sc_mcu9t5v0__dffrnq_2
X$6851 \$28511 \$28512 \$28513 \$15037 \$28534 \$28381
+ gf180mcu_fd_sc_mcu9t5v0__dffrnq_2
X$6852 \$26417 \$27472 \$17393 \$15037 \$27637 \$27449
+ gf180mcu_fd_sc_mcu9t5v0__dffrnq_2
X$6853 \$20065 \$21334 \$21335 \$15037 \$21498 \$21308
+ gf180mcu_fd_sc_mcu9t5v0__dffrnq_2
X$6854 \$28511 \$27813 \$27670 \$15037 \$27913 \$27776
+ gf180mcu_fd_sc_mcu9t5v0__dffrnq_2
X$6855 \$25951 \$25991 \$25953 \$15037 \$26088 \$25918
+ gf180mcu_fd_sc_mcu9t5v0__dffrnq_2
X$6856 \$26417 \$27299 \$27347 \$15037 \$27315 \$27153
+ gf180mcu_fd_sc_mcu9t5v0__dffrnq_2
X$6857 \$23214 \$24564 \$24615 \$15037 \$24593 \$24428
+ gf180mcu_fd_sc_mcu9t5v0__dffrnq_2
X$6858 \$25022 \$25484 \$25329 \$15037 \$25462 \$25347
+ gf180mcu_fd_sc_mcu9t5v0__dffrnq_2
X$6859 \$20065 \$20418 \$20419 \$15037 \$20515 \$20383
+ gf180mcu_fd_sc_mcu9t5v0__dffrnq_2
X$6860 \$20065 \$21035 \$21036 \$15037 \$21184 \$21011
+ gf180mcu_fd_sc_mcu9t5v0__dffrnq_2
X$6861 \$20233 \$22414 \$22415 \$15037 \$22387 \$22272
+ gf180mcu_fd_sc_mcu9t5v0__dffrnq_2
X$6862 \$23214 \$23476 \$20902 \$15037 \$23620 \$23454
+ gf180mcu_fd_sc_mcu9t5v0__dffrnq_2
X$6863 \$20233 \$22169 \$22170 \$15037 \$22387 \$22272
+ gf180mcu_fd_sc_mcu9t5v0__dffrnq_2
X$6864 \$28511 \$28585 \$28586 \$15037 \$28534 \$28381
+ gf180mcu_fd_sc_mcu9t5v0__dffrnq_2
X$6865 \$28511 \$27814 \$27941 \$15037 \$27913 \$27776
+ gf180mcu_fd_sc_mcu9t5v0__dffrnq_2
X$6866 \$28511 \$28389 \$28580 \$15037 \$28534 \$28381
+ gf180mcu_fd_sc_mcu9t5v0__dffrnq_2
X$6867 \$28511 \$28984 \$28955 \$15037 \$29123 \$28971
+ gf180mcu_fd_sc_mcu9t5v0__dffrnq_2
X$6868 \$28511 \$28390 \$27612 \$15037 \$28534 \$28381
+ gf180mcu_fd_sc_mcu9t5v0__dffrnq_2
X$6869 \$28511 \$27938 \$28065 \$15037 \$27913 \$27776
+ gf180mcu_fd_sc_mcu9t5v0__dffrnq_2
X$6870 \$24612 \$25942 \$25943 \$15037 \$26088 \$25918
+ gf180mcu_fd_sc_mcu9t5v0__dffrnq_2
X$6871 \$25951 \$25785 \$25645 \$15037 \$25797 \$25632
+ gf180mcu_fd_sc_mcu9t5v0__dffrnq_2
X$6872 \$24612 \$25480 \$25617 \$15037 \$25462 \$25347
+ gf180mcu_fd_sc_mcu9t5v0__dffrnq_2
X$6873 \$25022 \$26378 \$22589 \$15037 \$26401 \$26220
+ gf180mcu_fd_sc_mcu9t5v0__dffrnq_2
X$6874 \$18609 \$20549 \$19914 \$15037 \$20515 \$20383
+ gf180mcu_fd_sc_mcu9t5v0__dffrnq_2
X$6875 \$25022 \$25945 \$25774 \$15037 \$26088 \$25918
+ gf180mcu_fd_sc_mcu9t5v0__dffrnq_2
X$6876 \$21519 \$22934 \$21690 \$15037 \$23027 \$22837
+ gf180mcu_fd_sc_mcu9t5v0__dffrnq_2
X$6877 \$23214 \$22932 \$23167 \$15037 \$23027 \$22837
+ gf180mcu_fd_sc_mcu9t5v0__dffrnq_2
X$6878 \$15040 \$15045 \$15204 \$15143 gf180mcu_fd_sc_mcu9t5v0__clkinv_1
X$6879 \$15201 \$17490 \$15041 \$18250 \$18137 \$18293 \$18248
+ gf180mcu_fd_sc_mcu9t5v0__aoi22_1
X$6880 \$17491 \$17538 \$17367 \$15041 gf180mcu_fd_sc_mcu9t5v0__buf_8
X$6881 \$15147 \$15146 \$15041 \$15045 \$15204 \$15313
+ gf180mcu_fd_sc_mcu9t5v0__mux2_1
X$6882 \$15203 \$17027 \$15041 \$16914 \$17034 \$17026
+ gf180mcu_fd_sc_mcu9t5v0__mux2_1
X$6883 \$18291 \$18290 \$15041 \$18403 \$18293 \$18251
+ gf180mcu_fd_sc_mcu9t5v0__mux2_1
X$6884 \$15160 \$15159 \$15045 \$15204 \$15158 gf180mcu_fd_sc_mcu9t5v0__nand2_1
X$6885 \$15184 \$15183 \$15223 \$15045 \$15204 \$15225
+ gf180mcu_fd_sc_mcu9t5v0__mux2_1
X$6886 \$15204 \$15045 gf180mcu_fd_sc_mcu9t5v0__filltie
X$6887 \$15204 \$15045 gf180mcu_fd_sc_mcu9t5v0__filltie
X$6888 \$15204 \$15045 gf180mcu_fd_sc_mcu9t5v0__filltie
X$6889 \$15204 \$15045 gf180mcu_fd_sc_mcu9t5v0__filltie
X$6890 \$15204 \$15045 gf180mcu_fd_sc_mcu9t5v0__filltie
X$6891 \$15204 \$15045 gf180mcu_fd_sc_mcu9t5v0__filltie
X$6892 \$15204 \$15045 gf180mcu_fd_sc_mcu9t5v0__endcap
X$6893 \$22268 \$22383 \$22269 \$22387 \$22272 \$15050
+ gf180mcu_fd_sc_mcu9t5v0__aoi21_1
X$6894 \$15053 \$16452 \$17244 \$17966 \$17818 \$17952 \$17831
+ gf180mcu_fd_sc_mcu9t5v0__aoi22_1
X$6895 \$15190 \$15142 \$15321 \$15490 \$15191 gf180mcu_fd_sc_mcu9t5v0__or2_1
X$6896 \$15190 \$15142 \$15321 \$15204 \$15311 gf180mcu_fd_sc_mcu9t5v0__nand2_1
X$6897 \$15943 \$15145 \$15949 \$16070 \$16065 gf180mcu_fd_sc_mcu9t5v0__nand2_1
X$6898 \$15147 \$15745 \$16845 \$15628 \$15749 \$16067
+ gf180mcu_fd_sc_mcu9t5v0__mux2_1
X$6899 \$15147 \$19279 \$19278 \$19027 \$19149 \$19153
+ gf180mcu_fd_sc_mcu9t5v0__mux2_1
X$6900 \$15147 \$22437 \$22270 \$22387 \$22272 \$22384
+ gf180mcu_fd_sc_mcu9t5v0__mux2_1
X$6901 \$15147 \$22570 \$21496 \$22713 \$22440 \$22711
+ gf180mcu_fd_sc_mcu9t5v0__mux2_1
X$6902 \$15147 \$22079 \$20716 \$22074 \$21946 \$22078
+ gf180mcu_fd_sc_mcu9t5v0__mux2_1
X$6903 \$15147 \$15952 \$16438 \$16269 \$16070 \$16071
+ gf180mcu_fd_sc_mcu9t5v0__mux2_1
X$6904 \$15147 \$20516 \$19776 \$20515 \$20383 \$20576
+ gf180mcu_fd_sc_mcu9t5v0__mux2_1
X$6905 \$15505 \$16452 \$15166 \$15154 \$15628 \$15490 \$15632
+ gf180mcu_fd_sc_mcu9t5v0__aoi22_1
X$6906 \$15632 \$15156 \$15628 \$15749 \$15626 gf180mcu_fd_sc_mcu9t5v0__nand2_1
X$6907 \$15159 \$17662 \$17545 \$17538 \$17703 \$17663
+ gf180mcu_fd_sc_mcu9t5v0__oai21_1
X$6908 \$15159 \$15372 \$15638 \$15628 \$15749 \$15508
+ gf180mcu_fd_sc_mcu9t5v0__oai21_1
X$6909 \$15159 \$15758 \$15760 \$15628 \$15749 \$15759
+ gf180mcu_fd_sc_mcu9t5v0__oai21_1
X$6910 \$15159 \$25461 \$24996 \$24877 \$24997 \$24995
+ gf180mcu_fd_sc_mcu9t5v0__oai21_1
X$6911 \$15159 \$16389 \$18542 \$18403 \$18576 \$18414
+ gf180mcu_fd_sc_mcu9t5v0__oai21_1
X$6912 \$15159 \$16386 \$16387 \$16269 \$16376 \$16453
+ gf180mcu_fd_sc_mcu9t5v0__oai21_1
X$6913 \$15159 \$16735 \$17048 \$16914 \$17034 \$16863
+ gf180mcu_fd_sc_mcu9t5v0__oai21_1
X$6914 \$15159 \$24848 \$24299 \$24231 \$24428 \$24298
+ gf180mcu_fd_sc_mcu9t5v0__oai21_1
X$6915 \$15159 \$18266 \$18267 \$18137 \$18293 \$18265
+ gf180mcu_fd_sc_mcu9t5v0__oai21_1
X$6916 \$15159 \$26089 \$26090 \$26088 \$26220 \$26219
+ gf180mcu_fd_sc_mcu9t5v0__oai21_1
X$6917 \$15159 \$16469 \$16470 \$16436 \$16376 \$16869
+ gf180mcu_fd_sc_mcu9t5v0__oai21_1
X$6918 \$15159 \$17659 \$17500 \$17538 \$17367 \$17543
+ gf180mcu_fd_sc_mcu9t5v0__oai21_1
X$6919 \$15159 \$17499 \$17379 \$17538 \$17367 \$17657
+ gf180mcu_fd_sc_mcu9t5v0__oai21_1
X$6920 \$15159 \$15500 \$15501 \$15628 \$15490 \$15630
+ gf180mcu_fd_sc_mcu9t5v0__oai21_1
X$6921 \$15159 \$17385 \$18593 \$18701 \$18576 \$18830
+ gf180mcu_fd_sc_mcu9t5v0__oai21_1
X$6922 \$15159 \$18543 \$18595 \$18701 \$18576 \$18594
+ gf180mcu_fd_sc_mcu9t5v0__oai21_1
X$6923 \$15159 \$16861 \$16862 \$16914 \$16728 \$16920
+ gf180mcu_fd_sc_mcu9t5v0__oai21_1
X$6924 \$15159 \$16081 \$16137 \$16269 \$16070 \$16136
+ gf180mcu_fd_sc_mcu9t5v0__oai21_1
X$6925 \$15159 \$16139 \$16082 \$16269 \$16070 \$16138
+ gf180mcu_fd_sc_mcu9t5v0__oai21_1
X$6926 \$15159 \$15820 \$16143 \$16269 \$16070 \$16141
+ gf180mcu_fd_sc_mcu9t5v0__oai21_1
X$6927 \$15159 \$17827 \$17711 \$17818 \$17703 \$17710
+ gf180mcu_fd_sc_mcu9t5v0__oai21_1
X$6928 \$15159 \$16150 \$17835 \$17818 \$17703 \$17834
+ gf180mcu_fd_sc_mcu9t5v0__oai21_1
X$6929 \$15159 \$16144 \$16146 \$16269 \$16070 \$16145
+ gf180mcu_fd_sc_mcu9t5v0__oai21_1
X$6930 \$15159 \$18029 \$18030 \$18137 \$17952 \$18028
+ gf180mcu_fd_sc_mcu9t5v0__oai21_1
X$6931 \$15159 \$17117 \$17118 \$17085 \$17034 \$17248
+ gf180mcu_fd_sc_mcu9t5v0__oai21_1
X$6932 \$15159 \$16151 \$16272 \$16269 \$16070 \$16087
+ gf180mcu_fd_sc_mcu9t5v0__oai21_1
X$6933 \$15159 \$16467 \$17665 \$17818 \$17703 \$17836
+ gf180mcu_fd_sc_mcu9t5v0__oai21_1
X$6934 \$15159 \$17837 \$18301 \$18403 \$18293 \$18419
+ gf180mcu_fd_sc_mcu9t5v0__oai21_1
X$6935 \$23756 \$15159 \$24847 \$27775 \$27913 \$27776 \$27916
+ gf180mcu_fd_sc_mcu9t5v0__oai31_1
X$6936 \$15159 \$24847 \$28688 \$28488 \$28534 \$28689 \$28536
+ gf180mcu_fd_sc_mcu9t5v0__oai31_1
X$6937 \$15159 \$26679 \$26675 \$26521 \$26525 gf180mcu_fd_sc_mcu9t5v0__nand2_1
X$6938 \$16086 \$15159 \$16269 \$16376 \$16272 gf180mcu_fd_sc_mcu9t5v0__nand2_1
X$6939 \$16924 \$15159 \$16914 \$17034 \$16470 gf180mcu_fd_sc_mcu9t5v0__nand2_1
X$6940 \$16597 \$15159 \$16436 \$16728 \$16387 gf180mcu_fd_sc_mcu9t5v0__nand2_1
X$6941 \$18591 \$15159 \$18701 \$18870 \$18267 gf180mcu_fd_sc_mcu9t5v0__nand2_1
X$6942 \$15761 \$15159 \$15628 \$15749 \$15760 gf180mcu_fd_sc_mcu9t5v0__nand2_1
X$6943 \$15755 \$15159 \$16269 \$16376 \$16137 gf180mcu_fd_sc_mcu9t5v0__nand2_1
X$6944 \$16864 \$15159 \$16914 \$17034 \$17048 gf180mcu_fd_sc_mcu9t5v0__nand2_1
X$6945 \$17374 \$15159 \$26088 \$26220 \$26090 gf180mcu_fd_sc_mcu9t5v0__nand2_1
X$6946 \$17664 \$15159 \$17538 \$17703 \$17665 gf180mcu_fd_sc_mcu9t5v0__nand2_1
X$6947 \$18415 \$15159 \$18403 \$18576 \$18542 gf180mcu_fd_sc_mcu9t5v0__nand2_1
X$6948 \$16388 \$15159 \$15949 \$16070 \$16082 gf180mcu_fd_sc_mcu9t5v0__nand2_1
X$6949 \$17040 \$15159 \$24593 \$24428 \$24299 gf180mcu_fd_sc_mcu9t5v0__nand2_1
X$6950 \$17099 \$15159 \$24877 \$24721 \$24996 gf180mcu_fd_sc_mcu9t5v0__nand2_1
X$6951 \$28489 \$15159 \$28534 \$28381 \$28488 gf180mcu_fd_sc_mcu9t5v0__nand2_1
X$6952 \$27917 \$15159 \$27913 \$27776 \$27775 gf180mcu_fd_sc_mcu9t5v0__nand2_1
X$6953 \$17970 \$15159 \$18137 \$17952 \$17839 gf180mcu_fd_sc_mcu9t5v0__nand2_1
X$6954 \$16457 \$15159 \$16436 \$16376 \$16146 gf180mcu_fd_sc_mcu9t5v0__nand2_1
X$6955 \$17714 \$15159 \$17818 \$17703 \$17835 gf180mcu_fd_sc_mcu9t5v0__nand2_1
X$6956 \$17503 \$15159 \$17538 \$17367 \$17545 gf180mcu_fd_sc_mcu9t5v0__nand2_1
X$6957 \$17498 \$15159 \$26675 \$26521 \$26677 gf180mcu_fd_sc_mcu9t5v0__nand2_1
X$6958 \$16149 \$15159 \$18701 \$18576 \$18595 gf180mcu_fd_sc_mcu9t5v0__nand2_1
X$6959 \$15507 \$15159 \$15628 \$15490 \$15638 gf180mcu_fd_sc_mcu9t5v0__nand2_1
X$6960 \$18590 \$15159 \$18701 \$18576 \$18593 gf180mcu_fd_sc_mcu9t5v0__nand2_1
X$6961 \$18413 \$15159 \$18403 \$18293 \$18301 gf180mcu_fd_sc_mcu9t5v0__nand2_1
X$6962 \$18269 \$15159 \$18403 \$18293 \$18030 gf180mcu_fd_sc_mcu9t5v0__nand2_1
X$6963 \$15754 \$15159 \$15628 \$15490 \$15501 gf180mcu_fd_sc_mcu9t5v0__nand2_1
X$6964 \$17100 \$15159 \$17085 \$17034 \$16862 gf180mcu_fd_sc_mcu9t5v0__nand2_1
X$6965 \$17243 \$15159 \$17818 \$17703 \$17711 gf180mcu_fd_sc_mcu9t5v0__nand2_1
X$6966 \$17382 \$15159 \$17538 \$17367 \$17118 gf180mcu_fd_sc_mcu9t5v0__nand2_1
X$6967 \$17101 \$15159 \$17818 \$17703 \$17500 gf180mcu_fd_sc_mcu9t5v0__nand2_1
X$6968 \$16456 \$15159 \$16436 \$16376 \$16143 gf180mcu_fd_sc_mcu9t5v0__nand2_1
X$6969 \$17242 \$15159 \$17818 \$17703 \$17379 gf180mcu_fd_sc_mcu9t5v0__nand2_1
X$6970 \$27026 \$27015 \$27153 \$15159 gf180mcu_fd_sc_mcu9t5v0__buf_8
X$6971 \$15212 \$16452 \$15166 \$15160 \$15321 \$15490 \$15503
+ gf180mcu_fd_sc_mcu9t5v0__aoi22_1
X$6972 \$15165 \$15217 \$15321 \$15204 \$15206 gf180mcu_fd_sc_mcu9t5v0__nand2_1
X$6973 \$17714 \$16452 \$15166 \$18269 \$17818 \$17952 \$17833
+ gf180mcu_fd_sc_mcu9t5v0__aoi22_1
X$6974 \$17246 \$16452 \$15166 \$17384 \$17085 \$17367 \$17109
+ gf180mcu_fd_sc_mcu9t5v0__aoi22_1
X$6975 \$17100 \$16452 \$15166 \$17242 \$17085 \$17034 \$17046
+ gf180mcu_fd_sc_mcu9t5v0__aoi22_1
X$6976 \$16086 \$16452 \$15166 \$16149 \$16269 \$16070 \$16083
+ gf180mcu_fd_sc_mcu9t5v0__aoi22_1
X$6977 \$18145 \$15166 \$15216 \$16271 \$16914 \$17034 \$16868
+ gf180mcu_fd_sc_mcu9t5v0__aoi22_1
X$6978 \$18591 \$15166 \$15216 \$18415 \$18701 \$18576 \$18540
+ gf180mcu_fd_sc_mcu9t5v0__aoi22_1
X$6979 \$18877 \$15166 \$15216 \$18588 \$19027 \$18870 \$18876
+ gf180mcu_fd_sc_mcu9t5v0__aoi22_1
X$6980 \$16388 \$15166 \$17244 \$16864 \$16914 \$16728 \$16865
+ gf180mcu_fd_sc_mcu9t5v0__aoi22_1
X$6981 \$17503 \$15166 \$15216 \$16924 \$17538 \$17367 \$17544
+ gf180mcu_fd_sc_mcu9t5v0__aoi22_1
X$6982 \$18024 \$15166 \$17244 \$18023 \$18137 \$17952 \$17962
+ gf180mcu_fd_sc_mcu9t5v0__aoi22_1
X$6983 \$18027 \$15166 \$15216 \$18026 \$18137 \$17952 \$17965
+ gf180mcu_fd_sc_mcu9t5v0__aoi22_1
X$6984 \$25596 \$25462 \$25632 \$15166 gf180mcu_fd_sc_mcu9t5v0__buf_8
X$6985 \$16092 \$16093 \$15949 \$16070 \$15170 \$15767
+ gf180mcu_fd_sc_mcu9t5v0__xnor3_1
X$6986 \$16094 \$15768 \$15949 \$15749 \$15173 gf180mcu_fd_sc_mcu9t5v0__nand2_1
X$6987 \$15846 \$15845 \$16104 \$15949 \$16070 \$15179
+ gf180mcu_fd_sc_mcu9t5v0__aoi21_1
X$6988 \$15780 \$15628 \$15490 \$15180 \$15528 gf180mcu_fd_sc_mcu9t5v0__xor2_1
X$6989 \$15394 \$15393 \$15628 \$15490 \$15180 gf180mcu_fd_sc_mcu9t5v0__xnor2_1
X$6990 \$15394 \$15393 \$15321 \$15490 \$15181 gf180mcu_fd_sc_mcu9t5v0__nand2_1
X$6991 \$16416 \$15973 \$15949 \$16070 \$15184 \$16112
+ gf180mcu_fd_sc_mcu9t5v0__xnor3_1
X$6992 \$15195 \$17085 \$17367 \$15201 gf180mcu_fd_sc_mcu9t5v0__clkbuf_1
X$6993 \$15195 \$20825 \$20867 \$20824 \$20881 \$20718 \$20558
+ gf180mcu_fd_sc_mcu9t5v0__oai22_1
X$6994 \$22443 \$19150 \$21809 \$15195 \$22387 \$22440 \$22442
+ gf180mcu_fd_sc_mcu9t5v0__aoi22_1
X$6995 \$23621 \$15195 \$21621 \$23620 \$23807 \$23590
+ gf180mcu_fd_sc_mcu9t5v0__mux2_1
X$6996 \$23453 \$15195 \$22073 \$23183 \$23139 \$23324
+ gf180mcu_fd_sc_mcu9t5v0__mux2_1
X$6997 \$15195 \$23020 \$18991 \$23027 \$23139 \$22886
+ gf180mcu_fd_sc_mcu9t5v0__mux2_1
X$6998 \$15195 \$23453 \$20083 \$23620 \$23454 \$23455
+ gf180mcu_fd_sc_mcu9t5v0__mux2_1
X$6999 \$15357 \$15198 \$15321 \$15490 \$15488 gf180mcu_fd_sc_mcu9t5v0__nand2_1
X$7000 \$15200 \$15321 \$15204 \$15319 gf180mcu_fd_sc_mcu9t5v0__clkinv_1
X$7001 \$15201 \$22130 \$20716 \$22074 \$22272 \$22129
+ gf180mcu_fd_sc_mcu9t5v0__mux2_1
X$7002 \$15201 \$20882 \$19278 \$20881 \$21011 \$20839
+ gf180mcu_fd_sc_mcu9t5v0__mux2_1
X$7003 \$15201 \$17949 \$16438 \$17818 \$17952 \$17948
+ gf180mcu_fd_sc_mcu9t5v0__mux2_1
X$7004 \$15201 \$22708 \$22270 \$22713 \$22440 \$22707
+ gf180mcu_fd_sc_mcu9t5v0__mux2_1
X$7005 \$15201 \$22834 \$21496 \$22713 \$22440 \$22710
+ gf180mcu_fd_sc_mcu9t5v0__mux2_1
X$7006 \$15201 \$19467 \$19776 \$19605 \$19466 \$19326
+ gf180mcu_fd_sc_mcu9t5v0__mux2_1
X$7007 \$15201 \$17029 \$16845 \$17085 \$17034 \$17028
+ gf180mcu_fd_sc_mcu9t5v0__mux2_1
X$7008 \$15203 \$16434 \$16845 \$16269 \$16376 \$16374
+ gf180mcu_fd_sc_mcu9t5v0__mux2_1
X$7009 \$15203 \$21810 \$20716 \$21661 \$21946 \$21954
+ gf180mcu_fd_sc_mcu9t5v0__mux2_1
X$7010 \$15203 \$20583 \$19278 \$20515 \$20718 \$20582
+ gf180mcu_fd_sc_mcu9t5v0__mux2_1
X$7011 \$15203 \$23451 \$21496 \$23183 \$23139 \$23588
+ gf180mcu_fd_sc_mcu9t5v0__mux2_1
X$7012 \$15203 \$21141 \$22270 \$21184 \$21011 \$21140
+ gf180mcu_fd_sc_mcu9t5v0__mux2_1
X$7013 \$15203 \$18008 \$16438 \$18137 \$17952 \$18138
+ gf180mcu_fd_sc_mcu9t5v0__mux2_1
X$7014 \$15203 \$19929 \$19776 \$19927 \$19774 \$19928
+ gf180mcu_fd_sc_mcu9t5v0__mux2_1
X$7015 \$18406 \$15321 \$15204 \$15327 gf180mcu_fd_sc_mcu9t5v0__clkinv_1
X$7016 \$15343 \$15222 \$15321 \$15204 \$15342 gf180mcu_fd_sc_mcu9t5v0__nand2_1
X$7017 \$15204 \$15321 gf180mcu_fd_sc_mcu9t5v0__filltie
X$7018 \$15204 \$15321 gf180mcu_fd_sc_mcu9t5v0__filltie
X$7019 \$15204 \$15321 gf180mcu_fd_sc_mcu9t5v0__filltie
X$7020 \$15204 \$15321 gf180mcu_fd_sc_mcu9t5v0__filltie
X$7021 \$15204 \$15321 gf180mcu_fd_sc_mcu9t5v0__filltie
X$7022 \$15204 \$15321 gf180mcu_fd_sc_mcu9t5v0__filltie
X$7023 \$15204 \$15321 gf180mcu_fd_sc_mcu9t5v0__endcap
X$7024 \$16445 \$15747 \$15746 \$15206 \$15948 \$16436 \$16376 \$16446
+ gf180mcu_fd_sc_mcu9t5v0__aoi221_1
X$7025 \$16854 \$17093 \$15208 \$16914 \$17034 \$17037
+ gf180mcu_fd_sc_mcu9t5v0__nand3_1
X$7026 \$17041 \$17045 \$17044 \$16596 \$16914 \$17034 \$15210
+ gf180mcu_fd_sc_mcu9t5v0__nand4_1
X$7027 \$16457 \$16452 \$15216 \$16456 \$16436 \$16376 \$16454
+ gf180mcu_fd_sc_mcu9t5v0__aoi22_1
X$7028 \$17502 \$16452 \$15216 \$15831 \$17538 \$17367 \$17712
+ gf180mcu_fd_sc_mcu9t5v0__aoi22_1
X$7029 \$15754 \$15216 \$17244 \$15755 \$15628 \$15749 \$15631
+ gf180mcu_fd_sc_mcu9t5v0__aoi22_1
X$7030 \$16597 \$15216 \$17244 \$17101 \$17085 \$17034 \$17047
+ gf180mcu_fd_sc_mcu9t5v0__aoi22_1
X$7031 \$15507 \$15216 \$17244 \$15761 \$15949 \$15749 \$15823
+ gf180mcu_fd_sc_mcu9t5v0__aoi22_1
X$7032 \$17970 \$15216 \$17244 \$17664 \$18137 \$17952 \$17969
+ gf180mcu_fd_sc_mcu9t5v0__aoi22_1
X$7033 \$17049 \$15216 \$17244 \$17111 \$17085 \$17034 \$17110
+ gf180mcu_fd_sc_mcu9t5v0__aoi22_1
X$7034 \$25802 \$25797 \$25918 \$15216 gf180mcu_fd_sc_mcu9t5v0__buf_8
X$7035 \$21700 \$21843 \$15223 \$21661 \$21946 \$21697
+ gf180mcu_fd_sc_mcu9t5v0__aoi21_1
X$7036 \$15784 \$15536 \$15223 \$15628 \$15490 \$15520
+ gf180mcu_fd_sc_mcu9t5v0__aoi21_1
X$7037 \$15223 \$26548 \$26248 \$26401 \$26521 \$26389
+ gf180mcu_fd_sc_mcu9t5v0__oai21_1
X$7038 \$15223 \$17070 \$16929 \$16914 \$17034 \$16896
+ gf180mcu_fd_sc_mcu9t5v0__oai21_1
X$7039 \$15223 \$19053 \$19018 \$19027 \$19149 \$19017
+ gf180mcu_fd_sc_mcu9t5v0__oai21_1
X$7040 \$15223 \$24561 \$24562 \$24593 \$24428 \$24560
+ gf180mcu_fd_sc_mcu9t5v0__oai21_1
X$7041 \$15223 \$17689 \$17854 \$17396 \$17538 \$17703 \$17688
+ gf180mcu_fd_sc_mcu9t5v0__oai31_1
X$7042 \$15223 \$19497 \$19499 \$19182 \$19324 \$19466 \$19302
+ gf180mcu_fd_sc_mcu9t5v0__oai31_1
X$7043 \$15223 \$18850 \$18279 \$18151 \$18137 \$18293 \$18042
+ gf180mcu_fd_sc_mcu9t5v0__oai31_1
X$7044 \$15223 \$21704 \$21705 \$21403 \$21661 \$21622 \$21652
+ gf180mcu_fd_sc_mcu9t5v0__oai31_1
X$7045 \$15223 \$23830 \$24080 \$23828 \$23926 \$23807 \$23955
+ gf180mcu_fd_sc_mcu9t5v0__oai31_1
X$7046 \$15223 \$22167 \$21661 \$21946 \$21645 gf180mcu_fd_sc_mcu9t5v0__nor2_1
X$7047 \$20594 \$15223 \$21646 \$21645 \$21498 \$21622 \$21647
+ gf180mcu_fd_sc_mcu9t5v0__aoi22_1
X$7048 \$17521 \$15223 \$21698 \$21697 \$21661 \$21622 \$21696
+ gf180mcu_fd_sc_mcu9t5v0__aoi22_1
X$7049 \$15515 \$15223 \$16914 \$17034 \$16929 gf180mcu_fd_sc_mcu9t5v0__nand2_1
X$7050 \$17392 \$15223 \$18701 \$18870 \$19018 gf180mcu_fd_sc_mcu9t5v0__nand2_1
X$7051 \$16479 \$15223 \$19027 \$19149 \$19182 gf180mcu_fd_sc_mcu9t5v0__nand2_1
X$7052 \$24316 \$15223 \$26088 \$26220 \$26248 gf180mcu_fd_sc_mcu9t5v0__nand2_1
X$7053 \$16094 \$15223 \$18137 \$17952 \$18151 gf180mcu_fd_sc_mcu9t5v0__nand2_1
X$7054 \$21320 \$15223 \$24877 \$24721 \$24562 gf180mcu_fd_sc_mcu9t5v0__nand2_1
X$7055 \$23163 \$15223 \$23926 \$23807 \$23828 gf180mcu_fd_sc_mcu9t5v0__nand2_1
X$7056 \$17673 \$15223 \$21498 \$21308 \$21403 gf180mcu_fd_sc_mcu9t5v0__nand2_1
X$7057 \$28553 \$28534 \$28381 \$15223 gf180mcu_fd_sc_mcu9t5v0__buf_8
X$7058 \$24601 \$22903 \$15223 \$23926 \$24109 \$24118
+ gf180mcu_fd_sc_mcu9t5v0__mux2_1
X$7059 \$20346 \$20725 \$15223 \$20515 \$20718 \$20723
+ gf180mcu_fd_sc_mcu9t5v0__mux2_1
X$7060 \$26227 \$22848 \$15223 \$26088 \$26220 \$26228
+ gf180mcu_fd_sc_mcu9t5v0__mux2_1
X$7061 \$26541 \$22589 \$15223 \$26401 \$26521 \$26378
+ gf180mcu_fd_sc_mcu9t5v0__mux2_1
X$7062 \$20103 \$16406 \$15223 \$19927 \$20087 \$20104
+ gf180mcu_fd_sc_mcu9t5v0__mux2_1
X$7063 \$19356 \$17129 \$15223 \$19027 \$19149 \$19176
+ gf180mcu_fd_sc_mcu9t5v0__mux2_1
X$7064 \$27666 \$15344 \$15223 \$26675 \$26856 \$26875
+ gf180mcu_fd_sc_mcu9t5v0__mux2_1
X$7065 \$22585 \$22455 \$15223 \$22387 \$22440 \$22453
+ gf180mcu_fd_sc_mcu9t5v0__mux2_1
X$7066 \$28718 \$17679 \$15223 \$28211 \$28381 \$28388
+ gf180mcu_fd_sc_mcu9t5v0__mux2_1
X$7067 \$18278 \$15343 \$15223 \$17818 \$17952 \$17985
+ gf180mcu_fd_sc_mcu9t5v0__mux2_1
X$7068 \$21963 \$19615 \$15223 \$21498 \$21622 \$21683
+ gf180mcu_fd_sc_mcu9t5v0__mux2_1
X$7069 \$29104 \$18887 \$15223 \$27015 \$27153 \$27174
+ gf180mcu_fd_sc_mcu9t5v0__mux2_1
X$7070 \$17687 \$17252 \$15223 \$17538 \$17703 \$17527
+ gf180mcu_fd_sc_mcu9t5v0__mux2_1
X$7071 \$27177 \$24542 \$15223 \$27015 \$27153 \$26997
+ gf180mcu_fd_sc_mcu9t5v0__mux2_1
X$7072 \$27608 \$21330 \$15223 \$27015 \$27153 \$26834
+ gf180mcu_fd_sc_mcu9t5v0__mux2_1
X$7073 \$18423 \$16092 \$15223 \$17818 \$17952 \$18034
+ gf180mcu_fd_sc_mcu9t5v0__mux2_1
X$7074 \$26532 \$21960 \$15223 \$26401 \$26521 \$26533
+ gf180mcu_fd_sc_mcu9t5v0__mux2_1
X$7075 \$27345 \$17393 \$15223 \$27315 \$27449 \$27472
+ gf180mcu_fd_sc_mcu9t5v0__mux2_1
X$7076 \$22093 \$22096 \$15223 \$22074 \$22272 \$22153
+ gf180mcu_fd_sc_mcu9t5v0__mux2_1
X$7077 \$25604 \$22083 \$15223 \$25462 \$25632 \$25639
+ gf180mcu_fd_sc_mcu9t5v0__mux2_1
X$7078 \$24272 \$19351 \$15223 \$22713 \$22837 \$22933
+ gf180mcu_fd_sc_mcu9t5v0__mux2_1
X$7079 \$22875 \$21690 \$15223 \$22713 \$22837 \$22934
+ gf180mcu_fd_sc_mcu9t5v0__mux2_1
X$7080 \$25602 \$25314 \$15223 \$25462 \$25632 \$25636
+ gf180mcu_fd_sc_mcu9t5v0__mux2_1
X$7081 \$21325 \$21169 \$15223 \$21184 \$21308 \$21329
+ gf180mcu_fd_sc_mcu9t5v0__mux2_1
X$7082 \$23648 \$22597 \$15223 \$23926 \$24109 \$23943
+ gf180mcu_fd_sc_mcu9t5v0__mux2_1
X$7083 \$22402 \$18033 \$15223 \$22074 \$22272 \$22151
+ gf180mcu_fd_sc_mcu9t5v0__mux2_1
X$7084 \$17979 \$16164 \$15223 \$17818 \$17952 \$18035
+ gf180mcu_fd_sc_mcu9t5v0__mux2_1
X$7085 \$22460 \$16874 \$15223 \$22387 \$22440 \$22403
+ gf180mcu_fd_sc_mcu9t5v0__mux2_1
X$7086 \$23203 \$16607 \$15223 \$22713 \$22837 \$22915
+ gf180mcu_fd_sc_mcu9t5v0__mux2_1
X$7087 \$25479 \$16472 \$15223 \$25191 \$25347 \$25201
+ gf180mcu_fd_sc_mcu9t5v0__mux2_1
X$7088 \$22860 \$21386 \$15223 \$22387 \$22440 \$22458
+ gf180mcu_fd_sc_mcu9t5v0__mux2_1
X$7089 \$24330 \$23162 \$15223 \$24231 \$24428 \$24331
+ gf180mcu_fd_sc_mcu9t5v0__mux2_1
X$7090 \$28063 \$23945 \$15223 \$27315 \$27449 \$27471
+ gf180mcu_fd_sc_mcu9t5v0__mux2_1
X$7091 \$25615 \$25017 \$15223 \$24877 \$24997 \$25016
+ gf180mcu_fd_sc_mcu9t5v0__mux2_1
X$7092 \$21640 \$20894 \$15223 \$21498 \$21622 \$21639
+ gf180mcu_fd_sc_mcu9t5v0__mux2_1
X$7093 \$26996 \$18274 \$15223 \$26675 \$26856 \$26874
+ gf180mcu_fd_sc_mcu9t5v0__mux2_1
X$7094 \$25806 \$24740 \$15223 \$25462 \$25632 \$25637
+ gf180mcu_fd_sc_mcu9t5v0__mux2_1
X$7095 \$21509 \$21028 \$15223 \$21498 \$21622 \$21637
+ gf180mcu_fd_sc_mcu9t5v0__mux2_1
X$7096 \$28513 \$15847 \$15223 \$27315 \$27449 \$27473
+ gf180mcu_fd_sc_mcu9t5v0__mux2_1
X$7097 \$25202 \$17058 \$15223 \$22713 \$22837 \$22596
+ gf180mcu_fd_sc_mcu9t5v0__mux2_1
X$7098 \$18886 \$17847 \$15223 \$18701 \$18870 \$18889
+ gf180mcu_fd_sc_mcu9t5v0__mux2_1
X$7099 \$20844 \$21153 \$15223 \$21184 \$21308 \$21152
+ gf180mcu_fd_sc_mcu9t5v0__mux2_1
X$7100 \$19158 \$18427 \$15223 \$18403 \$18576 \$18426
+ gf180mcu_fd_sc_mcu9t5v0__mux2_1
X$7101 \$19011 \$17524 \$15223 \$18403 \$18576 \$18602
+ gf180mcu_fd_sc_mcu9t5v0__mux2_1
X$7102 \$23657 \$20896 \$15223 \$22387 \$22272 \$22418
+ gf180mcu_fd_sc_mcu9t5v0__mux2_1
X$7103 \$27611 \$23769 \$15223 \$27637 \$27449 \$27667
+ gf180mcu_fd_sc_mcu9t5v0__mux2_1
X$7104 \$28387 \$18548 \$15223 \$28534 \$28381 \$28235
+ gf180mcu_fd_sc_mcu9t5v0__mux2_1
X$7105 \$18836 \$17715 \$15223 \$19027 \$18870 \$18882
+ gf180mcu_fd_sc_mcu9t5v0__mux2_1
X$7106 \$22923 \$20592 \$15223 \$23027 \$22837 \$23044
+ gf180mcu_fd_sc_mcu9t5v0__mux2_1
X$7107 \$26366 \$25074 \$15223 \$26401 \$26220 \$26230
+ gf180mcu_fd_sc_mcu9t5v0__mux2_1
X$7108 \$23948 \$23210 \$15223 \$23620 \$23454 \$23346
+ gf180mcu_fd_sc_mcu9t5v0__mux2_1
X$7109 \$23823 \$20728 \$15223 \$23926 \$23807 \$23787
+ gf180mcu_fd_sc_mcu9t5v0__mux2_1
X$7110 \$18305 \$16401 \$15223 \$18403 \$18293 \$18424
+ gf180mcu_fd_sc_mcu9t5v0__mux2_1
X$7111 \$19755 \$19905 \$15223 \$19927 \$19774 \$19939
+ gf180mcu_fd_sc_mcu9t5v0__mux2_1
X$7112 \$25772 \$16876 \$15223 \$24877 \$24721 \$24891
+ gf180mcu_fd_sc_mcu9t5v0__mux2_1
X$7113 \$22862 \$21162 \$15223 \$22713 \$22440 \$22459
+ gf180mcu_fd_sc_mcu9t5v0__mux2_1
X$7114 \$25943 \$22464 \$15223 \$24593 \$24428 \$24558
+ gf180mcu_fd_sc_mcu9t5v0__mux2_1
X$7115 \$26114 \$21171 \$15223 \$25797 \$25632 \$25616
+ gf180mcu_fd_sc_mcu9t5v0__mux2_1
X$7116 \$23467 \$22457 \$15223 \$22713 \$22440 \$22594
+ gf180mcu_fd_sc_mcu9t5v0__mux2_1
X$7117 \$25617 \$25089 \$15223 \$25191 \$24997 \$25023
+ gf180mcu_fd_sc_mcu9t5v0__mux2_1
X$7118 \$25090 \$21680 \$15223 \$25191 \$24997 \$25203
+ gf180mcu_fd_sc_mcu9t5v0__mux2_1
X$7119 \$19481 \$16399 \$15223 \$19324 \$19149 \$19346
+ gf180mcu_fd_sc_mcu9t5v0__mux2_1
X$7120 \$19912 \$17666 \$15223 \$19927 \$19774 \$19942
+ gf180mcu_fd_sc_mcu9t5v0__mux2_1
X$7121 \$22163 \$20535 \$15223 \$20515 \$20383 \$20609
+ gf180mcu_fd_sc_mcu9t5v0__mux2_1
X$7122 \$23462 \$23596 \$15223 \$23620 \$23454 \$23634
+ gf180mcu_fd_sc_mcu9t5v0__mux2_1
X$7123 \$18047 \$16619 \$15223 \$18137 \$17952 \$18155
+ gf180mcu_fd_sc_mcu9t5v0__mux2_1
X$7124 \$24117 \$24881 \$15223 \$24877 \$24721 \$24880
+ gf180mcu_fd_sc_mcu9t5v0__mux2_1
X$7125 \$25600 \$24064 \$15223 \$25462 \$25347 \$25312
+ gf180mcu_fd_sc_mcu9t5v0__mux2_1
X$7126 \$21957 \$22144 \$15223 \$22074 \$21946 \$22081
+ gf180mcu_fd_sc_mcu9t5v0__mux2_1
X$7127 \$21370 \$21507 \$15223 \$21498 \$21308 \$21506
+ gf180mcu_fd_sc_mcu9t5v0__mux2_1
X$7128 \$18435 \$15776 \$15223 \$17818 \$17703 \$17849
+ gf180mcu_fd_sc_mcu9t5v0__mux2_1
X$7129 \$16175 \$15778 \$15223 \$16269 \$16070 \$16412
+ gf180mcu_fd_sc_mcu9t5v0__mux2_1
X$7130 \$18041 \$15835 \$15223 \$18137 \$17952 \$17850
+ gf180mcu_fd_sc_mcu9t5v0__mux2_1
X$7131 \$17526 \$15381 \$15223 \$17538 \$17367 \$17260
+ gf180mcu_fd_sc_mcu9t5v0__mux2_1
X$7132 \$21168 \$17517 \$15223 \$19605 \$19466 \$19347
+ gf180mcu_fd_sc_mcu9t5v0__mux2_1
X$7133 \$23829 \$22598 \$15223 \$23620 \$23454 \$23480
+ gf180mcu_fd_sc_mcu9t5v0__mux2_1
X$7134 \$15851 \$15532 \$15949 \$15749 \$15224 \$15972
+ gf180mcu_fd_sc_mcu9t5v0__xnor3_1
X$7135 \$15368 \$15315 \$15321 \$15490 \$15369 gf180mcu_fd_sc_mcu9t5v0__nor2_1
X$7136 \$15399 \$15398 \$15321 \$15490 \$15397 gf180mcu_fd_sc_mcu9t5v0__xnor2_1
X$7137 \$15512 \$15640 \$15377 \$15321 \$15490 \$15378
+ gf180mcu_fd_sc_mcu9t5v0__oai21_1
X$7138 \$15328 \$15321 \$15490 \$15366 gf180mcu_fd_sc_mcu9t5v0__buf_8
X$7139 \$15387 \$15388 \$15321 \$15490 \$15389 gf180mcu_fd_sc_mcu9t5v0__nor2_1
X$7140 \$15382 \$15378 \$15321 \$15490 \$15383 gf180mcu_fd_sc_mcu9t5v0__nand2_1
X$7141 \$15334 \$15371 \$15321 \$15490 \$15359 gf180mcu_fd_sc_mcu9t5v0__nand2_1
X$7142 \$15490 \$15321 gf180mcu_fd_sc_mcu9t5v0__filltie
X$7143 \$15490 \$15321 gf180mcu_fd_sc_mcu9t5v0__filltie
X$7144 \$15490 \$15321 gf180mcu_fd_sc_mcu9t5v0__filltie
X$7145 \$15490 \$15321 gf180mcu_fd_sc_mcu9t5v0__filltie
X$7146 \$15490 \$15321 gf180mcu_fd_sc_mcu9t5v0__filltie
X$7147 \$15490 \$15321 gf180mcu_fd_sc_mcu9t5v0__filltie
X$7148 \$15490 \$15321 gf180mcu_fd_sc_mcu9t5v0__endcap
X$7149 \$15496 \$15628 \$15490 \$15328 gf180mcu_fd_sc_mcu9t5v0__inv_2
X$7150 \$15329 \$16269 \$16376 \$I39889 gf180mcu_fd_sc_mcu9t5v0__clkbuf_8
X$7151 \$15330 \$15331 \$16133 \$16269 \$16376 \$16383
+ gf180mcu_fd_sc_mcu9t5v0__oai21_1
X$7152 \$17371 \$16730 \$16854 \$17085 \$17034 \$15331
+ gf180mcu_fd_sc_mcu9t5v0__nor3_1
X$7153 \$15331 \$15815 \$15628 \$15749 \$15367 gf180mcu_fd_sc_mcu9t5v0__or2_1
X$7154 \$17105 \$17039 \$16918 \$15333 \$16914 \$17034 \$16736
+ gf180mcu_fd_sc_mcu9t5v0__nand4_1
X$7155 \$15776 \$15779 \$15628 \$15749 \$15393 \$15344
+ gf180mcu_fd_sc_mcu9t5v0__xnor3_1
X$7156 \$15344 \$17538 \$17367 \$17525 gf180mcu_fd_sc_mcu9t5v0__clkinv_1
X$7157 \$16365 \$16060 \$15792 \$15949 \$16070 \$15347
+ gf180mcu_fd_sc_mcu9t5v0__nor3_1
X$7158 \$16062 \$15736 \$15348 \$15939 \$15949 \$16070 \$16121
+ gf180mcu_fd_sc_mcu9t5v0__nand4_1
X$7159 \$15348 \$15939 \$15790 \$15949 \$16070 \$16060
+ gf180mcu_fd_sc_mcu9t5v0__and3_1
X$7160 \$15939 \$15790 \$15348 \$15949 \$15749 \$15792
+ gf180mcu_fd_sc_mcu9t5v0__aoi21_1
X$7161 \$15736 \$15941 \$15737 \$15628 \$15749 \$15349
+ gf180mcu_fd_sc_mcu9t5v0__aoi21_1
X$7162 \$18524 \$15351 \$18403 \$18576 \$18526 gf180mcu_fd_sc_mcu9t5v0__nand2_1
X$7163 \$18986 \$15352 \$19027 \$18870 \$18987 gf180mcu_fd_sc_mcu9t5v0__nand2_1
X$7164 \$23617 \$15353 \$23757 \$23620 \$23807 \$23758
+ gf180mcu_fd_sc_mcu9t5v0__aoi21_1
X$7165 \$20380 \$20379 \$15353 \$20209 \$20383 \$20378
+ gf180mcu_fd_sc_mcu9t5v0__oai21_1
X$7166 \$15805 \$15747 \$15746 \$15359 \$15948 \$15949 \$16070 \$15946
+ gf180mcu_fd_sc_mcu9t5v0__aoi221_1
X$7167 \$15366 \$16731 \$16076 \$15949 \$16070 \$15497
+ gf180mcu_fd_sc_mcu9t5v0__oai21_1
X$7168 \$15366 \$29271 \$29123 \$29270 \$29851 gf180mcu_fd_sc_mcu9t5v0__nand2_1
X$7169 \$15510 \$15509 \$15628 \$15490 \$15375 gf180mcu_fd_sc_mcu9t5v0__nor2_1
X$7170 \$15510 \$15509 \$15628 \$15490 \$15376 gf180mcu_fd_sc_mcu9t5v0__and2_1
X$7171 \$15512 \$15640 \$15377 \$15628 \$15490 \$15379
+ gf180mcu_fd_sc_mcu9t5v0__or3_1
X$7172 \$15381 \$15513 \$15628 \$15490 \$15377 gf180mcu_fd_sc_mcu9t5v0__xnor2_1
X$7173 \$15381 \$16401 \$16269 \$16376 \$16091 gf180mcu_fd_sc_mcu9t5v0__xnor2_1
X$7174 \$15381 \$16471 \$16158 \$16269 \$16070 \$16093
+ gf180mcu_fd_sc_mcu9t5v0__oai21_1
X$7175 \$15381 \$15514 \$15628 \$15490 \$15382 gf180mcu_fd_sc_mcu9t5v0__nand2_1
X$7176 \$15515 \$15641 \$15628 \$15490 \$15385 gf180mcu_fd_sc_mcu9t5v0__and2_1
X$7177 \$20536 \$20538 \$20515 \$20383 \$15390 gf180mcu_fd_sc_mcu9t5v0__xnor2_1
X$7178 \$18273 \$18306 \$18137 \$18293 \$15391 gf180mcu_fd_sc_mcu9t5v0__xnor2_1
X$7179 \$15778 \$15628 \$15749 \$15394 gf180mcu_fd_sc_mcu9t5v0__clkinv_1
X$7180 \$15776 \$15394 \$15949 \$16070 \$16106 gf180mcu_fd_sc_mcu9t5v0__nor2_1
X$7181 \$15776 \$15394 \$15949 \$15749 \$15848 gf180mcu_fd_sc_mcu9t5v0__nand2_1
X$7182 \$15395 \$16914 \$16728 \$I54289 gf180mcu_fd_sc_mcu9t5v0__clkinv_1
X$7183 \$15851 \$16108 \$16110 \$16109 \$15949 \$16070 \$15396
+ gf180mcu_fd_sc_mcu9t5v0__oai22_1
X$7184 \$15531 \$15532 \$15533 \$15628 \$15490 \$15398
+ gf180mcu_fd_sc_mcu9t5v0__aoi21_1
X$7185 \$15850 \$15628 \$15749 \$15647 \$15399 gf180mcu_fd_sc_mcu9t5v0__xor2_1
X$7186 \$15531 \$15532 \$15533 \$15399 \$15628 \$15490 \$15534
+ gf180mcu_fd_sc_mcu9t5v0__aoi211_1
X$7187 \$15484 \$16269 \$16070 gf180mcu_fd_sc_mcu9t5v0__inv_3
X$7188 \$15794 \$15793 \$15790 \$15949 \$15749 \$15485
+ gf180mcu_fd_sc_mcu9t5v0__aoi21_1
X$7189 \$15648 \$15534 \$15535 \$15628 \$15490 \$15536
+ gf180mcu_fd_sc_mcu9t5v0__or3_1
X$7190 \$15513 \$15628 \$15490 \$15514 gf180mcu_fd_sc_mcu9t5v0__clkinv_1
X$7191 \$15782 \$15530 \$15628 \$15490 \$15531 gf180mcu_fd_sc_mcu9t5v0__nand2_1
X$7192 \$15490 \$15628 gf180mcu_fd_sc_mcu9t5v0__filltie
X$7193 \$15490 \$15628 gf180mcu_fd_sc_mcu9t5v0__filltie
X$7194 \$15490 \$15628 gf180mcu_fd_sc_mcu9t5v0__filltie
X$7195 \$15490 \$15628 gf180mcu_fd_sc_mcu9t5v0__filltie
X$7196 \$15490 \$15628 gf180mcu_fd_sc_mcu9t5v0__filltie
X$7197 \$15490 \$15628 gf180mcu_fd_sc_mcu9t5v0__filltie
X$7198 \$15490 \$15628 gf180mcu_fd_sc_mcu9t5v0__endcap
X$7199 \$16130 \$16073 \$16072 \$15949 \$16070 \$15492 \$15812
+ gf180mcu_fd_sc_mcu9t5v0__nor4_4
X$7200 \$15494 \$16132 \$15949 \$16070 \$15955 gf180mcu_fd_sc_mcu9t5v0__xnor2_1
X$7201 \$16591 \$16590 \$16436 \$16728 \$15496 gf180mcu_fd_sc_mcu9t5v0__nand2_2
X$7202 \$15496 \$15949 \$15749 \$15956 gf180mcu_fd_sc_mcu9t5v0__buf_8
X$7203 \$16860 \$16914 \$16728 \$15499 gf180mcu_fd_sc_mcu9t5v0__clkinv_1
X$7204 \$15631 \$15503 \$15628 \$15749 \$15810 gf180mcu_fd_sc_mcu9t5v0__nand2_1
X$7205 \$20357 \$20408 \$20358 \$20209 \$20383 \$15509
+ gf180mcu_fd_sc_mcu9t5v0__aoi21_1
X$7206 \$17251 \$17387 \$15510 \$17085 \$17367 \$17056
+ gf180mcu_fd_sc_mcu9t5v0__or3_1
X$7207 \$17508 \$17509 \$17538 \$17367 \$15510 gf180mcu_fd_sc_mcu9t5v0__xnor2_1
X$7208 \$17251 \$17387 \$15510 \$17085 \$17367 \$16089
+ gf180mcu_fd_sc_mcu9t5v0__oai21_1
X$7209 \$17546 \$17510 \$17538 \$17367 \$15511 gf180mcu_fd_sc_mcu9t5v0__xnor2_1
X$7210 \$15834 \$15833 \$15949 \$15749 \$15512 gf180mcu_fd_sc_mcu9t5v0__nor2_1
X$7211 \$16873 \$16914 \$16728 \$16872 \$15513 gf180mcu_fd_sc_mcu9t5v0__xor2_1
X$7212 \$16161 \$15515 \$16269 \$16070 \$16160 gf180mcu_fd_sc_mcu9t5v0__nor2_1
X$7213 \$16161 \$15515 \$16269 \$16070 \$16163 gf180mcu_fd_sc_mcu9t5v0__nand2_1
X$7214 \$15515 \$15949 \$15749 \$15767 gf180mcu_fd_sc_mcu9t5v0__clkinv_1
X$7215 \$15776 \$15644 \$15628 \$15749 \$15775 \$15519
+ gf180mcu_fd_sc_mcu9t5v0__xor3_1
X$7216 \$15846 \$15845 \$15949 \$15749 \$15522 gf180mcu_fd_sc_mcu9t5v0__nor2_1
X$7217 \$15846 \$15845 \$15949 \$15749 \$15523 gf180mcu_fd_sc_mcu9t5v0__and2_1
X$7218 \$15776 \$15775 \$15628 \$15749 \$15524 gf180mcu_fd_sc_mcu9t5v0__nor2_1
X$7219 \$15776 \$15775 \$15949 \$15749 \$15525 gf180mcu_fd_sc_mcu9t5v0__nand2_1
X$7220 \$16406 \$16405 \$16269 \$16376 \$15526 gf180mcu_fd_sc_mcu9t5v0__nor2_1
X$7221 \$15526 \$15777 \$15949 \$15749 \$15644 gf180mcu_fd_sc_mcu9t5v0__nor2_1
X$7222 \$15526 \$16269 \$16070 \$16102 gf180mcu_fd_sc_mcu9t5v0__clkinv_1
X$7223 \$15527 \$15645 \$15628 \$15749 \$15780 gf180mcu_fd_sc_mcu9t5v0__or2_1
X$7224 \$16105 \$15949 \$16070 \$15527 gf180mcu_fd_sc_mcu9t5v0__clkinv_1
X$7225 \$15781 \$15529 \$15628 \$15749 \$15646 gf180mcu_fd_sc_mcu9t5v0__nor2_1
X$7226 \$15530 \$16108 \$15974 \$16113 \$15949 \$16070 \$16111
+ gf180mcu_fd_sc_mcu9t5v0__oai22_1
X$7227 \$15972 \$15949 \$16070 \$15530 gf180mcu_fd_sc_mcu9t5v0__clkinv_1
X$7228 \$15782 \$15530 \$15628 \$15749 \$15533 gf180mcu_fd_sc_mcu9t5v0__nor2_1
X$7229 \$17853 \$17991 \$17689 \$17818 \$17703 \$15532
+ gf180mcu_fd_sc_mcu9t5v0__aoi21_1
X$7230 \$15648 \$15534 \$15535 \$15628 \$15749 \$15784
+ gf180mcu_fd_sc_mcu9t5v0__oai21_1
X$7231 \$16177 \$16178 \$15949 \$16070 \$15535 gf180mcu_fd_sc_mcu9t5v0__xnor2_1
X$7232 \$15621 \$16841 \$16914 \$17034 \$16912 gf180mcu_fd_sc_mcu9t5v0__and2_1
X$7233 \$17646 \$18701 \$18870 \$15621 gf180mcu_fd_sc_mcu9t5v0__clkinv_1
X$7234 \$21619 \$21498 \$21622 \$15625 gf180mcu_fd_sc_mcu9t5v0__buf_8
X$7235 \$15745 \$15747 \$15746 \$15626 \$15628 \$15749 \$15743
+ gf180mcu_fd_sc_mcu9t5v0__aoi22_1
X$7236 \$15628 \$15749 \$15734 gf180mcu_fd_sc_mcu9t5v0__tiel
X$7237 \$15736 \$15941 \$15940 \$15628 \$15749 \$15737
+ gf180mcu_fd_sc_mcu9t5v0__oai21_1
X$7238 \$15783 \$15647 \$15628 \$15749 \$15648 gf180mcu_fd_sc_mcu9t5v0__nor2_1
X$7239 \$15782 \$15628 \$15749 \$15851 gf180mcu_fd_sc_mcu9t5v0__clkinv_1
X$7240 \$15647 \$15786 \$16108 \$15628 \$15749 \$15785
+ gf180mcu_fd_sc_mcu9t5v0__mux2_1
X$7241 \$15749 \$15628 gf180mcu_fd_sc_mcu9t5v0__filltie
X$7242 \$15749 \$15628 gf180mcu_fd_sc_mcu9t5v0__filltie
X$7243 \$15749 \$15628 gf180mcu_fd_sc_mcu9t5v0__filltie
X$7244 \$15749 \$15628 gf180mcu_fd_sc_mcu9t5v0__filltie
X$7245 \$15749 \$15628 gf180mcu_fd_sc_mcu9t5v0__filltie
X$7246 \$15749 \$15628 gf180mcu_fd_sc_mcu9t5v0__filltie
X$7247 \$15749 \$15628 gf180mcu_fd_sc_mcu9t5v0__endcap
X$7248 \$15629 \$15949 \$15749 gf180mcu_fd_sc_mcu9t5v0__inv_4
X$7249 \$15635 \$15960 \$16079 \$15949 \$15749 \$15825
+ gf180mcu_fd_sc_mcu9t5v0__nand3_1
X$7250 \$17508 \$17509 \$17538 \$17367 \$15639 gf180mcu_fd_sc_mcu9t5v0__nand2_1
X$7251 \$16092 \$16609 \$16436 \$16728 \$15641 \$16472
+ gf180mcu_fd_sc_mcu9t5v0__xnor3_1
X$7252 \$16164 \$16162 \$15949 \$16070 \$15642 \$15769
+ gf180mcu_fd_sc_mcu9t5v0__xnor3_1
X$7253 \$16407 \$16615 \$15846 \$16269 \$16376 \$15645
+ gf180mcu_fd_sc_mcu9t5v0__aoi21_1
X$7254 \$17528 pad_din[6] \$I20747 \$I20765 \$I20756 \$I20774 \$I20783 \$I20801
+ \$I20792 \$I20810 \$I20819 \$I20837 \$I20828 \$I20846 \$I20855 \$I20864
+ \$I20873 \$I20882 \$I20891 \$I20900 \$I20909 \$I20918 \$I20927 \$I20936
+ \$I20945 \$I20954 \$I20963 \$I20981 \$I20972 \$I20990 \$I20999 \$I21017
+ \$I21008 \$I21026 \$I21044 \$I21035 \$I21053 \$I21062 \$I21071 \$I21089
+ \$I21080 \$I21098 \$I21107 \$I21116 \$I21125 \$I21134 \$I21143 \$I21161
+ \$I21152 \$I21170 \$I21179 \$I21197 \$I21188 \$I21206 \$I21215 \$I21233
+ \$I21224 \$I21242 \$I21251 \$I21269 \$I21260 \$I21278 \$I21287 \$I21296
+ \$I21305 \$I21314 \$I21323 \$I21332 \$I21341 \$I21350 \$I21368 \$I21377
+ \$I21404 \$I21413 \$I21359 \$I21395 \$I21386 \$I21431 \$I21422 \$I21458
+ \$I21449 \$I21467 \$I21440 \$I21485 \$I21476 \$I21494 \$I21512 \$I21539
+ \$I21548 \$I21557 \$I21503 \$I21530 \$I21521 \$I21575 \$I21566 \$I21584
+ \$I21593 \$I21602 \$I21611 \$I21620 \$I21629 \$I21638 \$15734 \$I21647
+ \$I21665 \$I21656 \$I21674 \$15734 \$17224 gf180mcu_fd_io__in_c
X$7255 \$16119 \$15735 \$15949 \$16070 \$16061 gf180mcu_fd_sc_mcu9t5v0__nand2_1
X$7256 \$15735 \$15949 \$15749 \$15794 gf180mcu_fd_sc_mcu9t5v0__clkinv_1
X$7257 \$15736 \$15941 \$16062 \$16269 \$16070 \$16122
+ gf180mcu_fd_sc_mcu9t5v0__aoi21_1
X$7258 \$25049 \$15746 \$15948 \$25797 \$25632 \$25630
+ gf180mcu_fd_sc_mcu9t5v0__nor3_1
X$7259 \$15746 \$26969 \$26352 \$27015 \$26856 \$26851
+ gf180mcu_fd_sc_mcu9t5v0__nor3_1
X$7260 \$17029 \$15747 \$15746 \$17238 \$17085 \$17367 \$17082
+ gf180mcu_fd_sc_mcu9t5v0__aoi22_1
X$7261 \$18005 \$15747 \$15746 \$17946 \$17818 \$17952 \$17696
+ gf180mcu_fd_sc_mcu9t5v0__aoi22_1
X$7262 \$16844 \$15747 \$15746 \$16584 \$16436 \$16728 \$16583
+ gf180mcu_fd_sc_mcu9t5v0__aoi22_1
X$7263 \$19146 \$15747 \$15746 \$18867 \$19027 \$19149 \$18868
+ gf180mcu_fd_sc_mcu9t5v0__aoi22_1
X$7264 \$16434 \$15747 \$15746 \$16375 \$16436 \$16376 \$16372
+ gf180mcu_fd_sc_mcu9t5v0__aoi22_1
X$7265 \$17650 \$15747 \$15746 \$17816 \$17818 \$17703 \$17701
+ gf180mcu_fd_sc_mcu9t5v0__aoi22_1
X$7266 \$26969 \$26800 \$26091 \$15746 \$25631 \$26675 \$26856 \$26795
+ gf180mcu_fd_sc_mcu9t5v0__aoi221_1
X$7267 \$16441 \$15747 \$15746 \$15951 \$15948 \$15949 \$16070 \$15751
+ gf180mcu_fd_sc_mcu9t5v0__aoi221_1
X$7268 \$17087 \$15747 \$15746 \$16847 \$15948 \$16914 \$17034 \$17035
+ gf180mcu_fd_sc_mcu9t5v0__aoi221_1
X$7269 \$18823 \$15747 \$15746 \$18532 \$15948 \$18701 \$18870 \$18578
+ gf180mcu_fd_sc_mcu9t5v0__aoi221_1
X$7270 \$17951 \$15747 \$15746 \$17704 \$15948 \$17818 \$17952 \$17705
+ gf180mcu_fd_sc_mcu9t5v0__aoi221_1
X$7271 \$17369 \$15747 \$15746 \$16915 \$15948 \$17085 \$17034 \$17088
+ gf180mcu_fd_sc_mcu9t5v0__aoi221_1
X$7272 \$15809 \$15747 \$15746 \$15810 \$15948 \$15949 \$15749 \$15811
+ gf180mcu_fd_sc_mcu9t5v0__aoi221_1
X$7273 \$17653 \$15747 \$15746 \$17495 \$15948 \$17538 \$17367 \$17539
+ gf180mcu_fd_sc_mcu9t5v0__aoi221_1
X$7274 \$27317 \$27315 \$27153 \$15746 gf180mcu_fd_sc_mcu9t5v0__buf_8
X$7275 \$25584 \$25049 \$15747 \$25191 \$24997 \$24989
+ gf180mcu_fd_sc_mcu9t5v0__and3_1
X$7276 \$25584 \$15747 \$26350 \$25462 \$25632 \$25048
+ gf180mcu_fd_sc_mcu9t5v0__nand3_1
X$7277 \$25302 \$25303 \$15747 \$25191 \$25347 \$25190
+ gf180mcu_fd_sc_mcu9t5v0__nand3_1
X$7278 \$25584 \$25047 \$15747 \$25797 \$25632 \$25744
+ gf180mcu_fd_sc_mcu9t5v0__nand3_1
X$7279 \$25588 \$25462 \$25632 \$15747 gf180mcu_fd_sc_mcu9t5v0__buf_8
X$7280 \$15748 \$16128 \$16586 \$16436 \$16728 \$16587
+ gf180mcu_fd_sc_mcu9t5v0__nor3_1
X$7281 \$15748 \$16726 \$16435 \$16436 \$16376 \$16585
+ gf180mcu_fd_sc_mcu9t5v0__nor3_1
X$7282 \$18817 \$18571 \$15748 \$18701 \$18576 \$18570
+ gf180mcu_fd_sc_mcu9t5v0__aoi21_1
X$7283 \$15748 \$16127 \$15949 \$16070 \$16069 gf180mcu_fd_sc_mcu9t5v0__nor2_1
X$7284 \$18818 \$18701 \$18870 \$15748 gf180mcu_fd_sc_mcu9t5v0__buf_8
X$7285 \$16419 \$15949 \$15749 \$15788 gf180mcu_fd_sc_mcu9t5v0__buf_1
X$7286 \$15838 \$15837 \$15949 \$15749 \$15774 gf180mcu_fd_sc_mcu9t5v0__and2_1
X$7287 \$15961 \$15826 \$15825 \$15949 \$15749 \$15828
+ gf180mcu_fd_sc_mcu9t5v0__nor3_1
X$7288 \$15940 \$15793 \$15794 \$15949 \$15749 \$15790
+ gf180mcu_fd_sc_mcu9t5v0__aoi21_1
X$7289 \$15939 \$15790 \$15791 \$15949 \$15749 \$15938
+ gf180mcu_fd_sc_mcu9t5v0__aoi21_1
X$7290 \$15852 \$16178 \$15784 \$15949 \$15749 \$15973
+ gf180mcu_fd_sc_mcu9t5v0__oai21_1
X$7291 \$15939 \$15790 \$15940 \$15949 \$15749 \$15791
+ gf180mcu_fd_sc_mcu9t5v0__oai21_1
X$7292 \$15836 \$16162 \$15965 \$15949 \$15749 \$15967
+ gf180mcu_fd_sc_mcu9t5v0__oai21_1
X$7293 \$15838 \$15837 \$15949 \$15749 \$15773 gf180mcu_fd_sc_mcu9t5v0__nor2_1
X$7294 \$15788 \$15949 \$15749 \$15789 gf180mcu_fd_sc_mcu9t5v0__buf_8
X$7295 \$15750 \$15949 \$15749 \$15808 gf180mcu_fd_sc_mcu9t5v0__buf_8
X$7296 \$15850 \$15949 \$15749 \$15783 gf180mcu_fd_sc_mcu9t5v0__clkinv_1
X$7297 \$15749 \$15949 gf180mcu_fd_sc_mcu9t5v0__filltie
X$7298 \$15749 \$15949 gf180mcu_fd_sc_mcu9t5v0__filltie
X$7299 \$15749 \$15949 gf180mcu_fd_sc_mcu9t5v0__filltie
X$7300 \$15749 \$15949 gf180mcu_fd_sc_mcu9t5v0__filltie
X$7301 \$15749 \$15949 gf180mcu_fd_sc_mcu9t5v0__filltie
X$7302 \$15749 \$15949 gf180mcu_fd_sc_mcu9t5v0__filltie
X$7303 \$15952 \$15809 \$16845 \$15949 \$15749 \$15953
+ gf180mcu_fd_sc_mcu9t5v0__mux2_1
X$7304 \$15806 \$15805 \$16845 \$15949 \$15749 \$16068
+ gf180mcu_fd_sc_mcu9t5v0__mux2_1
X$7305 \$15749 \$15949 gf180mcu_fd_sc_mcu9t5v0__endcap
X$7306 \$16085 \$15763 \$15827 \$16084 \$16390 \$15949 \$16070 \$15961
+ gf180mcu_fd_sc_mcu9t5v0__oai221_1
X$7307 \$16164 \$16610 \$16436 \$16728 \$15768 \$16875
+ gf180mcu_fd_sc_mcu9t5v0__xnor3_1
X$7308 \$16094 \$15949 \$16070 \$15769 gf180mcu_fd_sc_mcu9t5v0__clkinv_1
X$7309 \$16164 \$15769 \$16269 \$16070 \$15836 gf180mcu_fd_sc_mcu9t5v0__nor2_1
X$7310 \$16164 \$15769 \$15949 \$16070 \$15965 gf180mcu_fd_sc_mcu9t5v0__nand2_1
X$7311 \$20734 \$20603 \$20881 \$21011 \$15771 \$21170
+ gf180mcu_fd_sc_mcu9t5v0__xnor3_1
X$7312 \$15776 \$16411 \$16269 \$16070 \$15849 \$15778
+ gf180mcu_fd_sc_mcu9t5v0__xnor3_1
X$7313 \$15776 \$17525 \$17538 \$17367 \$17259 gf180mcu_fd_sc_mcu9t5v0__nor2_1
X$7314 \$15776 \$17525 \$17538 \$17367 \$17256 gf180mcu_fd_sc_mcu9t5v0__nand2_1
X$7315 \$16103 \$16173 \$16269 \$16070 \$15777 gf180mcu_fd_sc_mcu9t5v0__and2_1
X$7316 \$17258 \$17551 \$17394 \$17538 \$17367 \$15779
+ gf180mcu_fd_sc_mcu9t5v0__aoi21_1
X$7317 \$16930 \$16436 \$16376 \$16484 \$15786 gf180mcu_fd_sc_mcu9t5v0__xor2_1
X$7318 \$15789 \$18988 \$19605 \$19466 \$19597 gf180mcu_fd_sc_mcu9t5v0__and2_1
X$7319 \$15789 \$18988 \$19605 \$19466 \$19596 gf180mcu_fd_sc_mcu9t5v0__nand2_1
X$7320 \$16836 \$16835 \$16914 \$16728 \$15793 gf180mcu_fd_sc_mcu9t5v0__nand2_1
X$7321 \$15940 \$15793 \$16436 \$16728 \$16366 gf180mcu_fd_sc_mcu9t5v0__nand2_1
X$7322 \$18813 \$19023 \$15797 \$18701 \$18870 \$18814
+ gf180mcu_fd_sc_mcu9t5v0__oai21_1
X$7323 \$17646 \$15798 \$17360 \$17647 \$17538 \$17703 \$17695
+ gf180mcu_fd_sc_mcu9t5v0__oai31_1
X$7324 \$17646 \$15801 \$18245 \$18398 \$18403 \$18293 \$18399
+ gf180mcu_fd_sc_mcu9t5v0__oai31_1
X$7325 \$17234 \$15802 \$17085 \$17367 \$17361 gf180mcu_fd_sc_mcu9t5v0__nand2_1
X$7326 \$15806 \$22449 \$20716 \$22387 \$22440 \$22584
+ gf180mcu_fd_sc_mcu9t5v0__mux2_1
X$7327 \$15806 \$20385 \$19776 \$20209 \$20383 \$20384
+ gf180mcu_fd_sc_mcu9t5v0__mux2_1
X$7328 \$15806 \$19888 \$19278 \$19927 \$19774 \$19932
+ gf180mcu_fd_sc_mcu9t5v0__mux2_1
X$7329 \$15806 \$16443 \$16438 \$16436 \$16376 \$16442
+ gf180mcu_fd_sc_mcu9t5v0__mux2_1
X$7330 \$15806 \$22126 \$21496 \$22074 \$21946 \$22125
+ gf180mcu_fd_sc_mcu9t5v0__mux2_1
X$7331 \$18864 \$15812 \$19772 \$19605 \$19466 \$19321
+ gf180mcu_fd_sc_mcu9t5v0__nor3_2
X$7332 \$15812 \$19772 \$19605 \$19774 \$19322 gf180mcu_fd_sc_mcu9t5v0__nor2_4
X$7333 \$17232 \$15812 \$17645 \$17538 \$17703 \$17490
+ gf180mcu_fd_sc_mcu9t5v0__nor3_1
X$7334 \$20046 \$15812 \$19772 \$19927 \$20087 \$20574
+ gf180mcu_fd_sc_mcu9t5v0__nor3_1
X$7335 \$20337 \$15812 \$19772 \$20209 \$20087 \$22072
+ gf180mcu_fd_sc_mcu9t5v0__nor3_1
X$7336 \$15812 \$19275 \$18403 \$18293 \$17817 gf180mcu_fd_sc_mcu9t5v0__nor2_1
X$7337 \$15812 \$17645 \$17538 \$17367 \$17357 gf180mcu_fd_sc_mcu9t5v0__nor2_1
X$7338 \$20036 \$20209 \$20087 \$15812 gf180mcu_fd_sc_mcu9t5v0__buf_8
X$7339 \$16077 \$15956 \$15949 \$16070 \$15815 gf180mcu_fd_sc_mcu9t5v0__nor2_1
X$7340 \$15817 \$16452 \$17244 \$16450 \$16436 \$16376 \$16451
+ gf180mcu_fd_sc_mcu9t5v0__aoi22_1
X$7341 \$16083 \$15823 \$15949 \$16070 \$15951 gf180mcu_fd_sc_mcu9t5v0__nand2_1
X$7342 \$16400 \$16871 \$16914 \$16728 \$15833 \$16607
+ gf180mcu_fd_sc_mcu9t5v0__xnor3_1
X$7343 \$16399 \$16155 \$16269 \$16376 \$16154 \$15834
+ gf180mcu_fd_sc_mcu9t5v0__xnor3_1
X$7344 \$15835 \$16269 \$16070 \$15834 gf180mcu_fd_sc_mcu9t5v0__clkinv_1
X$7345 \$16400 \$15835 \$16269 \$16376 \$16156 gf180mcu_fd_sc_mcu9t5v0__nor2_1
X$7346 \$16400 \$15835 \$16269 \$16070 \$16157 gf180mcu_fd_sc_mcu9t5v0__nand2_1
X$7347 \$16168 \$15969 \$16404 \$16269 \$16376 \$15837
+ gf180mcu_fd_sc_mcu9t5v0__aoi21_1
X$7348 \$15838 \$15837 \$16169 \$16269 \$16070 \$16100
+ gf180mcu_fd_sc_mcu9t5v0__oai21_1
X$7349 \$17521 \$17520 \$17538 \$17367 \$15838 gf180mcu_fd_sc_mcu9t5v0__xnor2_1
X$7350 \$17067 \$16882 \$15838 \$16914 \$17034 \$16884
+ gf180mcu_fd_sc_mcu9t5v0__nor3_1
X$7351 \$17067 \$16882 \$15838 \$16914 \$17034 \$16885
+ gf180mcu_fd_sc_mcu9t5v0__oai21_1
X$7352 \$16099 \$16100 \$15949 \$16070 \$15840 gf180mcu_fd_sc_mcu9t5v0__and2_1
X$7353 \$16171 \$16170 \$16269 \$16070 \$15843 gf180mcu_fd_sc_mcu9t5v0__nor2_1
X$7354 \$16171 \$16170 \$16269 \$16070 \$15844 gf180mcu_fd_sc_mcu9t5v0__and2_1
X$7355 \$16171 \$16170 \$16172 \$16269 \$16070 \$15845
+ gf180mcu_fd_sc_mcu9t5v0__oai21_1
X$7356 \$16409 \$16478 \$16436 \$16376 \$15846 gf180mcu_fd_sc_mcu9t5v0__xnor2_1
X$7357 \$16408 \$15846 \$16269 \$16376 \$16276 gf180mcu_fd_sc_mcu9t5v0__xnor2_1
X$7358 \$16406 \$17551 \$16914 \$16728 \$16478 \$15847
+ gf180mcu_fd_sc_mcu9t5v0__xnor3_1
X$7359 \$15847 \$17538 \$17703 \$17257 gf180mcu_fd_sc_mcu9t5v0__clkinv_1
X$7360 \$15850 \$16107 \$16108 \$15949 \$16070 \$15971
+ gf180mcu_fd_sc_mcu9t5v0__mux2_1
X$7361 \$16177 \$15949 \$16070 \$15852 gf180mcu_fd_sc_mcu9t5v0__clkinv_1
X$7362 \$15940 \$17080 \$17230 \$17809 \$17538 \$17703 \$17228
+ gf180mcu_fd_sc_mcu9t5v0__aoi211_1
X$7363 \$16119 \$16060 \$15940 \$16269 \$16070 \$16118
+ gf180mcu_fd_sc_mcu9t5v0__oai21_1
X$7364 \$18566 \$18701 \$18576 \$15940 gf180mcu_fd_sc_mcu9t5v0__buf_8
X$7365 \$15940 \$18403 \$18293 \$16424 gf180mcu_fd_sc_mcu9t5v0__buf_8
X$7366 \$16119 \$16060 \$16269 \$16070 \$15941 gf180mcu_fd_sc_mcu9t5v0__and2_1
X$7367 \$15941 \$16118 \$16269 \$16376 \$16573 gf180mcu_fd_sc_mcu9t5v0__nor2_1
X$7368 \$19021 \$15942 \$19027 \$19149 \$19141 gf180mcu_fd_sc_mcu9t5v0__nand2_1
X$7369 \$15947 \$16269 \$16070 \$16129 gf180mcu_fd_sc_mcu9t5v0__buf_8
X$7370 \$26672 \$26851 \$27015 \$26856 \$15948 gf180mcu_fd_sc_mcu9t5v0__or2_1
X$7371 \$25916 \$24294 \$15948 \$25797 \$25918 \$25913
+ gf180mcu_fd_sc_mcu9t5v0__aoi21_1
X$7372 \$25589 \$24105 \$15948 \$25462 \$25632 \$25626
+ gf180mcu_fd_sc_mcu9t5v0__aoi21_1
X$7373 \$26519 \$24720 \$15948 \$26401 \$26521 \$26398
+ gf180mcu_fd_sc_mcu9t5v0__aoi21_1
X$7374 \$27019 \$24110 \$15948 \$27015 \$27153 \$26968
+ gf180mcu_fd_sc_mcu9t5v0__aoi21_1
X$7375 \$25050 \$24104 \$15948 \$25191 \$24997 \$25045
+ gf180mcu_fd_sc_mcu9t5v0__aoi21_1
X$7376 \$15948 \$26795 \$26788 \$26675 \$26856 \$26796
+ gf180mcu_fd_sc_mcu9t5v0__oai21_1
X$7377 \$15948 \$26853 \$27009 \$27015 \$27153 \$27150
+ gf180mcu_fd_sc_mcu9t5v0__oai21_1
X$7378 \$16091 \$16090 \$15949 \$16070 \$15963 gf180mcu_fd_sc_mcu9t5v0__xnor2_1
X$7379 \$16099 \$16100 \$15949 \$16070 \$15970 gf180mcu_fd_sc_mcu9t5v0__nor2_1
X$7380 \$16103 \$16102 \$15949 \$16070 \$16101 gf180mcu_fd_sc_mcu9t5v0__nand2_1
X$7381 \$16096 \$16095 \$15949 \$16070 \$15968 gf180mcu_fd_sc_mcu9t5v0__nand2_1
X$7382 \$16070 \$15949 gf180mcu_fd_sc_mcu9t5v0__filltie
X$7383 \$16070 \$15949 gf180mcu_fd_sc_mcu9t5v0__filltie
X$7384 \$16070 \$15949 gf180mcu_fd_sc_mcu9t5v0__filltie
X$7385 \$16070 \$15949 gf180mcu_fd_sc_mcu9t5v0__filltie
X$7386 \$16070 \$15949 gf180mcu_fd_sc_mcu9t5v0__filltie
X$7387 \$16070 \$15949 gf180mcu_fd_sc_mcu9t5v0__filltie
X$7388 \$16070 \$15949 gf180mcu_fd_sc_mcu9t5v0__endcap
X$7389 \$15950 \$16128 \$16269 \$16070 \$16127 gf180mcu_fd_sc_mcu9t5v0__xnor2_1
X$7390 \$16727 \$15950 \$17031 \$16914 \$17034 \$17084
+ gf180mcu_fd_sc_mcu9t5v0__nand3_1
X$7391 \$15954 \$16914 \$17034 \$16916 gf180mcu_fd_sc_mcu9t5v0__buf_8
X$7392 \$16380 \$16378 \$15955 \$16379 \$16269 \$16376 \$16377
+ gf180mcu_fd_sc_mcu9t5v0__oai31_1
X$7393 \$30543 \$15956 \$30545 \$30564 \$30485 \$30546
+ gf180mcu_fd_sc_mcu9t5v0__nor3_1
X$7394 \$30409 \$30318 \$30316 \$15956 \$30402 \$30339 \$30407
+ gf180mcu_fd_sc_mcu9t5v0__aoi211_1
X$7395 \$15956 \$23032 \$23027 \$23139 \$23033 gf180mcu_fd_sc_mcu9t5v0__nor2_1
X$7396 \$19299 \$19352 \$19174 \$19324 \$19149 \$15969
+ gf180mcu_fd_sc_mcu9t5v0__oai21_1
X$7397 \$16748 \$16747 \$16631 \$16436 \$16728 \$15974
+ gf180mcu_fd_sc_mcu9t5v0__nor3_1
X$7398 \$16059 \$17085 \$17367 gf180mcu_fd_sc_mcu9t5v0__clkinv_3
X$7399 \$16061 \$16121 \$16269 \$16070 \$16267 gf180mcu_fd_sc_mcu9t5v0__nor2_1
X$7400 \$16173 \$16269 \$16070 \$16101 \$16167 gf180mcu_fd_sc_mcu9t5v0__xor2_1
X$7401 \$16099 \$16100 \$16744 \$16269 \$16070 \$16170
+ gf180mcu_fd_sc_mcu9t5v0__aoi21_1
X$7402 \$16160 \$16093 \$16163 \$16269 \$16070 \$16162
+ gf180mcu_fd_sc_mcu9t5v0__oai21_1
X$7403 \$16156 \$16155 \$16157 \$16269 \$16070 \$16090
+ gf180mcu_fd_sc_mcu9t5v0__oai21_1
X$7404 \$16156 \$16155 \$16157 \$16091 \$16269 \$16070 \$16158
+ gf180mcu_fd_sc_mcu9t5v0__oai211_1
X$7405 \$16126 \$16269 \$16070 \$16120 gf180mcu_fd_sc_mcu9t5v0__buf_8
X$7406 \$16271 \$16269 \$16070 \$16084 gf180mcu_fd_sc_mcu9t5v0__clkinv_1
X$7407 \$16130 \$16269 \$16070 \$16131 gf180mcu_fd_sc_mcu9t5v0__clkinv_1
X$7408 \$16108 \$16481 \$16269 \$16070 \$16109 gf180mcu_fd_sc_mcu9t5v0__nand2_1
X$7409 \$16108 \$16179 \$16269 \$16070 \$16113 gf180mcu_fd_sc_mcu9t5v0__nand2_1
X$7410 \$16070 \$16269 gf180mcu_fd_sc_mcu9t5v0__filltie
X$7411 \$16070 \$16269 gf180mcu_fd_sc_mcu9t5v0__filltie
X$7412 \$16070 \$16269 gf180mcu_fd_sc_mcu9t5v0__filltie
X$7413 \$16070 \$16269 gf180mcu_fd_sc_mcu9t5v0__filltie
X$7414 \$16070 \$16269 gf180mcu_fd_sc_mcu9t5v0__filltie
X$7415 \$16070 \$16269 gf180mcu_fd_sc_mcu9t5v0__filltie
X$7416 \$16178 \$16180 \$16108 \$16269 \$16070 \$16114
+ gf180mcu_fd_sc_mcu9t5v0__mux2_1
X$7417 \$16177 \$16176 \$16108 \$16269 \$16070 \$16277
+ gf180mcu_fd_sc_mcu9t5v0__mux2_1
X$7418 \$16070 \$16269 gf180mcu_fd_sc_mcu9t5v0__endcap
X$7419 \$20207 \$20212 \$19926 \$18246 \$20209 \$20087 \$16072
+ gf180mcu_fd_sc_mcu9t5v0__aoi211_4
X$7420 \$16072 \$19927 \$19774 \$19772 gf180mcu_fd_sc_mcu9t5v0__buf_8
X$7421 \$18294 \$18137 \$18293 \$16073 gf180mcu_fd_sc_mcu9t5v0__clkinv_1
X$7422 \$16594 \$16595 \$16447 \$16436 \$16728 \$16079
+ gf180mcu_fd_sc_mcu9t5v0__nor3_1
X$7423 \$16088 \$16395 \$16269 \$16376 \$16153 gf180mcu_fd_sc_mcu9t5v0__nand2_1
X$7424 \$16396 \$16089 \$16269 \$16376 \$16397 gf180mcu_fd_sc_mcu9t5v0__nand2_1
X$7425 \$16092 \$17513 \$17085 \$17367 \$17122 \$17123
+ gf180mcu_fd_sc_mcu9t5v0__xnor3_1
X$7426 \$16092 \$17123 \$17085 \$17367 \$17388 gf180mcu_fd_sc_mcu9t5v0__nor2_1
X$7427 \$16092 \$17123 \$17085 \$17034 \$17124 gf180mcu_fd_sc_mcu9t5v0__nand2_1
X$7428 \$16092 \$16269 \$16376 \$16161 gf180mcu_fd_sc_mcu9t5v0__clkinv_1
X$7429 \$17523 \$17255 \$17085 \$17367 \$16099 gf180mcu_fd_sc_mcu9t5v0__xnor2_1
X$7430 \$17068 \$16885 \$16099 \$16914 \$17034 \$16890
+ gf180mcu_fd_sc_mcu9t5v0__aoi21_1
X$7431 \$17068 \$16885 \$16099 \$16914 \$17034 \$16888
+ gf180mcu_fd_sc_mcu9t5v0__nand3_1
X$7432 \$16406 \$16405 \$16269 \$16376 \$16103 gf180mcu_fd_sc_mcu9t5v0__nand2_1
X$7433 \$16479 \$16478 \$16436 \$16376 \$16104 gf180mcu_fd_sc_mcu9t5v0__nor2_1
X$7434 \$16409 \$16478 \$16269 \$16376 \$16105 gf180mcu_fd_sc_mcu9t5v0__or2_1
X$7435 \$16746 \$16269 \$16376 \$16413 \$16107 gf180mcu_fd_sc_mcu9t5v0__xor2_1
X$7436 \$16108 \$21043 \$21498 \$21308 \$21398 gf180mcu_fd_sc_mcu9t5v0__nand2_1
X$7437 \$21328 \$23183 \$23139 \$16108 gf180mcu_fd_sc_mcu9t5v0__buf_8
X$7438 \$23957 \$23222 \$16108 \$23620 \$23807 \$23610
+ gf180mcu_fd_sc_mcu9t5v0__mux2_1
X$7439 \$19051 \$19178 \$16108 \$19027 \$19149 \$19177
+ gf180mcu_fd_sc_mcu9t5v0__mux2_1
X$7440 \$24579 \$25820 \$16108 \$25462 \$25632 \$25492
+ gf180mcu_fd_sc_mcu9t5v0__mux2_1
X$7441 \$23353 \$23355 \$16108 \$23183 \$23454 \$23487
+ gf180mcu_fd_sc_mcu9t5v0__mux2_1
X$7442 \$20106 \$20066 \$16108 \$19927 \$20087 \$20105
+ gf180mcu_fd_sc_mcu9t5v0__mux2_1
X$7443 \$17991 \$17989 \$16108 \$17818 \$17952 \$17990
+ gf180mcu_fd_sc_mcu9t5v0__mux2_1
X$7444 \$24095 \$24278 \$16108 \$24231 \$24428 \$24279
+ gf180mcu_fd_sc_mcu9t5v0__mux2_1
X$7445 \$25341 \$25793 \$16108 \$25462 \$25632 \$25493
+ gf180mcu_fd_sc_mcu9t5v0__mux2_1
X$7446 \$25958 \$25822 \$16108 \$25797 \$25918 \$25957
+ gf180mcu_fd_sc_mcu9t5v0__mux2_1
X$7447 \$22880 \$22615 \$16108 \$22713 \$22837 \$22616
+ gf180mcu_fd_sc_mcu9t5v0__mux2_1
X$7448 \$27184 \$26835 \$16108 \$27015 \$27153 \$27183
+ gf180mcu_fd_sc_mcu9t5v0__mux2_1
X$7449 \$16416 \$16415 \$16108 \$16269 \$16376 \$16414
+ gf180mcu_fd_sc_mcu9t5v0__mux2_1
X$7450 \$28590 \$29284 \$16108 \$28810 \$28971 \$28987
+ gf180mcu_fd_sc_mcu9t5v0__mux2_1
X$7451 \$25336 \$25645 \$16108 \$25191 \$25347 \$25363
+ gf180mcu_fd_sc_mcu9t5v0__mux2_1
X$7452 \$27186 \$27185 \$16108 \$27015 \$27153 \$27301
+ gf180mcu_fd_sc_mcu9t5v0__mux2_1
X$7453 \$27350 \$27476 \$16108 \$27315 \$27449 \$27304
+ gf180mcu_fd_sc_mcu9t5v0__mux2_1
X$7454 \$22415 \$22471 \$16108 \$22387 \$22440 \$22414
+ gf180mcu_fd_sc_mcu9t5v0__mux2_1
X$7455 \$28077 \$28395 \$16108 \$27913 \$28089 \$28119
+ gf180mcu_fd_sc_mcu9t5v0__mux2_1
X$7456 \$24274 \$24893 \$16108 \$24593 \$24721 \$24755
+ gf180mcu_fd_sc_mcu9t5v0__mux2_1
X$7457 \$25953 \$25952 \$16108 \$25797 \$25918 \$25991
+ gf180mcu_fd_sc_mcu9t5v0__mux2_1
X$7458 \$25340 \$25339 \$16108 \$25191 \$25347 \$25364
+ gf180mcu_fd_sc_mcu9t5v0__mux2_1
X$7459 \$28393 \$28986 \$16108 \$28534 \$28689 \$28368
+ gf180mcu_fd_sc_mcu9t5v0__mux2_1
X$7460 \$24089 \$24335 \$16108 \$24231 \$24428 \$24275
+ gf180mcu_fd_sc_mcu9t5v0__mux2_1
X$7461 \$24091 \$24130 \$16108 \$24231 \$24428 \$24276
+ gf180mcu_fd_sc_mcu9t5v0__mux2_1
X$7462 \$23484 \$23352 \$16108 \$23183 \$23454 \$23483
+ gf180mcu_fd_sc_mcu9t5v0__mux2_1
X$7463 \$26838 \$26668 \$16108 \$26675 \$26856 \$26880
+ gf180mcu_fd_sc_mcu9t5v0__mux2_1
X$7464 \$27305 \$27678 \$16108 \$27315 \$27449 \$27477
+ gf180mcu_fd_sc_mcu9t5v0__mux2_1
X$7465 \$28079 \$28078 \$16108 \$27913 \$28089 \$28121
+ gf180mcu_fd_sc_mcu9t5v0__mux2_1
X$7466 \$27670 \$27940 \$16108 \$27637 \$27776 \$27813
+ gf180mcu_fd_sc_mcu9t5v0__mux2_1
X$7467 \$26253 \$26251 \$16108 \$26088 \$26220 \$26252
+ gf180mcu_fd_sc_mcu9t5v0__mux2_1
X$7468 \$23491 \$23357 \$16108 \$23183 \$23454 \$23490
+ gf180mcu_fd_sc_mcu9t5v0__mux2_1
X$7469 \$28366 \$28721 \$16108 \$28211 \$28381 \$28392
+ gf180mcu_fd_sc_mcu9t5v0__mux2_1
X$7470 \$19495 \$20072 \$16108 \$19927 \$20087 \$20108
+ gf180mcu_fd_sc_mcu9t5v0__mux2_1
X$7471 \$24568 \$24620 \$16108 \$24593 \$24721 \$24570
+ gf180mcu_fd_sc_mcu9t5v0__mux2_1
X$7472 \$24758 \$24870 \$16108 \$24877 \$24997 \$24871
+ gf180mcu_fd_sc_mcu9t5v0__mux2_1
X$7473 \$28842 \$29113 \$16108 \$28810 \$28689 \$28958
+ gf180mcu_fd_sc_mcu9t5v0__mux2_1
X$7474 \$26381 \$26383 \$16108 \$26401 \$26220 \$26382
+ gf180mcu_fd_sc_mcu9t5v0__mux2_1
X$7475 \$28068 \$28955 \$16108 \$28534 \$28381 \$28583
+ gf180mcu_fd_sc_mcu9t5v0__mux2_1
X$7476 \$27052 \$27000 \$16108 \$27015 \$26856 \$27054
+ gf180mcu_fd_sc_mcu9t5v0__mux2_1
X$7477 \$28518 \$28517 \$16108 \$28534 \$28381 \$28593
+ gf180mcu_fd_sc_mcu9t5v0__mux2_1
X$7478 \$24577 \$25490 \$16108 \$25462 \$25347 \$25337
+ gf180mcu_fd_sc_mcu9t5v0__mux2_1
X$7479 \$26879 \$27060 \$16108 \$27015 \$26856 \$26837
+ gf180mcu_fd_sc_mcu9t5v0__mux2_1
X$7480 \$27621 \$27349 \$16108 \$27637 \$27449 \$27676
+ gf180mcu_fd_sc_mcu9t5v0__mux2_1
X$7481 \$24892 \$25489 \$16108 \$25462 \$25347 \$25620
+ gf180mcu_fd_sc_mcu9t5v0__mux2_1
X$7482 \$19496 \$19494 \$16108 \$19605 \$19466 \$19630
+ gf180mcu_fd_sc_mcu9t5v0__mux2_1
X$7483 \$19918 \$19917 \$16108 \$19927 \$19774 \$19945
+ gf180mcu_fd_sc_mcu9t5v0__mux2_1
X$7484 \$20859 \$20860 \$16108 \$20881 \$20718 \$20904
+ gf180mcu_fd_sc_mcu9t5v0__mux2_1
X$7485 \$18606 \$18607 \$16108 \$18701 \$18576 \$18553
+ gf180mcu_fd_sc_mcu9t5v0__mux2_1
X$7486 \$19626 \$20067 \$16108 \$19605 \$19466 \$19764
+ gf180mcu_fd_sc_mcu9t5v0__mux2_1
X$7487 \$25619 \$25949 \$16108 \$26088 \$25918 \$25948
+ gf180mcu_fd_sc_mcu9t5v0__mux2_1
X$7488 \$19921 \$20238 \$16108 \$20209 \$20087 \$20073
+ gf180mcu_fd_sc_mcu9t5v0__mux2_1
X$7489 \$20109 \$20236 \$16108 \$20209 \$20087 \$20237
+ gf180mcu_fd_sc_mcu9t5v0__mux2_1
X$7490 \$20552 \$20909 \$16108 \$20881 \$20718 \$20619
+ gf180mcu_fd_sc_mcu9t5v0__mux2_1
X$7491 \$16112 \$16485 \$16108 \$16436 \$16376 \$16417
+ gf180mcu_fd_sc_mcu9t5v0__mux2_1
X$7492 \$17855 \$17724 \$16108 \$17818 \$17703 \$17993
+ gf180mcu_fd_sc_mcu9t5v0__mux2_1
X$7493 \$24128 \$24751 \$16108 \$24231 \$24109 \$24273
+ gf180mcu_fd_sc_mcu9t5v0__mux2_1
X$7494 \$16624 \$16622 \$16483 \$16436 \$16376 \$16110
+ gf180mcu_fd_sc_mcu9t5v0__nor3_1
X$7495 \$17529 pad_dout[7] \$I20746 \$I20755 \$I20764 \$I20773 \$I20782
+ \$I20791 \$I20800 \$I20809 \$I20818 \$I20827 \$I20836 \$I20845 \$I20854
+ \$I20863 \$I20872 \$I20881 \$I20890 \$I20899 \$I20908 \$I20917 \$I20926
+ \$I20935 \$I20944 \$I20953 \$I20962 \$I20971 \$I20980 \$I20989 \$I20998
+ \$I21007 \$I21016 \$I21025 \$I21034 \$I21043 \$I21052 \$I21061 \$I21070
+ \$I21079 \$I21088 \$I21097 \$I21106 \$I21115 \$I21124 \$I21133 \$I21142
+ \$I21151 \$I21160 \$I21169 \$I21178 \$I21187 \$I21196 \$I21205 \$I21214
+ \$I21223 \$I21232 \$I21241 \$I21250 \$I21259 \$I21268 \$I21277 \$I21286
+ \$I21295 \$I21304 \$I21313 \$16115 \$I21322 \$I21331 \$I21340 \$I21349
+ \$I21358 \$I21367 \$I21376 \$I21385 \$I21394 \$I21403 \$I21412 \$I21421
+ \$I21430 \$I21439 \$I21448 \$I21457 \$I21466 \$I21475 \$I21484 \$I21493
+ \$I21502 \$I21511 \$I21520 \$I21529 \$I21538 \$I21547 \$I21556 \$I21565
+ \$I21574 \$I21583 \$I21592 \$I21601 \$16116 \$I21610 \$I21619 \$I21628
+ \$I21637 \$I21646 \$I21655 \$I21664 \$I21673 \$16116 \$16116 \$16115 \$16116
+ \$16116 \$18031 \$16115 gf180mcu_fd_io__bi_t
X$7496 \$18137 \$17952 \$16115 gf180mcu_fd_sc_mcu9t5v0__tieh
X$7497 \$18137 \$17952 \$16116 gf180mcu_fd_sc_mcu9t5v0__tiel
X$7498 \$16267 \$16366 \$16122 \$16365 \$16269 \$16376 \$16367
+ gf180mcu_fd_sc_mcu9t5v0__aoi211_1
X$7499 \$16437 \$16726 \$16436 \$16376 \$16128 gf180mcu_fd_sc_mcu9t5v0__and2_1
X$7500 \$20215 \$29089 \$29088 \$29087 \$29123 \$28971 \$16133
+ gf180mcu_fd_sc_mcu9t5v0__or4_1
X$7501 \$19032 \$19031 \$16133 \$17708 \$19027 \$19149 \$18581
+ gf180mcu_fd_sc_mcu9t5v0__oai211_1
X$7502 \$26408 \$27784 \$16133 \$27637 \$27776 \$27640
+ gf180mcu_fd_sc_mcu9t5v0__nand3_1
X$7503 \$19032 \$27454 \$16133 \$27637 \$27449 \$27579
+ gf180mcu_fd_sc_mcu9t5v0__nand3_1
X$7504 \$16133 \$28544 \$28534 \$28689 \$28695 gf180mcu_fd_sc_mcu9t5v0__nand2_1
X$7505 \$16133 \$16592 \$16436 \$16728 \$16732 gf180mcu_fd_sc_mcu9t5v0__nand2_1
X$7506 \$17113 \$16147 \$17112 \$17114 \$17085 \$17034 \$17381
+ gf180mcu_fd_sc_mcu9t5v0__oai211_1
X$7507 \$18303 \$18302 \$18421 \$18420 \$18403 \$18293 \$16155
+ gf180mcu_fd_sc_mcu9t5v0__oai31_1
X$7508 \$22278 \$19154 \$22910 \$16159 \$22713 \$22837 \$22867
+ gf180mcu_fd_sc_mcu9t5v0__aoi22_1
X$7509 \$16161 \$16472 \$16436 \$16376 \$16474 gf180mcu_fd_sc_mcu9t5v0__nor2_1
X$7510 \$16161 \$16472 \$16436 \$16728 \$16611 gf180mcu_fd_sc_mcu9t5v0__nand2_1
X$7511 \$16164 \$17514 \$17538 \$17703 \$17389 \$17720
+ gf180mcu_fd_sc_mcu9t5v0__xor3_1
X$7512 \$16164 \$17389 \$17085 \$17367 \$17390 gf180mcu_fd_sc_mcu9t5v0__and2_1
X$7513 \$16164 \$17389 \$17538 \$17367 \$17515 gf180mcu_fd_sc_mcu9t5v0__or2_1
X$7514 \$16164 \$16875 \$16914 \$16728 \$16925 gf180mcu_fd_sc_mcu9t5v0__nor2_1
X$7515 \$16164 \$16875 \$16914 \$17034 \$16926 gf180mcu_fd_sc_mcu9t5v0__nand2_1
X$7516 \$17517 \$17252 \$17085 \$17367 \$16165 gf180mcu_fd_sc_mcu9t5v0__xnor2_1
X$7517 \$18040 \$18150 \$18137 \$17952 \$16166 gf180mcu_fd_sc_mcu9t5v0__xnor2_1
X$7518 \$17254 \$17253 \$17085 \$17367 \$16168 gf180mcu_fd_sc_mcu9t5v0__xnor2_1
X$7519 \$17066 \$17065 \$16168 \$16914 \$17034 \$16882
+ gf180mcu_fd_sc_mcu9t5v0__aoi21_1
X$7520 \$17066 \$17065 \$16168 \$16914 \$17034 \$16881
+ gf180mcu_fd_sc_mcu9t5v0__nand3_1
X$7521 \$17521 \$17520 \$17538 \$17367 \$16169 gf180mcu_fd_sc_mcu9t5v0__nand2_1
X$7522 \$16891 \$16890 \$16171 \$16914 \$16728 \$16892
+ gf180mcu_fd_sc_mcu9t5v0__or3_1
X$7523 \$16619 \$16620 \$16914 \$16728 \$16171 gf180mcu_fd_sc_mcu9t5v0__xnor2_1
X$7524 \$16891 \$16890 \$16171 \$16436 \$16728 \$16615
+ gf180mcu_fd_sc_mcu9t5v0__oai21_1
X$7525 \$16619 \$16620 \$16436 \$16728 \$16172 gf180mcu_fd_sc_mcu9t5v0__or2_1
X$7526 \$17129 \$17984 \$17983 \$17818 \$17952 \$16173
+ gf180mcu_fd_sc_mcu9t5v0__aoi21_1
X$7527 \$18557 \$18280 \$18701 \$18576 \$16175 \$18558
+ gf180mcu_fd_sc_mcu9t5v0__xnor3_1
X$7528 \$16898 \$16627 \$16914 \$16728 \$16176 \$16900
+ gf180mcu_fd_sc_mcu9t5v0__xnor3_1
X$7529 \$16748 \$16631 \$16747 \$16914 \$16728 \$16179
+ gf180mcu_fd_sc_mcu9t5v0__oai21_1
X$7530 \$16632 \$16179 \$16436 \$16376 \$16484 gf180mcu_fd_sc_mcu9t5v0__nand2_1
X$7531 \$16636 \$16635 \$16914 \$16728 \$16180 \$16637
+ gf180mcu_fd_sc_mcu9t5v0__xnor3_1
X$7532 \$16267 \$16366 \$16723 \$16436 \$16728 \$16574
+ gf180mcu_fd_sc_mcu9t5v0__aoi21_1
X$7533 \$16723 \$16267 \$16914 \$17034 \$16835 gf180mcu_fd_sc_mcu9t5v0__nand2_1
X$7534 \$16480 \$16410 \$16269 \$16376 \$16411 gf180mcu_fd_sc_mcu9t5v0__nor2_1
X$7535 \$16365 \$16364 \$16269 \$16376 \$16363 gf180mcu_fd_sc_mcu9t5v0__nor2_1
X$7536 \$16451 \$16384 \$16269 \$16376 \$16375 gf180mcu_fd_sc_mcu9t5v0__nand2_1
X$7537 \$16383 \$16382 \$16269 \$16376 \$16378 gf180mcu_fd_sc_mcu9t5v0__nand2_1
X$7538 \$16376 \$16269 gf180mcu_fd_sc_mcu9t5v0__filltie
X$7539 \$16376 \$16269 gf180mcu_fd_sc_mcu9t5v0__filltie
X$7540 \$16376 \$16269 gf180mcu_fd_sc_mcu9t5v0__filltie
X$7541 \$16376 \$16269 gf180mcu_fd_sc_mcu9t5v0__filltie
X$7542 \$16376 \$16269 gf180mcu_fd_sc_mcu9t5v0__filltie
X$7543 \$16376 \$16269 gf180mcu_fd_sc_mcu9t5v0__filltie
X$7544 \$16376 \$16269 gf180mcu_fd_sc_mcu9t5v0__endcap
X$7545 \$16425 \$16422 \$16426 \$16436 \$16376 \$16362
+ gf180mcu_fd_sc_mcu9t5v0__aoi21_1
X$7546 \$16571 \$16436 \$16728 \$16572 \$16364 gf180mcu_fd_sc_mcu9t5v0__xor2_1
X$7547 \$16365 \$16574 \$16436 \$16728 \$16834 gf180mcu_fd_sc_mcu9t5v0__nor2_1
X$7548 \$16578 \$16436 \$16728 \$16365 gf180mcu_fd_sc_mcu9t5v0__buf_8
X$7549 \$16423 \$16570 \$16424 \$16436 \$16376 \$16421
+ gf180mcu_fd_sc_mcu9t5v0__oai21_1
X$7550 \$16425 \$16422 \$16424 \$16436 \$16376 \$16426
+ gf180mcu_fd_sc_mcu9t5v0__oai21_1
X$7551 \$16422 \$16421 \$16436 \$16376 \$16420 gf180mcu_fd_sc_mcu9t5v0__nor2_1
X$7552 \$16406 \$16409 \$16436 \$16376 \$16480 gf180mcu_fd_sc_mcu9t5v0__nor2_1
X$7553 \$16401 \$16436 \$16376 \$16471 gf180mcu_fd_sc_mcu9t5v0__clkinv_1
X$7554 \$16482 \$16481 \$16436 \$16376 \$16413 gf180mcu_fd_sc_mcu9t5v0__nand2_1
X$7555 \$16407 \$16615 \$16436 \$16376 \$16408 gf180mcu_fd_sc_mcu9t5v0__nand2_1
X$7556 \$16376 \$16436 gf180mcu_fd_sc_mcu9t5v0__filltie
X$7557 \$16376 \$16436 gf180mcu_fd_sc_mcu9t5v0__filltie
X$7558 \$16376 \$16436 gf180mcu_fd_sc_mcu9t5v0__filltie
X$7559 \$16376 \$16436 gf180mcu_fd_sc_mcu9t5v0__filltie
X$7560 \$16376 \$16436 gf180mcu_fd_sc_mcu9t5v0__filltie
X$7561 \$16376 \$16436 gf180mcu_fd_sc_mcu9t5v0__filltie
X$7562 \$16443 \$16445 \$16845 \$16436 \$16376 \$16444
+ gf180mcu_fd_sc_mcu9t5v0__mux2_1
X$7563 \$16376 \$16436 gf180mcu_fd_sc_mcu9t5v0__endcap
X$7564 \$16855 \$16592 \$17096 \$16380 \$17085 \$17034 \$17095
+ gf180mcu_fd_sc_mcu9t5v0__aoi211_1
X$7565 \$28814 \$28810 \$28689 \$16380 gf180mcu_fd_sc_mcu9t5v0__buf_8
X$7566 \$16383 \$16592 \$16732 \$16730 \$16914 \$16728 \$16857
+ gf180mcu_fd_sc_mcu9t5v0__oai22_1
X$7567 \$16385 \$17042 \$16914 \$17034 \$17043 gf180mcu_fd_sc_mcu9t5v0__nand2_1
X$7568 \$17667 \$17538 \$17367 \$16396 gf180mcu_fd_sc_mcu9t5v0__clkinv_1
X$7569 \$16399 \$17841 \$17818 \$17703 \$17668 gf180mcu_fd_sc_mcu9t5v0__or2_1
X$7570 \$16399 \$17841 \$17818 \$17703 \$17511 gf180mcu_fd_sc_mcu9t5v0__nand2_1
X$7571 \$16399 \$16436 \$16728 \$16400 gf180mcu_fd_sc_mcu9t5v0__clkinv_1
X$7572 \$16400 \$16607 \$16914 \$17034 \$16740 gf180mcu_fd_sc_mcu9t5v0__nor2_1
X$7573 \$16400 \$16607 \$16436 \$16728 \$16741 gf180mcu_fd_sc_mcu9t5v0__nand2_1
X$7574 \$16401 \$17512 \$17538 \$17367 \$17547 gf180mcu_fd_sc_mcu9t5v0__xnor2_1
X$7575 \$16401 \$16874 \$16914 \$16728 \$16873 gf180mcu_fd_sc_mcu9t5v0__xnor2_1
X$7576 \$16401 \$17512 \$17818 \$17703 \$17719 gf180mcu_fd_sc_mcu9t5v0__nand2_1
X$7577 \$17673 \$17253 \$17538 \$17367 \$16404 gf180mcu_fd_sc_mcu9t5v0__nor2_1
X$7578 \$16406 \$16621 \$16914 \$16728 \$16477 \$16479
+ gf180mcu_fd_sc_mcu9t5v0__xnor3_1
X$7579 \$16406 \$17257 \$17085 \$17367 \$17394 gf180mcu_fd_sc_mcu9t5v0__nor2_1
X$7580 \$17129 \$16745 \$16409 \$16406 \$16894 \$16914 \$16728 \$16410
+ gf180mcu_fd_sc_mcu9t5v0__aoi221_1
X$7581 \$16406 \$17257 \$17085 \$17367 \$17258 gf180mcu_fd_sc_mcu9t5v0__nand2_1
X$7582 \$16745 \$16620 \$16914 \$17034 \$16407 gf180mcu_fd_sc_mcu9t5v0__or2_1
X$7583 \$16479 \$16436 \$16728 \$16409 gf180mcu_fd_sc_mcu9t5v0__clkinv_1
X$7584 \$16902 \$16630 \$16914 \$16728 \$16415 gf180mcu_fd_sc_mcu9t5v0__xnor2_1
X$7585 \$17224 \$16914 \$17034 \$16419 gf180mcu_fd_sc_mcu9t5v0__dlyc_1
X$7586 \$16423 \$16570 \$16436 \$16728 \$16422 gf180mcu_fd_sc_mcu9t5v0__and2_1
X$7587 \$16423 \$17229 \$16425 \$16571 \$16914 \$16728 \$16908
+ gf180mcu_fd_sc_mcu9t5v0__nor4_1
X$7588 \$16423 \$16425 \$16570 \$16436 \$16728 \$16572
+ gf180mcu_fd_sc_mcu9t5v0__nand3_1
X$7589 \$16424 \$17080 \$17230 \$17085 \$17034 \$17079
+ gf180mcu_fd_sc_mcu9t5v0__aoi21_1
X$7590 \$17229 \$17353 \$16424 \$17085 \$17367 \$17076
+ gf180mcu_fd_sc_mcu9t5v0__oai21_1
X$7591 \$17017 \$17079 \$16424 \$17085 \$17034 \$17078
+ gf180mcu_fd_sc_mcu9t5v0__oai21_1
X$7592 \$17690 \$17228 \$16424 \$17818 \$17703 \$17942
+ gf180mcu_fd_sc_mcu9t5v0__oai21_1
X$7593 \$17226 \$17227 \$16424 \$17538 \$17367 \$17225
+ gf180mcu_fd_sc_mcu9t5v0__oai21_1
X$7594 \$18521 \$16424 \$17995 \$18137 \$17952 \$17994
+ gf180mcu_fd_sc_mcu9t5v0__oai21_1
X$7595 \$16424 \$17080 \$17085 \$17367 \$17356 gf180mcu_fd_sc_mcu9t5v0__nand2_1
X$7596 \$16424 \$17996 \$18137 \$17952 \$18134 gf180mcu_fd_sc_mcu9t5v0__nand2_1
X$7597 \$17637 \$16424 \$18137 \$18293 \$18285 gf180mcu_fd_sc_mcu9t5v0__nand2_1
X$7598 \$18286 \$16424 \$18403 \$18293 \$17995 gf180mcu_fd_sc_mcu9t5v0__nand2_1
X$7599 \$18521 \$17692 \$16424 \$18403 \$18576 \$18396
+ gf180mcu_fd_sc_mcu9t5v0__mux2_1
X$7600 \$17018 \$16914 \$17034 \$16428 gf180mcu_fd_sc_mcu9t5v0__clkinv_1
X$7601 \$16428 \$17019 \$16914 \$17034 \$16579 gf180mcu_fd_sc_mcu9t5v0__nor2_1
X$7602 \$16727 \$16846 \$16914 \$16728 \$16435 gf180mcu_fd_sc_mcu9t5v0__nor2_1
X$7603 \$16625 \$16482 \$16623 \$16626 \$16436 \$16728 \$16627
+ gf180mcu_fd_sc_mcu9t5v0__and4_1
X$7604 \$16632 \$16633 \$16749 \$16634 \$16436 \$16728 \$16635
+ gf180mcu_fd_sc_mcu9t5v0__and4_1
X$7605 \$16898 \$16901 \$16627 \$16436 \$16728 \$16629
+ gf180mcu_fd_sc_mcu9t5v0__and3_1
X$7606 \$16636 \$16638 \$16635 \$16436 \$16728 \$16905
+ gf180mcu_fd_sc_mcu9t5v0__and3_1
X$7607 \$17129 \$16745 \$16894 \$16436 \$16728 \$16621
+ gf180mcu_fd_sc_mcu9t5v0__aoi21_1
X$7608 \$16471 \$16874 \$16608 \$16436 \$16728 \$16609
+ gf180mcu_fd_sc_mcu9t5v0__oai21_1
X$7609 \$16609 \$16474 \$16611 \$16436 \$16728 \$16610
+ gf180mcu_fd_sc_mcu9t5v0__oai21_1
X$7610 \$16624 \$16483 \$16622 \$16436 \$16728 \$16481
+ gf180mcu_fd_sc_mcu9t5v0__oai21_1
X$7611 \$16740 \$16871 \$16741 \$16873 \$16436 \$16728 \$16608
+ gf180mcu_fd_sc_mcu9t5v0__oai211_1
X$7612 \$16624 \$16746 \$16622 \$16436 \$16728 \$16623
+ gf180mcu_fd_sc_mcu9t5v0__nand3_1
X$7613 \$16606 \$16605 \$16436 \$16728 \$16870 gf180mcu_fd_sc_mcu9t5v0__nor2_1
X$7614 \$16629 \$16628 \$16436 \$16728 \$16630 gf180mcu_fd_sc_mcu9t5v0__nor2_1
X$7615 \$16464 \$16452 \$17244 \$16462 \$16436 \$16728 \$16601
+ gf180mcu_fd_sc_mcu9t5v0__aoi22_1
X$7616 \$16637 \$16436 \$16728 \$16638 gf180mcu_fd_sc_mcu9t5v0__clkinv_1
X$7617 \$16589 \$16441 \$16845 \$16436 \$16728 \$16440
+ gf180mcu_fd_sc_mcu9t5v0__mux2_1
X$7618 \$16728 \$16436 gf180mcu_fd_sc_mcu9t5v0__filltie
X$7619 \$16728 \$16436 gf180mcu_fd_sc_mcu9t5v0__filltie
X$7620 \$16728 \$16436 gf180mcu_fd_sc_mcu9t5v0__filltie
X$7621 \$16728 \$16436 gf180mcu_fd_sc_mcu9t5v0__filltie
X$7622 \$16728 \$16436 gf180mcu_fd_sc_mcu9t5v0__filltie
X$7623 \$16728 \$16436 gf180mcu_fd_sc_mcu9t5v0__filltie
X$7624 \$16728 \$16436 gf180mcu_fd_sc_mcu9t5v0__endcap
X$7625 \$16437 \$17084 \$17241 \$17085 \$17367 \$17240
+ gf180mcu_fd_sc_mcu9t5v0__oai21_1
X$7626 \$16437 \$16726 \$16914 \$16728 \$16586 gf180mcu_fd_sc_mcu9t5v0__nor2_1
X$7627 \$16437 \$17084 \$17538 \$17367 \$18530 gf180mcu_fd_sc_mcu9t5v0__nor2_1
X$7628 \$21007 \$20372 \$21184 \$21011 \$16438 gf180mcu_fd_sc_mcu9t5v0__nand2_1
X$7629 \$16438 \$20836 \$20881 \$20718 \$20711 gf180mcu_fd_sc_mcu9t5v0__nand2_1
X$7630 \$18291 \$18871 \$16438 \$19027 \$18870 \$18822
+ gf180mcu_fd_sc_mcu9t5v0__mux2_1
X$7631 \$16439 \$17538 \$17367 gf180mcu_fd_sc_mcu9t5v0__clkinv_3
X$7632 \$18299 \$16452 \$17244 \$18297 \$18403 \$18293 \$18411
+ gf180mcu_fd_sc_mcu9t5v0__aoi22_1
X$7633 \$18590 \$16452 \$17244 \$18413 \$18701 \$18576 \$18541
+ gf180mcu_fd_sc_mcu9t5v0__aoi22_1
X$7634 \$17382 \$16452 \$17244 \$17243 \$17538 \$17367 \$17501
+ gf180mcu_fd_sc_mcu9t5v0__aoi22_1
X$7635 \$25308 \$25191 \$25347 \$16452 gf180mcu_fd_sc_mcu9t5v0__buf_8
X$7636 \$16865 \$16454 \$16914 \$16728 \$16847 gf180mcu_fd_sc_mcu9t5v0__nand2_1
X$7637 \$16898 \$16899 \$16914 \$16728 \$16482 gf180mcu_fd_sc_mcu9t5v0__nand2_1
X$7638 \$16626 \$16914 \$16728 \$16483 gf180mcu_fd_sc_mcu9t5v0__clkinv_1
X$7639 \$16907 \$16906 \$16914 \$16728 \$16485 gf180mcu_fd_sc_mcu9t5v0__xnor2_1
X$7640 \$17226 \$17229 \$17690 \$17228 \$17085 \$17367 \$16570
+ gf180mcu_fd_sc_mcu9t5v0__and4_1
X$7641 \$16570 \$17076 \$17085 \$17034 \$17077 gf180mcu_fd_sc_mcu9t5v0__nor2_1
X$7642 \$18001 \$18135 \$18002 \$18137 \$17952 \$16578
+ gf180mcu_fd_sc_mcu9t5v0__nor3_1
X$7643 \$16578 \$17490 \$17538 \$17367 \$17491 gf180mcu_fd_sc_mcu9t5v0__nor2_1
X$7644 \$16580 \$17085 \$17367 \$17354 gf180mcu_fd_sc_mcu9t5v0__buf_8
X$7645 \$16601 \$16868 \$16914 \$16728 \$16584 gf180mcu_fd_sc_mcu9t5v0__nand2_1
X$7646 \$17371 \$17097 \$17538 \$17367 \$16590 gf180mcu_fd_sc_mcu9t5v0__nor2_4
X$7647 \$16854 \$16590 \$16914 \$16728 \$16729 gf180mcu_fd_sc_mcu9t5v0__nand2_1
X$7648 \$16590 \$17085 \$17367 \$17093 gf180mcu_fd_sc_mcu9t5v0__buf_8
X$7649 \$16854 \$16914 \$17034 \$16591 gf180mcu_fd_sc_mcu9t5v0__inv_1
X$7650 \$16856 \$16592 \$16732 \$16591 \$16914 \$16728 \$16852
+ gf180mcu_fd_sc_mcu9t5v0__oai22_1
X$7651 \$17371 \$17097 \$16591 \$17538 \$17367 \$17709
+ gf180mcu_fd_sc_mcu9t5v0__nand3_1
X$7652 \$16855 \$16854 \$16592 \$16914 \$17034 \$17096
+ gf180mcu_fd_sc_mcu9t5v0__nor3_1
X$7653 \$25598 \$19334 \$18875 \$25462 \$25632 \$16595
+ gf180mcu_fd_sc_mcu9t5v0__nor3_1
X$7654 \$18016 \$17826 \$18021 \$18137 \$17952 \$16598
+ gf180mcu_fd_sc_mcu9t5v0__nor3_1
X$7655 \$17715 \$18270 \$18137 \$18293 \$16604 \$17666
+ gf180mcu_fd_sc_mcu9t5v0__xnor3_1
X$7656 \$16925 \$16610 \$16926 \$16914 \$17034 \$16877
+ gf180mcu_fd_sc_mcu9t5v0__oai21_1
X$7657 \$17129 \$16619 \$17085 \$17034 \$17128 gf180mcu_fd_sc_mcu9t5v0__xnor2_1
X$7658 \$16619 \$16914 \$16728 \$16745 gf180mcu_fd_sc_mcu9t5v0__clkinv_1
X$7659 \$17684 \$17538 \$17703 \$17550 \$16620 gf180mcu_fd_sc_mcu9t5v0__xor2_1
X$7660 \$16898 \$16914 \$16728 \$16899 \$16622 gf180mcu_fd_sc_mcu9t5v0__xor2_1
X$7661 \$17852 \$17723 \$17818 \$17703 \$16624 gf180mcu_fd_sc_mcu9t5v0__and2_1
X$7662 \$16898 \$16897 \$16914 \$16728 \$16625 gf180mcu_fd_sc_mcu9t5v0__nand2_1
X$7663 \$17986 \$17988 \$16898 \$17818 \$17952 \$16626
+ gf180mcu_fd_sc_mcu9t5v0__oai21_1
X$7664 \$16898 \$16901 \$16627 \$16914 \$17034 \$16628
+ gf180mcu_fd_sc_mcu9t5v0__nor3_1
X$7665 \$16634 \$16914 \$17034 \$16631 gf180mcu_fd_sc_mcu9t5v0__clkinv_1
X$7666 \$16636 \$16904 \$16914 \$16728 \$16632 gf180mcu_fd_sc_mcu9t5v0__nand2_1
X$7667 \$16636 \$17073 \$16914 \$17034 \$16633 gf180mcu_fd_sc_mcu9t5v0__nand2_1
X$7668 \$18152 \$18154 \$16636 \$18137 \$17952 \$16634
+ gf180mcu_fd_sc_mcu9t5v0__oai21_1
X$7669 \$16636 \$16638 \$16635 \$16914 \$17034 \$17074
+ gf180mcu_fd_sc_mcu9t5v0__nor3_1
X$7670 \$16636 \$16914 \$17034 \$17073 \$16930 gf180mcu_fd_sc_mcu9t5v0__xor2_1
X$7671 \$16636 \$18137 \$17952 \$18154 \$18046 gf180mcu_fd_sc_mcu9t5v0__xor2_1
X$7672 \$16636 \$16914 \$16728 \$16904 \$16747 gf180mcu_fd_sc_mcu9t5v0__xor2_1
X$7673 \$16636 \$18152 \$18701 \$18576 \$18855 gf180mcu_fd_sc_mcu9t5v0__xnor2_1
X$7674 \$16636 \$18152 \$18283 \$18137 \$18293 \$18153
+ gf180mcu_fd_sc_mcu9t5v0__aoi21_1
X$7675 \$16636 \$22930 \$23027 \$22837 \$22931 gf180mcu_fd_sc_mcu9t5v0__nand2_1
X$7676 \$16637 \$17135 \$17139 \$17538 \$17367 \$17265
+ gf180mcu_fd_sc_mcu9t5v0__mux2_1
X$7677 \$16727 \$16846 \$16914 \$16728 \$16726 gf180mcu_fd_sc_mcu9t5v0__and2_1
X$7678 \$16898 \$16914 \$16728 \$16897 \$16746 gf180mcu_fd_sc_mcu9t5v0__xor2_1
X$7679 \$16855 \$16730 \$16854 \$16914 \$16728 \$16731
+ gf180mcu_fd_sc_mcu9t5v0__nor3_1
X$7680 \$16740 \$16871 \$16741 \$16914 \$16728 \$16872
+ gf180mcu_fd_sc_mcu9t5v0__oai21_1
X$7681 \$16748 \$16747 \$16930 \$16914 \$16728 \$16749
+ gf180mcu_fd_sc_mcu9t5v0__nand3_1
X$7682 \$16867 \$16866 \$16921 \$16914 \$16728 \$16922
+ gf180mcu_fd_sc_mcu9t5v0__nand3_1
X$7683 \$16905 \$17074 \$16914 \$16728 \$16906 gf180mcu_fd_sc_mcu9t5v0__nor2_1
X$7684 \$16848 \$16914 \$16728 \$16917 gf180mcu_fd_sc_mcu9t5v0__buf_8
X$7685 \$16900 \$16914 \$16728 \$16901 gf180mcu_fd_sc_mcu9t5v0__clkinv_1
X$7686 \$16728 \$16914 gf180mcu_fd_sc_mcu9t5v0__filltie
X$7687 \$16728 \$16914 gf180mcu_fd_sc_mcu9t5v0__filltie
X$7688 \$16728 \$16914 gf180mcu_fd_sc_mcu9t5v0__filltie
X$7689 \$16728 \$16914 gf180mcu_fd_sc_mcu9t5v0__filltie
X$7690 \$16728 \$16914 gf180mcu_fd_sc_mcu9t5v0__filltie
X$7691 \$16728 \$16914 gf180mcu_fd_sc_mcu9t5v0__filltie
X$7692 \$16728 \$16914 gf180mcu_fd_sc_mcu9t5v0__endcap
X$7693 \$17709 \$16729 \$17708 \$17818 \$17703 \$18013
+ gf180mcu_fd_sc_mcu9t5v0__aoi21_2
X$7694 \$17097 \$17538 \$17367 \$16730 gf180mcu_fd_sc_mcu9t5v0__clkinv_1
X$7695 \$16855 \$16730 \$17538 \$17703 \$17823 gf180mcu_fd_sc_mcu9t5v0__nand2_1
X$7696 \$17392 \$17255 \$17085 \$17367 \$16744 gf180mcu_fd_sc_mcu9t5v0__nor2_1
X$7697 \$18283 \$18046 \$18137 \$18293 \$16748 gf180mcu_fd_sc_mcu9t5v0__and2_1
X$7698 \$17486 \$17357 \$17538 \$17367 \$16836 gf180mcu_fd_sc_mcu9t5v0__and2_1
X$7699 \$18567 \$18811 \$18701 \$18576 \$16840 gf180mcu_fd_sc_mcu9t5v0__nand2_1
X$7700 \$17645 \$16840 \$18137 \$18293 \$18246 gf180mcu_fd_sc_mcu9t5v0__nand2_1
X$7701 \$16845 \$24845 \$24877 \$24721 \$24990 gf180mcu_fd_sc_mcu9t5v0__nand2_1
X$7702 \$20712 \$20881 \$20718 \$16845 gf180mcu_fd_sc_mcu9t5v0__buf_8
X$7703 \$18291 \$19146 \$16845 \$19027 \$19149 \$19145
+ gf180mcu_fd_sc_mcu9t5v0__mux2_1
X$7704 \$17949 \$17951 \$16845 \$17818 \$17952 \$17950
+ gf180mcu_fd_sc_mcu9t5v0__mux2_1
X$7705 \$18871 \$18823 \$16845 \$18701 \$18870 \$18872
+ gf180mcu_fd_sc_mcu9t5v0__mux2_1
X$7706 \$18008 \$17369 \$16845 \$17818 \$17952 \$17954
+ gf180mcu_fd_sc_mcu9t5v0__mux2_1
X$7707 \$17651 \$17653 \$16845 \$17818 \$17703 \$17652
+ gf180mcu_fd_sc_mcu9t5v0__mux2_1
X$7708 \$17366 \$17087 \$16845 \$17085 \$17034 \$17086
+ gf180mcu_fd_sc_mcu9t5v0__mux2_1
X$7709 \$17240 \$17239 \$17364 \$17085 \$17367 \$16846
+ gf180mcu_fd_sc_mcu9t5v0__aoi21_1
X$7710 \$17364 \$17240 \$16846 \$17538 \$17703 \$17492
+ gf180mcu_fd_sc_mcu9t5v0__aoi21_1
X$7711 \$18873 \$16849 \$23327 \$23183 \$23139 \$23187
+ gf180mcu_fd_sc_mcu9t5v0__nand3_1
X$7712 \$16851 \$24070 \$23941 \$24231 \$24109 \$24262
+ gf180mcu_fd_sc_mcu9t5v0__aoi21_1
X$7713 \$16851 \$22912 \$23027 \$22837 \$23035 gf180mcu_fd_sc_mcu9t5v0__nand2_1
X$7714 \$17823 \$18137 \$17952 \$16851 gf180mcu_fd_sc_mcu9t5v0__buf_8
X$7715 \$17371 \$17085 \$17367 \$16855 gf180mcu_fd_sc_mcu9t5v0__clkinv_1
X$7716 \$17038 \$16919 \$16858 \$16914 \$17034 \$16918
+ gf180mcu_fd_sc_mcu9t5v0__nand3_1
X$7717 \$17840 \$17974 \$17975 \$17818 \$17952 \$16871
+ gf180mcu_fd_sc_mcu9t5v0__oai21_1
X$7718 \$17058 \$16914 \$17034 \$16875 gf180mcu_fd_sc_mcu9t5v0__clkinv_1
X$7719 \$17722 \$17818 \$17703 \$17548 \$16883 gf180mcu_fd_sc_mcu9t5v0__xor2_1
X$7720 \$17523 \$17255 \$17085 \$17034 \$16891 gf180mcu_fd_sc_mcu9t5v0__nor2_1
X$7721 \$17128 \$17127 \$17069 \$16914 \$17034 \$16894
+ gf180mcu_fd_sc_mcu9t5v0__and3_1
X$7722 \$17132 \$16897 \$17133 \$17085 \$17034 \$17131
+ gf180mcu_fd_sc_mcu9t5v0__mux2_1
X$7723 \$16898 \$18137 \$17952 \$17986 \$17723 gf180mcu_fd_sc_mcu9t5v0__xor2_1
X$7724 \$16898 \$17988 \$19027 \$19149 \$19179 gf180mcu_fd_sc_mcu9t5v0__xnor2_1
X$7725 \$16898 \$17988 \$17852 \$18137 \$17952 \$18044
+ gf180mcu_fd_sc_mcu9t5v0__aoi21_1
X$7726 \$16898 \$22928 \$23027 \$22837 \$22929 gf180mcu_fd_sc_mcu9t5v0__nand2_1
X$7727 \$17261 \$16899 \$17133 \$17085 \$17367 \$17395
+ gf180mcu_fd_sc_mcu9t5v0__mux2_1
X$7728 \$17135 \$16900 \$17133 \$17085 \$17034 \$17134
+ gf180mcu_fd_sc_mcu9t5v0__mux2_1
X$7729 \$16902 \$17133 \$17085 \$17034 \$17137 gf180mcu_fd_sc_mcu9t5v0__nand2_1
X$7730 \$16904 \$17261 \$17139 \$17085 \$17367 \$17397
+ gf180mcu_fd_sc_mcu9t5v0__mux2_1
X$7731 \$16907 \$17139 \$17085 \$17367 \$17266 gf180mcu_fd_sc_mcu9t5v0__nor2_1
X$7732 \$17483 \$17638 \$16908 \$17538 \$17367 \$17531
+ gf180mcu_fd_sc_mcu9t5v0__nand3_1
X$7733 \$17646 \$17811 \$16910 \$18243 \$18137 \$18293 \$18247
+ gf180mcu_fd_sc_mcu9t5v0__oai31_2
X$7734 \$16912 \$19027 \$19149 \$19144 gf180mcu_fd_sc_mcu9t5v0__clkinv_1
X$7735 \$17035 \$17030 \$16914 \$17034 \$17036 gf180mcu_fd_sc_mcu9t5v0__nor2_1
X$7736 \$17021 \$16914 \$17034 \$17081 gf180mcu_fd_sc_mcu9t5v0__clkinv_1
X$7737 \$17060 \$17061 \$16914 \$17034 \$16928 gf180mcu_fd_sc_mcu9t5v0__nand2_1
X$7738 \$17047 \$17046 \$16914 \$17034 \$16915 gf180mcu_fd_sc_mcu9t5v0__nand2_1
X$7739 \$17034 \$16914 gf180mcu_fd_sc_mcu9t5v0__filltie
X$7740 \$17034 \$16914 gf180mcu_fd_sc_mcu9t5v0__filltie
X$7741 \$17034 \$16914 gf180mcu_fd_sc_mcu9t5v0__filltie
X$7742 \$17034 \$16914 gf180mcu_fd_sc_mcu9t5v0__filltie
X$7743 \$17034 \$16914 gf180mcu_fd_sc_mcu9t5v0__filltie
X$7744 \$17034 \$16914 gf180mcu_fd_sc_mcu9t5v0__filltie
X$7745 \$17034 \$16914 gf180mcu_fd_sc_mcu9t5v0__endcap
X$7746 \$17960 \$17826 \$18137 \$17952 \$16919 gf180mcu_fd_sc_mcu9t5v0__nor2_1
X$7747 \$16919 \$17540 \$17538 \$17367 \$17496 gf180mcu_fd_sc_mcu9t5v0__nand2_1
X$7748 \$17108 \$17050 \$17106 \$17107 \$16923 \$17085 \$17034 \$17104
+ gf180mcu_fd_sc_mcu9t5v0__oai221_1
X$7749 \$17228 \$17078 \$17085 \$17034 \$17016 gf180mcu_fd_sc_mcu9t5v0__nor2_1
X$7750 \$17017 \$17085 \$17367 \$17809 gf180mcu_fd_sc_mcu9t5v0__clkinv_1
X$7751 \$17018 \$17019 \$17486 \$17538 \$17367 \$17533
+ gf180mcu_fd_sc_mcu9t5v0__nand3_1
X$7752 \$26512 \$26640 \$17019 \$26399 \$26351 \$26675 \$26521 \$26673
+ gf180mcu_fd_sc_mcu9t5v0__oai221_1
X$7753 \$25584 \$27276 \$27275 \$27315 \$27153 \$17019
+ gf180mcu_fd_sc_mcu9t5v0__oai21_1
X$7754 \$17020 \$17085 \$17367 gf180mcu_fd_sc_mcu9t5v0__clkinv_3
X$7755 \$26399 \$17023 \$26088 \$26220 \$26210 gf180mcu_fd_sc_mcu9t5v0__nand2_1
X$7756 \$25584 \$25302 \$28044 \$27315 \$27153 \$17023
+ gf180mcu_fd_sc_mcu9t5v0__mux2_1
X$7757 \$17031 \$17085 \$17367 \$17364 gf180mcu_fd_sc_mcu9t5v0__clkinv_1
X$7758 \$17091 \$17090 \$17085 \$17034 \$17092 gf180mcu_fd_sc_mcu9t5v0__xnor2_1
X$7759 \$17258 \$17551 \$17085 \$17034 \$17130 gf180mcu_fd_sc_mcu9t5v0__and2_1
X$7760 \$17127 \$17069 \$17128 \$17085 \$17034 \$17126
+ gf180mcu_fd_sc_mcu9t5v0__aoi21_1
X$7761 \$17136 \$17133 \$17137 \$17085 \$17034 \$17072
+ gf180mcu_fd_sc_mcu9t5v0__oai21_1
X$7762 \$17125 \$17085 \$17034 \$17067 gf180mcu_fd_sc_mcu9t5v0__clkinv_1
X$7763 \$17110 \$17109 \$17085 \$17034 \$17238 gf180mcu_fd_sc_mcu9t5v0__nand2_1
X$7764 \$17034 \$17085 gf180mcu_fd_sc_mcu9t5v0__filltie
X$7765 \$17034 \$17085 gf180mcu_fd_sc_mcu9t5v0__filltie
X$7766 \$17034 \$17085 gf180mcu_fd_sc_mcu9t5v0__filltie
X$7767 \$17034 \$17085 gf180mcu_fd_sc_mcu9t5v0__filltie
X$7768 \$17034 \$17085 gf180mcu_fd_sc_mcu9t5v0__filltie
X$7769 \$17034 \$17085 gf180mcu_fd_sc_mcu9t5v0__filltie
X$7770 \$17073 \$17132 \$17139 \$17085 \$17034 \$17263
+ gf180mcu_fd_sc_mcu9t5v0__mux2_1
X$7771 \$17034 \$17085 gf180mcu_fd_sc_mcu9t5v0__endcap
X$7772 \$17036 \$17085 \$17367 \$17368 gf180mcu_fd_sc_mcu9t5v0__buf_8
X$7773 \$26408 \$17037 \$19886 \$27454 \$27315 \$27449 \$27453
+ gf180mcu_fd_sc_mcu9t5v0__aoi211_1
X$7774 \$17038 \$17037 \$27782 \$25350 \$25462 \$25347 \$23322
+ gf180mcu_fd_sc_mcu9t5v0__aoi211_1
X$7775 \$25804 \$26088 \$25918 \$17038 gf180mcu_fd_sc_mcu9t5v0__buf_8
X$7776 \$17099 \$17040 \$24106 \$24593 \$24428 \$24592
+ gf180mcu_fd_sc_mcu9t5v0__mux2_1
X$7777 \$22598 \$22597 \$22713 \$22440 \$17059 gf180mcu_fd_sc_mcu9t5v0__xnor2_1
X$7778 \$18147 \$18137 \$17952 \$18038 \$17063 gf180mcu_fd_sc_mcu9t5v0__xor2_1
X$7779 \$19763 \$20541 \$19299 \$19605 \$19774 \$17065
+ gf180mcu_fd_sc_mcu9t5v0__oai21_1
X$7780 \$19349 \$19047 \$19324 \$19149 \$17066 gf180mcu_fd_sc_mcu9t5v0__or2_1
X$7781 \$17677 \$17520 \$17538 \$17703 \$17068 gf180mcu_fd_sc_mcu9t5v0__nand2_1
X$7782 \$17392 \$17678 \$17549 \$17538 \$17367 \$17069
+ gf180mcu_fd_sc_mcu9t5v0__oai21_1
X$7783 \$19049 \$19624 \$19027 \$19149 \$17070 gf180mcu_fd_sc_mcu9t5v0__nand2_1
X$7784 \$17230 \$17080 \$17079 \$17538 \$17367 \$17484
+ gf180mcu_fd_sc_mcu9t5v0__aoi21_1
X$7785 \$17232 \$17357 \$17085 \$17367 \$17080 gf180mcu_fd_sc_mcu9t5v0__nand2_1
X$7786 \$17226 \$17227 \$17085 \$17367 \$17353 gf180mcu_fd_sc_mcu9t5v0__and2_1
X$7787 \$17254 \$17253 \$17085 \$17367 \$17125 gf180mcu_fd_sc_mcu9t5v0__or2_1
X$7788 \$17136 \$17139 \$17266 \$17085 \$17367 \$17398
+ gf180mcu_fd_sc_mcu9t5v0__aoi21_1
X$7789 \$17089 \$17085 \$17367 \$17370 gf180mcu_fd_sc_mcu9t5v0__buf_8
X$7790 \$17236 \$17085 \$17367 \$17363 gf180mcu_fd_sc_mcu9t5v0__buf_8
X$7791 \$17353 \$17225 \$17085 \$17367 \$17352 gf180mcu_fd_sc_mcu9t5v0__nor2_1
X$7792 \$17355 \$17085 \$17367 \$17230 gf180mcu_fd_sc_mcu9t5v0__clkinv_1
X$7793 \$17392 \$17678 \$17085 \$17367 \$17127 gf180mcu_fd_sc_mcu9t5v0__nand2_1
X$7794 \$17367 \$17085 gf180mcu_fd_sc_mcu9t5v0__filltie
X$7795 \$17367 \$17085 gf180mcu_fd_sc_mcu9t5v0__filltie
X$7796 \$17367 \$17085 gf180mcu_fd_sc_mcu9t5v0__filltie
X$7797 \$17367 \$17085 gf180mcu_fd_sc_mcu9t5v0__filltie
X$7798 \$17367 \$17085 gf180mcu_fd_sc_mcu9t5v0__filltie
X$7799 \$17367 \$17085 gf180mcu_fd_sc_mcu9t5v0__filltie
X$7800 \$17367 \$17085 gf180mcu_fd_sc_mcu9t5v0__endcap
X$7801 \$17093 \$22445 \$22713 \$22837 \$22719 gf180mcu_fd_sc_mcu9t5v0__nor2_1
X$7802 \$17093 \$21363 \$22387 \$22272 \$22390 gf180mcu_fd_sc_mcu9t5v0__nor2_1
X$7803 \$17093 \$22911 \$23027 \$22837 \$22857 gf180mcu_fd_sc_mcu9t5v0__nor2_1
X$7804 \$17093 \$21361 \$21498 \$21308 \$21362 gf180mcu_fd_sc_mcu9t5v0__nor2_1
X$7805 \$17124 \$17513 \$17388 \$17538 \$17367 \$17514
+ gf180mcu_fd_sc_mcu9t5v0__aoi21_1
X$7806 \$17129 \$17984 \$18137 \$17952 \$18040 gf180mcu_fd_sc_mcu9t5v0__xnor2_1
X$7807 \$17129 \$17393 \$17818 \$17703 \$17684 gf180mcu_fd_sc_mcu9t5v0__xnor2_1
X$7808 \$17129 \$17685 \$17538 \$17703 \$17686 gf180mcu_fd_sc_mcu9t5v0__nand2_1
X$7809 \$31836 \$31810 \$31886 \$17132 gf180mcu_fd_sc_mcu9t5v0__buf_8
X$7810 \$21335 \$17132 \$21197 \$21184 \$21308 \$21334
+ gf180mcu_fd_sc_mcu9t5v0__mux2_1
X$7811 \$17132 \$26543 \$23348 \$26401 \$26521 \$26542
+ gf180mcu_fd_sc_mcu9t5v0__mux2_1
X$7812 \$17132 \$24085 \$22928 \$23926 \$24109 \$24129
+ gf180mcu_fd_sc_mcu9t5v0__mux2_1
X$7813 \$17132 \$24868 \$22930 \$24877 \$24721 \$24894
+ gf180mcu_fd_sc_mcu9t5v0__mux2_1
X$7814 \$17132 \$26386 \$23479 \$26401 \$26220 \$26385
+ gf180mcu_fd_sc_mcu9t5v0__mux2_1
X$7815 \$17132 \$20363 \$19014 \$20209 \$20087 \$20362
+ gf180mcu_fd_sc_mcu9t5v0__mux2_1
X$7816 \$28983 \$29109 \$29123 \$28971 \$17133 gf180mcu_fd_sc_mcu9t5v0__nand2_1
X$7817 \$21844 \$21701 \$17133 \$21661 \$21946 \$21972
+ gf180mcu_fd_sc_mcu9t5v0__mux2_1
X$7818 \$17987 \$17986 \$17133 \$17818 \$17952 \$18043
+ gf180mcu_fd_sc_mcu9t5v0__mux2_1
X$7819 \$27344 \$25787 \$17133 \$26401 \$26521 \$26549
+ gf180mcu_fd_sc_mcu9t5v0__mux2_1
X$7820 \$18554 \$17988 \$17133 \$18403 \$18576 \$18610
+ gf180mcu_fd_sc_mcu9t5v0__mux2_1
X$7821 \$20615 \$19914 \$17133 \$20209 \$20383 \$20549
+ gf180mcu_fd_sc_mcu9t5v0__mux2_1
X$7822 \$26391 \$26118 \$17133 \$26675 \$26521 \$26698
+ gf180mcu_fd_sc_mcu9t5v0__mux2_1
X$7823 \$22607 \$22606 \$17133 \$22713 \$22440 \$22727
+ gf180mcu_fd_sc_mcu9t5v0__mux2_1
X$7824 \$23481 \$23351 \$17133 \$23620 \$23454 \$23658
+ gf180mcu_fd_sc_mcu9t5v0__mux2_1
X$7825 \$26246 \$24754 \$17133 \$25191 \$24997 \$25032
+ gf180mcu_fd_sc_mcu9t5v0__mux2_1
X$7826 \$21048 \$21179 \$17133 \$21184 \$21011 \$21178
+ gf180mcu_fd_sc_mcu9t5v0__mux2_1
X$7827 \$32357 \$32339 \$32307 \$17135 gf180mcu_fd_sc_mcu9t5v0__buf_8
X$7828 \$21036 \$17135 \$21197 \$20881 \$21011 \$21035
+ gf180mcu_fd_sc_mcu9t5v0__mux2_1
X$7829 \$17135 \$25776 \$23348 \$26088 \$26220 \$25987
+ gf180mcu_fd_sc_mcu9t5v0__mux2_1
X$7830 \$17135 \$25783 \$23479 \$25797 \$25632 \$25818
+ gf180mcu_fd_sc_mcu9t5v0__mux2_1
X$7831 \$17135 \$22613 \$22930 \$22713 \$22440 \$22729
+ gf180mcu_fd_sc_mcu9t5v0__mux2_1
X$7832 \$17135 \$19491 \$19014 \$19324 \$19149 \$19361
+ gf180mcu_fd_sc_mcu9t5v0__mux2_1
X$7833 \$17135 \$23219 \$22928 \$23183 \$23139 \$23350
+ gf180mcu_fd_sc_mcu9t5v0__mux2_1
X$7834 \$17136 \$23479 \$25029 \$24877 \$24997 \$25028
+ gf180mcu_fd_sc_mcu9t5v0__oai21_1
X$7835 \$17136 \$23348 \$25328 \$25462 \$25632 \$25484
+ gf180mcu_fd_sc_mcu9t5v0__oai21_1
X$7836 \$17136 \$22930 \$21847 \$21661 \$21946 \$21846
+ gf180mcu_fd_sc_mcu9t5v0__oai21_1
X$7837 \$17136 \$19014 \$19015 \$19027 \$18870 \$18851
+ gf180mcu_fd_sc_mcu9t5v0__oai21_1
X$7838 \$27809 \$17136 \$27668 \$27637 \$27776 \$27808
+ gf180mcu_fd_sc_mcu9t5v0__oai21_1
X$7839 \$22928 \$17136 \$22612 \$22713 \$22440 \$22728
+ gf180mcu_fd_sc_mcu9t5v0__oai21_1
X$7840 \$31694 \$31232 \$31175 \$17136 gf180mcu_fd_sc_mcu9t5v0__buf_8
X$7841 \$29108 \$29134 \$29109 \$29123 \$28971 \$17139
+ gf180mcu_fd_sc_mcu9t5v0__and3_1
X$7842 \$22614 \$23481 \$17139 \$22713 \$22837 \$22879
+ gf180mcu_fd_sc_mcu9t5v0__mux2_1
X$7843 \$20907 \$21844 \$17139 \$20881 \$21011 \$20861
+ gf180mcu_fd_sc_mcu9t5v0__mux2_1
X$7844 \$20550 \$20615 \$17139 \$20515 \$20718 \$20737
+ gf180mcu_fd_sc_mcu9t5v0__mux2_1
X$7845 \$18154 \$17987 \$17139 \$18137 \$18293 \$18284
+ gf180mcu_fd_sc_mcu9t5v0__mux2_1
X$7846 \$22289 \$22607 \$17139 \$22387 \$22272 \$22422
+ gf180mcu_fd_sc_mcu9t5v0__mux2_1
X$7847 \$24756 \$26246 \$17139 \$24877 \$24721 \$24895
+ gf180mcu_fd_sc_mcu9t5v0__mux2_1
X$7848 \$25955 \$27344 \$17139 \$26675 \$26521 \$26550
+ gf180mcu_fd_sc_mcu9t5v0__mux2_1
X$7849 \$25790 \$26391 \$17139 \$26401 \$26220 \$26390
+ gf180mcu_fd_sc_mcu9t5v0__mux2_1
X$7850 \$20912 \$21048 \$17139 \$21184 \$21011 \$21180
+ gf180mcu_fd_sc_mcu9t5v0__mux2_1
X$7851 \$18152 \$18554 \$17139 \$18701 \$18576 \$18555
+ gf180mcu_fd_sc_mcu9t5v0__mux2_1
X$7852 \$17690 \$17691 \$17639 \$17637 \$17226 \$17538 \$17703 \$17483
+ gf180mcu_fd_sc_mcu9t5v0__oai32_1
X$7853 \$17226 \$17637 \$17538 \$17703 \$17638 gf180mcu_fd_sc_mcu9t5v0__nand2_1
X$7854 \$17690 \$17228 \$17538 \$17703 \$17227 gf180mcu_fd_sc_mcu9t5v0__and2_1
X$7855 \$17227 \$17942 \$17818 \$17952 \$17941 gf180mcu_fd_sc_mcu9t5v0__nor2_1
X$7856 \$18286 \$17230 \$17692 \$17809 \$17818 \$17703 \$17691
+ gf180mcu_fd_sc_mcu9t5v0__aoi22_1
X$7857 \$17232 \$17531 \$17538 \$17367 \$17486 gf180mcu_fd_sc_mcu9t5v0__and2_1
X$7858 \$17232 \$17357 \$17538 \$17367 \$17485 gf180mcu_fd_sc_mcu9t5v0__nor2_1
X$7859 \$18527 \$17237 \$18403 \$18576 \$18569 gf180mcu_fd_sc_mcu9t5v0__nand2_1
X$7860 \$19024 \$19455 \$18405 \$18994 \$19027 \$19149 \$17239
+ gf180mcu_fd_sc_mcu9t5v0__nand4_1
X$7861 \$18007 \$17817 \$18137 \$17952 \$17241 gf180mcu_fd_sc_mcu9t5v0__and2_1
X$7862 \$25968 \$26088 \$25918 \$17244 gf180mcu_fd_sc_mcu9t5v0__buf_8
X$7863 \$17507 \$17538 \$17367 \$17251 gf180mcu_fd_sc_mcu9t5v0__clkinv_1
X$7864 \$18430 \$18547 \$18403 \$18576 \$17253 \$18548
+ gf180mcu_fd_sc_mcu9t5v0__xnor3_1
X$7865 \$17254 \$17845 \$17538 \$17703 \$17519 \$18427
+ gf180mcu_fd_sc_mcu9t5v0__xnor3_1
X$7866 \$17673 \$17538 \$17703 \$17254 gf180mcu_fd_sc_mcu9t5v0__clkinv_1
X$7867 \$17254 \$18427 \$17818 \$17952 \$17676 gf180mcu_fd_sc_mcu9t5v0__nor2_1
X$7868 \$17254 \$18427 \$17818 \$17703 \$17674 gf180mcu_fd_sc_mcu9t5v0__nand2_1
X$7869 \$17678 \$17680 \$17538 \$17703 \$17255 \$17679
+ gf180mcu_fd_sc_mcu9t5v0__xnor3_1
X$7870 \$28110 \$27913 \$28089 \$17261 gf180mcu_fd_sc_mcu9t5v0__buf_8
X$7871 \$21839 \$17261 \$21197 \$21661 \$21946 \$21968
+ gf180mcu_fd_sc_mcu9t5v0__mux2_1
X$7872 \$17261 \$25954 \$22930 \$26088 \$26220 \$26250
+ gf180mcu_fd_sc_mcu9t5v0__mux2_1
X$7873 \$17261 \$27055 \$23479 \$27015 \$27153 \$27182
+ gf180mcu_fd_sc_mcu9t5v0__mux2_1
X$7874 \$17261 \$19944 \$19014 \$19927 \$19774 \$19943
+ gf180mcu_fd_sc_mcu9t5v0__mux2_1
X$7875 \$17261 \$25788 \$22928 \$26088 \$25918 \$26120
+ gf180mcu_fd_sc_mcu9t5v0__mux2_1
X$7876 \$17261 \$27295 \$23348 \$27637 \$27449 \$27669
+ gf180mcu_fd_sc_mcu9t5v0__mux2_1
X$7877 \$17356 \$17485 \$17538 \$17367 \$17532 gf180mcu_fd_sc_mcu9t5v0__nor2_1
X$7878 \$26967 \$25625 \$17359 \$26399 \$26968 \$27015 \$26856 \$27008
+ gf180mcu_fd_sc_mcu9t5v0__aoi221_1
X$7879 \$17523 \$17549 \$17538 \$17367 \$17522 \$17524
+ gf180mcu_fd_sc_mcu9t5v0__xnor3_1
X$7880 \$17496 \$17376 \$17375 \$17380 \$17538 \$17367 \$17377
+ gf180mcu_fd_sc_mcu9t5v0__nand4_1
X$7881 \$17515 \$17514 \$17390 \$17538 \$17367 \$17516
+ gf180mcu_fd_sc_mcu9t5v0__aoi21_1
X$7882 \$17682 \$17680 \$17681 \$17538 \$17367 \$17550
+ gf180mcu_fd_sc_mcu9t5v0__oai21_1
X$7883 \$17541 \$17372 \$17538 \$17367 \$17497 gf180mcu_fd_sc_mcu9t5v0__nor2_1
X$7884 \$17511 \$17538 \$17367 \$17669 gf180mcu_fd_sc_mcu9t5v0__clkinv_1
X$7885 \$17386 \$17505 \$17538 \$17367 \$17506 gf180mcu_fd_sc_mcu9t5v0__nand2_1
X$7886 \$17367 \$17538 gf180mcu_fd_sc_mcu9t5v0__filltie
X$7887 \$17367 \$17538 gf180mcu_fd_sc_mcu9t5v0__filltie
X$7888 \$17367 \$17538 gf180mcu_fd_sc_mcu9t5v0__filltie
X$7889 \$17367 \$17538 gf180mcu_fd_sc_mcu9t5v0__filltie
X$7890 \$17367 \$17538 gf180mcu_fd_sc_mcu9t5v0__filltie
X$7891 \$17367 \$17538 gf180mcu_fd_sc_mcu9t5v0__filltie
X$7892 \$17367 \$17538 gf180mcu_fd_sc_mcu9t5v0__endcap
X$7893 \$17541 \$17825 \$17538 \$17703 \$17373 gf180mcu_fd_sc_mcu9t5v0__nor2_1
X$7894 \$17374 \$17498 \$24106 \$25462 \$25632 \$25594
+ gf180mcu_fd_sc_mcu9t5v0__mux2_1
X$7895 \$20534 \$20355 \$20357 \$20209 \$20383 \$17387
+ gf180mcu_fd_sc_mcu9t5v0__aoi21_1
X$7896 \$17387 \$20224 \$20209 \$20087 \$20060 gf180mcu_fd_sc_mcu9t5v0__nor2_1
X$7897 \$22463 \$22462 \$22387 \$22440 \$17391 gf180mcu_fd_sc_mcu9t5v0__nor2_1
X$7898 \$17392 \$17538 \$17703 \$17523 gf180mcu_fd_sc_mcu9t5v0__clkinv_1
X$7899 \$17393 \$17538 \$17703 \$17685 gf180mcu_fd_sc_mcu9t5v0__clkinv_1
X$7900 \$17644 \$17694 \$17640 \$17641 \$17488 \$17818 \$17703 \$17487
+ gf180mcu_fd_sc_mcu9t5v0__oai32_1
X$7901 \$17643 \$17538 \$17703 \$17488 gf180mcu_fd_sc_mcu9t5v0__clkinv_1
X$7902 \$17833 \$17969 \$17818 \$17703 \$17495 gf180mcu_fd_sc_mcu9t5v0__nand2_1
X$7903 \$17501 \$17544 \$17538 \$17703 \$17704 gf180mcu_fd_sc_mcu9t5v0__nand2_1
X$7904 \$24316 \$24231 \$24428 \$24318 \$17504 gf180mcu_fd_sc_mcu9t5v0__xor2_1
X$7905 \$19752 \$20100 \$20209 \$20087 \$17507 gf180mcu_fd_sc_mcu9t5v0__or2_1
X$7906 \$17666 \$17818 \$17703 \$17508 gf180mcu_fd_sc_mcu9t5v0__clkinv_1
X$7907 \$17715 \$17508 \$18403 \$18576 \$18303 gf180mcu_fd_sc_mcu9t5v0__nor2_1
X$7908 \$17715 \$17508 \$18403 \$18293 \$18420 gf180mcu_fd_sc_mcu9t5v0__nand2_1
X$7909 \$17715 \$17974 \$17818 \$17952 \$17509 \$17973
+ gf180mcu_fd_sc_mcu9t5v0__xnor3_1
X$7910 \$17666 \$17509 \$17538 \$17703 \$17667 gf180mcu_fd_sc_mcu9t5v0__and2_1
X$7911 \$17511 \$17668 \$17538 \$17703 \$17510 gf180mcu_fd_sc_mcu9t5v0__nand2_1
X$7912 \$17719 \$17670 \$17538 \$17703 \$17513 gf180mcu_fd_sc_mcu9t5v0__and2_1
X$7913 \$18036 \$18146 \$17818 \$17952 \$17520 gf180mcu_fd_sc_mcu9t5v0__xnor2_1
X$7914 \$17847 \$17521 \$17675 \$17538 \$17703 \$17549
+ gf180mcu_fd_sc_mcu9t5v0__aoi21_1
X$7915 \$17677 \$20881 \$21011 \$17521 gf180mcu_fd_sc_mcu9t5v0__clkinv_1
X$7916 \$17524 \$18149 \$18137 \$17952 \$17981 gf180mcu_fd_sc_mcu9t5v0__or2_1
X$7917 \$17524 \$18149 \$18137 \$18293 \$18039 gf180mcu_fd_sc_mcu9t5v0__nand2_1
X$7918 \$17524 \$17538 \$17703 \$17678 gf180mcu_fd_sc_mcu9t5v0__clkinv_1
X$7919 \$19358 \$19357 \$19324 \$19466 \$17526 gf180mcu_fd_sc_mcu9t5v0__xnor2_1
X$7920 \$17534 \$17538 \$17703 \$17530 gf180mcu_fd_sc_mcu9t5v0__buf_8
X$7921 \$18003 \$18135 \$17533 \$18137 \$17952 \$17645
+ gf180mcu_fd_sc_mcu9t5v0__nand3_1
X$7922 \$17686 \$17683 \$17538 \$17703 \$17551 gf180mcu_fd_sc_mcu9t5v0__and2_1
X$7923 \$17643 \$17642 \$17538 \$17703 \$17644 gf180mcu_fd_sc_mcu9t5v0__and2_1
X$7924 \$17674 \$17845 \$17676 \$17538 \$17703 \$17548
+ gf180mcu_fd_sc_mcu9t5v0__aoi21_1
X$7925 \$17669 \$17546 \$17668 \$17538 \$17703 \$17716
+ gf180mcu_fd_sc_mcu9t5v0__oai21_1
X$7926 \$17669 \$17546 \$17668 \$17717 \$17538 \$17703 \$17670
+ gf180mcu_fd_sc_mcu9t5v0__oai211_1
X$7927 \$17682 \$17680 \$17681 \$17684 \$17538 \$17703 \$17683
+ gf180mcu_fd_sc_mcu9t5v0__oai211_1
X$7928 \$17541 \$17706 \$17538 \$17703 \$17655 gf180mcu_fd_sc_mcu9t5v0__nor2_1
X$7929 \$17678 \$17679 \$17538 \$17703 \$17682 gf180mcu_fd_sc_mcu9t5v0__nor2_1
X$7930 \$17649 \$17538 \$17703 \$17698 gf180mcu_fd_sc_mcu9t5v0__clkinv_1
X$7931 \$17678 \$17679 \$17538 \$17703 \$17681 gf180mcu_fd_sc_mcu9t5v0__nand2_1
X$7932 \$17642 \$17646 \$17538 \$17703 \$17647 gf180mcu_fd_sc_mcu9t5v0__nand2_1
X$7933 \$17641 \$17640 \$17642 \$17538 \$17703 \$17693
+ gf180mcu_fd_sc_mcu9t5v0__mux2_1
X$7934 \$17703 \$17538 gf180mcu_fd_sc_mcu9t5v0__filltie
X$7935 \$17703 \$17538 gf180mcu_fd_sc_mcu9t5v0__filltie
X$7936 \$17703 \$17538 gf180mcu_fd_sc_mcu9t5v0__filltie
X$7937 \$17703 \$17538 gf180mcu_fd_sc_mcu9t5v0__filltie
X$7938 \$17703 \$17538 gf180mcu_fd_sc_mcu9t5v0__filltie
X$7939 \$17703 \$17538 gf180mcu_fd_sc_mcu9t5v0__filltie
X$7940 \$17703 \$17538 gf180mcu_fd_sc_mcu9t5v0__endcap
X$7941 \$18016 \$18017 \$18137 \$17952 \$17541 gf180mcu_fd_sc_mcu9t5v0__or2_1
X$7942 \$19045 \$19167 \$19294 \$19295 \$19324 \$19149 \$17546
+ gf180mcu_fd_sc_mcu9t5v0__oai31_1
X$7943 \$17547 \$17818 \$17703 \$17717 gf180mcu_fd_sc_mcu9t5v0__clkinv_1
X$7944 \$18241 \$18137 \$18293 \$17637 gf180mcu_fd_sc_mcu9t5v0__clkinv_1
X$7945 \$17692 \$17809 \$17818 \$17703 \$17639 gf180mcu_fd_sc_mcu9t5v0__nor2_1
X$7946 \$19457 \$19317 \$18863 \$19027 \$19149 \$17640
+ gf180mcu_fd_sc_mcu9t5v0__nand3_1
X$7947 \$18397 \$17644 \$17641 \$18403 \$18293 \$18806
+ gf180mcu_fd_sc_mcu9t5v0__and3_1
X$7948 \$17644 \$17641 \$18397 \$18701 \$18576 \$18564
+ gf180mcu_fd_sc_mcu9t5v0__aoi21_1
X$7949 \$19315 \$19314 \$19324 \$19466 \$17641 gf180mcu_fd_sc_mcu9t5v0__nor2_1
X$7950 \$17643 \$17642 \$17818 \$17703 \$17694 gf180mcu_fd_sc_mcu9t5v0__nor2_1
X$7951 \$17646 \$18985 \$19027 \$19149 \$19021 gf180mcu_fd_sc_mcu9t5v0__nand2_1
X$7952 \$17646 \$18984 \$19027 \$18870 \$18986 gf180mcu_fd_sc_mcu9t5v0__nand2_1
X$7953 \$18397 \$17646 \$18403 \$18576 \$18524 gf180mcu_fd_sc_mcu9t5v0__nand2_1
X$7954 \$19139 \$17646 \$18701 \$18576 \$18398 gf180mcu_fd_sc_mcu9t5v0__nand2_1
X$7955 \$18563 \$17646 \$18403 \$18293 \$18243 gf180mcu_fd_sc_mcu9t5v0__nand2_1
X$7956 \$18139 \$17957 \$17956 \$18012 \$17818 \$17952 \$17654
+ gf180mcu_fd_sc_mcu9t5v0__aoi22_1
X$7957 \$18585 \$18827 \$18403 \$18576 \$17656 gf180mcu_fd_sc_mcu9t5v0__nor2_1
X$7958 \$17658 \$19324 \$19466 gf180mcu_fd_sc_mcu9t5v0__clkbuf_4
X$7959 \$19882 \$19324 \$19149 \$17658 gf180mcu_fd_sc_mcu9t5v0__clkbuf_8
X$7960 \$17658 \$20521 \$20394 \$20515 \$20383 gf180mcu_fd_sc_mcu9t5v0__dffq_2
X$7961 \$22094 \$22074 \$21946 \$21965 \$17671 gf180mcu_fd_sc_mcu9t5v0__xor2_1
X$7962 \$17674 \$17845 \$17676 \$17722 \$17818 \$17703 \$17675
+ gf180mcu_fd_sc_mcu9t5v0__aoi211_1
X$7963 \$17847 \$17818 \$17703 \$17677 \$17722 gf180mcu_fd_sc_mcu9t5v0__xor2_1
X$7964 \$18037 \$18146 \$18148 \$18137 \$17952 \$17680
+ gf180mcu_fd_sc_mcu9t5v0__oai21_1
X$7965 \$18606 \$18894 \$18701 \$18576 \$17687 \$18893
+ gf180mcu_fd_sc_mcu9t5v0__xnor3_1
X$7966 \$18281 \$18280 \$18282 \$18045 \$18137 \$18293 \$17689
+ gf180mcu_fd_sc_mcu9t5v0__aoi211_1
X$7967 \$18563 \$18397 \$17694 \$18403 \$18576 \$18862
+ gf180mcu_fd_sc_mcu9t5v0__nand3_1
X$7968 \$26510 \$25625 \$17695 \$25741 \$26401 \$26521 \$26788
+ gf180mcu_fd_sc_mcu9t5v0__aoi22_1
X$7969 \$17717 \$17716 \$17818 \$17703 \$17842 gf180mcu_fd_sc_mcu9t5v0__xnor2_1
X$7970 \$17715 \$17973 \$17818 \$17703 \$17840 gf180mcu_fd_sc_mcu9t5v0__nor2_1
X$7971 \$17821 \$17818 \$17703 \$17822 gf180mcu_fd_sc_mcu9t5v0__buf_8
X$7972 \$17703 \$17818 gf180mcu_fd_sc_mcu9t5v0__filltie
X$7973 \$17703 \$17818 gf180mcu_fd_sc_mcu9t5v0__filltie
X$7974 \$17703 \$17818 gf180mcu_fd_sc_mcu9t5v0__filltie
X$7975 \$17703 \$17818 gf180mcu_fd_sc_mcu9t5v0__filltie
X$7976 \$17703 \$17818 gf180mcu_fd_sc_mcu9t5v0__filltie
X$7977 \$17703 \$17818 gf180mcu_fd_sc_mcu9t5v0__filltie
X$7978 \$17703 \$17818 gf180mcu_fd_sc_mcu9t5v0__endcap
X$7979 \$17707 \$23927 \$24106 \$23926 \$23807 \$24051
+ gf180mcu_fd_sc_mcu9t5v0__mux2_1
X$7980 \$17708 \$18825 \$18824 \$18701 \$18870 \$18826
+ gf180mcu_fd_sc_mcu9t5v0__aoi21_1
X$7981 \$17962 \$17712 \$17818 \$17952 \$17946 gf180mcu_fd_sc_mcu9t5v0__nand2_1
X$7982 \$17715 \$19044 \$19324 \$19149 \$19345 \$17972
+ gf180mcu_fd_sc_mcu9t5v0__xor3_1
X$7983 \$17715 \$19345 \$19027 \$19149 \$19045 gf180mcu_fd_sc_mcu9t5v0__nor2_1
X$7984 \$17715 \$19345 \$19324 \$19466 \$19295 gf180mcu_fd_sc_mcu9t5v0__nand2_1
X$7985 \$17715 \$17973 \$18137 \$17952 \$17975 gf180mcu_fd_sc_mcu9t5v0__nand2_1
X$7986 \$17723 \$18044 \$17818 \$17952 \$17989 gf180mcu_fd_sc_mcu9t5v0__xnor2_1
X$7987 \$18046 \$18153 \$18137 \$17952 \$17724 gf180mcu_fd_sc_mcu9t5v0__xnor2_1
X$7988 \$17813 \$19605 \$19466 \$19591 gf180mcu_fd_sc_mcu9t5v0__buf_8
X$7989 \$17815 \$18137 \$18293 \$18252 gf180mcu_fd_sc_mcu9t5v0__buf_8
X$7990 \$17831 \$17965 \$17818 \$17952 \$17816 gf180mcu_fd_sc_mcu9t5v0__nand2_1
X$7991 \$18007 \$17817 \$17818 \$17952 \$17947 gf180mcu_fd_sc_mcu9t5v0__nor2_1
X$7992 \$17855 \$17991 \$17818 \$17952 \$17992 gf180mcu_fd_sc_mcu9t5v0__xnor2_1
X$7993 \$18039 \$18147 \$17982 \$18040 \$17818 \$17952 \$17983
+ gf180mcu_fd_sc_mcu9t5v0__aoi211_1
X$7994 \$17992 \$17856 \$17818 \$17952 \$17854 gf180mcu_fd_sc_mcu9t5v0__nor2_1
X$7995 \$17981 \$17818 \$17952 \$17982 gf180mcu_fd_sc_mcu9t5v0__clkinv_1
X$7996 \$17855 \$17818 \$17952 \$17853 gf180mcu_fd_sc_mcu9t5v0__clkinv_1
X$7997 \$17952 \$17818 gf180mcu_fd_sc_mcu9t5v0__filltie
X$7998 \$17952 \$17818 gf180mcu_fd_sc_mcu9t5v0__filltie
X$7999 \$17952 \$17818 gf180mcu_fd_sc_mcu9t5v0__filltie
X$8000 \$17952 \$17818 gf180mcu_fd_sc_mcu9t5v0__filltie
X$8001 \$17952 \$17818 gf180mcu_fd_sc_mcu9t5v0__filltie
X$8002 \$17952 \$17818 gf180mcu_fd_sc_mcu9t5v0__filltie
X$8003 \$17952 \$17818 gf180mcu_fd_sc_mcu9t5v0__endcap
X$8004 \$17819 \$18701 \$18576 \$18704 gf180mcu_fd_sc_mcu9t5v0__buf_8
X$8005 \$18585 \$18587 \$18586 \$17826 \$18701 \$18576 \$18583
+ gf180mcu_fd_sc_mcu9t5v0__oai22_1
X$8006 \$18016 \$17826 \$18137 \$18293 \$18264 gf180mcu_fd_sc_mcu9t5v0__nor2_1
X$8007 \$18535 \$18585 \$18403 \$18576 \$17826 gf180mcu_fd_sc_mcu9t5v0__nand2_1
X$8008 \$18427 \$18272 \$18137 \$18293 \$17844 \$18428
+ gf180mcu_fd_sc_mcu9t5v0__xnor3_1
X$8009 \$19905 \$19349 \$19762 \$19324 \$19466 \$17845
+ gf180mcu_fd_sc_mcu9t5v0__aoi21_1
X$8010 \$17847 \$18274 \$18137 \$17952 \$18036 gf180mcu_fd_sc_mcu9t5v0__xnor2_1
X$8011 \$17847 \$18432 \$18403 \$18293 \$18273 gf180mcu_fd_sc_mcu9t5v0__xnor2_1
X$8012 \$17847 \$18432 \$18308 \$18403 \$18293 \$18147
+ gf180mcu_fd_sc_mcu9t5v0__aoi21_1
X$8013 \$17847 \$18275 \$18137 \$18293 \$18148 gf180mcu_fd_sc_mcu9t5v0__nand2_1
X$8014 \$19363 \$19362 \$19179 \$19324 \$19466 \$17852
+ gf180mcu_fd_sc_mcu9t5v0__aoi21_1
X$8015 \$18434 \$17852 \$19181 \$19180 \$19027 \$19149 \$19052
+ gf180mcu_fd_sc_mcu9t5v0__oai31_1
X$8016 \$17855 \$18137 \$17952 \$17991 \$18045 gf180mcu_fd_sc_mcu9t5v0__xor2_1
X$8017 \$18281 \$18280 \$18282 \$18137 \$18293 \$17856
+ gf180mcu_fd_sc_mcu9t5v0__aoi21_1
X$8018 \$18567 \$19023 \$18701 \$18576 \$17944 gf180mcu_fd_sc_mcu9t5v0__nand2_2
X$8019 \$18137 \$17952 \$18132 gf180mcu_fd_sc_mcu9t5v0__tiel
X$8020 \$17999 \$17997 \$18000 \$18137 \$17952 \$18242
+ gf180mcu_fd_sc_mcu9t5v0__aoi21_1
X$8021 \$18016 \$18017 \$18137 \$17952 \$18140 gf180mcu_fd_sc_mcu9t5v0__nor2_1
X$8022 \$17955 \$18012 \$18011 \$18139 \$18137 \$17952 \$18010
+ gf180mcu_fd_sc_mcu9t5v0__aoi22_1
X$8023 \$18033 \$18137 \$17952 \$17973 gf180mcu_fd_sc_mcu9t5v0__clkinv_1
X$8024 \$18001 \$18137 \$17952 \$17999 gf180mcu_fd_sc_mcu9t5v0__clkinv_1
X$8025 \$18036 \$18137 \$17952 \$18037 gf180mcu_fd_sc_mcu9t5v0__clkinv_1
X$8026 \$18039 \$17981 \$18137 \$17952 \$18038 gf180mcu_fd_sc_mcu9t5v0__nand2_1
X$8027 \$17955 \$18009 \$18137 \$17952 \$18011 gf180mcu_fd_sc_mcu9t5v0__nand2_1
X$8028 \$18135 \$17997 \$18137 \$17952 \$17996 gf180mcu_fd_sc_mcu9t5v0__nand2_1
X$8029 \$17952 \$18137 gf180mcu_fd_sc_mcu9t5v0__filltie
X$8030 \$17952 \$18137 gf180mcu_fd_sc_mcu9t5v0__filltie
X$8031 \$17952 \$18137 gf180mcu_fd_sc_mcu9t5v0__filltie
X$8032 \$17952 \$18137 gf180mcu_fd_sc_mcu9t5v0__filltie
X$8033 \$17952 \$18137 gf180mcu_fd_sc_mcu9t5v0__filltie
X$8034 \$17952 \$18137 gf180mcu_fd_sc_mcu9t5v0__filltie
X$8035 \$17952 \$18137 gf180mcu_fd_sc_mcu9t5v0__endcap
X$8036 \$18295 \$17957 \$18403 \$18293 \$18258 gf180mcu_fd_sc_mcu9t5v0__nor2_1
X$8037 \$19285 \$19156 \$19027 \$19149 \$17960 gf180mcu_fd_sc_mcu9t5v0__nand2_1
X$8038 \$19334 \$17960 \$19927 \$19774 \$19889 gf180mcu_fd_sc_mcu9t5v0__nand2_1
X$8039 \$18535 \$18410 \$18403 \$18576 \$17961 gf180mcu_fd_sc_mcu9t5v0__nand2_1
X$8040 \$18412 \$18537 \$18539 \$18538 \$18403 \$18576 \$17964
+ gf180mcu_fd_sc_mcu9t5v0__nand4_1
X$8041 \$19615 \$21195 \$21030 \$20881 \$21011 \$17974
+ gf180mcu_fd_sc_mcu9t5v0__aoi21_1
X$8042 \$18845 \$17979 \$18434 \$18403 \$18293 \$18425
+ gf180mcu_fd_sc_mcu9t5v0__mux2_1
X$8043 \$18039 \$18147 \$17982 \$18137 \$18293 \$18150
+ gf180mcu_fd_sc_mcu9t5v0__aoi21_1
X$8044 \$29247 \$29123 \$29270 \$17987 gf180mcu_fd_sc_mcu9t5v0__buf_8
X$8045 \$22286 \$17987 \$21197 \$22387 \$22272 \$22407
+ gf180mcu_fd_sc_mcu9t5v0__mux2_1
X$8046 \$17987 \$26119 \$22928 \$26088 \$26220 \$26249
+ gf180mcu_fd_sc_mcu9t5v0__mux2_1
X$8047 \$17987 \$20614 \$19014 \$20515 \$20718 \$20736
+ gf180mcu_fd_sc_mcu9t5v0__mux2_1
X$8048 \$17987 \$27941 \$23479 \$27637 \$27776 \$27814
+ gf180mcu_fd_sc_mcu9t5v0__mux2_1
X$8049 \$17987 \$25789 \$22930 \$25797 \$25632 \$25819
+ gf180mcu_fd_sc_mcu9t5v0__mux2_1
X$8050 \$17987 \$28581 \$23348 \$28534 \$28381 \$28363
+ gf180mcu_fd_sc_mcu9t5v0__mux2_1
X$8051 \$18001 \$18135 \$18137 \$18293 \$18810 gf180mcu_fd_sc_mcu9t5v0__nor2_1
X$8052 \$19320 \$18002 \$18244 \$19324 \$19466 \$19461
+ gf180mcu_fd_sc_mcu9t5v0__aoi21_1
X$8053 \$18525 \$18244 \$18002 \$18403 \$18576 \$18565
+ gf180mcu_fd_sc_mcu9t5v0__oai21_1
X$8054 \$19270 \$19022 \$19324 \$19149 \$18002 gf180mcu_fd_sc_mcu9t5v0__nand2_1
X$8055 \$18003 \$18244 \$19027 \$19149 \$19142 gf180mcu_fd_sc_mcu9t5v0__nand2_1
X$8056 \$18003 \$18701 \$18870 \$18525 gf180mcu_fd_sc_mcu9t5v0__clkinv_1
X$8057 \$18531 \$18405 \$18009 \$18404 \$18403 \$18576 \$18575
+ gf180mcu_fd_sc_mcu9t5v0__oai211_1
X$8058 \$18406 \$18009 \$18139 \$18403 \$18576 \$18534
+ gf180mcu_fd_sc_mcu9t5v0__nand3_1
X$8059 \$19593 \$19875 \$19324 \$19149 \$18009 gf180mcu_fd_sc_mcu9t5v0__nand2_1
X$8060 \$18259 \$18009 \$18137 \$18293 \$18261 gf180mcu_fd_sc_mcu9t5v0__nand2_1
X$8061 \$19608 \$18009 \$19605 \$19466 \$19331 gf180mcu_fd_sc_mcu9t5v0__nand2_1
X$8062 \$18139 \$18258 \$18137 \$18293 \$18012 gf180mcu_fd_sc_mcu9t5v0__nor2_1
X$8063 \$18139 \$18261 \$18260 \$18012 \$18403 \$18293 \$18409
+ gf180mcu_fd_sc_mcu9t5v0__aoi22_1
X$8064 \$26980 \$18013 \$26806 \$26675 \$26856 \$26406
+ gf180mcu_fd_sc_mcu9t5v0__oai21_1
X$8065 \$20885 \$18015 \$24106 \$23926 \$24109 \$24055
+ gf180mcu_fd_sc_mcu9t5v0__mux2_1
X$8066 \$18875 \$18016 \$18137 \$18293 \$18141 gf180mcu_fd_sc_mcu9t5v0__nor2_1
X$8067 \$19285 \$19284 \$19324 \$19466 \$18016 gf180mcu_fd_sc_mcu9t5v0__nand2_1
X$8068 \$19334 \$18017 \$18701 \$18576 \$18536 gf180mcu_fd_sc_mcu9t5v0__nor2_1
X$8069 \$18017 \$18018 \$18137 \$18293 \$18019 gf180mcu_fd_sc_mcu9t5v0__nor2_1
X$8070 \$18706 \$18585 \$18701 \$18576 \$18017 gf180mcu_fd_sc_mcu9t5v0__nand2_1
X$8071 \$19157 \$19156 \$19027 \$19149 \$18018 gf180mcu_fd_sc_mcu9t5v0__nand2_1
X$8072 \$19001 \$19027 \$19149 \$18031 gf180mcu_fd_sc_mcu9t5v0__buf_8
X$8073 \$20611 \$20547 \$20515 \$20718 \$18041 gf180mcu_fd_sc_mcu9t5v0__xnor2_1
X$8074 \$19502 \$19635 \$19605 \$19466 \$18047 gf180mcu_fd_sc_mcu9t5v0__xnor2_1
X$8075 \$19767 pad_din[7] \$I20747 \$I20765 \$I20756 \$I20774 \$I20783 \$I20801
+ \$I20792 \$I20810 \$I20819 \$I20837 \$I20828 \$I20846 \$I20855 \$I20864
+ \$I20873 \$I20882 \$I20891 \$I20900 \$I20909 \$I20918 \$I20927 \$I20936
+ \$I20945 \$I20954 \$I20963 \$I20981 \$I20972 \$I20990 \$I20999 \$I21017
+ \$I21008 \$I21026 \$I21044 \$I21035 \$I21053 \$I21062 \$I21071 \$I21089
+ \$I21080 \$I21098 \$I21107 \$I21116 \$I21125 \$I21134 \$I21143 \$I21161
+ \$I21152 \$I21170 \$I21179 \$I21197 \$I21188 \$I21206 \$I21215 \$I21233
+ \$I21224 \$I21242 \$I21251 \$I21269 \$I21260 \$I21278 \$I21287 \$I21296
+ \$I21305 \$I21314 \$I21323 \$I21332 \$I21341 \$I21350 \$I21368 \$I21377
+ \$I21404 \$I21413 \$I21359 \$I21395 \$I21386 \$I21431 \$I21422 \$I21458
+ \$I21449 \$I21467 \$I21440 \$I21485 \$I21476 \$I21494 \$I21512 \$I21539
+ \$I21548 \$I21557 \$I21503 \$I21530 \$I21521 \$I21575 \$I21566 \$I21584
+ \$I21593 \$I21602 \$I21611 \$I21620 \$I21629 \$I21638 \$18132 \$I21647
+ \$I21665 \$I21656 \$I21674 \$18132 \$19304 gf180mcu_fd_io__in_c
X$8076 \$18240 \$18293 \$18137 \$18133 gf180mcu_fd_sc_mcu9t5v0__buf_8
X$8077 \$18796 \$18293 \$18137 \$18240 gf180mcu_fd_sc_mcu9t5v0__buf_1
X$8078 \$18259 \$18408 \$18296 \$18137 \$18293 \$18260
+ gf180mcu_fd_sc_mcu9t5v0__oai21_1
X$8079 \$18274 \$18137 \$18293 \$18275 gf180mcu_fd_sc_mcu9t5v0__clkinv_1
X$8080 \$18262 \$18137 \$18293 \$18142 gf180mcu_fd_sc_mcu9t5v0__clkinv_1
X$8081 \$18248 \$18137 \$18293 \$18249 gf180mcu_fd_sc_mcu9t5v0__clkinv_1
X$8082 \$18276 \$18278 \$18434 \$18137 \$18293 \$18277
+ gf180mcu_fd_sc_mcu9t5v0__mux2_1
X$8083 \$18293 \$18137 gf180mcu_fd_sc_mcu9t5v0__filltie
X$8084 \$18293 \$18137 gf180mcu_fd_sc_mcu9t5v0__filltie
X$8085 \$18293 \$18137 gf180mcu_fd_sc_mcu9t5v0__filltie
X$8086 \$18293 \$18137 gf180mcu_fd_sc_mcu9t5v0__filltie
X$8087 \$18293 \$18137 gf180mcu_fd_sc_mcu9t5v0__filltie
X$8088 \$18293 \$18137 gf180mcu_fd_sc_mcu9t5v0__filltie
X$8089 \$18293 \$18137 gf180mcu_fd_sc_mcu9t5v0__endcap
X$8090 \$18139 \$18295 \$18701 \$18576 \$18705 gf180mcu_fd_sc_mcu9t5v0__or2_1
X$8091 \$18294 \$18405 \$18403 \$18576 \$18139 gf180mcu_fd_sc_mcu9t5v0__nand2_1
X$8092 \$18309 \$18547 \$18431 \$18403 \$18293 \$18146
+ gf180mcu_fd_sc_mcu9t5v0__oai21_1
X$8093 \$24988 \$25625 \$18247 \$25741 \$25045 \$25191 \$24997 \$25044
+ gf180mcu_fd_sc_mcu9t5v0__aoi221_2
X$8094 \$18302 \$18421 \$18403 \$18293 \$18270 gf180mcu_fd_sc_mcu9t5v0__nor2_1
X$8095 \$20231 \$20417 \$20209 \$20383 \$18272 gf180mcu_fd_sc_mcu9t5v0__and2_1
X$8096 \$18307 \$18272 \$18429 \$18403 \$18293 \$18306
+ gf180mcu_fd_sc_mcu9t5v0__aoi21_1
X$8097 \$18307 \$18272 \$18429 \$18273 \$18403 \$18293 \$18308
+ gf180mcu_fd_sc_mcu9t5v0__aoi211_1
X$8098 \$18276 \$18603 \$18842 \$18701 \$18576 \$18549
+ gf180mcu_fd_sc_mcu9t5v0__mux2_1
X$8099 \$19013 \$19049 \$18892 \$19027 \$18870 \$18279
+ gf180mcu_fd_sc_mcu9t5v0__and3_1
X$8100 \$19496 \$19631 \$19497 \$19605 \$19466 \$18280
+ gf180mcu_fd_sc_mcu9t5v0__aoi21_1
X$8101 \$18557 \$18558 \$18403 \$18576 \$18281 gf180mcu_fd_sc_mcu9t5v0__or2_1
X$8102 \$18556 \$18403 \$18576 \$18282 gf180mcu_fd_sc_mcu9t5v0__clkinv_1
X$8103 \$18854 \$18853 \$18855 \$18701 \$18870 \$18283
+ gf180mcu_fd_sc_mcu9t5v0__aoi21_1
X$8104 \$18434 \$18283 \$18856 \$18613 \$18701 \$18576 \$18614
+ gf180mcu_fd_sc_mcu9t5v0__oai31_1
X$8105 \$18288 \$18403 \$18293 \$18400 gf180mcu_fd_sc_mcu9t5v0__clkinv_1
X$8106 \$18291 \$23585 \$22270 \$23183 \$23454 \$23449
+ gf180mcu_fd_sc_mcu9t5v0__mux2_1
X$8107 \$18291 \$21012 \$19776 \$21184 \$21308 \$21307
+ gf180mcu_fd_sc_mcu9t5v0__mux2_1
X$8108 \$18291 \$20341 \$19278 \$20209 \$20383 \$20389
+ gf180mcu_fd_sc_mcu9t5v0__mux2_1
X$8109 \$18291 \$23452 \$21496 \$23183 \$23139 \$23182
+ gf180mcu_fd_sc_mcu9t5v0__mux2_1
X$8110 \$18291 \$22841 \$20716 \$23027 \$22837 \$22840
+ gf180mcu_fd_sc_mcu9t5v0__mux2_1
X$8111 \$18406 \$18296 \$18403 \$18293 \$18295 gf180mcu_fd_sc_mcu9t5v0__or2_1
X$8112 \$18874 \$18403 \$18293 \$18410 gf180mcu_fd_sc_mcu9t5v0__buf_8
X$8113 \$18427 \$18403 \$18293 \$18430 gf180mcu_fd_sc_mcu9t5v0__clkinv_1
X$8114 \$18427 \$18428 \$18403 \$18293 \$18307 gf180mcu_fd_sc_mcu9t5v0__nand2_1
X$8115 \$18293 \$18403 gf180mcu_fd_sc_mcu9t5v0__filltie
X$8116 \$18293 \$18403 gf180mcu_fd_sc_mcu9t5v0__filltie
X$8117 \$18293 \$18403 gf180mcu_fd_sc_mcu9t5v0__filltie
X$8118 \$18293 \$18403 gf180mcu_fd_sc_mcu9t5v0__filltie
X$8119 \$18293 \$18403 gf180mcu_fd_sc_mcu9t5v0__filltie
X$8120 \$18293 \$18403 gf180mcu_fd_sc_mcu9t5v0__filltie
X$8121 \$18293 \$18403 gf180mcu_fd_sc_mcu9t5v0__endcap
X$8122 \$18294 \$18866 \$20210 \$19879 \$19927 \$19774 \$19878
+ gf180mcu_fd_sc_mcu9t5v0__nor4_1
X$8123 \$18294 \$18405 \$18295 \$18403 \$18576 \$18404
+ gf180mcu_fd_sc_mcu9t5v0__nand3_1
X$8124 \$19615 \$19752 \$19605 \$19774 \$18302 gf180mcu_fd_sc_mcu9t5v0__nor2_1
X$8125 \$19170 \$18305 \$18434 \$18701 \$18870 \$18843
+ gf180mcu_fd_sc_mcu9t5v0__mux2_1
X$8126 \$18430 \$18548 \$18701 \$18576 \$18309 gf180mcu_fd_sc_mcu9t5v0__nor2_1
X$8127 \$19768 pad_dout_valid_o \$I20746 \$I20755 \$I20764 \$I20773 \$I20782
+ \$I20791 \$I20800 \$I20809 \$I20818 \$I20827 \$I20836 \$I20845 \$I20854
+ \$I20863 \$I20872 \$I20881 \$I20890 \$I20899 \$I20908 \$I20917 \$I20926
+ \$I20935 \$I20944 \$I20953 \$I20962 \$I20971 \$I20980 \$I20989 \$I20998
+ \$I21007 \$I21016 \$I21025 \$I21034 \$I21043 \$I21052 \$I21061 \$I21070
+ \$I21079 \$I21088 \$I21097 \$I21106 \$I21115 \$I21124 \$I21133 \$I21142
+ \$I21151 \$I21160 \$I21169 \$I21178 \$I21187 \$I21196 \$I21205 \$I21214
+ \$I21223 \$I21232 \$I21241 \$I21250 \$I21259 \$I21268 \$I21277 \$I21286
+ \$I21295 \$I21304 \$I21313 \$18436 \$I21322 \$I21331 \$I21340 \$I21349
+ \$I21358 \$I21367 \$I21376 \$I21385 \$I21394 \$I21403 \$I21412 \$I21421
+ \$I21430 \$I21439 \$I21448 \$I21457 \$I21466 \$I21475 \$I21484 \$I21493
+ \$I21502 \$I21511 \$I21520 \$I21529 \$I21538 \$I21547 \$I21556 \$I21565
+ \$I21574 \$I21583 \$I21592 \$I21601 \$18310 \$I21610 \$I21619 \$I21628
+ \$I21637 \$I21646 \$I21655 \$I21664 \$I21673 \$18310 \$18310 \$18436 \$18310
+ \$18310 \$20206 \$18436 gf180mcu_fd_io__bi_t
X$8128 \$20209 \$20383 \$18310 gf180mcu_fd_sc_mcu9t5v0__tiel
X$8129 \$18399 \$25741 \$25625 \$25624 \$25626 \$25797 \$25632 \$25627
+ gf180mcu_fd_sc_mcu9t5v0__aoi221_1
X$8130 \$22268 \$22709 \$22387 \$22440 \$18402 gf180mcu_fd_sc_mcu9t5v0__and2_1
X$8131 \$33774 \$18576 \$18403 \$18416 gf180mcu_fd_sc_mcu9t5v0__clkbuf_16
X$8132 \$18404 \$18408 \$18407 \$18534 \$18403 \$18576 \$18579
+ gf180mcu_fd_sc_mcu9t5v0__oai31_1
X$8133 \$18427 \$18428 \$18403 \$18576 \$18429 gf180mcu_fd_sc_mcu9t5v0__nor2_1
X$8134 \$18558 \$18434 \$18403 \$18576 \$18613 gf180mcu_fd_sc_mcu9t5v0__nand2_1
X$8135 \$18557 \$18558 \$18403 \$18576 \$18556 gf180mcu_fd_sc_mcu9t5v0__nand2_1
X$8136 \$18430 \$18548 \$18403 \$18576 \$18431 gf180mcu_fd_sc_mcu9t5v0__nand2_1
X$8137 \$18541 \$18540 \$18403 \$18576 \$18532 gf180mcu_fd_sc_mcu9t5v0__nand2_1
X$8138 \$18550 \$18435 \$18434 \$18403 \$18576 \$18551
+ gf180mcu_fd_sc_mcu9t5v0__mux2_1
X$8139 \$18550 \$18849 \$18842 \$18403 \$18576 \$18604
+ gf180mcu_fd_sc_mcu9t5v0__mux2_1
X$8140 \$18841 \$18423 \$18434 \$18403 \$18576 \$18422
+ gf180mcu_fd_sc_mcu9t5v0__mux2_1
X$8141 \$18891 \$18552 \$18434 \$18403 \$18576 \$18605
+ gf180mcu_fd_sc_mcu9t5v0__mux2_1
X$8142 \$18576 \$18403 gf180mcu_fd_sc_mcu9t5v0__filltie
X$8143 \$18576 \$18403 gf180mcu_fd_sc_mcu9t5v0__filltie
X$8144 \$18576 \$18403 gf180mcu_fd_sc_mcu9t5v0__filltie
X$8145 \$18576 \$18403 gf180mcu_fd_sc_mcu9t5v0__filltie
X$8146 \$18576 \$18403 gf180mcu_fd_sc_mcu9t5v0__filltie
X$8147 \$18576 \$18403 gf180mcu_fd_sc_mcu9t5v0__filltie
X$8148 \$18576 \$18403 gf180mcu_fd_sc_mcu9t5v0__endcap
X$8149 \$19277 \$18405 \$19278 \$19324 \$19149 \$19276
+ gf180mcu_fd_sc_mcu9t5v0__oai21_1
X$8150 \$19602 \$18405 \$19605 \$19466 \$19278 gf180mcu_fd_sc_mcu9t5v0__nand2_1
X$8151 \$19465 \$18405 \$19605 \$19466 \$19776 gf180mcu_fd_sc_mcu9t5v0__nand2_1
X$8152 \$19730 \$19605 \$19774 \$18405 gf180mcu_fd_sc_mcu9t5v0__buf_8
X$8153 \$18410 \$18827 \$18701 \$18870 \$18828 gf180mcu_fd_sc_mcu9t5v0__nor2_1
X$8154 \$18410 \$19335 \$19027 \$19149 \$19033 gf180mcu_fd_sc_mcu9t5v0__nor2_1
X$8155 \$18410 \$19333 \$19324 \$19149 \$19286 gf180mcu_fd_sc_mcu9t5v0__nor2_1
X$8156 \$18706 \$18410 \$18701 \$18870 \$18875 gf180mcu_fd_sc_mcu9t5v0__nand2_1
X$8157 \$18411 \$18876 \$19027 \$18870 \$18867 gf180mcu_fd_sc_mcu9t5v0__nand2_1
X$8158 \$19902 \$19900 \$19927 \$19774 \$18421 gf180mcu_fd_sc_mcu9t5v0__and2_1
X$8159 \$18434 \$24866 \$25207 \$25334 \$25191 \$25347 \$25332
+ gf180mcu_fd_sc_mcu9t5v0__oai31_1
X$8160 \$18434 \$23826 \$23827 \$23825 \$23926 \$23807 \$23954
+ gf180mcu_fd_sc_mcu9t5v0__oai31_1
X$8161 \$18434 \$22420 \$21977 \$21976 \$22074 \$21946 \$22176
+ gf180mcu_fd_sc_mcu9t5v0__oai31_1
X$8162 \$18434 \$22609 \$22288 \$21973 \$22387 \$22272 \$22174
+ gf180mcu_fd_sc_mcu9t5v0__oai31_1
X$8163 \$25097 \$18434 \$25191 \$25347 \$25334 gf180mcu_fd_sc_mcu9t5v0__nand2_1
X$8164 \$22926 \$18434 \$23620 \$23807 \$23825 gf180mcu_fd_sc_mcu9t5v0__nand2_1
X$8165 \$22104 \$18434 \$22387 \$22272 \$21976 gf180mcu_fd_sc_mcu9t5v0__nand2_1
X$8166 \$21041 \$18434 \$21498 \$21308 \$21517 gf180mcu_fd_sc_mcu9t5v0__nand2_1
X$8167 \$22103 \$18434 \$22074 \$21946 \$21973 gf180mcu_fd_sc_mcu9t5v0__nand2_1
X$8168 \$19016 \$18434 \$19027 \$18870 \$19180 gf180mcu_fd_sc_mcu9t5v0__nand2_1
X$8169 \$28821 \$28810 \$28689 \$18434 gf180mcu_fd_sc_mcu9t5v0__buf_8
X$8170 \$23931 \$24117 \$18434 \$23926 \$24109 \$24116
+ gf180mcu_fd_sc_mcu9t5v0__mux2_1
X$8171 \$19893 \$19755 \$18434 \$19605 \$19774 \$19754
+ gf180mcu_fd_sc_mcu9t5v0__mux2_1
X$8172 \$26990 \$25604 \$18434 \$26675 \$26856 \$26656
+ gf180mcu_fd_sc_mcu9t5v0__mux2_1
X$8173 \$26986 \$26227 \$18434 \$26088 \$26220 \$26226
+ gf180mcu_fd_sc_mcu9t5v0__mux2_1
X$8174 \$18835 \$18836 \$18434 \$18701 \$18870 \$18599
+ gf180mcu_fd_sc_mcu9t5v0__mux2_1
X$8175 \$25975 \$25602 \$18434 \$25797 \$25918 \$25807
+ gf180mcu_fd_sc_mcu9t5v0__mux2_1
X$8176 \$25601 \$25600 \$18434 \$25462 \$25632 \$25764
+ gf180mcu_fd_sc_mcu9t5v0__mux2_1
X$8177 \$24738 \$24601 \$18434 \$24593 \$24721 \$24540
+ gf180mcu_fd_sc_mcu9t5v0__mux2_1
X$8178 \$21824 \$21963 \$18434 \$21661 \$21946 \$21962
+ gf180mcu_fd_sc_mcu9t5v0__mux2_1
X$8179 \$25643 \$25615 \$18434 \$25462 \$25632 \$25773
+ gf180mcu_fd_sc_mcu9t5v0__mux2_1
X$8180 \$25939 \$25943 \$18434 \$25797 \$25918 \$25942
+ gf180mcu_fd_sc_mcu9t5v0__mux2_1
X$8181 \$26817 \$22860 \$18434 \$22713 \$22837 \$22859
+ gf180mcu_fd_sc_mcu9t5v0__mux2_1
X$8182 \$24856 \$23467 \$18434 \$23183 \$23454 \$23466
+ gf180mcu_fd_sc_mcu9t5v0__mux2_1
X$8183 \$28578 \$28513 \$18434 \$28534 \$28689 \$28512
+ gf180mcu_fd_sc_mcu9t5v0__mux2_1
X$8184 \$24329 \$24330 \$18434 \$24231 \$24428 \$24328
+ gf180mcu_fd_sc_mcu9t5v0__mux2_1
X$8185 \$28712 \$28387 \$18434 \$28534 \$28689 \$28361
+ gf180mcu_fd_sc_mcu9t5v0__mux2_1
X$8186 \$19473 \$19158 \$18434 \$19324 \$19466 \$19338
+ gf180mcu_fd_sc_mcu9t5v0__mux2_1
X$8187 \$24434 \$21640 \$18434 \$23027 \$23139 \$22914
+ gf180mcu_fd_sc_mcu9t5v0__mux2_1
X$8188 \$30859 \$26114 \$18434 \$26088 \$26220 \$26243
+ gf180mcu_fd_sc_mcu9t5v0__mux2_1
X$8189 \$21151 \$21325 \$18434 \$21184 \$21308 \$21324
+ gf180mcu_fd_sc_mcu9t5v0__mux2_1
X$8190 \$27173 \$27176 \$18434 \$27015 \$27153 \$27175
+ gf180mcu_fd_sc_mcu9t5v0__mux2_1
X$8191 \$24125 \$23948 \$18434 \$23926 \$24109 \$23947
+ gf180mcu_fd_sc_mcu9t5v0__mux2_1
X$8192 \$26833 \$25774 \$18434 \$25797 \$25918 \$25945
+ gf180mcu_fd_sc_mcu9t5v0__mux2_1
X$8193 \$26244 \$25361 \$18434 \$25797 \$25918 \$25944
+ gf180mcu_fd_sc_mcu9t5v0__mux2_1
X$8194 \$25770 \$25479 \$18434 \$25462 \$25632 \$25478
+ gf180mcu_fd_sc_mcu9t5v0__mux2_1
X$8195 \$21023 \$21370 \$18434 \$21184 \$21308 \$21311
+ gf180mcu_fd_sc_mcu9t5v0__mux2_1
X$8196 \$30712 \$28063 \$18434 \$27913 \$28089 \$28114
+ gf180mcu_fd_sc_mcu9t5v0__mux2_1
X$8197 \$19485 \$19011 \$18434 \$19027 \$19149 \$19010
+ gf180mcu_fd_sc_mcu9t5v0__mux2_1
X$8198 \$29867 \$29104 \$18434 \$29123 \$28971 \$28949
+ gf180mcu_fd_sc_mcu9t5v0__mux2_1
X$8199 \$29278 \$27345 \$18434 \$28534 \$28381 \$28362
+ gf180mcu_fd_sc_mcu9t5v0__mux2_1
X$8200 \$28115 \$27666 \$18434 \$27913 \$27776 \$27665
+ gf180mcu_fd_sc_mcu9t5v0__mux2_1
X$8201 \$26531 \$26366 \$18434 \$26401 \$26220 \$26365
+ gf180mcu_fd_sc_mcu9t5v0__mux2_1
X$8202 \$20414 \$19481 \$18434 \$19605 \$19466 \$19616
+ gf180mcu_fd_sc_mcu9t5v0__mux2_1
X$8203 \$19297 \$18886 \$18434 \$19027 \$18870 \$19006
+ gf180mcu_fd_sc_mcu9t5v0__mux2_1
X$8204 \$24548 \$22862 \$18434 \$23027 \$22837 \$22861
+ gf180mcu_fd_sc_mcu9t5v0__mux2_1
X$8205 \$25326 \$22460 \$18434 \$23926 \$23807 \$23942
+ gf180mcu_fd_sc_mcu9t5v0__mux2_1
X$8206 \$23205 \$23203 \$18434 \$23183 \$23139 \$23342
+ gf180mcu_fd_sc_mcu9t5v0__mux2_1
X$8207 \$27610 \$26996 \$18434 \$27015 \$26856 \$27046
+ gf180mcu_fd_sc_mcu9t5v0__mux2_1
X$8208 \$21814 \$22093 \$18434 \$22074 \$21946 \$22092
+ gf180mcu_fd_sc_mcu9t5v0__mux2_1
X$8209 \$19895 \$20346 \$18434 \$20209 \$20087 \$20219
+ gf180mcu_fd_sc_mcu9t5v0__mux2_1
X$8210 \$25088 \$25025 \$18434 \$25191 \$24997 \$25024
+ gf180mcu_fd_sc_mcu9t5v0__mux2_1
X$8211 \$22285 \$21838 \$18434 \$22387 \$22272 \$22162
+ gf180mcu_fd_sc_mcu9t5v0__mux2_1
X$8212 \$22283 \$22402 \$18434 \$22387 \$22272 \$22401
+ gf180mcu_fd_sc_mcu9t5v0__mux2_1
X$8213 \$20419 \$20103 \$18434 \$20209 \$20087 \$20232
+ gf180mcu_fd_sc_mcu9t5v0__mux2_1
X$8214 \$19910 \$19911 \$18434 \$19927 \$19774 \$19941
+ gf180mcu_fd_sc_mcu9t5v0__mux2_1
X$8215 \$19486 \$19356 \$18434 \$19324 \$19149 \$19355
+ gf180mcu_fd_sc_mcu9t5v0__mux2_1
X$8216 \$27609 \$27608 \$18434 \$27637 \$27449 \$27607
+ gf180mcu_fd_sc_mcu9t5v0__mux2_1
X$8217 \$23594 \$23462 \$18434 \$23620 \$23454 \$23331
+ gf180mcu_fd_sc_mcu9t5v0__mux2_1
X$8218 \$22394 \$22585 \$18434 \$22713 \$22440 \$22452
+ gf180mcu_fd_sc_mcu9t5v0__mux2_1
X$8219 \$28838 \$28718 \$18434 \$28810 \$28689 \$28579
+ gf180mcu_fd_sc_mcu9t5v0__mux2_1
X$8220 \$25926 \$25806 \$18434 \$26088 \$25918 \$25927
+ gf180mcu_fd_sc_mcu9t5v0__mux2_1
X$8221 \$21674 \$21957 \$18434 \$22074 \$21946 \$22080
+ gf180mcu_fd_sc_mcu9t5v0__mux2_1
X$8222 \$21315 \$21509 \$18434 \$21498 \$21308 \$21508
+ gf180mcu_fd_sc_mcu9t5v0__mux2_1
X$8223 \$20393 \$20844 \$18434 \$20881 \$20718 \$20887
+ gf180mcu_fd_sc_mcu9t5v0__mux2_1
X$8224 \$27037 \$26532 \$18434 \$26675 \$26521 \$26815
+ gf180mcu_fd_sc_mcu9t5v0__mux2_1
X$8225 \$25983 \$25202 \$18434 \$25462 \$25347 \$25327
+ gf180mcu_fd_sc_mcu9t5v0__mux2_1
X$8226 \$23149 \$23648 \$18434 \$23620 \$23454 \$23647
+ gf180mcu_fd_sc_mcu9t5v0__mux2_1
X$8227 \$20209 \$20383 \$18436 gf180mcu_fd_sc_mcu9t5v0__tieh
X$8228 \$18858 \$18860 \$18521 \$18859 \$19027 \$18870 \$18982
+ gf180mcu_fd_sc_mcu9t5v0__oai31_1
X$8229 \$19769 \$19922 \$19927 \$19774 \$18521 gf180mcu_fd_sc_mcu9t5v0__nor2_1
X$8230 \$18806 \$18804 \$18564 \$18701 \$18576 \$18522
+ gf180mcu_fd_sc_mcu9t5v0__nor3_1
X$8231 \$22065 \$22433 \$22268 \$22566 \$22387 \$22440 \$18523
+ gf180mcu_fd_sc_mcu9t5v0__aoi211_1
X$8232 \$18820 \$18701 \$18870 \$18531 gf180mcu_fd_sc_mcu9t5v0__clkinv_1
X$8233 \$18535 \$19157 \$19156 \$19324 \$19149 \$19333
+ gf180mcu_fd_sc_mcu9t5v0__nand3_1
X$8234 \$18535 \$19157 \$19284 \$19324 \$19149 \$18827
+ gf180mcu_fd_sc_mcu9t5v0__nand3_1
X$8235 \$18535 \$19027 \$18870 \$18706 gf180mcu_fd_sc_mcu9t5v0__clkinv_1
X$8236 \$23344 \$20515 \$20383 \$18545 gf180mcu_fd_sc_mcu9t5v0__clkbuf_8
X$8237 \$18888 \$19009 \$19298 \$19027 \$18870 \$18547
+ gf180mcu_fd_sc_mcu9t5v0__oai21_1
X$8238 \$31819 \$31820 \$31810 \$31733 \$18554 gf180mcu_fd_sc_mcu9t5v0__xnor2_1
X$8239 \$22603 \$18554 \$21197 \$22713 \$22440 \$22726
+ gf180mcu_fd_sc_mcu9t5v0__mux2_1
X$8240 \$18554 \$25645 \$22928 \$25462 \$25632 \$25785
+ gf180mcu_fd_sc_mcu9t5v0__mux2_1
X$8241 \$18554 \$28065 \$23348 \$27913 \$28089 \$27938
+ gf180mcu_fd_sc_mcu9t5v0__mux2_1
X$8242 \$18554 \$28955 \$23479 \$28810 \$28971 \$28984
+ gf180mcu_fd_sc_mcu9t5v0__mux2_1
X$8243 \$18554 \$24751 \$22930 \$24877 \$24721 \$25031
+ gf180mcu_fd_sc_mcu9t5v0__mux2_1
X$8244 \$18554 \$21046 \$19014 \$21184 \$21011 \$21177
+ gf180mcu_fd_sc_mcu9t5v0__mux2_1
X$8245 \$19016 \$19027 \$18870 \$18557 gf180mcu_fd_sc_mcu9t5v0__clkinv_1
X$8246 \$18798 \$19267 \$18699 \$18800 \$18701 \$18870 \$18561
+ gf180mcu_fd_sc_mcu9t5v0__oai31_1
X$8247 \$18562 \$19019 \$18979 \$19307 \$19027 \$19149
+ gf180mcu_fd_sc_mcu9t5v0__dffrnq_2
X$8248 \$18562 \$19305 \$19451 \$19307 \$19605 \$19466
+ gf180mcu_fd_sc_mcu9t5v0__dffrnq_2
X$8249 \$18562 \$20194 \$20032 \$19307 \$20209 \$20087
+ gf180mcu_fd_sc_mcu9t5v0__dffrnq_2
X$8250 \$18562 \$19324 \$19149 gf180mcu_fd_sc_mcu9t5v0__inv_4
X$8251 \$20044 \$19324 \$19466 \$18562 gf180mcu_fd_sc_mcu9t5v0__clkbuf_8
X$8252 \$18563 \$18984 \$18806 \$19027 \$18870 \$18805
+ gf180mcu_fd_sc_mcu9t5v0__and3_1
X$8253 \$18563 \$18806 \$18984 \$18701 \$18870 \$18803
+ gf180mcu_fd_sc_mcu9t5v0__aoi21_1
X$8254 \$18563 \$18806 \$18808 \$18701 \$18870 \$18807
+ gf180mcu_fd_sc_mcu9t5v0__aoi21_1
X$8255 \$18563 \$18806 \$19312 \$19457 \$19027 \$18870 \$18808
+ gf180mcu_fd_sc_mcu9t5v0__oai22_1
X$8256 \$19024 \$19023 \$19022 \$18810 \$19027 \$19149 \$18566
+ gf180mcu_fd_sc_mcu9t5v0__nand4_1
X$8257 \$18567 \$19027 \$18870 \$18864 gf180mcu_fd_sc_mcu9t5v0__clkinv_1
X$8258 \$18568 \$19927 \$20087 gf180mcu_fd_sc_mcu9t5v0__inv_3
X$8259 \$20044 \$19927 \$20087 \$18568 gf180mcu_fd_sc_mcu9t5v0__clkbuf_8
X$8260 \$18570 \$18701 \$18576 \$18816 gf180mcu_fd_sc_mcu9t5v0__clkinv_1
X$8261 \$18819 \$18571 \$18701 \$18870 \$18869 gf180mcu_fd_sc_mcu9t5v0__nand2_1
X$8262 \$18993 \$18701 \$18870 \$18574 gf180mcu_fd_sc_mcu9t5v0__clkinv_1
X$8263 \$18608 \$18710 \$18701 \$18576 \$18607 gf180mcu_fd_sc_mcu9t5v0__xnor2_1
X$8264 \$18706 \$18586 \$18587 \$18701 \$18576 \$18584
+ gf180mcu_fd_sc_mcu9t5v0__aoi21_1
X$8265 \$18576 \$18701 gf180mcu_fd_sc_mcu9t5v0__filltie
X$8266 \$18576 \$18701 gf180mcu_fd_sc_mcu9t5v0__filltie
X$8267 \$18576 \$18701 gf180mcu_fd_sc_mcu9t5v0__filltie
X$8268 \$18576 \$18701 gf180mcu_fd_sc_mcu9t5v0__filltie
X$8269 \$18576 \$18701 gf180mcu_fd_sc_mcu9t5v0__filltie
X$8270 \$18576 \$18701 gf180mcu_fd_sc_mcu9t5v0__filltie
X$8271 \$18600 \$18603 \$19737 \$18701 \$18576 \$18709
+ gf180mcu_fd_sc_mcu9t5v0__mux2_1
X$8272 \$18576 \$18701 gf180mcu_fd_sc_mcu9t5v0__endcap
X$8273 \$18577 \$19027 \$19149 \$19152 gf180mcu_fd_sc_mcu9t5v0__buf_8
X$8274 \$18585 \$25633 \$25462 \$25632 \$25634 gf180mcu_fd_sc_mcu9t5v0__or2_1
X$8275 \$18585 \$19335 \$19605 \$19466 \$19336 gf180mcu_fd_sc_mcu9t5v0__nor2_1
X$8276 \$19282 \$19324 \$19149 \$18585 gf180mcu_fd_sc_mcu9t5v0__buf_8
X$8277 \$19333 \$19283 \$19887 \$19324 \$19466 \$18587
+ gf180mcu_fd_sc_mcu9t5v0__aoi21_1
X$8278 \$18592 \$19027 \$18870 gf180mcu_fd_sc_mcu9t5v0__inv_3
X$8279 \$18596 \$20881 \$20718 gf180mcu_fd_sc_mcu9t5v0__inv_4
X$8280 \$24740 \$24316 \$24231 \$24428 \$18598 gf180mcu_fd_sc_mcu9t5v0__xnor2_1
X$8281 \$18608 \$19014 \$19027 \$18870 \$19015 gf180mcu_fd_sc_mcu9t5v0__nand2_1
X$8282 \$21200 \$19927 \$20087 \$18609 gf180mcu_fd_sc_mcu9t5v0__clkbuf_8
X$8283 \$18609 \$20209 \$20087 \$I54455 gf180mcu_fd_sc_mcu9t5v0__clkinv_1
X$8284 \$18799 \$19020 \$18801 \$18701 \$18870 \$18699
+ gf180mcu_fd_sc_mcu9t5v0__aoi21_1
X$8285 \$18805 \$18804 \$18803 \$18701 \$18870 \$18861
+ gf180mcu_fd_sc_mcu9t5v0__nor3_1
X$8286 \$18855 \$18854 \$18853 \$18701 \$18870 \$18856
+ gf180mcu_fd_sc_mcu9t5v0__and3_1
X$8287 \$19013 \$19049 \$18892 \$18701 \$18870 \$18850
+ gf180mcu_fd_sc_mcu9t5v0__aoi21_1
X$8288 \$18866 \$18701 \$18870 \$18813 gf180mcu_fd_sc_mcu9t5v0__clkinv_1
X$8289 \$18799 \$18798 \$18701 \$18870 \$18800 gf180mcu_fd_sc_mcu9t5v0__nand2_1
X$8290 \$18847 \$18849 \$19737 \$18701 \$18870 \$18890
+ gf180mcu_fd_sc_mcu9t5v0__mux2_1
X$8291 \$18845 \$18844 \$18842 \$18701 \$18870 \$18884
+ gf180mcu_fd_sc_mcu9t5v0__mux2_1
X$8292 \$18833 \$18832 \$18834 \$18701 \$18870 \$18880
+ gf180mcu_fd_sc_mcu9t5v0__mux2_1
X$8293 \$18841 \$18839 \$18842 \$18701 \$18870 \$18840
+ gf180mcu_fd_sc_mcu9t5v0__mux2_1
X$8294 \$18835 \$18832 \$18842 \$18701 \$18870 \$18881
+ gf180mcu_fd_sc_mcu9t5v0__mux2_1
X$8295 \$18870 \$18701 gf180mcu_fd_sc_mcu9t5v0__filltie
X$8296 \$18870 \$18701 gf180mcu_fd_sc_mcu9t5v0__filltie
X$8297 \$18870 \$18701 gf180mcu_fd_sc_mcu9t5v0__filltie
X$8298 \$18870 \$18701 gf180mcu_fd_sc_mcu9t5v0__filltie
X$8299 \$18870 \$18701 gf180mcu_fd_sc_mcu9t5v0__filltie
X$8300 \$18870 \$18701 gf180mcu_fd_sc_mcu9t5v0__filltie
X$8301 \$18870 \$18701 gf180mcu_fd_sc_mcu9t5v0__endcap
X$8302 \$18705 \$19331 \$18825 \$19324 \$19149 \$19281
+ gf180mcu_fd_sc_mcu9t5v0__aoi21_1
X$8303 \$18705 \$19609 \$19324 \$19466 \$19471 gf180mcu_fd_sc_mcu9t5v0__nand2_1
X$8304 \$18706 \$19285 \$19156 \$19324 \$19149 \$19335
+ gf180mcu_fd_sc_mcu9t5v0__nand3_1
X$8305 \$18883 \$18839 \$18834 \$19027 \$18870 \$18708
+ gf180mcu_fd_sc_mcu9t5v0__mux2_1
X$8306 \$19493 \$19360 \$19324 \$19466 \$18710 gf180mcu_fd_sc_mcu9t5v0__nor2_1
X$8307 \$19304 \$19324 \$19149 \$18796 gf180mcu_fd_sc_mcu9t5v0__dlyc_1
X$8308 \$19589 \$18798 \$19722 \$19605 \$19466 \$19592
+ gf180mcu_fd_sc_mcu9t5v0__aoi21_1
X$8309 \$18798 \$18982 \$18981 \$19027 \$18870 \$18802
+ gf180mcu_fd_sc_mcu9t5v0__oai21_1
X$8310 \$19451 \$18798 \$19605 \$19774 \$19308 gf180mcu_fd_sc_mcu9t5v0__nand2_1
X$8311 \$20197 \$18798 \$20209 \$20383 \$20196 gf180mcu_fd_sc_mcu9t5v0__nand2_1
X$8312 \$20032 \$18798 \$20209 \$20087 \$20323 gf180mcu_fd_sc_mcu9t5v0__nand2_1
X$8313 \$18980 \$18798 \$19027 \$18870 \$18981 gf180mcu_fd_sc_mcu9t5v0__nand2_1
X$8314 \$19453 \$18798 \$19605 \$19466 \$19590 gf180mcu_fd_sc_mcu9t5v0__nand2_1
X$8315 \$20034 \$19927 \$20087 \$18798 gf180mcu_fd_sc_mcu9t5v0__buf_8
X$8316 \$18857 \$18979 \$18798 \$19027 \$18870 \$19019
+ gf180mcu_fd_sc_mcu9t5v0__mux2_1
X$8317 \$18799 \$19020 \$18858 \$19027 \$18870 \$18801
+ gf180mcu_fd_sc_mcu9t5v0__oai21_1
X$8318 \$18979 \$18799 \$19020 \$19451 \$19324 \$19466 \$19587
+ gf180mcu_fd_sc_mcu9t5v0__oai31_1
X$8319 \$18980 \$18799 \$19324 \$19149 \$19310 gf180mcu_fd_sc_mcu9t5v0__nor2_1
X$8320 \$18799 \$19020 \$19027 \$19149 \$19309 gf180mcu_fd_sc_mcu9t5v0__nor2_1
X$8321 \$19457 \$19312 \$19324 \$19466 \$18804 gf180mcu_fd_sc_mcu9t5v0__nor2_1
X$8322 \$18804 \$19726 \$19605 \$19774 \$19456 gf180mcu_fd_sc_mcu9t5v0__nor2_1
X$8323 \$18804 \$19140 \$19324 \$19149 \$19269 gf180mcu_fd_sc_mcu9t5v0__nor2_1
X$8324 \$19139 \$18805 \$19027 \$19149 \$19140 gf180mcu_fd_sc_mcu9t5v0__xnor2_1
X$8325 \$19139 \$18805 \$19324 \$19149 \$19311 gf180mcu_fd_sc_mcu9t5v0__nand2_1
X$8326 \$19457 \$18863 \$19027 \$18870 \$18809 gf180mcu_fd_sc_mcu9t5v0__nand2_1
X$8327 \$26349 \$26088 \$26220 \$18811 gf180mcu_fd_sc_mcu9t5v0__buf_8
X$8328 \$18817 \$18993 \$18865 \$19027 \$18870 \$18818
+ gf180mcu_fd_sc_mcu9t5v0__nor3_1
X$8329 \$18817 \$18993 \$19027 \$18870 \$18994 gf180mcu_fd_sc_mcu9t5v0__nor2_1
X$8330 \$19464 \$18817 \$19324 \$19149 \$19275 gf180mcu_fd_sc_mcu9t5v0__nand2_1
X$8331 \$18820 \$19602 \$19024 \$19465 \$19605 \$19466 \$19604
+ gf180mcu_fd_sc_mcu9t5v0__nor4_1
X$8332 \$18997 \$18991 \$18821 \$19027 \$18870 \$18824
+ gf180mcu_fd_sc_mcu9t5v0__aoi21_1
X$8333 \$19274 \$18821 \$18991 \$19324 \$19149 \$19323
+ gf180mcu_fd_sc_mcu9t5v0__oai21_1
X$8334 \$19464 \$18821 \$19605 \$19466 \$19603 gf180mcu_fd_sc_mcu9t5v0__nand2_1
X$8335 \$18827 \$19335 \$25598 \$25462 \$25632 \$25633
+ gf180mcu_fd_sc_mcu9t5v0__mux2_2
X$8336 \$31103 \$18842 \$18834 \$31100 \$31032 \$31090
+ gf180mcu_fd_sc_mcu9t5v0__oai21_1
X$8337 \$18834 \$20388 \$20211 \$20213 \$20209 \$20383 \$20340
+ gf180mcu_fd_sc_mcu9t5v0__oai31_1
X$8338 \$18834 \$23625 \$21018 \$23592 \$23620 \$23454 \$23764
+ gf180mcu_fd_sc_mcu9t5v0__oai31_1
X$8339 \$18834 \$21504 \$20883 \$21020 \$21184 \$21011 \$21148
+ gf180mcu_fd_sc_mcu9t5v0__oai31_1
X$8340 \$18834 \$20841 \$20719 \$20720 \$20881 \$20718 \$20884
+ gf180mcu_fd_sc_mcu9t5v0__oai31_1
X$8341 \$18834 \$19883 \$19778 \$19779 \$19927 \$19774 \$19780
+ gf180mcu_fd_sc_mcu9t5v0__oai31_1
X$8342 \$18834 \$23622 \$23326 \$23809 \$23926 \$23807 \$23928
+ gf180mcu_fd_sc_mcu9t5v0__oai31_1
X$8343 \$25973 \$18834 \$26088 \$26220 \$26098 gf180mcu_fd_sc_mcu9t5v0__nand2_1
X$8344 \$23626 \$18834 \$23620 \$23454 \$23592 gf180mcu_fd_sc_mcu9t5v0__nand2_1
X$8345 \$19931 \$18834 \$19927 \$19774 \$19779 gf180mcu_fd_sc_mcu9t5v0__nand2_1
X$8346 \$23929 \$18834 \$23926 \$23807 \$23809 gf180mcu_fd_sc_mcu9t5v0__nand2_1
X$8347 \$20842 \$18834 \$20881 \$20718 \$20720 gf180mcu_fd_sc_mcu9t5v0__nand2_1
X$8348 \$21186 \$18834 \$21184 \$21011 \$21020 gf180mcu_fd_sc_mcu9t5v0__nand2_1
X$8349 \$20214 \$18834 \$20209 \$20087 \$20213 gf180mcu_fd_sc_mcu9t5v0__nand2_1
X$8350 \$18834 \$31100 \$31175 \$26094 gf180mcu_fd_sc_mcu9t5v0__clkinv_1
X$8351 \$31235 \$31232 \$31175 \$18834 gf180mcu_fd_sc_mcu9t5v0__buf_8
X$8352 \$20359 \$20413 \$18834 \$20209 \$20383 \$20412
+ gf180mcu_fd_sc_mcu9t5v0__mux2_1
X$8353 \$20050 \$19935 \$18834 \$19927 \$20087 \$19894
+ gf180mcu_fd_sc_mcu9t5v0__mux2_1
X$8354 \$21154 \$21313 \$18834 \$21184 \$21308 \$21371
+ gf180mcu_fd_sc_mcu9t5v0__mux2_1
X$8355 \$19482 \$19756 \$18834 \$19605 \$19466 \$19617
+ gf180mcu_fd_sc_mcu9t5v0__mux2_1
X$8356 \$21031 \$21166 \$18834 \$21184 \$21011 \$21165
+ gf180mcu_fd_sc_mcu9t5v0__mux2_1
X$8357 \$20846 \$22090 \$18834 \$22074 \$21946 \$22089
+ gf180mcu_fd_sc_mcu9t5v0__mux2_1
X$8358 \$19296 \$18844 \$18834 \$19027 \$18870 \$19004
+ gf180mcu_fd_sc_mcu9t5v0__mux2_1
X$8359 \$18838 \$19927 \$20087 \$I54574 gf180mcu_fd_sc_mcu9t5v0__clkinv_1
X$8360 \$18842 \$29447 \$29290 \$29270 \$29325 gf180mcu_fd_sc_mcu9t5v0__and2_1
X$8361 \$31019 \$31100 \$31175 \$18842 gf180mcu_fd_sc_mcu9t5v0__buf_20
X$8362 \$32792 \$18842 \$32639 \$30059 \$31879 \$31391 \$32543 \$32629 \$32640
+ gf180mcu_fd_sc_mcu9t5v0__aoi222_1
X$8363 \$32089 \$18842 \$32026 \$30059 \$31879 \$31935 \$31967 \$32034 \$31880
+ gf180mcu_fd_sc_mcu9t5v0__aoi222_1
X$8364 \$32530 \$18842 \$32858 \$30059 \$31879 \$31956 \$32543 \$32629 \$32534
+ gf180mcu_fd_sc_mcu9t5v0__aoi222_1
X$8365 \$32935 \$18842 \$32531 \$30059 \$31879 \$32163 \$32543 \$32467 \$32470
+ gf180mcu_fd_sc_mcu9t5v0__aoi222_1
X$8366 \$31826 \$18842 \$31688 \$30059 \$31879 \$31816 \$31810 \$31733 \$31748
+ gf180mcu_fd_sc_mcu9t5v0__aoi222_1
X$8367 \$31933 \$18842 \$32036 \$30059 \$31879 \$31954 \$31967 \$31886 \$31934
+ gf180mcu_fd_sc_mcu9t5v0__aoi222_1
X$8368 \$31617 \$18842 \$31619 \$30059 \$31879 \$31746 \$31810 \$31733 \$31745
+ gf180mcu_fd_sc_mcu9t5v0__aoi222_1
X$8369 \$30173 \$25809 \$18842 \$30321 \$30251 \$30339 \$30258
+ gf180mcu_fd_sc_mcu9t5v0__oai211_1
X$8370 \$29930 \$25809 \$18842 \$30325 \$30251 \$30339 \$30327
+ gf180mcu_fd_sc_mcu9t5v0__oai211_1
X$8371 \$30322 \$25809 \$18842 \$30619 \$30564 \$30625 \$30633
+ gf180mcu_fd_sc_mcu9t5v0__oai211_1
X$8372 \$30494 \$25809 \$18842 \$30711 \$30696 \$30763 \$31243
+ gf180mcu_fd_sc_mcu9t5v0__oai211_1
X$8373 \$27652 \$25809 \$18842 \$28351 \$28211 \$28381 \$28352
+ gf180mcu_fd_sc_mcu9t5v0__oai211_1
X$8374 \$30631 \$25809 \$18842 \$30856 \$30819 \$30900 \$30857
+ gf180mcu_fd_sc_mcu9t5v0__oai211_1
X$8375 \$27654 \$25809 \$18842 \$29099 \$29123 \$29270 \$29242
+ gf180mcu_fd_sc_mcu9t5v0__oai211_1
X$8376 \$26690 \$25809 \$18842 \$26822 \$26675 \$26856 \$29935
+ gf180mcu_fd_sc_mcu9t5v0__oai211_1
X$8377 \$30687 \$25809 \$18842 \$30630 \$30696 \$30625 \$30833
+ gf180mcu_fd_sc_mcu9t5v0__oai211_1
X$8378 \$27286 \$25809 \$18842 \$27786 \$27913 \$27776 \$27928
+ gf180mcu_fd_sc_mcu9t5v0__oai211_1
X$8379 \$26652 \$25809 \$18842 \$27930 \$27913 \$27776 \$27929
+ gf180mcu_fd_sc_mcu9t5v0__oai211_1
X$8380 \$26231 \$25809 \$18842 \$28100 \$28211 \$28089 \$28222
+ gf180mcu_fd_sc_mcu9t5v0__oai211_1
X$8381 \$30349 \$25809 \$18842 \$30903 \$30971 \$30900 \$30904
+ gf180mcu_fd_sc_mcu9t5v0__oai211_1
X$8382 \$18842 \$26832 \$26831 \$26675 \$26856 \$25018
+ gf180mcu_fd_sc_mcu9t5v0__nand3_1
X$8383 \$29646 \$18842 \$29634 \$29720 \$29712 gf180mcu_fd_sc_mcu9t5v0__nor2_1
X$8384 \$26112 \$18842 \$26088 \$25918 \$26376 gf180mcu_fd_sc_mcu9t5v0__nor2_1
X$8385 \$18842 \$30067 \$30054 \$30185 \$30175 gf180mcu_fd_sc_mcu9t5v0__nand2_1
X$8386 \$18842 \$24888 \$24593 \$24721 \$24551 gf180mcu_fd_sc_mcu9t5v0__nand2_1
X$8387 \$18842 \$25085 \$24877 \$24997 \$25014 gf180mcu_fd_sc_mcu9t5v0__nand2_1
X$8388 \$18842 \$30420 \$31232 \$31175 \$31325 gf180mcu_fd_sc_mcu9t5v0__nand2_1
X$8389 \$18842 \$24855 \$24877 \$24721 \$24546 gf180mcu_fd_sc_mcu9t5v0__nand2_1
X$8390 \$18842 \$27343 \$27913 \$27776 \$27605 gf180mcu_fd_sc_mcu9t5v0__nand2_1
X$8391 \$31743 \$18842 \$31535 \$31465 \$31525 gf180mcu_fd_sc_mcu9t5v0__nand2_1
X$8392 \$32532 \$32792 \$18842 \$32721 \$32765 \$32724
+ gf180mcu_fd_sc_mcu9t5v0__mux2_1
X$8393 \$26531 \$26529 \$18842 \$26401 \$26521 \$26530
+ gf180mcu_fd_sc_mcu9t5v0__mux2_1
X$8394 \$21327 \$21166 \$18842 \$21184 \$21308 \$21326
+ gf180mcu_fd_sc_mcu9t5v0__mux2_1
X$8395 \$23931 \$23929 \$18842 \$23620 \$23807 \$23810
+ gf180mcu_fd_sc_mcu9t5v0__mux2_1
X$8396 \$31616 \$31542 \$18842 \$31535 \$31584 \$31593
+ gf180mcu_fd_sc_mcu9t5v0__mux2_1
X$8397 \$32638 \$32576 \$18842 \$32543 \$32629 \$32637
+ gf180mcu_fd_sc_mcu9t5v0__mux2_1
X$8398 \$32774 \$32772 \$18842 \$32721 \$32765 \$32773
+ gf180mcu_fd_sc_mcu9t5v0__mux2_1
X$8399 \$20419 \$20546 \$18842 \$20209 \$20383 \$20418
+ gf180mcu_fd_sc_mcu9t5v0__mux2_1
X$8400 \$20414 \$20413 \$18842 \$20209 \$20383 \$20227
+ gf180mcu_fd_sc_mcu9t5v0__mux2_1
X$8401 \$31747 \$31826 \$18842 \$31810 \$31886 \$31815
+ gf180mcu_fd_sc_mcu9t5v0__mux2_1
X$8402 \$29303 \$27787 \$18842 \$29123 \$29270 \$29275
+ gf180mcu_fd_sc_mcu9t5v0__mux2_1
X$8403 \$31878 \$31876 \$18842 \$31810 \$31886 \$31877
+ gf180mcu_fd_sc_mcu9t5v0__mux2_1
X$8404 \$22394 \$21186 \$18842 \$22387 \$22440 \$22393
+ gf180mcu_fd_sc_mcu9t5v0__mux2_1
X$8405 \$25926 \$25973 \$18842 \$25797 \$25918 \$25925
+ gf180mcu_fd_sc_mcu9t5v0__mux2_1
X$8406 \$23149 \$22844 \$18842 \$23027 \$23139 \$23148
+ gf180mcu_fd_sc_mcu9t5v0__mux2_1
X$8407 \$25326 \$25324 \$18842 \$25191 \$25347 \$25325
+ gf180mcu_fd_sc_mcu9t5v0__mux2_1
X$8408 \$21814 \$21813 \$18842 \$21661 \$21946 \$21956
+ gf180mcu_fd_sc_mcu9t5v0__mux2_1
X$8409 \$21151 \$21150 \$18842 \$21184 \$21308 \$21310
+ gf180mcu_fd_sc_mcu9t5v0__mux2_1
X$8410 \$29867 \$30709 \$18842 \$30696 \$30763 \$30713
+ gf180mcu_fd_sc_mcu9t5v0__mux2_1
X$8411 \$25643 \$26241 \$18842 \$26088 \$26220 \$25984
+ gf180mcu_fd_sc_mcu9t5v0__mux2_1
X$8412 \$19170 \$19756 \$18842 \$19027 \$19149 \$19169
+ gf180mcu_fd_sc_mcu9t5v0__mux2_1
X$8413 \$31167 \$28098 \$18842 \$31100 \$31175 \$31181
+ gf180mcu_fd_sc_mcu9t5v0__mux2_1
X$8414 \$32101 \$32158 \$18842 \$32100 \$32171 \$32160
+ gf180mcu_fd_sc_mcu9t5v0__mux2_1
X$8415 \$22285 \$22873 \$18842 \$22713 \$22837 \$22602
+ gf180mcu_fd_sc_mcu9t5v0__mux2_1
X$8416 \$32347 \$32178 \$18842 \$32248 \$32307 \$32319
+ gf180mcu_fd_sc_mcu9t5v0__mux2_1
X$8417 \$21315 \$21313 \$18842 \$21184 \$21308 \$21314
+ gf180mcu_fd_sc_mcu9t5v0__mux2_1
X$8418 \$31618 \$31617 \$18842 \$31607 \$31584 \$31687
+ gf180mcu_fd_sc_mcu9t5v0__mux2_1
X$8419 \$21393 \$20856 \$18842 \$21498 \$21308 \$21333
+ gf180mcu_fd_sc_mcu9t5v0__mux2_1
X$8420 \$24125 \$24124 \$18842 \$24231 \$24109 \$24266
+ gf180mcu_fd_sc_mcu9t5v0__mux2_1
X$8421 \$19297 \$19290 \$18842 \$19324 \$19149 \$19348
+ gf180mcu_fd_sc_mcu9t5v0__mux2_1
X$8422 \$25983 \$26238 \$18842 \$26088 \$25918 \$26113
+ gf180mcu_fd_sc_mcu9t5v0__mux2_1
X$8423 \$27610 \$27659 \$18842 \$27637 \$27449 \$27664
+ gf180mcu_fd_sc_mcu9t5v0__mux2_1
X$8424 \$31621 \$31686 \$18842 \$31607 \$31584 \$31620
+ gf180mcu_fd_sc_mcu9t5v0__mux2_1
X$8425 \$21824 \$22090 \$18842 \$22074 \$21946 \$22091
+ gf180mcu_fd_sc_mcu9t5v0__mux2_1
X$8426 \$28705 \$26863 \$18842 \$28810 \$28689 \$28824
+ gf180mcu_fd_sc_mcu9t5v0__mux2_1
X$8427 \$27609 \$28221 \$18842 \$28211 \$28089 \$28064
+ gf180mcu_fd_sc_mcu9t5v0__mux2_1
X$8428 \$19910 \$19909 \$18842 \$19927 \$19774 \$19940
+ gf180mcu_fd_sc_mcu9t5v0__mux2_1
X$8429 \$19485 \$19484 \$18842 \$19605 \$19466 \$19353
+ gf180mcu_fd_sc_mcu9t5v0__mux2_1
X$8430 \$19486 \$19620 \$18842 \$19605 \$19466 \$19621
+ gf180mcu_fd_sc_mcu9t5v0__mux2_1
X$8431 \$18891 \$19048 \$18842 \$19027 \$18870 \$19012
+ gf180mcu_fd_sc_mcu9t5v0__mux2_1
X$8432 \$32985 \$32935 \$18842 \$32992 \$32934 \$32997
+ gf180mcu_fd_sc_mcu9t5v0__mux2_1
X$8433 \$25975 \$26654 \$18842 \$26088 \$25918 \$26100
+ gf180mcu_fd_sc_mcu9t5v0__mux2_1
X$8434 \$32090 \$31933 \$18842 \$32100 \$32034 \$31953
+ gf180mcu_fd_sc_mcu9t5v0__mux2_1
X$8435 \$32999 \$32530 \$18842 \$32992 \$32934 \$32998
+ gf180mcu_fd_sc_mcu9t5v0__mux2_1
X$8436 \$23594 \$23626 \$18842 \$23620 \$23454 \$23631
+ gf180mcu_fd_sc_mcu9t5v0__mux2_1
X$8437 \$19473 \$19472 \$18842 \$19605 \$19466 \$19610
+ gf180mcu_fd_sc_mcu9t5v0__mux2_1
X$8438 \$19893 \$19891 \$18842 \$19927 \$19774 \$19934
+ gf180mcu_fd_sc_mcu9t5v0__mux2_1
X$8439 \$20393 \$19931 \$18842 \$20209 \$20087 \$20217
+ gf180mcu_fd_sc_mcu9t5v0__mux2_1
X$8440 \$21023 \$20842 \$18842 \$20881 \$20718 \$20886
+ gf180mcu_fd_sc_mcu9t5v0__mux2_1
X$8441 \$21674 \$20214 \$18842 \$21661 \$21622 \$21673
+ gf180mcu_fd_sc_mcu9t5v0__mux2_1
X$8442 \$32161 \$32089 \$18842 \$32248 \$32171 \$32091
+ gf180mcu_fd_sc_mcu9t5v0__mux2_1
X$8443 \$19895 \$19935 \$18842 \$19927 \$19774 \$19741
+ gf180mcu_fd_sc_mcu9t5v0__mux2_1
X$8444 \$24329 \$24884 \$18842 \$24877 \$24721 \$24611
+ gf180mcu_fd_sc_mcu9t5v0__mux2_1
X$8445 \$22597 \$22724 \$22713 \$22837 \$18846 gf180mcu_fd_sc_mcu9t5v0__xnor2_1
X$8446 \$19051 \$19050 \$18850 \$19027 \$18870 \$18894
+ gf180mcu_fd_sc_mcu9t5v0__aoi21_1
X$8447 \$20616 \$20550 \$20551 \$20515 \$20383 \$18853
+ gf180mcu_fd_sc_mcu9t5v0__oai21_1
X$8448 \$20616 \$20550 \$20881 \$20718 \$18854 gf180mcu_fd_sc_mcu9t5v0__nand2_1
X$8449 \$19922 \$19267 \$19268 \$18858 \$19324 \$19149 \$18857
+ gf180mcu_fd_sc_mcu9t5v0__aoi22_1
X$8450 \$18858 \$19593 \$19455 \$19605 \$19466 \$19267
+ gf180mcu_fd_sc_mcu9t5v0__nor3_1
X$8451 \$20039 \$20037 \$18858 \$19927 \$20087 \$19923
+ gf180mcu_fd_sc_mcu9t5v0__aoi21_1
X$8452 \$18858 \$19454 \$19723 \$20034 \$19605 \$19774 \$19722
+ gf180mcu_fd_sc_mcu9t5v0__aoi211_1
X$8453 \$18858 \$20368 \$20367 \$20209 \$20383 \$20034
+ gf180mcu_fd_sc_mcu9t5v0__oai21_1
X$8454 \$18858 \$19020 \$18983 \$19027 \$18870 \$18859
+ gf180mcu_fd_sc_mcu9t5v0__nand3_1
X$8455 \$18858 \$20368 \$20209 \$20383 \$20201 gf180mcu_fd_sc_mcu9t5v0__nor2_1
X$8456 \$19922 \$19923 \$20078 \$18858 \$19927 \$20087 \$20035
+ gf180mcu_fd_sc_mcu9t5v0__aoi22_1
X$8457 \$18858 \$20367 \$20209 \$20383 \$19450 gf180mcu_fd_sc_mcu9t5v0__nand2_1
X$8458 \$18858 \$20200 \$20515 \$20383 \$20373 gf180mcu_fd_sc_mcu9t5v0__nand2_1
X$8459 \$18858 \$20515 \$20718 \$20560 gf180mcu_fd_sc_mcu9t5v0__clkinv_1
X$8460 \$20038 \$20037 \$19927 \$20087 \$18860 gf180mcu_fd_sc_mcu9t5v0__nor2_1
X$8461 \$19875 \$18860 \$19927 \$19774 \$19770 gf180mcu_fd_sc_mcu9t5v0__nand2_1
X$8462 \$19139 \$18984 \$18985 \$18862 \$19027 \$18870 \$18863
+ gf180mcu_fd_sc_mcu9t5v0__or4_1
X$8463 \$19139 \$18984 \$18985 \$18862 \$19027 \$19149 \$19318
+ gf180mcu_fd_sc_mcu9t5v0__nor4_1
X$8464 \$19455 \$19270 \$19027 \$19149 \$18865 gf180mcu_fd_sc_mcu9t5v0__nand2_1
X$8465 \$18865 \$19027 \$18870 \$18991 gf180mcu_fd_sc_mcu9t5v0__buf_8
X$8466 \$19905 \$19008 \$19027 \$18870 \$18888 gf180mcu_fd_sc_mcu9t5v0__nor2_1
X$8467 \$18874 \$19027 \$18870 \$19282 gf180mcu_fd_sc_mcu9t5v0__clkinv_1
X$8468 \$18887 \$19027 \$18870 \$19008 gf180mcu_fd_sc_mcu9t5v0__clkinv_1
X$8469 \$18870 \$19027 gf180mcu_fd_sc_mcu9t5v0__filltie
X$8470 \$18870 \$19027 gf180mcu_fd_sc_mcu9t5v0__filltie
X$8471 \$18870 \$19027 gf180mcu_fd_sc_mcu9t5v0__filltie
X$8472 \$18870 \$19027 gf180mcu_fd_sc_mcu9t5v0__filltie
X$8473 \$18870 \$19027 gf180mcu_fd_sc_mcu9t5v0__filltie
X$8474 \$18870 \$19027 gf180mcu_fd_sc_mcu9t5v0__filltie
X$8475 \$18870 \$19027 gf180mcu_fd_sc_mcu9t5v0__endcap
X$8476 \$18873 \$23192 \$27464 \$30251 \$30339 \$30256
+ gf180mcu_fd_sc_mcu9t5v0__aoi21_1
X$8477 \$18873 \$24319 \$26651 \$27315 \$27153 \$27292
+ gf180mcu_fd_sc_mcu9t5v0__aoi21_1
X$8478 \$29438 \$28979 \$18873 \$29290 \$29270 \$29304
+ gf180mcu_fd_sc_mcu9t5v0__aoi21_1
X$8479 \$29931 \$29932 \$18873 \$29954 \$29847 \$29969
+ gf180mcu_fd_sc_mcu9t5v0__aoi21_1
X$8480 \$30955 \$30347 \$18873 \$30819 \$30763 \$30628
+ gf180mcu_fd_sc_mcu9t5v0__aoi21_1
X$8481 \$31320 \$30405 \$23032 \$31405 \$18873 \$31376 \$31465 \$31406
+ gf180mcu_fd_sc_mcu9t5v0__oai221_1
X$8482 \$30486 \$30405 \$23032 \$31233 \$18873 \$31232 \$31175 \$31234
+ gf180mcu_fd_sc_mcu9t5v0__oai221_1
X$8483 \$30470 \$30405 \$23032 \$30902 \$18873 \$30971 \$30900 \$30973
+ gf180mcu_fd_sc_mcu9t5v0__oai221_1
X$8484 \$31321 \$30405 \$23032 \$31520 \$18873 \$31535 \$31465 \$31538
+ gf180mcu_fd_sc_mcu9t5v0__oai221_1
X$8485 \$31524 \$30405 \$23032 \$31519 \$18873 \$31535 \$31465 \$31523
+ gf180mcu_fd_sc_mcu9t5v0__oai221_1
X$8486 \$30469 \$30405 \$23032 \$31518 \$18873 \$31535 \$31465 \$31379
+ gf180mcu_fd_sc_mcu9t5v0__oai221_1
X$8487 \$18873 \$29724 \$29723 \$29780 \$29720 \$29790
+ gf180mcu_fd_sc_mcu9t5v0__oai21_1
X$8488 \$26993 \$25323 \$18873 \$27015 \$26856 \$27044
+ gf180mcu_fd_sc_mcu9t5v0__oai21_1
X$8489 \$26981 \$18873 \$23187 \$27015 \$26856 \$26982
+ gf180mcu_fd_sc_mcu9t5v0__oai21_1
X$8490 \$22865 \$18873 \$23157 \$19753 \$23027 \$23139 \$22864
+ gf180mcu_fd_sc_mcu9t5v0__oai211_1
X$8491 \$23812 \$18873 \$23157 \$18995 \$23926 \$24109 \$24245
+ gf180mcu_fd_sc_mcu9t5v0__oai211_1
X$8492 \$26222 \$18873 \$26094 \$18996 \$26088 \$26220 \$26095
+ gf180mcu_fd_sc_mcu9t5v0__oai211_1
X$8493 \$23763 \$18873 \$23620 \$23807 \$23622 gf180mcu_fd_sc_mcu9t5v0__nor2_1
X$8494 \$20391 \$18873 \$20209 \$20383 \$19739 gf180mcu_fd_sc_mcu9t5v0__nor2_1
X$8495 \$23591 \$18873 \$23620 \$23807 \$23625 gf180mcu_fd_sc_mcu9t5v0__nor2_1
X$8496 \$21367 \$18873 \$21498 \$21622 \$21504 gf180mcu_fd_sc_mcu9t5v0__nor2_1
X$8497 \$29637 \$18873 \$29634 \$29720 \$29701 gf180mcu_fd_sc_mcu9t5v0__nor2_1
X$8498 \$20518 \$18873 \$20515 \$20383 \$20388 gf180mcu_fd_sc_mcu9t5v0__nor2_1
X$8499 \$22391 \$18873 \$22387 \$22272 \$21672 gf180mcu_fd_sc_mcu9t5v0__nor2_1
X$8500 \$21187 \$18873 \$21498 \$21308 \$21368 gf180mcu_fd_sc_mcu9t5v0__nor2_1
X$8501 \$19892 \$18873 \$19605 \$19466 \$19287 gf180mcu_fd_sc_mcu9t5v0__nor2_1
X$8502 \$20580 \$18873 \$20881 \$20718 \$20841 gf180mcu_fd_sc_mcu9t5v0__nor2_1
X$8503 \$20522 \$18873 \$20515 \$20383 \$20398 gf180mcu_fd_sc_mcu9t5v0__nor2_1
X$8504 \$22897 \$18873 \$23027 \$22837 \$22899 gf180mcu_fd_sc_mcu9t5v0__nor2_1
X$8505 \$19734 \$18873 \$19927 \$19774 \$19883 gf180mcu_fd_sc_mcu9t5v0__nor2_1
X$8506 \$18873 \$24882 \$29780 \$29720 \$29723 gf180mcu_fd_sc_mcu9t5v0__nand2_1
X$8507 \$18873 \$30627 \$30696 \$30625 \$30852 gf180mcu_fd_sc_mcu9t5v0__nand2_1
X$8508 \$30771 \$30819 \$30763 \$18873 gf180mcu_fd_sc_mcu9t5v0__buf_8
X$8509 \$29700 \$23623 \$18873 \$29634 \$29720 \$29699
+ gf180mcu_fd_sc_mcu9t5v0__mux2_1
X$8510 \$20396 \$19154 \$19042 \$20209 \$20383 \$18885
+ gf180mcu_fd_sc_mcu9t5v0__aoi21_1
X$8511 \$19905 \$19009 \$19027 \$19149 \$19047 \$18887
+ gf180mcu_fd_sc_mcu9t5v0__xnor3_1
X$8512 \$19051 \$19050 \$19027 \$19149 \$18892 gf180mcu_fd_sc_mcu9t5v0__xnor2_1
X$8513 \$18893 \$21515 \$21199 \$21498 \$21622 \$21648
+ gf180mcu_fd_sc_mcu9t5v0__mux2_1
X$8514 \$18979 \$19309 \$19324 \$19149 \$19268 gf180mcu_fd_sc_mcu9t5v0__xnor2_1
X$8515 \$18979 \$19451 \$19324 \$19466 \$19452 gf180mcu_fd_sc_mcu9t5v0__nor2_1
X$8516 \$19453 \$19138 \$18980 \$19027 \$19149 \$19020
+ gf180mcu_fd_sc_mcu9t5v0__or3_1
X$8517 \$19453 \$19138 \$18980 \$19027 \$19149 \$18983
+ gf180mcu_fd_sc_mcu9t5v0__oai21_1
X$8518 \$18985 \$19324 \$19466 \$19311 \$19726 gf180mcu_fd_sc_mcu9t5v0__xor2_1
X$8519 \$26397 \$25625 \$18987 \$26399 \$26398 \$26401 \$26521 \$26511
+ gf180mcu_fd_sc_mcu9t5v0__aoi221_2
X$8520 \$18988 \$19927 \$19774 \$19925 gf180mcu_fd_sc_mcu9t5v0__clkinv_1
X$8521 \$23587 \$18991 \$19600 \$23183 \$23454 \$23450
+ gf180mcu_fd_sc_mcu9t5v0__aoi21_1
X$8522 \$19769 \$22110 \$18991 \$22074 \$22272 \$22109
+ gf180mcu_fd_sc_mcu9t5v0__mux2_1
X$8523 \$18992 \$19927 \$20087 \$20045 gf180mcu_fd_sc_mcu9t5v0__buf_8
X$8524 \$19608 \$18997 \$20216 \$20209 \$20087 \$20215
+ gf180mcu_fd_sc_mcu9t5v0__oai21_1
X$8525 \$20230 \$19927 \$20087 \$19005 gf180mcu_fd_sc_mcu9t5v0__clkinv_1
X$8526 \$19905 \$19008 \$19324 \$19149 \$19298 gf180mcu_fd_sc_mcu9t5v0__nand2_1
X$8527 \$21173 \$21034 \$21196 \$21033 \$21184 \$21011 \$19009
+ gf180mcu_fd_sc_mcu9t5v0__oai31_1
X$8528 \$19626 \$19627 \$19605 \$19466 \$19013 gf180mcu_fd_sc_mcu9t5v0__nand2_1
X$8529 \$29137 \$29106 \$28983 \$28810 \$28971 \$19014
+ gf180mcu_fd_sc_mcu9t5v0__nand3_1
X$8530 \$22607 \$25335 \$19014 \$25191 \$25347 \$25100
+ gf180mcu_fd_sc_mcu9t5v0__mux2_1
X$8531 \$23481 \$25782 \$19014 \$25797 \$25918 \$25781
+ gf180mcu_fd_sc_mcu9t5v0__mux2_1
X$8532 \$21048 \$24332 \$19014 \$24231 \$24428 \$24333
+ gf180mcu_fd_sc_mcu9t5v0__mux2_1
X$8533 \$21844 \$23167 \$19014 \$23027 \$23139 \$22932
+ gf180mcu_fd_sc_mcu9t5v0__mux2_1
X$8534 \$27344 \$27347 \$19014 \$27315 \$27449 \$27299
+ gf180mcu_fd_sc_mcu9t5v0__mux2_1
X$8535 \$20615 \$22170 \$19014 \$22074 \$22272 \$22169
+ gf180mcu_fd_sc_mcu9t5v0__mux2_1
X$8536 \$26246 \$26422 \$19014 \$26401 \$26220 \$26388
+ gf180mcu_fd_sc_mcu9t5v0__mux2_1
X$8537 \$26391 \$28514 \$19014 \$28534 \$28381 \$28584
+ gf180mcu_fd_sc_mcu9t5v0__mux2_1
X$8538 \$20865 \$19022 \$20871 \$20872 \$20881 \$20718 \$20707
+ gf180mcu_fd_sc_mcu9t5v0__oai22_1
X$8539 \$19725 \$19724 \$19605 \$19774 \$19022 gf180mcu_fd_sc_mcu9t5v0__nor2_1
X$8540 \$19024 \$19023 \$19324 \$19149 \$19270 gf180mcu_fd_sc_mcu9t5v0__and2_1
X$8541 \$19322 \$19324 \$19466 \$19023 gf180mcu_fd_sc_mcu9t5v0__buf_8
X$8542 \$20838 \$19730 \$20713 \$19024 \$20881 \$20718 \$20837
+ gf180mcu_fd_sc_mcu9t5v0__aoi22_1
X$8543 \$19024 \$19730 \$20209 \$20087 \$20081 gf180mcu_fd_sc_mcu9t5v0__nand2_1
X$8544 \$20044 \$20209 \$20087 \$19026 gf180mcu_fd_sc_mcu9t5v0__clkbuf_8
X$8545 \$19026 \$20209 \$20087 \$I54318 gf180mcu_fd_sc_mcu9t5v0__clkinv_1
X$8546 \$19026 \$20086 \$20047 \$19927 \$20087 gf180mcu_fd_sc_mcu9t5v0__dffq_2
X$8547 \$19026 \$21143 \$21306 \$21184 \$21308 gf180mcu_fd_sc_mcu9t5v0__dffq_2
X$8548 \$19026 \$21013 \$21014 \$20881 \$21011 gf180mcu_fd_sc_mcu9t5v0__dffq_2
X$8549 \$19026 \$20577 \$20578 \$20515 \$20718 gf180mcu_fd_sc_mcu9t5v0__dffq_2
X$8550 \$19026 \$19148 \$19028 \$19324 \$19149 gf180mcu_fd_sc_mcu9t5v0__dffq_2
X$8551 \$19351 \$19047 \$19027 \$19149 \$19174 gf180mcu_fd_sc_mcu9t5v0__or2_1
X$8552 \$19167 \$19294 \$19027 \$19149 \$19044 gf180mcu_fd_sc_mcu9t5v0__nor2_1
X$8553 \$21200 \$19027 \$19149 \$19300 gf180mcu_fd_sc_mcu9t5v0__clkbuf_8
X$8554 \$19028 \$19154 \$19027 \$19149 \$19029 gf180mcu_fd_sc_mcu9t5v0__nand2_1
X$8555 \$19172 \$19048 \$19737 \$19027 \$19149 \$19175
+ gf180mcu_fd_sc_mcu9t5v0__mux2_1
X$8556 \$19147 \$19028 \$19150 \$19027 \$19149 \$19148
+ gf180mcu_fd_sc_mcu9t5v0__mux2_1
X$8557 \$19149 \$19027 gf180mcu_fd_sc_mcu9t5v0__filltie
X$8558 \$19149 \$19027 gf180mcu_fd_sc_mcu9t5v0__filltie
X$8559 \$19149 \$19027 gf180mcu_fd_sc_mcu9t5v0__filltie
X$8560 \$19149 \$19027 gf180mcu_fd_sc_mcu9t5v0__filltie
X$8561 \$19149 \$19027 gf180mcu_fd_sc_mcu9t5v0__filltie
X$8562 \$19149 \$19027 gf180mcu_fd_sc_mcu9t5v0__filltie
X$8563 \$19149 \$19027 gf180mcu_fd_sc_mcu9t5v0__endcap
X$8564 \$19279 \$19030 \$19150 \$19324 \$19149 \$19330
+ gf180mcu_fd_sc_mcu9t5v0__mux2_1
X$8565 \$19775 \$19330 \$19030 \$19324 \$19466 gf180mcu_fd_sc_mcu9t5v0__dffq_2
X$8566 \$27578 \$27452 \$27453 \$27637 \$27449 \$19031
+ gf180mcu_fd_sc_mcu9t5v0__oai21_1
X$8567 \$28340 \$19031 \$28534 \$28381 \$28544 gf180mcu_fd_sc_mcu9t5v0__nand2_1
X$8568 \$19469 \$27315 \$27449 \$19032 gf180mcu_fd_sc_mcu9t5v0__clkinv_1
X$8569 \$19032 \$19886 \$19927 \$19774 \$19781 gf180mcu_fd_sc_mcu9t5v0__nand2_1
X$8570 \$19042 \$31385 \$31384 \$30823 \$31376 \$31310 \$31159
+ gf180mcu_fd_sc_mcu9t5v0__nand4_1
X$8571 \$19042 \$32151 \$30699 \$30819 \$30900 \$30851
+ gf180mcu_fd_sc_mcu9t5v0__aoi21_1
X$8572 \$19042 \$28355 \$24737 \$28211 \$28381 \$28219
+ gf180mcu_fd_sc_mcu9t5v0__aoi21_1
X$8573 \$19042 \$28353 \$24430 \$28211 \$28381 \$28354
+ gf180mcu_fd_sc_mcu9t5v0__aoi21_1
X$8574 \$19042 \$30424 \$28570 \$30402 \$30339 \$30425
+ gf180mcu_fd_sc_mcu9t5v0__aoi21_1
X$8575 \$27803 \$19154 \$19042 \$27913 \$28089 \$27597
+ gf180mcu_fd_sc_mcu9t5v0__aoi21_1
X$8576 \$28510 \$19154 \$19042 \$28810 \$28971 \$28944
+ gf180mcu_fd_sc_mcu9t5v0__aoi21_1
X$8577 \$25468 \$19154 \$19042 \$25462 \$25632 \$26688
+ gf180mcu_fd_sc_mcu9t5v0__aoi21_1
X$8578 \$20387 \$19154 \$19042 \$20515 \$20383 \$20519
+ gf180mcu_fd_sc_mcu9t5v0__aoi21_1
X$8579 \$25196 \$19154 \$19042 \$25462 \$25347 \$25469
+ gf180mcu_fd_sc_mcu9t5v0__aoi21_1
X$8580 \$19042 \$27456 \$27032 \$26651 \$27315 \$27449 \$27457
+ gf180mcu_fd_sc_mcu9t5v0__aoi211_1
X$8581 \$19042 \$30188 \$30169 \$27464 \$30251 \$30185 \$30240
+ gf180mcu_fd_sc_mcu9t5v0__aoi211_1
X$8582 \$19042 \$30171 \$29956 \$27464 \$30251 \$30185 \$30241
+ gf180mcu_fd_sc_mcu9t5v0__aoi211_1
X$8583 \$19042 \$29788 \$29631 \$27464 \$29954 \$29847 \$29959
+ gf180mcu_fd_sc_mcu9t5v0__aoi211_1
X$8584 \$19042 \$22582 \$27326 \$27325 \$27315 \$27449 \$27327
+ gf180mcu_fd_sc_mcu9t5v0__oai22_1
X$8585 \$19042 \$25762 \$28217 \$28211 \$28089 \$28216
+ gf180mcu_fd_sc_mcu9t5v0__oai21_1
X$8586 \$19042 \$21629 \$26808 \$26675 \$26521 \$26683
+ gf180mcu_fd_sc_mcu9t5v0__oai21_1
X$8587 \$29315 \$29314 \$19042 \$29290 \$29270 \$29316
+ gf180mcu_fd_sc_mcu9t5v0__oai21_1
X$8588 \$19042 \$23819 \$22858 \$24066 \$23926 \$24109 \$24257
+ gf180mcu_fd_sc_mcu9t5v0__oai31_1
X$8589 \$19042 \$23340 \$22902 \$29638 \$29634 \$29720 \$29705
+ gf180mcu_fd_sc_mcu9t5v0__oai31_1
X$8590 \$19042 \$23340 \$22454 \$29791 \$29780 \$29847 \$29857
+ gf180mcu_fd_sc_mcu9t5v0__oai31_1
X$8591 \$19042 \$23340 \$21953 \$30476 \$30402 \$30485 \$30491
+ gf180mcu_fd_sc_mcu9t5v0__oai31_1
X$8592 \$19042 \$23340 \$22389 \$29792 \$29780 \$29847 \$29725
+ gf180mcu_fd_sc_mcu9t5v0__oai31_1
X$8593 \$19042 \$23819 \$23199 \$25605 \$25462 \$25632 \$25640
+ gf180mcu_fd_sc_mcu9t5v0__oai31_1
X$8594 \$19042 \$23340 \$23041 \$23474 \$23183 \$23454 \$23602
+ gf180mcu_fd_sc_mcu9t5v0__oai31_1
X$8595 \$19042 \$23340 \$22869 \$24074 \$23926 \$24109 \$24123
+ gf180mcu_fd_sc_mcu9t5v0__oai31_1
X$8596 \$19042 \$23340 \$23042 \$26239 \$26088 \$26220 \$26240
+ gf180mcu_fd_sc_mcu9t5v0__oai31_1
X$8597 \$19042 \$23340 \$22916 \$24072 \$23926 \$24109 \$24122
+ gf180mcu_fd_sc_mcu9t5v0__oai31_1
X$8598 \$19042 \$23819 \$23036 \$24067 \$23926 \$24109 \$24120
+ gf180mcu_fd_sc_mcu9t5v0__oai31_1
X$8599 \$19042 \$23340 \$22723 \$23153 \$23027 \$23139 \$23154
+ gf180mcu_fd_sc_mcu9t5v0__oai31_1
X$8600 \$19042 \$23340 \$23039 \$23783 \$23620 \$23807 \$23780
+ gf180mcu_fd_sc_mcu9t5v0__oai31_1
X$8601 \$19042 \$23819 \$24235 \$27158 \$27015 \$27153 \$27159
+ gf180mcu_fd_sc_mcu9t5v0__oai31_1
X$8602 \$19042 \$23819 \$22893 \$27156 \$27015 \$27153 \$27157
+ gf180mcu_fd_sc_mcu9t5v0__oai31_1
X$8603 \$19042 \$23819 \$23629 \$25976 \$26088 \$25918 \$25929
+ gf180mcu_fd_sc_mcu9t5v0__oai31_1
X$8604 \$19042 \$23819 \$22904 \$25977 \$26088 \$25918 \$26101
+ gf180mcu_fd_sc_mcu9t5v0__oai31_1
X$8605 \$19042 \$23340 \$21816 \$29538 \$29634 \$29424 \$29640
+ gf180mcu_fd_sc_mcu9t5v0__oai31_1
X$8606 \$19042 \$23340 \$22867 \$25358 \$25462 \$25347 \$25359
+ gf180mcu_fd_sc_mcu9t5v0__oai31_1
X$8607 \$19042 \$23340 \$22718 \$29928 \$29954 \$29847 \$29966
+ gf180mcu_fd_sc_mcu9t5v0__oai31_1
X$8608 \$19042 \$23340 \$23043 \$23206 \$23183 \$23139 \$23603
+ gf180mcu_fd_sc_mcu9t5v0__oai31_1
X$8609 \$19042 \$23819 \$23202 \$23600 \$23620 \$23454 \$23642
+ gf180mcu_fd_sc_mcu9t5v0__oai31_1
X$8610 \$19042 \$23819 \$22913 \$23817 \$23926 \$23807 \$23937
+ gf180mcu_fd_sc_mcu9t5v0__oai31_1
X$8611 \$19042 \$23819 \$24239 \$26647 \$26675 \$26521 \$26680
+ gf180mcu_fd_sc_mcu9t5v0__oai31_1
X$8612 \$19042 \$23819 \$22583 \$26648 \$26675 \$26521 \$26649
+ gf180mcu_fd_sc_mcu9t5v0__oai31_1
X$8613 \$19042 \$23819 \$23155 \$24553 \$24593 \$24428 \$24610
+ gf180mcu_fd_sc_mcu9t5v0__oai31_1
X$8614 \$19042 \$23340 \$22866 \$24556 \$24593 \$24428 \$24557
+ gf180mcu_fd_sc_mcu9t5v0__oai31_1
X$8615 \$19042 \$23340 \$22896 \$30348 \$30402 \$30339 \$30413
+ gf180mcu_fd_sc_mcu9t5v0__oai31_1
X$8616 \$19042 \$23819 \$23040 \$24121 \$24231 \$24109 \$24261
+ gf180mcu_fd_sc_mcu9t5v0__oai31_1
X$8617 \$19042 \$23819 \$21662 \$26364 \$26401 \$26220 \$26223
+ gf180mcu_fd_sc_mcu9t5v0__oai31_1
X$8618 \$19042 \$23819 \$23201 \$23818 \$23926 \$23807 \$23938
+ gf180mcu_fd_sc_mcu9t5v0__oai31_1
X$8619 \$19042 \$23819 \$21360 \$25971 \$26088 \$25918 \$26096
+ gf180mcu_fd_sc_mcu9t5v0__oai31_1
X$8620 \$19042 \$26099 \$30054 \$30185 \$30169 gf180mcu_fd_sc_mcu9t5v0__nor2_1
X$8621 \$19042 \$25062 \$29954 \$30027 \$29956 gf180mcu_fd_sc_mcu9t5v0__nor2_1
X$8622 \$19042 \$24886 \$29634 \$29424 \$29641 gf180mcu_fd_sc_mcu9t5v0__nor2_1
X$8623 \$19042 \$22134 \$27015 \$26856 \$27032 gf180mcu_fd_sc_mcu9t5v0__nor2_1
X$8624 \$19042 \$23188 \$29634 \$29424 \$29631 gf180mcu_fd_sc_mcu9t5v0__nor2_1
X$8625 \$30955 \$31812 \$31684 \$19042 \$31607 \$31733 \$31685
+ gf180mcu_fd_sc_mcu9t5v0__oai211_1
X$8626 \$19042 \$26536 \$23777 \$26688 \$26401 \$26521 \$26411
+ gf180mcu_fd_sc_mcu9t5v0__aoi22_1
X$8627 \$19042 \$29714 \$29648 \$28944 \$29634 \$29720 \$29713
+ gf180mcu_fd_sc_mcu9t5v0__aoi22_1
X$8628 \$19042 \$26819 \$23599 \$26688 \$26675 \$26856 \$26818
+ gf180mcu_fd_sc_mcu9t5v0__aoi22_1
X$8629 \$19042 \$26821 \$23200 \$26688 \$26675 \$26856 \$26820
+ gf180mcu_fd_sc_mcu9t5v0__aoi22_1
X$8630 \$19042 \$29442 \$24071 \$28944 \$29290 \$29424 \$29441
+ gf180mcu_fd_sc_mcu9t5v0__aoi22_1
X$8631 \$19042 \$26991 \$24432 \$25469 \$25462 \$25632 \$25606
+ gf180mcu_fd_sc_mcu9t5v0__aoi22_1
X$8632 \$19042 \$27660 \$27806 \$27597 \$27637 \$27776 \$27465
+ gf180mcu_fd_sc_mcu9t5v0__aoi22_1
X$8633 \$19042 \$25608 \$23776 \$25469 \$25462 \$25632 \$25607
+ gf180mcu_fd_sc_mcu9t5v0__aoi22_1
X$8634 \$19042 \$29101 \$24554 \$28944 \$29123 \$28971 \$28713
+ gf180mcu_fd_sc_mcu9t5v0__aoi22_1
X$8635 \$19042 \$27599 \$25087 \$27597 \$27637 \$27449 \$27598
+ gf180mcu_fd_sc_mcu9t5v0__aoi22_1
X$8636 \$19042 \$28229 \$25941 \$27597 \$28211 \$28089 \$28061
+ gf180mcu_fd_sc_mcu9t5v0__aoi22_1
X$8637 \$19042 \$25475 \$23778 \$25469 \$25462 \$25347 \$25356
+ gf180mcu_fd_sc_mcu9t5v0__aoi22_1
X$8638 \$19042 \$29958 \$30054 \$30185 \$30172 gf180mcu_fd_sc_mcu9t5v0__nand2_1
X$8639 \$19042 \$26809 \$26675 \$26856 \$26808 gf180mcu_fd_sc_mcu9t5v0__nand2_1
X$8640 \$19042 \$28701 \$28534 \$28689 \$28217 gf180mcu_fd_sc_mcu9t5v0__nand2_1
X$8641 \$19042 \$27455 \$27637 \$27449 \$27325 gf180mcu_fd_sc_mcu9t5v0__nand2_1
X$8642 \$19042 \$30975 \$31607 \$31584 \$31613 gf180mcu_fd_sc_mcu9t5v0__nand2_1
X$8643 \$19042 \$30347 \$31810 \$31733 \$32021 gf180mcu_fd_sc_mcu9t5v0__nand2_1
X$8644 \$30695 \$30696 \$30625 \$19042 gf180mcu_fd_sc_mcu9t5v0__buf_8
X$8645 \$24539 \$28942 \$19042 \$28810 \$28971 \$28977
+ gf180mcu_fd_sc_mcu9t5v0__mux2_1
X$8646 \$24878 \$28347 \$19042 \$28211 \$28381 \$28346
+ gf180mcu_fd_sc_mcu9t5v0__mux2_1
X$8647 \$19937 \$19605 \$19774 \$19046 gf180mcu_fd_sc_mcu9t5v0__clkinv_1
X$8648 \$19351 \$19047 \$19324 \$19466 \$19299 gf180mcu_fd_sc_mcu9t5v0__xnor2_1
X$8649 \$19625 \$19358 \$19487 \$19489 \$19605 \$19466 \$19049
+ gf180mcu_fd_sc_mcu9t5v0__oai211_1
X$8650 \$19050 \$21039 \$21199 \$21184 \$21308 \$21176
+ gf180mcu_fd_sc_mcu9t5v0__mux2_1
X$8651 \$19501 \$19364 \$19324 \$19466 \$19053 gf180mcu_fd_sc_mcu9t5v0__nand2_1
X$8652 \$19453 \$19138 \$19324 \$19466 \$19454 gf180mcu_fd_sc_mcu9t5v0__xnor2_1
X$8653 \$19138 \$19324 \$19466 \$19589 gf180mcu_fd_sc_mcu9t5v0__clkinv_1
X$8654 \$25796 \$25625 \$19141 \$25741 \$25913 \$25797 \$25918 \$25914
+ gf180mcu_fd_sc_mcu9t5v0__aoi221_1
X$8655 \$19594 \$19271 \$19142 \$19324 \$19149 \$19272
+ gf180mcu_fd_sc_mcu9t5v0__oai21_1
X$8656 \$27567 \$27566 \$19143 \$27637 \$27449 \$27630
+ gf180mcu_fd_sc_mcu9t5v0__oai21_1
X$8657 \$19143 \$27907 \$27913 \$28089 \$28043 gf180mcu_fd_sc_mcu9t5v0__nand2_1
X$8658 \$19143 \$19144 \$24877 \$24997 \$25741 gf180mcu_fd_sc_mcu9t5v0__nand2_1
X$8659 \$19179 \$19363 \$19362 \$19324 \$19149 \$19181
+ gf180mcu_fd_sc_mcu9t5v0__and3_1
X$8660 \$19737 \$19287 \$19337 \$19288 \$19324 \$19149 \$19289
+ gf180mcu_fd_sc_mcu9t5v0__oai31_1
X$8661 \$21388 \$19324 \$19149 \$19168 gf180mcu_fd_sc_mcu9t5v0__clkinv_1
X$8662 \$19156 \$19324 \$19149 \$19284 gf180mcu_fd_sc_mcu9t5v0__clkinv_1
X$8663 \$19465 \$19324 \$19149 \$19277 gf180mcu_fd_sc_mcu9t5v0__clkinv_1
X$8664 \$19273 \$19324 \$19149 \$19271 gf180mcu_fd_sc_mcu9t5v0__clkinv_1
X$8665 \$19151 \$19154 \$19324 \$19149 \$19280 gf180mcu_fd_sc_mcu9t5v0__nand2_1
X$8666 \$19290 \$19737 \$19324 \$19149 \$19288 gf180mcu_fd_sc_mcu9t5v0__nand2_1
X$8667 \$19149 \$19324 gf180mcu_fd_sc_mcu9t5v0__filltie
X$8668 \$19149 \$19324 gf180mcu_fd_sc_mcu9t5v0__filltie
X$8669 \$19149 \$19324 gf180mcu_fd_sc_mcu9t5v0__filltie
X$8670 \$19149 \$19324 gf180mcu_fd_sc_mcu9t5v0__filltie
X$8671 \$19149 \$19324 gf180mcu_fd_sc_mcu9t5v0__filltie
X$8672 \$19149 \$19324 gf180mcu_fd_sc_mcu9t5v0__filltie
X$8673 \$19887 \$19283 \$19284 \$19324 \$19149 \$19332
+ gf180mcu_fd_sc_mcu9t5v0__mux2_1
X$8674 \$19467 \$19151 \$19150 \$19324 \$19149 \$19327
+ gf180mcu_fd_sc_mcu9t5v0__mux2_1
X$8675 \$19149 \$19324 gf180mcu_fd_sc_mcu9t5v0__endcap
X$8676 \$19150 \$24596 \$24534 \$24593 \$24721 \$24724
+ gf180mcu_fd_sc_mcu9t5v0__oai21_1
X$8677 \$19150 \$24056 \$24058 \$23926 \$24109 \$24057
+ gf180mcu_fd_sc_mcu9t5v0__oai21_1
X$8678 \$19150 \$22714 \$22836 \$22713 \$22837 \$22835
+ gf180mcu_fd_sc_mcu9t5v0__oai21_1
X$8679 \$19150 \$21359 \$21500 \$21498 \$21622 \$21499
+ gf180mcu_fd_sc_mcu9t5v0__oai21_1
X$8680 \$19150 \$21145 \$21185 \$21184 \$21011 \$21146
+ gf180mcu_fd_sc_mcu9t5v0__oai21_1
X$8681 \$19150 \$21497 \$21952 \$22276 \$21661 \$21946 \$21951
+ gf180mcu_fd_sc_mcu9t5v0__oai211_1
X$8682 \$19150 \$21358 \$21625 \$21624 \$21498 \$21622 \$21623
+ gf180mcu_fd_sc_mcu9t5v0__oai211_1
X$8683 \$22133 \$19150 \$21809 \$22130 \$22074 \$22272 \$22132
+ gf180mcu_fd_sc_mcu9t5v0__aoi22_1
X$8684 \$22838 \$19150 \$21809 \$22579 \$22387 \$22440 \$22441
+ gf180mcu_fd_sc_mcu9t5v0__aoi22_1
X$8685 \$21807 \$19150 \$21809 \$21804 \$21661 \$21946 \$21950
+ gf180mcu_fd_sc_mcu9t5v0__aoi22_1
X$8686 \$22447 \$19150 \$21809 \$22079 \$22387 \$22440 \$22135
+ gf180mcu_fd_sc_mcu9t5v0__aoi22_1
X$8687 \$21805 \$19150 \$21661 \$21946 \$21625 gf180mcu_fd_sc_mcu9t5v0__nand2_1
X$8688 \$24111 \$19150 \$23926 \$24109 \$24058 gf180mcu_fd_sc_mcu9t5v0__nand2_1
X$8689 \$22716 \$19150 \$22713 \$22837 \$22836 gf180mcu_fd_sc_mcu9t5v0__nand2_1
X$8690 \$21501 \$19150 \$21498 \$21622 \$21500 gf180mcu_fd_sc_mcu9t5v0__nand2_1
X$8691 \$21147 \$19150 \$21184 \$21011 \$21185 gf180mcu_fd_sc_mcu9t5v0__nand2_1
X$8692 \$22077 \$19150 \$22074 \$21946 \$21952 gf180mcu_fd_sc_mcu9t5v0__nand2_1
X$8693 \$24725 \$19150 \$24593 \$24428 \$24534 gf180mcu_fd_sc_mcu9t5v0__nand2_1
X$8694 \$21364 \$21498 \$21308 \$19150 gf180mcu_fd_sc_mcu9t5v0__buf_8
X$8695 \$23030 \$23147 \$19150 \$23027 \$23139 \$23146
+ gf180mcu_fd_sc_mcu9t5v0__mux2_1
X$8696 \$22580 \$23142 \$19150 \$23027 \$23139 \$23141
+ gf180mcu_fd_sc_mcu9t5v0__mux2_1
X$8697 \$21803 \$21944 \$19150 \$21661 \$21946 \$21943
+ gf180mcu_fd_sc_mcu9t5v0__mux2_1
X$8698 \$19733 \$20047 \$19150 \$20209 \$20383 \$20086
+ gf180mcu_fd_sc_mcu9t5v0__mux2_1
X$8699 \$20882 \$21016 \$19150 \$21184 \$21308 \$21015
+ gf180mcu_fd_sc_mcu9t5v0__mux2_1
X$8700 \$19929 \$20089 \$19150 \$19927 \$20087 \$20088
+ gf180mcu_fd_sc_mcu9t5v0__mux2_1
X$8701 \$20385 \$20387 \$19150 \$20209 \$20383 \$20386
+ gf180mcu_fd_sc_mcu9t5v0__mux2_1
X$8702 \$19607 \$19328 \$19150 \$19324 \$19466 \$19468
+ gf180mcu_fd_sc_mcu9t5v0__mux2_1
X$8703 \$23138 \$23185 \$19150 \$23183 \$23139 \$23184
+ gf180mcu_fd_sc_mcu9t5v0__mux2_1
X$8704 \$22574 \$22575 \$19150 \$22713 \$22440 \$22715
+ gf180mcu_fd_sc_mcu9t5v0__mux2_1
X$8705 \$23455 \$23325 \$19150 \$23183 \$23139 \$23186
+ gf180mcu_fd_sc_mcu9t5v0__mux2_1
X$8706 \$23621 \$23457 \$19150 \$23620 \$23454 \$23456
+ gf180mcu_fd_sc_mcu9t5v0__mux2_1
X$8707 \$21012 \$21014 \$19150 \$21184 \$21011 \$21013
+ gf180mcu_fd_sc_mcu9t5v0__mux2_1
X$8708 \$21010 \$21306 \$19150 \$21184 \$21011 \$21143
+ gf180mcu_fd_sc_mcu9t5v0__mux2_1
X$8709 \$20516 \$20578 \$19150 \$20515 \$20383 \$20577
+ gf180mcu_fd_sc_mcu9t5v0__mux2_1
X$8710 \$19775 \$19327 \$19151 \$19324 \$19466 gf180mcu_fd_sc_mcu9t5v0__dffq_2
X$8711 \$27293 \$19154 \$27015 \$26856 \$26993 gf180mcu_fd_sc_mcu9t5v0__and2_1
X$8712 \$19154 \$27600 \$31321 \$31607 \$31733 \$31741
+ gf180mcu_fd_sc_mcu9t5v0__aoi21_1
X$8713 \$19154 \$26094 \$30486 \$31100 \$31175 \$31253
+ gf180mcu_fd_sc_mcu9t5v0__aoi21_1
X$8714 \$19154 \$23157 \$30469 \$31535 \$31584 \$31588
+ gf180mcu_fd_sc_mcu9t5v0__aoi21_1
X$8715 \$19154 \$31612 \$31524 \$31810 \$31886 \$31875
+ gf180mcu_fd_sc_mcu9t5v0__aoi21_1
X$8716 \$19154 \$31970 \$31320 \$31967 \$32034 \$31971
+ gf180mcu_fd_sc_mcu9t5v0__aoi21_1
X$8717 \$19154 \$30167 \$30058 \$30054 \$30185 \$30166
+ gf180mcu_fd_sc_mcu9t5v0__aoi21_1
X$8718 \$19154 \$30565 \$29632 \$30564 \$30625 \$30609
+ gf180mcu_fd_sc_mcu9t5v0__aoi21_1
X$8719 \$19154 \$30823 \$30163 \$31376 \$31310 \$31377
+ gf180mcu_fd_sc_mcu9t5v0__aoi21_1
X$8720 \$19154 \$30972 \$30470 \$30971 \$30900 \$30956
+ gf180mcu_fd_sc_mcu9t5v0__aoi21_1
X$8721 \$21805 \$19154 \$21019 \$21628 \$21498 \$21622 \$21629
+ gf180mcu_fd_sc_mcu9t5v0__aoi22_1
X$8722 \$23142 \$19154 \$23028 \$23145 \$23183 \$23139 \$23188
+ gf180mcu_fd_sc_mcu9t5v0__aoi22_1
X$8723 \$24999 \$19154 \$24877 \$24997 \$25000 gf180mcu_fd_sc_mcu9t5v0__nand2_1
X$8724 \$23325 \$19154 \$23183 \$23454 \$23327 gf180mcu_fd_sc_mcu9t5v0__nand2_1
X$8725 \$24247 \$19154 \$24231 \$24428 \$24248 gf180mcu_fd_sc_mcu9t5v0__nand2_1
X$8726 \$23147 \$19154 \$23183 \$23139 \$23191 gf180mcu_fd_sc_mcu9t5v0__nand2_1
X$8727 \$30313 \$30251 \$30339 \$19154 gf180mcu_fd_sc_mcu9t5v0__buf_8
X$8728 \$19737 \$21368 \$19155 \$21021 \$21184 \$21011 \$21022
+ gf180mcu_fd_sc_mcu9t5v0__oai31_1
X$8729 \$19157 \$19887 \$19283 \$19889 \$19927 \$19774 \$19890
+ gf180mcu_fd_sc_mcu9t5v0__aoi22_1
X$8730 \$19157 \$19284 \$19324 \$19466 \$19334 gf180mcu_fd_sc_mcu9t5v0__nand2_1
X$8731 \$19157 \$19324 \$19466 \$19285 gf180mcu_fd_sc_mcu9t5v0__clkinv_1
X$8732 \$19341 \$19324 \$19466 \$19342 \$19163 gf180mcu_fd_sc_mcu9t5v0__xor2_1
X$8733 \$21319 \$21498 \$21308 \$21382 \$19164 gf180mcu_fd_sc_mcu9t5v0__xor2_1
X$8734 \$20519 \$20515 \$20383 \$19165 gf180mcu_fd_sc_mcu9t5v0__buf_8
X$8735 \$19749 \$19324 \$19466 \$19166 gf180mcu_fd_sc_mcu9t5v0__clkinv_1
X$8736 \$19615 \$19480 \$19605 \$19466 \$19167 gf180mcu_fd_sc_mcu9t5v0__nor2_1
X$8737 \$19167 \$19324 \$19466 \$19343 gf180mcu_fd_sc_mcu9t5v0__clkinv_1
X$8738 \$19938 \$19324 \$19466 \$19171 gf180mcu_fd_sc_mcu9t5v0__clkinv_1
X$8739 \$19628 \$19359 \$19324 \$19466 \$19178 \$19491
+ gf180mcu_fd_sc_mcu9t5v0__xnor3_1
X$8740 \$19270 \$19324 \$19466 \$19875 gf180mcu_fd_sc_mcu9t5v0__buf_8
X$8741 \$19594 \$19273 \$19605 \$19466 \$19599 gf180mcu_fd_sc_mcu9t5v0__nand2_1
X$8742 \$19464 \$19605 \$19466 \$19274 gf180mcu_fd_sc_mcu9t5v0__clkinv_1
X$8743 \$19604 \$19878 \$19877 \$19275 \$19927 \$19774 \$19926
+ gf180mcu_fd_sc_mcu9t5v0__nand4_1
X$8744 \$25633 \$25464 \$19282 \$23176 \$25797 \$25632 \$26978
+ gf180mcu_fd_sc_mcu9t5v0__oai31_4
X$8745 \$22591 \$22590 \$22713 \$22440 \$19291 gf180mcu_fd_sc_mcu9t5v0__xnor2_1
X$8746 \$19344 \$19341 \$19324 \$19466 \$19294 gf180mcu_fd_sc_mcu9t5v0__and2_1
X$8747 \$19763 \$20541 \$19299 \$19908 \$19927 \$19774 \$19789
+ gf180mcu_fd_sc_mcu9t5v0__oai31_1
X$8748 \$19300 \$19324 \$19466 \$I54586 gf180mcu_fd_sc_mcu9t5v0__clkinv_1
X$8749 \$19450 \$19306 \$19308 \$19324 \$19466 \$19305
+ gf180mcu_fd_sc_mcu9t5v0__oai21_1
X$8750 \$20033 \$19587 \$19605 \$19466 \$19306 gf180mcu_fd_sc_mcu9t5v0__and2_1
X$8751 \$25799 \$28538 \$28541 \$19307 \$28689 \$28534
+ gf180mcu_fd_sc_mcu9t5v0__dffsnq_2
X$8752 \$21791 \$22820 \$22065 \$19307 \$22713 \$22837
+ gf180mcu_fd_sc_mcu9t5v0__dffrnq_2
X$8753 \$26394 \$27002 \$27003 \$19307 \$27015 \$27153
+ gf180mcu_fd_sc_mcu9t5v0__dffrnq_2
X$8754 \$23915 \$24580 \$24520 \$19307 \$24593 \$24721
+ gf180mcu_fd_sc_mcu9t5v0__dffrnq_2
X$8755 \$23915 \$25293 \$25187 \$19307 \$25191 \$25347
+ gf180mcu_fd_sc_mcu9t5v0__dffrnq_2
X$8756 \$28927 \$28959 \$28928 \$19307 \$28810 \$28971
+ gf180mcu_fd_sc_mcu9t5v0__dffrnq_2
X$8757 \$23308 \$24582 \$24281 \$19307 \$24593 \$24721
+ gf180mcu_fd_sc_mcu9t5v0__dffrnq_2
X$8758 \$23915 \$25449 \$25342 \$19307 \$25462 \$25632
+ gf180mcu_fd_sc_mcu9t5v0__dffrnq_2
X$8759 \$27905 \$29117 \$29076 \$19307 \$29123 \$29270
+ gf180mcu_fd_sc_mcu9t5v0__dffrnq_2
X$8760 \$28080 \$29228 \$29075 \$19307 \$29123 \$29270
+ gf180mcu_fd_sc_mcu9t5v0__dffrnq_2
X$8761 \$28080 \$29227 \$29073 \$19307 \$29123 \$29270
+ gf180mcu_fd_sc_mcu9t5v0__dffrnq_2
X$8762 \$28080 \$28326 \$28327 \$19307 \$28211 \$28381
+ gf180mcu_fd_sc_mcu9t5v0__dffrnq_2
X$8763 \$26394 \$27763 \$27764 \$19307 \$27637 \$27776
+ gf180mcu_fd_sc_mcu9t5v0__dffrnq_2
X$8764 \$26394 \$27623 \$27563 \$19307 \$27637 \$27776
+ gf180mcu_fd_sc_mcu9t5v0__dffrnq_2
X$8765 \$23915 \$26076 \$26077 \$19307 \$26088 \$26220
+ gf180mcu_fd_sc_mcu9t5v0__dffrnq_2
X$8766 \$23308 \$23917 \$23797 \$19307 \$23926 \$24109
+ gf180mcu_fd_sc_mcu9t5v0__dffrnq_2
X$8767 \$23308 \$23168 \$23576 \$19307 \$23183 \$23454
+ gf180mcu_fd_sc_mcu9t5v0__dffrnq_2
X$8768 \$23308 \$24982 \$25035 \$19307 \$24877 \$24997
+ gf180mcu_fd_sc_mcu9t5v0__dffrnq_2
X$8769 \$23915 \$25794 \$25623 \$19307 \$25797 \$25918
+ gf180mcu_fd_sc_mcu9t5v0__dffrnq_2
X$8770 \$23915 \$25296 \$25297 \$19307 \$25191 \$25347
+ gf180mcu_fd_sc_mcu9t5v0__dffrnq_2
X$8771 \$26394 \$27004 \$26639 \$19307 \$27015 \$27153
+ gf180mcu_fd_sc_mcu9t5v0__dffrnq_2
X$8772 \$23308 \$23578 \$23751 \$19307 \$23620 \$23807
+ gf180mcu_fd_sc_mcu9t5v0__dffrnq_2
X$8773 \$21791 \$23019 \$22430 \$19307 \$23027 \$23139
+ gf180mcu_fd_sc_mcu9t5v0__dffrnq_2
X$8774 \$23308 \$24522 \$24583 \$19307 \$24593 \$24721
+ gf180mcu_fd_sc_mcu9t5v0__dffrnq_2
X$8775 \$26394 \$25451 \$25452 \$19307 \$25462 \$25632
+ gf180mcu_fd_sc_mcu9t5v0__dffrnq_2
X$8776 \$26394 \$25907 \$25908 \$19307 \$25797 \$25918
+ gf180mcu_fd_sc_mcu9t5v0__dffrnq_2
X$8777 \$28927 \$29116 \$28960 \$19307 \$29123 \$29270
+ gf180mcu_fd_sc_mcu9t5v0__dffrnq_2
X$8778 \$26394 \$27307 \$27308 \$19307 \$27315 \$27449
+ gf180mcu_fd_sc_mcu9t5v0__dffrnq_2
X$8779 \$28080 \$28035 \$27900 \$19307 \$27913 \$28089
+ gf180mcu_fd_sc_mcu9t5v0__dffrnq_2
X$8780 \$23915 \$27306 \$27436 \$19307 \$27315 \$27449
+ gf180mcu_fd_sc_mcu9t5v0__dffrnq_2
X$8781 \$28080 \$28324 \$28325 \$19307 \$28211 \$28381
+ gf180mcu_fd_sc_mcu9t5v0__dffrnq_2
X$8782 \$27905 \$27902 \$28037 \$19307 \$27913 \$28089
+ gf180mcu_fd_sc_mcu9t5v0__dffrnq_2
X$8783 \$21791 \$22701 \$22425 \$19307 \$22713 \$22837
+ gf180mcu_fd_sc_mcu9t5v0__dffrnq_2
X$8784 \$23915 \$24707 \$24519 \$19307 \$24593 \$24721
+ gf180mcu_fd_sc_mcu9t5v0__dffrnq_2
X$8785 \$23915 \$24872 \$24873 \$19307 \$24877 \$24997
+ gf180mcu_fd_sc_mcu9t5v0__dffrnq_2
X$8786 \$23915 \$24217 \$24280 \$19307 \$24231 \$24428
+ gf180mcu_fd_sc_mcu9t5v0__dffrnq_2
X$8787 \$31231 \$32980 \$32981 \$19307 \$32992 \$33062
+ gf180mcu_fd_sc_mcu9t5v0__dffrnq_2
X$8788 \$23308 \$23313 \$23311 \$19307 \$23183 \$23454
+ gf180mcu_fd_sc_mcu9t5v0__dffrnq_2
X$8789 \$31231 \$32405 \$32228 \$19307 \$32543 \$32629
+ gf180mcu_fd_sc_mcu9t5v0__dffrnq_2
X$8790 \$31231 \$33070 \$31966 \$19307 \$33071 \$33184
+ gf180mcu_fd_sc_mcu9t5v0__dffrnq_2
X$8791 \$29235 \$32402 \$32244 \$19307 \$32339 \$32467
+ gf180mcu_fd_sc_mcu9t5v0__dffrnq_2
X$8792 \$31231 \$32779 \$32627 \$19307 \$32853 \$32934
+ gf180mcu_fd_sc_mcu9t5v0__dffrnq_2
X$8793 \$27905 \$28039 \$28084 \$19307 \$27913 \$28089
+ gf180mcu_fd_sc_mcu9t5v0__dffrnq_2
X$8794 \$27905 \$28524 \$28523 \$19307 \$28534 \$28689
+ gf180mcu_fd_sc_mcu9t5v0__dffrnq_2
X$8795 \$26394 \$26079 \$25964 \$19307 \$26088 \$26220
+ gf180mcu_fd_sc_mcu9t5v0__dffrnq_2
X$8796 \$26394 \$25456 \$25344 \$19307 \$25462 \$25632
+ gf180mcu_fd_sc_mcu9t5v0__dffrnq_2
X$8797 \$23915 \$26393 \$25960 \$19307 \$26401 \$26521
+ gf180mcu_fd_sc_mcu9t5v0__dffrnq_2
X$8798 \$26394 \$26637 \$26395 \$19307 \$26401 \$26521
+ gf180mcu_fd_sc_mcu9t5v0__dffrnq_2
X$8799 \$26394 \$26342 \$26343 \$19307 \$26401 \$26521
+ gf180mcu_fd_sc_mcu9t5v0__dffrnq_2
X$8800 \$26394 \$26508 \$26345 \$19307 \$26401 \$26521
+ gf180mcu_fd_sc_mcu9t5v0__dffrnq_2
X$8801 \$23915 \$26340 \$26341 \$19307 \$26401 \$26521
+ gf180mcu_fd_sc_mcu9t5v0__dffrnq_2
X$8802 \$31231 \$32145 \$31932 \$19307 \$32100 \$32171
+ gf180mcu_fd_sc_mcu9t5v0__dffrnq_2
X$8803 \$23308 \$23171 \$23170 \$19307 \$23183 \$23454
+ gf180mcu_fd_sc_mcu9t5v0__dffrnq_2
X$8804 \$21791 \$22378 \$22263 \$19307 \$22387 \$22440
+ gf180mcu_fd_sc_mcu9t5v0__dffrnq_2
X$8805 \$29235 \$30843 \$30184 \$19307 \$30819 \$30900
+ gf180mcu_fd_sc_mcu9t5v0__dffrnq_2
X$8806 \$31381 \$31254 \$30163 \$19307 \$31232 \$31310
+ gf180mcu_fd_sc_mcu9t5v0__dffrnq_2
X$8807 \$29235 \$30309 \$29924 \$19307 \$30251 \$30339
+ gf180mcu_fd_sc_mcu9t5v0__dffrnq_2
X$8808 \$29235 \$30608 \$28813 \$19307 \$30564 \$30625
+ gf180mcu_fd_sc_mcu9t5v0__dffrnq_2
X$8809 \$27005 \$28207 \$28044 \$19307 \$28211 \$28381
+ gf180mcu_fd_sc_mcu9t5v0__dffrnq_2
X$8810 \$28212 \$29921 \$29848 \$19307 \$29780 \$29847
+ gf180mcu_fd_sc_mcu9t5v0__dffrnq_2
X$8811 \$25799 \$29238 \$28487 \$19307 \$29123 \$29270
+ gf180mcu_fd_sc_mcu9t5v0__dffrnq_2
X$8812 \$29235 \$29081 \$27573 \$19307 \$29123 \$29270
+ gf180mcu_fd_sc_mcu9t5v0__dffrnq_2
X$8813 \$28212 \$30311 \$30237 \$19307 \$30251 \$30339
+ gf180mcu_fd_sc_mcu9t5v0__dffrnq_2
X$8814 \$28212 \$30342 \$30343 \$19307 \$30402 \$30485
+ gf180mcu_fd_sc_mcu9t5v0__dffrnq_2
X$8815 \$28554 \$30957 \$30470 \$19307 \$30971 \$31032
+ gf180mcu_fd_sc_mcu9t5v0__dffrnq_2
X$8816 \$29235 \$30607 \$30468 \$19307 \$30564 \$30625
+ gf180mcu_fd_sc_mcu9t5v0__dffrnq_2
X$8817 \$31381 \$31824 \$31519 \$19307 \$31810 \$31886
+ gf180mcu_fd_sc_mcu9t5v0__dffrnq_2
X$8818 \$31381 \$31610 \$31743 \$19307 \$31607 \$31733
+ gf180mcu_fd_sc_mcu9t5v0__dffrnq_2
X$8819 \$31381 \$31609 \$31321 \$19307 \$31607 \$31733
+ gf180mcu_fd_sc_mcu9t5v0__dffrnq_2
X$8820 \$31231 \$31969 \$32085 \$19307 \$31967 \$32034
+ gf180mcu_fd_sc_mcu9t5v0__dffrnq_2
X$8821 \$31231 \$31537 \$31233 \$19307 \$31535 \$31584
+ gf180mcu_fd_sc_mcu9t5v0__dffrnq_2
X$8822 \$28212 \$30471 \$30543 \$19307 \$30402 \$30485
+ gf180mcu_fd_sc_mcu9t5v0__dffrnq_2
X$8823 \$31381 \$30959 \$30902 \$19307 \$30971 \$31032
+ gf180mcu_fd_sc_mcu9t5v0__dffrnq_2
X$8824 \$29235 \$30970 \$31013 \$19307 \$30971 \$31032
+ gf180mcu_fd_sc_mcu9t5v0__dffrnq_2
X$8825 \$28212 \$30310 \$29849 \$19307 \$30251 \$30339
+ gf180mcu_fd_sc_mcu9t5v0__dffrnq_2
X$8826 \$31231 \$31946 \$31405 \$19307 \$31967 \$32034
+ gf180mcu_fd_sc_mcu9t5v0__dffrnq_2
X$8827 \$27005 \$28043 \$27908 \$19307 \$27913 \$28089
+ gf180mcu_fd_sc_mcu9t5v0__dffrnq_2
X$8828 \$31089 \$31951 \$31876 \$19307 \$31967 \$32034
+ gf180mcu_fd_sc_mcu9t5v0__dffrnq_2
X$8829 \$27005 \$27630 \$27632 \$19307 \$27637 \$27776
+ gf180mcu_fd_sc_mcu9t5v0__dffrnq_2
X$8830 \$27005 \$27007 \$26967 \$19307 \$27015 \$27153
+ gf180mcu_fd_sc_mcu9t5v0__dffrnq_2
X$8831 \$27905 \$28526 \$28329 \$19307 \$28534 \$28689
+ gf180mcu_fd_sc_mcu9t5v0__dffrnq_2
X$8832 \$27905 \$29230 \$29262 \$19307 \$29123 \$29270
+ gf180mcu_fd_sc_mcu9t5v0__dffrnq_2
X$8833 \$27905 \$29229 \$27626 \$19307 \$29123 \$29270
+ gf180mcu_fd_sc_mcu9t5v0__dffrnq_2
X$8834 \$28212 \$29845 \$29628 \$19307 \$29780 \$29847
+ gf180mcu_fd_sc_mcu9t5v0__dffrnq_2
X$8835 \$27005 \$27006 \$27149 \$19307 \$27015 \$27153
+ gf180mcu_fd_sc_mcu9t5v0__dffrnq_2
X$8836 \$27005 \$27629 \$27768 \$19307 \$27637 \$27776
+ gf180mcu_fd_sc_mcu9t5v0__dffrnq_2
X$8837 \$27005 \$29231 \$29232 \$19307 \$29123 \$29270
+ gf180mcu_fd_sc_mcu9t5v0__dffrnq_2
X$8838 \$27005 \$28929 \$28930 \$19307 \$28810 \$28971
+ gf180mcu_fd_sc_mcu9t5v0__dffrnq_2
X$8839 \$23615 \$24987 \$24988 \$19307 \$24877 \$24997
+ gf180mcu_fd_sc_mcu9t5v0__dffrnq_2
X$8840 \$23615 \$25459 \$25624 \$19307 \$25462 \$25632
+ gf180mcu_fd_sc_mcu9t5v0__dffrnq_2
X$8841 \$23615 \$26509 \$26510 \$19307 \$26401 \$26521
+ gf180mcu_fd_sc_mcu9t5v0__dffrnq_2
X$8842 \$21791 \$20998 \$21002 \$19307 \$21184 \$21308
+ gf180mcu_fd_sc_mcu9t5v0__dffrnq_2
X$8843 \$21791 \$20195 \$20197 \$19307 \$20515 \$20718
+ gf180mcu_fd_sc_mcu9t5v0__dffrnq_2
X$8844 \$21791 \$21792 \$22376 \$19307 \$21661 \$21946
+ gf180mcu_fd_sc_mcu9t5v0__dffrnq_2
X$8845 \$21791 \$20555 \$20556 \$19307 \$20515 \$20718
+ gf180mcu_fd_sc_mcu9t5v0__dffrnq_2
X$8846 \$23615 \$25580 \$25457 \$19307 \$25462 \$25632
+ gf180mcu_fd_sc_mcu9t5v0__dffrnq_2
X$8847 \$23615 \$24985 \$21796 \$19307 \$24877 \$24997
+ gf180mcu_fd_sc_mcu9t5v0__dffrnq_2
X$8848 \$23615 \$23177 \$23178 \$19307 \$23183 \$23454
+ gf180mcu_fd_sc_mcu9t5v0__dffrnq_2
X$8849 \$23615 \$24287 \$24223 \$19307 \$24231 \$24428
+ gf180mcu_fd_sc_mcu9t5v0__dffrnq_2
X$8850 \$23615 \$23753 \$23584 \$19307 \$23620 \$23807
+ gf180mcu_fd_sc_mcu9t5v0__dffrnq_2
X$8851 \$28554 \$30751 \$30820 \$19307 \$30696 \$30763
+ gf180mcu_fd_sc_mcu9t5v0__dffrnq_2
X$8852 \$23615 \$24222 \$24286 \$19307 \$24231 \$24109
+ gf180mcu_fd_sc_mcu9t5v0__dffrnq_2
X$8853 \$23615 \$24714 \$24716 \$19307 \$24877 \$24721
+ gf180mcu_fd_sc_mcu9t5v0__dffrnq_2
X$8854 \$31231 \$32911 \$32519 \$19307 \$32992 \$32934
+ gf180mcu_fd_sc_mcu9t5v0__dffrnq_2
X$8855 \$23615 \$25039 \$25040 \$19307 \$25191 \$24997
+ gf180mcu_fd_sc_mcu9t5v0__dffrnq_2
X$8856 \$27005 \$28375 \$28333 \$19307 \$28534 \$28381
+ gf180mcu_fd_sc_mcu9t5v0__dffrnq_2
X$8857 \$27005 \$28964 \$28332 \$19307 \$29123 \$28971
+ gf180mcu_fd_sc_mcu9t5v0__dffrnq_2
X$8858 \$27905 \$29263 \$29264 \$19307 \$29290 \$29270
+ gf180mcu_fd_sc_mcu9t5v0__dffrnq_2
X$8859 \$31231 \$32767 \$31516 \$19307 \$32853 \$32765
+ gf180mcu_fd_sc_mcu9t5v0__dffrnq_2
X$8860 \$23615 \$26208 \$26209 \$19307 \$26401 \$26220
+ gf180mcu_fd_sc_mcu9t5v0__dffrnq_2
X$8861 \$23615 \$25739 \$24844 \$19307 \$25797 \$25632
+ gf180mcu_fd_sc_mcu9t5v0__dffrnq_2
X$8862 \$27005 \$28376 \$25749 \$19307 \$28534 \$28381
+ gf180mcu_fd_sc_mcu9t5v0__dffrnq_2
X$8863 \$27905 \$29077 \$29261 \$19307 \$29123 \$28971
+ gf180mcu_fd_sc_mcu9t5v0__dffrnq_2
X$8864 \$31381 \$32018 \$31320 \$19307 \$32100 \$32034
+ gf180mcu_fd_sc_mcu9t5v0__dffrnq_2
X$8865 \$23615 \$26396 \$26397 \$19307 \$26401 \$26220
+ gf180mcu_fd_sc_mcu9t5v0__dffrnq_2
X$8866 \$31231 \$32719 \$32697 \$19307 \$32853 \$32765
+ gf180mcu_fd_sc_mcu9t5v0__dffrnq_2
X$8867 \$31231 \$33072 \$31606 \$19307 \$33071 \$33062
+ gf180mcu_fd_sc_mcu9t5v0__dffrnq_2
X$8868 \$23615 \$25628 \$25581 \$19307 \$25797 \$25632
+ gf180mcu_fd_sc_mcu9t5v0__dffrnq_2
X$8869 \$27905 \$28373 \$28328 \$19307 \$28534 \$28381
+ gf180mcu_fd_sc_mcu9t5v0__dffrnq_2
X$8870 \$27005 \$26966 \$26847 \$19307 \$27015 \$26856
+ gf180mcu_fd_sc_mcu9t5v0__dffrnq_2
X$8871 \$27905 \$28374 \$28331 \$19307 \$28534 \$28381
+ gf180mcu_fd_sc_mcu9t5v0__dffrnq_2
X$8872 \$27905 \$28963 \$28330 \$19307 \$29123 \$28971
+ gf180mcu_fd_sc_mcu9t5v0__dffrnq_2
X$8873 \$23615 \$25740 \$25796 \$19307 \$25797 \$25632
+ gf180mcu_fd_sc_mcu9t5v0__dffrnq_2
X$8874 \$31231 \$33068 \$32172 \$19307 \$33071 \$33062
+ gf180mcu_fd_sc_mcu9t5v0__dffrnq_2
X$8875 \$23615 \$26348 \$26344 \$19307 \$26401 \$26220
+ gf180mcu_fd_sc_mcu9t5v0__dffrnq_2
X$8876 \$27905 \$27767 \$27625 \$19307 \$27913 \$27776
+ gf180mcu_fd_sc_mcu9t5v0__dffrnq_2
X$8877 \$26394 \$26846 \$26787 \$19307 \$27015 \$26856
+ gf180mcu_fd_sc_mcu9t5v0__dffrnq_2
X$8878 \$26394 \$27274 \$27148 \$19307 \$27315 \$27153
+ gf180mcu_fd_sc_mcu9t5v0__dffrnq_2
X$8879 \$27905 \$27906 \$28041 \$19307 \$27913 \$27776
+ gf180mcu_fd_sc_mcu9t5v0__dffrnq_2
X$8880 \$27005 \$27441 \$25302 \$19307 \$27637 \$27449
+ gf180mcu_fd_sc_mcu9t5v0__dffrnq_2
X$8881 \$23615 \$24100 \$24102 \$19307 \$24231 \$24109
+ gf180mcu_fd_sc_mcu9t5v0__dffrnq_2
X$8882 \$23615 \$24712 \$24874 \$19307 \$24877 \$24721
+ gf180mcu_fd_sc_mcu9t5v0__dffrnq_2
X$8883 \$26394 \$27147 \$26786 \$19307 \$27315 \$27153
+ gf180mcu_fd_sc_mcu9t5v0__dffrnq_2
X$8884 \$27905 \$27765 \$27766 \$19307 \$27913 \$27776
+ gf180mcu_fd_sc_mcu9t5v0__dffrnq_2
X$8885 \$27005 \$26850 \$26513 \$19307 \$27015 \$26856
+ gf180mcu_fd_sc_mcu9t5v0__dffrnq_2
X$8886 \$27005 \$27276 \$27566 \$19307 \$27913 \$27776
+ gf180mcu_fd_sc_mcu9t5v0__dffrnq_2
X$8887 \$29235 \$29268 \$26674 \$19307 \$29290 \$29270
+ gf180mcu_fd_sc_mcu9t5v0__dffrnq_2
X$8888 \$28212 \$29126 \$28535 \$19307 \$29290 \$29270
+ gf180mcu_fd_sc_mcu9t5v0__dffrnq_2
X$8889 \$23915 \$25450 \$25579 \$19307 \$25462 \$25347
+ gf180mcu_fd_sc_mcu9t5v0__dffrnq_2
X$8890 \$31231 \$31608 \$30469 \$19307 \$31607 \$31584
+ gf180mcu_fd_sc_mcu9t5v0__dffrnq_2
X$8891 \$31381 \$31589 \$31520 \$19307 \$31607 \$31584
+ gf180mcu_fd_sc_mcu9t5v0__dffrnq_2
X$8892 \$31381 \$31591 \$31035 \$19307 \$31607 \$31584
+ gf180mcu_fd_sc_mcu9t5v0__dffrnq_2
X$8893 \$23915 \$25034 \$25295 \$19307 \$25191 \$24997
+ gf180mcu_fd_sc_mcu9t5v0__dffrnq_2
X$8894 \$31381 \$31950 \$31933 \$19307 \$31967 \$31886
+ gf180mcu_fd_sc_mcu9t5v0__dffrnq_2
X$8895 \$23915 \$25961 \$26078 \$19307 \$26088 \$25918
+ gf180mcu_fd_sc_mcu9t5v0__dffrnq_2
X$8896 \$31381 \$31949 \$32089 \$19307 \$31967 \$31886
+ gf180mcu_fd_sc_mcu9t5v0__dffrnq_2
X$8897 \$31231 \$31176 \$31250 \$19307 \$31232 \$31175
+ gf180mcu_fd_sc_mcu9t5v0__dffrnq_2
X$8898 \$31231 \$31311 \$31515 \$19307 \$31535 \$31465
+ gf180mcu_fd_sc_mcu9t5v0__dffrnq_2
X$8899 \$29235 \$30764 \$30679 \$19307 \$30819 \$30763
+ gf180mcu_fd_sc_mcu9t5v0__dffrnq_2
X$8900 \$23915 \$25732 \$25734 \$19307 \$26088 \$25918
+ gf180mcu_fd_sc_mcu9t5v0__dffrnq_2
X$8901 \$23308 \$23442 \$23310 \$19307 \$23620 \$23454
+ gf180mcu_fd_sc_mcu9t5v0__dffrnq_2
X$8902 \$21791 \$22816 \$22882 \$19307 \$23027 \$22837
+ gf180mcu_fd_sc_mcu9t5v0__dffrnq_2
X$8903 \$31381 \$31948 \$31524 \$19307 \$31967 \$31886
+ gf180mcu_fd_sc_mcu9t5v0__dffrnq_2
X$8904 \$31231 \$31739 \$31518 \$19307 \$31810 \$31733
+ gf180mcu_fd_sc_mcu9t5v0__dffrnq_2
X$8905 \$21791 \$22883 \$22264 \$19307 \$23027 \$22837
+ gf180mcu_fd_sc_mcu9t5v0__dffrnq_2
X$8906 \$26394 \$27438 \$27439 \$19307 \$27637 \$27449
+ gf180mcu_fd_sc_mcu9t5v0__dffrnq_2
X$8907 \$29235 \$30954 \$30901 \$19307 \$30971 \$30900
+ gf180mcu_fd_sc_mcu9t5v0__dffrnq_2
X$8908 \$21791 \$22374 \$22375 \$19307 \$22387 \$22272
+ gf180mcu_fd_sc_mcu9t5v0__dffrnq_2
X$8909 \$28212 \$30626 \$29632 \$19307 \$30696 \$30625
+ gf180mcu_fd_sc_mcu9t5v0__dffrnq_2
X$8910 \$23915 \$23794 \$23747 \$19307 \$23926 \$23807
+ gf180mcu_fd_sc_mcu9t5v0__dffrnq_2
X$8911 \$28080 \$28082 \$28033 \$19307 \$28211 \$28089
+ gf180mcu_fd_sc_mcu9t5v0__dffrnq_2
X$8912 \$28080 \$28807 \$28681 \$19307 \$28810 \$28689
+ gf180mcu_fd_sc_mcu9t5v0__dffrnq_2
X$8913 \$28927 \$28679 \$28680 \$19307 \$28810 \$28689
+ gf180mcu_fd_sc_mcu9t5v0__dffrnq_2
X$8914 \$31231 \$31177 \$30486 \$19307 \$31232 \$31175
+ gf180mcu_fd_sc_mcu9t5v0__dffrnq_2
X$8915 \$31231 \$31811 \$31404 \$19307 \$31810 \$31733
+ gf180mcu_fd_sc_mcu9t5v0__dffrnq_2
X$8916 \$23308 \$24983 \$24984 \$19307 \$25191 \$24997
+ gf180mcu_fd_sc_mcu9t5v0__dffrnq_2
X$8917 \$23308 \$24284 \$24218 \$19307 \$24593 \$24428
+ gf180mcu_fd_sc_mcu9t5v0__dffrnq_2
X$8918 \$21791 \$21609 \$21137 \$19307 \$21661 \$21622
+ gf180mcu_fd_sc_mcu9t5v0__dffrnq_2
X$8919 \$21791 \$21933 \$22064 \$19307 \$22074 \$21946
+ gf180mcu_fd_sc_mcu9t5v0__dffrnq_2
X$8920 \$28212 \$28690 \$23757 \$19307 \$29123 \$28971
+ gf180mcu_fd_sc_mcu9t5v0__dffrnq_2
X$8921 \$23308 \$23800 \$23801 \$19307 \$23926 \$23807
+ gf180mcu_fd_sc_mcu9t5v0__dffrnq_2
X$8922 \$28212 \$29291 \$29078 \$19307 \$29290 \$29270
+ gf180mcu_fd_sc_mcu9t5v0__dffrnq_2
X$8923 \$23308 \$22886 \$23020 \$19307 \$23027 \$22837
+ gf180mcu_fd_sc_mcu9t5v0__dffrnq_2
X$8924 \$23308 \$23174 \$23175 \$19307 \$23183 \$23139
+ gf180mcu_fd_sc_mcu9t5v0__dffrnq_2
X$8925 \$27905 \$27903 \$27904 \$19307 \$27913 \$27776
+ gf180mcu_fd_sc_mcu9t5v0__dffrnq_2
X$8926 \$28212 \$28972 \$28811 \$19307 \$29123 \$28971
+ gf180mcu_fd_sc_mcu9t5v0__dffrnq_2
X$8927 \$26394 \$26844 \$26785 \$19307 \$27015 \$26856
+ gf180mcu_fd_sc_mcu9t5v0__dffrnq_2
X$8928 \$27905 \$28371 \$28480 \$19307 \$28534 \$28381
+ gf180mcu_fd_sc_mcu9t5v0__dffrnq_2
X$8929 \$28212 \$30053 \$29691 \$19307 \$30054 \$30027
+ gf180mcu_fd_sc_mcu9t5v0__dffrnq_2
X$8930 \$27905 \$28961 \$28519 \$19307 \$29123 \$28971
+ gf180mcu_fd_sc_mcu9t5v0__dffrnq_2
X$8931 \$27905 \$28683 \$28684 \$19307 \$28810 \$28689
+ gf180mcu_fd_sc_mcu9t5v0__dffrnq_2
X$8932 \$27905 \$28083 \$28038 \$19307 \$28211 \$28089
+ gf180mcu_fd_sc_mcu9t5v0__dffrnq_2
X$8933 \$28080 \$29074 \$28682 \$19307 \$29123 \$28971
+ gf180mcu_fd_sc_mcu9t5v0__dffrnq_2
X$8934 \$23915 \$26842 \$26843 \$19307 \$27015 \$26856
+ gf180mcu_fd_sc_mcu9t5v0__dffrnq_2
X$8935 \$23915 \$26841 \$26784 \$19307 \$27015 \$26856
+ gf180mcu_fd_sc_mcu9t5v0__dffrnq_2
X$8936 \$23915 \$27562 \$27437 \$19307 \$27637 \$27449
+ gf180mcu_fd_sc_mcu9t5v0__dffrnq_2
X$8937 \$28212 \$29127 \$28542 \$19307 \$29123 \$28971
+ gf180mcu_fd_sc_mcu9t5v0__dffrnq_2
X$8938 \$28927 \$29259 \$29072 \$19307 \$29290 \$29270
+ gf180mcu_fd_sc_mcu9t5v0__dffrnq_2
X$8939 \$26394 \$26670 \$26638 \$19307 \$27015 \$26856
+ gf180mcu_fd_sc_mcu9t5v0__dffrnq_2
X$8940 \$27905 \$29260 \$28962 \$19307 \$29290 \$29270
+ gf180mcu_fd_sc_mcu9t5v0__dffrnq_2
X$8941 \$26394 \$26845 \$26346 \$19307 \$27015 \$26856
+ gf180mcu_fd_sc_mcu9t5v0__dffrnq_2
X$8942 \$29235 \$30183 \$28540 \$19307 \$30251 \$30185
+ gf180mcu_fd_sc_mcu9t5v0__dffrnq_2
X$8943 \$28080 \$28081 \$28031 \$19307 \$28211 \$28089
+ gf180mcu_fd_sc_mcu9t5v0__dffrnq_2
X$8944 \$26394 \$26507 \$26635 \$19307 \$26675 \$26521
+ gf180mcu_fd_sc_mcu9t5v0__dffrnq_2
X$8945 \$27905 \$28521 \$28520 \$19307 \$28534 \$28381
+ gf180mcu_fd_sc_mcu9t5v0__dffrnq_2
X$8946 \$19307 \$27440 \$29123 \$29270 \$29118 gf180mcu_fd_sc_mcu9t5v0__nand2_4
X$8947 \$19307 \$27440 \$29290 \$29270 \$29289 gf180mcu_fd_sc_mcu9t5v0__nand2_4
X$8948 \$19309 \$19452 \$19324 \$19466 \$20033 gf180mcu_fd_sc_mcu9t5v0__nand2_1
X$8949 \$19453 \$19589 \$19310 \$19452 \$19605 \$19466 \$19588
+ gf180mcu_fd_sc_mcu9t5v0__nand4_1
X$8950 \$19316 \$19460 \$19324 \$19466 \$19312 gf180mcu_fd_sc_mcu9t5v0__nand2_1
X$8951 \$19457 \$19316 \$19324 \$19466 \$19314 gf180mcu_fd_sc_mcu9t5v0__nor2_1
X$8952 \$19317 \$19458 \$19324 \$19466 \$19315 gf180mcu_fd_sc_mcu9t5v0__nand2_1
X$8953 \$19728 \$19727 \$19316 \$19605 \$19774 \$19317
+ gf180mcu_fd_sc_mcu9t5v0__oai21_1
X$8954 \$19457 \$19318 \$19324 \$19466 \$19458 gf180mcu_fd_sc_mcu9t5v0__nand2_1
X$8955 \$23587 \$23802 \$19320 \$24593 \$24721 \$24719
+ gf180mcu_fd_sc_mcu9t5v0__nor3_1
X$8956 \$23587 \$19320 \$24877 \$24721 \$24875 gf180mcu_fd_sc_mcu9t5v0__nor2_1
X$8957 \$19320 \$24877 \$24721 \$24846 gf180mcu_fd_sc_mcu9t5v0__clkinv_1
X$8958 \$19322 \$19605 \$19774 \$19730 gf180mcu_fd_sc_mcu9t5v0__buf_8
X$8959 \$19351 \$19324 \$19466 \$19349 gf180mcu_fd_sc_mcu9t5v0__clkinv_1
X$8960 \$19488 \$19324 \$19466 \$19489 gf180mcu_fd_sc_mcu9t5v0__clkinv_1
X$8961 \$19636 \$19500 \$19324 \$19466 \$19364 gf180mcu_fd_sc_mcu9t5v0__nand2_1
X$8962 \$19344 \$19343 \$19324 \$19466 \$19342 gf180mcu_fd_sc_mcu9t5v0__nand2_1
X$8963 \$19757 \$19484 \$19737 \$19324 \$19466 \$19483
+ gf180mcu_fd_sc_mcu9t5v0__mux2_1
X$8964 \$19466 \$19324 gf180mcu_fd_sc_mcu9t5v0__filltie
X$8965 \$19466 \$19324 gf180mcu_fd_sc_mcu9t5v0__filltie
X$8966 \$19466 \$19324 gf180mcu_fd_sc_mcu9t5v0__filltie
X$8967 \$19466 \$19324 gf180mcu_fd_sc_mcu9t5v0__filltie
X$8968 \$19466 \$19324 gf180mcu_fd_sc_mcu9t5v0__filltie
X$8969 \$19466 \$19324 gf180mcu_fd_sc_mcu9t5v0__filltie
X$8970 \$19466 \$19324 gf180mcu_fd_sc_mcu9t5v0__endcap
X$8971 \$19775 \$19468 \$19328 \$19605 \$19466 gf180mcu_fd_sc_mcu9t5v0__dffq_2
X$8972 \$21028 \$21190 \$21384 \$21498 \$21308 \$19341
+ gf180mcu_fd_sc_mcu9t5v0__aoi21_1
X$8973 \$19615 \$19480 \$19605 \$19466 \$19344 gf180mcu_fd_sc_mcu9t5v0__nand2_1
X$8974 \$19905 \$19927 \$20087 \$19351 \$19907 gf180mcu_fd_sc_mcu9t5v0__xor2_1
X$8975 \$19351 \$21171 \$20528 \$20515 \$20383 \$20360
+ gf180mcu_fd_sc_mcu9t5v0__mux2_1
X$8976 \$20543 \$20544 \$20606 \$20515 \$20718 \$19352
+ gf180mcu_fd_sc_mcu9t5v0__aoi21_1
X$8977 \$19622 \$19487 \$19605 \$19466 \$19357 gf180mcu_fd_sc_mcu9t5v0__nand2_1
X$8978 \$20611 \$20612 \$20613 \$20610 \$20515 \$20718 \$19358
+ gf180mcu_fd_sc_mcu9t5v0__oai31_1
X$8979 \$19487 \$19358 \$19605 \$19774 \$19623 gf180mcu_fd_sc_mcu9t5v0__nand2_1
X$8980 \$19628 \$19629 \$19359 \$19605 \$19774 \$19360
+ gf180mcu_fd_sc_mcu9t5v0__nor3_1
X$8981 \$19628 \$19629 \$19359 \$19605 \$19466 \$19493
+ gf180mcu_fd_sc_mcu9t5v0__and3_1
X$8982 \$20365 \$20070 \$20421 \$20209 \$20383 \$19359
+ gf180mcu_fd_sc_mcu9t5v0__aoi21_1
X$8983 \$19915 \$19914 \$19916 \$19927 \$19774 \$19362
+ gf180mcu_fd_sc_mcu9t5v0__oai21_1
X$8984 \$19915 \$19914 \$19927 \$19774 \$19363 gf180mcu_fd_sc_mcu9t5v0__nand2_1
X$8985 \$19450 \$20031 \$20323 \$20209 \$20383 \$20194
+ gf180mcu_fd_sc_mcu9t5v0__oai21_1
X$8986 \$20074 \$19450 \$20196 \$20209 \$20087 \$20195
+ gf180mcu_fd_sc_mcu9t5v0__oai21_1
X$8987 \$19453 \$19450 \$19590 \$19927 \$19774 \$19721
+ gf180mcu_fd_sc_mcu9t5v0__oai21_1
X$8988 \$21135 \$19455 \$20881 \$20718 \$20825 gf180mcu_fd_sc_mcu9t5v0__nand2_1
X$8989 \$19455 \$20823 \$20865 \$20881 \$20718 \$20705
+ gf180mcu_fd_sc_mcu9t5v0__mux2_1
X$8990 \$19457 \$26080 \$26088 \$26220 \$25299 gf180mcu_fd_sc_mcu9t5v0__and2_1
X$8991 \$22065 \$19457 \$21796 \$23620 \$23807 \$23582
+ gf180mcu_fd_sc_mcu9t5v0__nor3_1
X$8992 \$26344 \$26671 \$19457 \$26401 \$26220 \$25737
+ gf180mcu_fd_sc_mcu9t5v0__aoi21_1
X$8993 \$19457 \$25041 \$24986 \$22065 \$25191 \$24997 \$25042
+ gf180mcu_fd_sc_mcu9t5v0__aoi211_1
X$8994 \$22065 \$19457 \$21796 \$21795 \$22074 \$21946 \$21004
+ gf180mcu_fd_sc_mcu9t5v0__oai31_1
X$8995 \$19457 \$24587 \$24877 \$24997 \$24986 gf180mcu_fd_sc_mcu9t5v0__nor2_1
X$8996 \$19458 \$19605 \$19466 \$19459 gf180mcu_fd_sc_mcu9t5v0__clkinv_1
X$8997 \$19728 \$19727 \$19605 \$19774 \$19460 gf180mcu_fd_sc_mcu9t5v0__nor2_1
X$8998 \$19460 \$19461 \$19605 \$19466 \$19595 gf180mcu_fd_sc_mcu9t5v0__nor2_1
X$8999 \$22268 \$23320 \$23444 \$23183 \$23454 \$19463
+ gf180mcu_fd_sc_mcu9t5v0__aoi21_1
X$9000 \$19636 \$19500 \$19605 \$19466 \$19501 gf180mcu_fd_sc_mcu9t5v0__or2_1
X$9001 \$19632 \$19633 \$19498 \$19605 \$19466 \$19497
+ gf180mcu_fd_sc_mcu9t5v0__and3_1
X$9002 \$19469 \$19608 \$19470 \$19605 \$19466 \$19609
+ gf180mcu_fd_sc_mcu9t5v0__oai21_1
X$9003 \$19488 \$19622 \$19623 \$19605 \$19466 \$19624
+ gf180mcu_fd_sc_mcu9t5v0__nand3_1
X$9004 \$19495 \$19605 \$19466 \$19631 gf180mcu_fd_sc_mcu9t5v0__clkinv_1
X$9005 \$19622 \$19605 \$19466 \$19625 gf180mcu_fd_sc_mcu9t5v0__clkinv_1
X$9006 \$19491 \$19605 \$19466 \$19629 gf180mcu_fd_sc_mcu9t5v0__clkinv_1
X$9007 \$19634 \$19633 \$19605 \$19466 \$19635 gf180mcu_fd_sc_mcu9t5v0__nand2_1
X$9008 \$19766 \$19501 \$19605 \$19466 \$19502 gf180mcu_fd_sc_mcu9t5v0__nand2_1
X$9009 \$19466 \$19605 gf180mcu_fd_sc_mcu9t5v0__filltie
X$9010 \$19466 \$19605 gf180mcu_fd_sc_mcu9t5v0__filltie
X$9011 \$19466 \$19605 gf180mcu_fd_sc_mcu9t5v0__filltie
X$9012 \$19466 \$19605 gf180mcu_fd_sc_mcu9t5v0__filltie
X$9013 \$19466 \$19605 gf180mcu_fd_sc_mcu9t5v0__filltie
X$9014 \$19466 \$19605 gf180mcu_fd_sc_mcu9t5v0__filltie
X$9015 \$19466 \$19605 gf180mcu_fd_sc_mcu9t5v0__endcap
X$9016 \$19469 \$19608 \$19885 \$19599 \$19927 \$19774 \$19777
+ gf180mcu_fd_sc_mcu9t5v0__oai31_1
X$9017 \$19469 \$26408 \$27452 \$26401 \$26521 \$26363
+ gf180mcu_fd_sc_mcu9t5v0__nand3_1
X$9018 \$19469 \$28341 \$28211 \$28381 \$26980 gf180mcu_fd_sc_mcu9t5v0__nor2_1
X$9019 \$19469 \$26408 \$26675 \$26856 \$26805 gf180mcu_fd_sc_mcu9t5v0__nand2_1
X$9020 \$19469 \$19886 \$27637 \$27449 \$27581 gf180mcu_fd_sc_mcu9t5v0__nand2_1
X$9021 \$19469 \$27452 \$27913 \$27776 \$27784 gf180mcu_fd_sc_mcu9t5v0__nand2_1
X$9022 \$28340 \$28211 \$28381 \$19469 gf180mcu_fd_sc_mcu9t5v0__buf_8
X$9023 \$19470 \$19605 \$19774 \$19885 gf180mcu_fd_sc_mcu9t5v0__clkinv_1
X$9024 \$19472 \$19737 \$19927 \$20087 \$20397 gf180mcu_fd_sc_mcu9t5v0__nand2_1
X$9025 \$21507 \$21316 \$21184 \$21308 \$19475 \$21188
+ gf180mcu_fd_sc_mcu9t5v0__xnor3_1
X$9026 \$20729 \$20847 \$20848 \$20881 \$20718 \$19476
+ gf180mcu_fd_sc_mcu9t5v0__oai21_1
X$9027 \$19749 \$23314 \$19735 \$19605 \$19774 \$19479
+ gf180mcu_fd_sc_mcu9t5v0__mux2_1
X$9028 \$20535 \$21162 \$20528 \$20881 \$20718 \$19480
+ gf180mcu_fd_sc_mcu9t5v0__mux2_1
X$9029 \$20106 \$19913 \$19927 \$19774 \$19487 gf180mcu_fd_sc_mcu9t5v0__or2_1
X$9030 \$19626 \$19627 \$19605 \$19774 \$19488 gf180mcu_fd_sc_mcu9t5v0__xnor2_1
X$9031 \$19915 \$19916 \$19927 \$20087 \$19914 \$19494
+ gf180mcu_fd_sc_mcu9t5v0__xor3_1
X$9032 \$19496 \$19495 \$19605 \$19774 \$19632 gf180mcu_fd_sc_mcu9t5v0__xnor2_1
X$9033 \$19633 \$19498 \$19632 \$19605 \$19774 \$19499
+ gf180mcu_fd_sc_mcu9t5v0__aoi21_1
X$9034 \$19636 \$19500 \$19634 \$19766 \$19605 \$19774 \$19498
+ gf180mcu_fd_sc_mcu9t5v0__oai211_1
X$9035 \$21974 \$22105 \$21704 \$21975 \$22074 \$21946 \$19500
+ gf180mcu_fd_sc_mcu9t5v0__oai31_1
X$9036 \$20032 \$20197 \$20076 \$19588 \$20209 \$20087 \$20366
+ gf180mcu_fd_sc_mcu9t5v0__nor4_1
X$9037 \$19724 \$20332 \$19605 \$19774 \$19593 gf180mcu_fd_sc_mcu9t5v0__nor2_1
X$9038 \$19596 \$20375 \$20203 \$20209 \$20383 \$20331
+ gf180mcu_fd_sc_mcu9t5v0__oai21_1
X$9039 \$19596 \$20512 \$20203 \$20041 \$20515 \$20383 \$20511
+ gf180mcu_fd_sc_mcu9t5v0__oai211_1
X$9040 \$19598 \$19927 \$20087 \$19724 gf180mcu_fd_sc_mcu9t5v0__dlyc_1
X$9041 \$19732 \$19730 \$19770 \$19605 \$19774 \$19601
+ gf180mcu_fd_sc_mcu9t5v0__oai21_1
X$9042 \$19602 \$19605 \$19774 \$19732 gf180mcu_fd_sc_mcu9t5v0__clkinv_1
X$9043 \$21183 \$20085 \$19603 \$19927 \$20087 \$20084
+ gf180mcu_fd_sc_mcu9t5v0__oai21_1
X$9044 \$19725 \$19724 \$19605 \$19774 \$19922 gf180mcu_fd_sc_mcu9t5v0__or2_1
X$9045 \$19737 \$19739 \$19782 \$19783 \$19605 \$19774 \$19738
+ gf180mcu_fd_sc_mcu9t5v0__oai31_1
X$9046 \$19758 \$19620 \$19737 \$19605 \$19774 \$19790
+ gf180mcu_fd_sc_mcu9t5v0__mux2_1
X$9047 \$19734 \$23021 \$19735 \$19605 \$19774 \$19930
+ gf180mcu_fd_sc_mcu9t5v0__mux2_1
X$9048 \$19774 \$19605 gf180mcu_fd_sc_mcu9t5v0__filltie
X$9049 \$19774 \$19605 gf180mcu_fd_sc_mcu9t5v0__filltie
X$9050 \$19774 \$19605 gf180mcu_fd_sc_mcu9t5v0__filltie
X$9051 \$19774 \$19605 gf180mcu_fd_sc_mcu9t5v0__filltie
X$9052 \$19774 \$19605 gf180mcu_fd_sc_mcu9t5v0__filltie
X$9053 \$19774 \$19605 gf180mcu_fd_sc_mcu9t5v0__filltie
X$9054 \$19774 \$19605 gf180mcu_fd_sc_mcu9t5v0__endcap
X$9055 \$21322 \$21321 \$21184 \$21308 \$19612 gf180mcu_fd_sc_mcu9t5v0__xnor2_1
X$9056 \$19615 \$21164 \$21184 \$21011 \$20100 \$21195
+ gf180mcu_fd_sc_mcu9t5v0__xnor3_1
X$9057 \$19615 \$19752 \$19927 \$19774 \$19902 gf180mcu_fd_sc_mcu9t5v0__nand2_1
X$9058 \$19615 \$20881 \$20718 \$20595 gf180mcu_fd_sc_mcu9t5v0__clkinv_1
X$9059 \$20106 \$19913 \$19927 \$19774 \$19622 gf180mcu_fd_sc_mcu9t5v0__nand2_1
X$9060 \$19627 \$21338 \$21199 \$21184 \$21308 \$21339
+ gf180mcu_fd_sc_mcu9t5v0__mux2_1
X$9061 \$19628 \$20614 \$20881 \$21011 \$20906 gf180mcu_fd_sc_mcu9t5v0__xnor2_1
X$9062 \$19628 \$20363 \$20209 \$20383 \$20068 gf180mcu_fd_sc_mcu9t5v0__xnor2_1
X$9063 \$19628 \$19944 \$19927 \$20087 \$20069 gf180mcu_fd_sc_mcu9t5v0__xnor2_1
X$9064 \$19628 \$20614 \$21045 \$20365 \$20881 \$20718 \$20107
+ gf180mcu_fd_sc_mcu9t5v0__aoi211_1
X$9065 \$19628 \$21046 \$21498 \$21308 \$21399 gf180mcu_fd_sc_mcu9t5v0__nor2_1
X$9066 \$19628 \$20363 \$20209 \$20383 \$20420 gf180mcu_fd_sc_mcu9t5v0__nand2_1
X$9067 \$19628 \$20614 \$20515 \$20718 \$20548 gf180mcu_fd_sc_mcu9t5v0__nand2_1
X$9068 \$19628 \$23479 \$23620 \$23454 \$23607 gf180mcu_fd_sc_mcu9t5v0__nand2_1
X$9069 \$19628 \$21046 \$21184 \$21011 \$21044 gf180mcu_fd_sc_mcu9t5v0__nand2_1
X$9070 \$19628 \$19944 \$20209 \$20087 \$20235 gf180mcu_fd_sc_mcu9t5v0__nand2_1
X$9071 \$19919 \$19918 \$19927 \$19774 \$19633 gf180mcu_fd_sc_mcu9t5v0__or2_1
X$9072 \$19919 \$19918 \$19927 \$19774 \$19634 gf180mcu_fd_sc_mcu9t5v0__nand2_1
X$9073 \$20109 \$19927 \$19774 \$19921 \$19636 gf180mcu_fd_sc_mcu9t5v0__xor2_1
X$9074 \$19724 \$20042 \$20081 \$20043 \$20209 \$20087 \$20082
+ gf180mcu_fd_sc_mcu9t5v0__oai31_1
X$9075 \$19724 \$20332 \$20511 \$20374 \$20515 \$20383 \$20561
+ gf180mcu_fd_sc_mcu9t5v0__oai211_1
X$9076 \$19769 \$19725 \$20040 \$19876 \$19927 \$19774 \$19771
+ gf180mcu_fd_sc_mcu9t5v0__oai31_1
X$9077 \$19769 \$19725 \$19927 \$19774 \$20042 gf180mcu_fd_sc_mcu9t5v0__nand2_1
X$9078 \$23757 \$23756 \$23620 \$23807 \$19727 gf180mcu_fd_sc_mcu9t5v0__nand2_1
X$9079 \$19728 \$23757 \$23756 \$23926 \$23807 \$23586
+ gf180mcu_fd_sc_mcu9t5v0__and3_1
X$9080 \$19728 \$23757 \$23756 \$24231 \$24109 \$24225
+ gf180mcu_fd_sc_mcu9t5v0__nand3_1
X$9081 \$23587 \$19728 \$24228 \$24231 \$24109 \$24049
+ gf180mcu_fd_sc_mcu9t5v0__mux2_1
X$9082 \$20714 \$19730 \$20716 \$20881 \$20718 \$20878
+ gf180mcu_fd_sc_mcu9t5v0__oai21_1
X$9083 \$20715 \$19730 \$20881 \$21011 \$21008 gf180mcu_fd_sc_mcu9t5v0__nand2_1
X$9084 \$20083 \$19730 \$20881 \$20718 \$20879 gf180mcu_fd_sc_mcu9t5v0__nand2_1
X$9085 \$20562 \$19730 \$20881 \$20718 \$20713 gf180mcu_fd_sc_mcu9t5v0__nand2_1
X$9086 \$19730 \$20209 \$20383 \$20382 gf180mcu_fd_sc_mcu9t5v0__buf_8
X$9087 \$19735 \$29692 \$29693 \$29634 \$29720 \$29779
+ gf180mcu_fd_sc_mcu9t5v0__oai21_1
X$9088 \$29426 \$29290 \$29424 \$19735 gf180mcu_fd_sc_mcu9t5v0__buf_8
X$9089 \$20587 \$23446 \$19735 \$20515 \$20718 \$20726
+ gf180mcu_fd_sc_mcu9t5v0__mux2_1
X$9090 \$20597 \$23317 \$19735 \$20515 \$20718 \$20596
+ gf180mcu_fd_sc_mcu9t5v0__mux2_1
X$9091 \$23763 \$23180 \$19735 \$23620 \$23807 \$23808
+ gf180mcu_fd_sc_mcu9t5v0__mux2_1
X$9092 \$26222 \$22887 \$19735 \$26088 \$26220 \$26362
+ gf180mcu_fd_sc_mcu9t5v0__mux2_1
X$9093 \$20580 \$24221 \$19735 \$20515 \$20718 \$20840
+ gf180mcu_fd_sc_mcu9t5v0__mux2_1
X$9094 \$21825 \$23922 \$19735 \$21661 \$21946 \$21684
+ gf180mcu_fd_sc_mcu9t5v0__mux2_1
X$9095 \$20401 \$20400 \$19735 \$20209 \$20383 \$20399
+ gf180mcu_fd_sc_mcu9t5v0__mux2_1
X$9096 \$20063 \$23315 \$19735 \$20209 \$20087 \$20228
+ gf180mcu_fd_sc_mcu9t5v0__mux2_1
X$9097 \$21388 \$23445 \$19735 \$21498 \$21308 \$21641
+ gf180mcu_fd_sc_mcu9t5v0__mux2_1
X$9098 \$20853 \$20226 \$19735 \$20881 \$20718 \$20895
+ gf180mcu_fd_sc_mcu9t5v0__mux2_1
X$9099 \$21367 \$21366 \$19735 \$21498 \$21308 \$21365
+ gf180mcu_fd_sc_mcu9t5v0__mux2_1
X$9100 \$23591 \$22279 \$19735 \$23620 \$23454 \$23624
+ gf180mcu_fd_sc_mcu9t5v0__mux2_1
X$9101 \$20518 \$20517 \$19735 \$20515 \$20383 \$20579
+ gf180mcu_fd_sc_mcu9t5v0__mux2_1
X$9102 \$21958 \$22833 \$19735 \$22074 \$21946 \$21817
+ gf180mcu_fd_sc_mcu9t5v0__mux2_1
X$9103 \$31257 \$31019 \$19737 \$31232 \$31310 \$31259
+ gf180mcu_fd_sc_mcu9t5v0__oai21_1
X$9104 \$19737 \$20398 \$20345 \$20397 \$20209 \$20383 \$20218
+ gf180mcu_fd_sc_mcu9t5v0__oai31_1
X$9105 \$19737 \$21672 \$20090 \$21670 \$21661 \$21622 \$21671
+ gf180mcu_fd_sc_mcu9t5v0__oai31_1
X$9106 \$19737 \$22899 \$21017 \$22843 \$23027 \$22837 \$22900
+ gf180mcu_fd_sc_mcu9t5v0__oai31_1
X$9107 \$22873 \$19737 \$22713 \$22837 \$22725 gf180mcu_fd_sc_mcu9t5v0__nand2_1
X$9108 \$22844 \$19737 \$22713 \$22837 \$22843 gf180mcu_fd_sc_mcu9t5v0__nand2_1
X$9109 \$19891 \$19737 \$19927 \$20087 \$19783 gf180mcu_fd_sc_mcu9t5v0__nand2_1
X$9110 \$21813 \$19737 \$22074 \$21946 \$21670 gf180mcu_fd_sc_mcu9t5v0__nand2_1
X$9111 \$21150 \$19737 \$21184 \$21011 \$21021 gf180mcu_fd_sc_mcu9t5v0__nand2_1
X$9112 \$24124 \$19737 \$24231 \$24109 \$24265 gf180mcu_fd_sc_mcu9t5v0__nand2_1
X$9113 \$19737 \$31232 \$31310 \$23157 gf180mcu_fd_sc_mcu9t5v0__clkinv_1
X$9114 \$31378 \$31376 \$31465 \$19737 gf180mcu_fd_sc_mcu9t5v0__buf_8
X$9115 \$20064 \$19909 \$19737 \$19927 \$20087 \$20102
+ gf180mcu_fd_sc_mcu9t5v0__mux2_1
X$9116 \$20599 \$20856 \$19737 \$20881 \$20718 \$20607
+ gf180mcu_fd_sc_mcu9t5v0__mux2_1
X$9117 \$20416 \$20546 \$19737 \$20515 \$20383 \$20545
+ gf180mcu_fd_sc_mcu9t5v0__mux2_1
X$9118 \$19740 \$20395 \$20396 \$20515 \$20383 gf180mcu_fd_sc_mcu9t5v0__dffq_2
X$9119 \$19742 \$20051 \$19927 \$20087 \$19896 gf180mcu_fd_sc_mcu9t5v0__nand2_1
X$9120 \$20352 \$20350 \$19927 \$20087 \$19746 gf180mcu_fd_sc_mcu9t5v0__nor2_1
X$9121 \$19899 \$19898 \$19927 \$19774 \$19748 gf180mcu_fd_sc_mcu9t5v0__nor2_1
X$9122 \$19900 \$20061 \$19901 \$19927 \$19774 \$19751
+ gf180mcu_fd_sc_mcu9t5v0__oai21_1
X$9123 \$19752 \$20100 \$20209 \$20383 \$20357 gf180mcu_fd_sc_mcu9t5v0__xnor2_1
X$9124 \$20535 \$20515 \$20383 \$19752 gf180mcu_fd_sc_mcu9t5v0__clkinv_1
X$9125 \$19907 \$19906 \$19927 \$19774 \$19761 gf180mcu_fd_sc_mcu9t5v0__nand2_1
X$9126 \$19907 \$19906 \$19927 \$19774 \$19762 gf180mcu_fd_sc_mcu9t5v0__nor2_1
X$9127 \$20900 \$20899 \$20901 \$20881 \$21011 \$19763
+ gf180mcu_fd_sc_mcu9t5v0__aoi21_1
X$9128 \$20109 \$19920 \$19927 \$19774 \$19766 gf180mcu_fd_sc_mcu9t5v0__nand2_1
X$9129 \$20083 \$19770 \$19927 \$20087 \$20043 gf180mcu_fd_sc_mcu9t5v0__nand2_1
X$9130 \$19773 \$19770 \$19927 \$19774 \$19876 gf180mcu_fd_sc_mcu9t5v0__nand2_1
X$9131 \$19772 \$20201 \$20205 \$20080 \$20209 \$20087 \$20370
+ gf180mcu_fd_sc_mcu9t5v0__oai211_1
X$9132 \$19773 \$23190 \$20343 \$23183 \$23139 \$23189
+ gf180mcu_fd_sc_mcu9t5v0__mux2_1
X$9133 \$19899 \$19898 \$19927 \$19774 \$19786 gf180mcu_fd_sc_mcu9t5v0__and2_1
X$9134 \$20732 \$19927 \$19774 \$19787 gf180mcu_fd_sc_mcu9t5v0__clkinv_1
X$9135 \$19882 \$19927 \$19774 \$19775 gf180mcu_fd_sc_mcu9t5v0__clkbuf_8
X$9136 \$19774 \$19927 gf180mcu_fd_sc_mcu9t5v0__filltie
X$9137 \$19774 \$19927 gf180mcu_fd_sc_mcu9t5v0__filltie
X$9138 \$19774 \$19927 gf180mcu_fd_sc_mcu9t5v0__filltie
X$9139 \$19774 \$19927 gf180mcu_fd_sc_mcu9t5v0__filltie
X$9140 \$19774 \$19927 gf180mcu_fd_sc_mcu9t5v0__filltie
X$9141 \$19774 \$19927 gf180mcu_fd_sc_mcu9t5v0__filltie
X$9142 \$23021 \$19892 \$20392 \$19927 \$19774 \$19784
+ gf180mcu_fd_sc_mcu9t5v0__mux2_1
X$9143 \$23314 \$19937 \$20392 \$19927 \$19774 \$19936
+ gf180mcu_fd_sc_mcu9t5v0__mux2_1
X$9144 \$19774 \$19927 gf180mcu_fd_sc_mcu9t5v0__endcap
X$9145 \$19775 \$19927 \$20087 gf180mcu_fd_sc_mcu9t5v0__clkbuf_4
X$9146 \$19775 \$21146 \$21147 \$21184 \$21308 gf180mcu_fd_sc_mcu9t5v0__dffq_2
X$9147 \$19775 \$20386 \$20387 \$20515 \$20383 gf180mcu_fd_sc_mcu9t5v0__dffq_2
X$9148 \$19775 \$20088 \$20089 \$20209 \$20087 gf180mcu_fd_sc_mcu9t5v0__dffq_2
X$9149 \$20046 \$20382 \$19776 \$20515 \$20718 \$20717
+ gf180mcu_fd_sc_mcu9t5v0__oai21_1
X$9150 \$21183 \$20336 \$20379 \$20335 \$19777 \$20209 \$20383 \$20381
+ gf180mcu_fd_sc_mcu9t5v0__aoi221_1
X$9151 \$21376 \$21375 \$21184 \$21308 \$19785 gf180mcu_fd_sc_mcu9t5v0__xnor2_1
X$9152 \$20597 \$20515 \$20718 \$19788 gf180mcu_fd_sc_mcu9t5v0__clkinv_1
X$9153 \$20039 \$19875 \$19927 \$20087 \$20040 gf180mcu_fd_sc_mcu9t5v0__nand2_1
X$9154 \$19877 \$20382 \$20338 \$20209 \$20383 \$20208
+ gf180mcu_fd_sc_mcu9t5v0__aoi21_1
X$9155 \$20083 \$20715 \$20515 \$20383 \$19877 gf180mcu_fd_sc_mcu9t5v0__nand2_1
X$9156 \$19879 \$20382 \$20515 \$20718 \$20573 gf180mcu_fd_sc_mcu9t5v0__nand2_1
X$9157 \$19879 \$20515 \$20718 \$20046 gf180mcu_fd_sc_mcu9t5v0__clkinv_1
X$9158 \$25460 \$26521 \$26675 \$19882 gf180mcu_fd_sc_mcu9t5v0__clkbuf_16
X$9159 \$19882 \$32248 \$32307 \$31231 gf180mcu_fd_sc_mcu9t5v0__clkbuf_8
X$9160 \$19882 \$29290 \$29424 \$27926 gf180mcu_fd_sc_mcu9t5v0__clkbuf_8
X$9161 \$19882 \$30054 \$30185 \$28554 gf180mcu_fd_sc_mcu9t5v0__clkbuf_8
X$9162 \$19882 \$25191 \$25347 \$24301 gf180mcu_fd_sc_mcu9t5v0__clkbuf_8
X$9163 \$19882 \$27315 \$27449 \$25799 gf180mcu_fd_sc_mcu9t5v0__clkbuf_8
X$9164 \$19882 \$30696 \$30625 \$29235 gf180mcu_fd_sc_mcu9t5v0__clkbuf_8
X$9165 \$19882 \$29780 \$29720 \$28212 gf180mcu_fd_sc_mcu9t5v0__clkbuf_8
X$9166 \$19882 \$26675 \$26521 \$25805 gf180mcu_fd_sc_mcu9t5v0__clkbuf_8
X$9167 \$19882 \$21498 \$21308 \$20342 gf180mcu_fd_sc_mcu9t5v0__clkbuf_8
X$9168 \$19882 \$22387 \$22272 \$21942 gf180mcu_fd_sc_mcu9t5v0__clkbuf_8
X$9169 \$19882 \$22713 \$22440 \$21369 gf180mcu_fd_sc_mcu9t5v0__clkbuf_8
X$9170 \$19882 \$24231 \$24109 \$23765 gf180mcu_fd_sc_mcu9t5v0__clkbuf_8
X$9171 \$19882 \$23926 \$23807 \$23323 gf180mcu_fd_sc_mcu9t5v0__clkbuf_8
X$9172 \$19882 \$31607 \$31584 \$31381 gf180mcu_fd_sc_mcu9t5v0__clkbuf_8
X$9173 \$20048 \$19927 \$20087 \$19887 gf180mcu_fd_sc_mcu9t5v0__clkinv_1
X$9174 \$19888 \$20396 \$20343 \$20209 \$20383 \$20395
+ gf180mcu_fd_sc_mcu9t5v0__mux2_1
X$9175 \$19890 \$20209 \$20087 \$20049 gf180mcu_fd_sc_mcu9t5v0__clkinv_1
X$9176 \$20095 \$20348 \$20209 \$20087 \$19897 gf180mcu_fd_sc_mcu9t5v0__nor2_1
X$9177 \$20352 \$20350 \$20354 \$20209 \$20383 \$19898
+ gf180mcu_fd_sc_mcu9t5v0__aoi21_1
X$9178 \$19899 \$19898 \$20409 \$20209 \$20383 \$20408
+ gf180mcu_fd_sc_mcu9t5v0__oai21_1
X$9179 \$20356 \$20852 \$20515 \$20383 \$19899 gf180mcu_fd_sc_mcu9t5v0__xnor2_1
X$9180 \$20059 \$19899 \$19927 \$20087 \$20098 gf180mcu_fd_sc_mcu9t5v0__xnor2_1
X$9181 \$20407 \$20353 \$19899 \$20209 \$20383 \$20355
+ gf180mcu_fd_sc_mcu9t5v0__oai21_1
X$9182 \$20594 \$21028 \$20731 \$20881 \$20718 \$19900
+ gf180mcu_fd_sc_mcu9t5v0__aoi21_1
X$9183 \$19900 \$20061 \$20528 \$19927 \$20087 \$19901
+ gf180mcu_fd_sc_mcu9t5v0__aoi21_1
X$9184 \$19902 \$20062 \$19927 \$20087 \$20061 gf180mcu_fd_sc_mcu9t5v0__nand2_1
X$9185 \$20063 \$19927 \$20087 \$19903 gf180mcu_fd_sc_mcu9t5v0__clkinv_1
X$9186 \$21826 \$21661 \$21946 \$19904 gf180mcu_fd_sc_mcu9t5v0__clkinv_1
X$9187 \$19905 \$20209 \$20383 \$20360 \$20536 gf180mcu_fd_sc_mcu9t5v0__xor2_1
X$9188 \$19905 \$20360 \$20209 \$20087 \$20231 gf180mcu_fd_sc_mcu9t5v0__nand2_1
X$9189 \$20855 \$20898 \$20897 \$20881 \$21011 \$19906
+ gf180mcu_fd_sc_mcu9t5v0__oai21_1
X$9190 \$21041 \$21042 \$21184 \$21011 \$19912 \$20903
+ gf180mcu_fd_sc_mcu9t5v0__xnor3_1
X$9191 \$22413 \$19913 \$22074 \$21946 \$22100 gf180mcu_fd_sc_mcu9t5v0__nand2_1
X$9192 \$23652 \$19915 \$22928 \$23926 \$23807 \$23605
+ gf180mcu_fd_sc_mcu9t5v0__mux2_1
X$9193 \$21651 \$21518 \$21702 \$21498 \$21622 \$19916
+ gf180mcu_fd_sc_mcu9t5v0__oai21_1
X$9194 \$21699 \$21518 \$21661 \$21622 \$19917 \$21701
+ gf180mcu_fd_sc_mcu9t5v0__xnor3_1
X$9195 \$20552 \$20515 \$20383 \$19919 gf180mcu_fd_sc_mcu9t5v0__clkinv_1
X$9196 \$19921 \$19927 \$20087 \$19920 gf180mcu_fd_sc_mcu9t5v0__clkinv_1
X$9197 \$19924 \$20039 \$19927 \$20087 \$20038 gf180mcu_fd_sc_mcu9t5v0__nor2_1
X$9198 \$20032 \$19927 \$20087 \$20033 \$20031 gf180mcu_fd_sc_mcu9t5v0__xor2_1
X$9199 \$20352 \$20350 \$19927 \$20087 \$20057 gf180mcu_fd_sc_mcu9t5v0__and2_1
X$9200 \$20032 \$20197 \$20033 \$19927 \$20087 \$20077
+ gf180mcu_fd_sc_mcu9t5v0__nor3_1
X$9201 \$20094 \$20054 \$20055 \$19927 \$20087 \$20051
+ gf180mcu_fd_sc_mcu9t5v0__oai21_1
X$9202 \$20032 \$20033 \$19927 \$20087 \$20075 gf180mcu_fd_sc_mcu9t5v0__nor2_1
X$9203 \$20069 \$20068 \$19927 \$20087 \$20070 gf180mcu_fd_sc_mcu9t5v0__nor2_1
X$9204 \$20035 \$20076 \$20034 \$19927 \$20087 \$20198
+ gf180mcu_fd_sc_mcu9t5v0__mux2_1
X$9205 \$20087 \$19927 gf180mcu_fd_sc_mcu9t5v0__filltie
X$9206 \$20087 \$19927 gf180mcu_fd_sc_mcu9t5v0__filltie
X$9207 \$20087 \$19927 gf180mcu_fd_sc_mcu9t5v0__filltie
X$9208 \$20087 \$19927 gf180mcu_fd_sc_mcu9t5v0__filltie
X$9209 \$20087 \$19927 gf180mcu_fd_sc_mcu9t5v0__filltie
X$9210 \$20087 \$19927 gf180mcu_fd_sc_mcu9t5v0__filltie
X$9211 \$20087 \$19927 gf180mcu_fd_sc_mcu9t5v0__endcap
X$9212 \$23315 \$19938 \$20392 \$20515 \$20718 \$20733
+ gf180mcu_fd_sc_mcu9t5v0__mux2_1
X$9213 \$20332 \$20376 \$20515 \$20718 \$20037 gf180mcu_fd_sc_mcu9t5v0__nand2_1
X$9214 \$21620 \$20037 \$22387 \$22272 \$22386 gf180mcu_fd_sc_mcu9t5v0__nand2_1
X$9215 \$20865 \$20038 \$20330 \$21292 \$21295 \$21184 \$21308 \$21294
+ gf180mcu_fd_sc_mcu9t5v0__oai32_1
X$9216 \$20038 \$20561 \$20515 \$20718 \$20562 gf180mcu_fd_sc_mcu9t5v0__nand2_1
X$9217 \$20376 \$20040 \$20377 \$20209 \$20383 \$20334
+ gf180mcu_fd_sc_mcu9t5v0__oai21_1
X$9218 \$20042 \$20834 \$20708 \$21300 \$21184 \$21308 \$21301
+ gf180mcu_fd_sc_mcu9t5v0__oai31_1
X$9219 \$25460 \$25347 \$25462 \$20044 gf180mcu_fd_sc_mcu9t5v0__clkbuf_16
X$9220 \$20044 \$25797 \$25918 \$23915 gf180mcu_fd_sc_mcu9t5v0__clkbuf_8
X$9221 \$20044 \$22387 \$22440 \$21658 gf180mcu_fd_sc_mcu9t5v0__clkbuf_8
X$9222 \$20044 \$25191 \$25347 \$23615 gf180mcu_fd_sc_mcu9t5v0__clkbuf_8
X$9223 \$20044 \$25462 \$25632 \$I39903 gf180mcu_fd_sc_mcu9t5v0__clkbuf_8
X$9224 \$20044 \$28534 \$28689 \$28080 gf180mcu_fd_sc_mcu9t5v0__clkbuf_8
X$9225 \$20044 \$27637 \$27776 \$27005 gf180mcu_fd_sc_mcu9t5v0__clkbuf_8
X$9226 \$20044 \$26675 \$26856 \$26394 gf180mcu_fd_sc_mcu9t5v0__clkbuf_8
X$9227 \$20044 \$23926 \$23807 \$23308 gf180mcu_fd_sc_mcu9t5v0__clkbuf_8
X$9228 \$20044 \$28534 \$28381 \$27905 gf180mcu_fd_sc_mcu9t5v0__clkbuf_8
X$9229 \$20044 \$24231 \$24109 \$23616 gf180mcu_fd_sc_mcu9t5v0__clkbuf_8
X$9230 \$20044 \$22074 \$21946 \$21791 gf180mcu_fd_sc_mcu9t5v0__clkbuf_8
X$9231 \$20044 \$21184 \$21011 \$20826 gf180mcu_fd_sc_mcu9t5v0__clkbuf_8
X$9232 \$20044 \$25191 \$24997 \$23321 gf180mcu_fd_sc_mcu9t5v0__clkbuf_8
X$9233 \$25350 \$20048 \$25462 \$25347 \$25463 gf180mcu_fd_sc_mcu9t5v0__and2_1
X$9234 \$23636 \$23334 \$23183 \$23454 \$20052 gf180mcu_fd_sc_mcu9t5v0__xnor2_1
X$9235 \$20094 \$20054 \$20891 \$20881 \$21011 \$20348
+ gf180mcu_fd_sc_mcu9t5v0__aoi21_1
X$9236 \$21376 \$21375 \$21377 \$21498 \$21308 \$20054
+ gf180mcu_fd_sc_mcu9t5v0__oai21_1
X$9237 \$20407 \$20353 \$20209 \$20383 \$20059 gf180mcu_fd_sc_mcu9t5v0__nor2_1
X$9238 \$20595 \$20535 \$20515 \$20718 \$20062 gf180mcu_fd_sc_mcu9t5v0__nand2_1
X$9239 \$20065 \$21661 \$21622 gf180mcu_fd_sc_mcu9t5v0__clkbuf_4
X$9240 \$21200 \$21498 \$21622 \$20065 gf180mcu_fd_sc_mcu9t5v0__clkbuf_8
X$9241 \$20069 \$20209 \$20087 \$20107 \$20066 gf180mcu_fd_sc_mcu9t5v0__xor2_1
X$9242 \$20068 \$20234 \$20209 \$20087 \$20067 gf180mcu_fd_sc_mcu9t5v0__xnor2_1
X$9243 \$20069 \$20107 \$20235 \$20209 \$20087 \$20234
+ gf180mcu_fd_sc_mcu9t5v0__oai21_1
X$9244 \$20616 \$20551 \$20515 \$20718 \$20550 \$20072
+ gf180mcu_fd_sc_mcu9t5v0__xor3_1
X$9245 \$20197 \$20075 \$20209 \$20087 \$20074 gf180mcu_fd_sc_mcu9t5v0__xnor2_1
X$9246 \$20076 \$20077 \$20209 \$20087 \$20078 gf180mcu_fd_sc_mcu9t5v0__xnor2_1
X$9247 \$21007 \$21303 \$21302 \$21498 \$21308 \$20080
+ gf180mcu_fd_sc_mcu9t5v0__nor3_1
X$9248 \$20083 \$21008 \$20879 \$20714 \$20881 \$21011 \$21009
+ gf180mcu_fd_sc_mcu9t5v0__oai22_1
X$9249 \$20083 \$21008 \$20381 \$20837 \$20881 \$21011 \$20880
+ gf180mcu_fd_sc_mcu9t5v0__oai211_1
X$9250 \$20083 \$24112 \$24231 \$24109 \$24240 gf180mcu_fd_sc_mcu9t5v0__nor2_1
X$9251 \$20083 \$24723 \$24531 \$24233 \$24593 \$24721 \$24596
+ gf180mcu_fd_sc_mcu9t5v0__aoi22_1
X$9252 \$20083 \$22573 \$22387 \$22440 \$22439 gf180mcu_fd_sc_mcu9t5v0__nand2_1
X$9253 \$20083 \$24730 \$24593 \$24721 \$24536 gf180mcu_fd_sc_mcu9t5v0__nand2_1
X$9254 \$20083 \$24727 \$24593 \$24721 \$24728 gf180mcu_fd_sc_mcu9t5v0__nand2_1
X$9255 \$20083 \$24060 \$24231 \$24109 \$24244 gf180mcu_fd_sc_mcu9t5v0__nand2_1
X$9256 \$20083 \$23620 \$23454 \$21620 gf180mcu_fd_sc_mcu9t5v0__clkinv_1
X$9257 \$20336 \$20209 \$20383 \$20085 gf180mcu_fd_sc_mcu9t5v0__clkinv_1
X$9258 \$20095 \$20348 \$20209 \$20087 \$20096 gf180mcu_fd_sc_mcu9t5v0__and2_1
X$9259 \$20099 \$20223 \$20209 \$20087 \$20224 gf180mcu_fd_sc_mcu9t5v0__nor2_1
X$9260 \$20204 \$20202 \$20209 \$20087 \$20377 gf180mcu_fd_sc_mcu9t5v0__nand2_1
X$9261 \$20087 \$20209 gf180mcu_fd_sc_mcu9t5v0__filltie
X$9262 \$20087 \$20209 gf180mcu_fd_sc_mcu9t5v0__filltie
X$9263 \$20087 \$20209 gf180mcu_fd_sc_mcu9t5v0__filltie
X$9264 \$20087 \$20209 gf180mcu_fd_sc_mcu9t5v0__filltie
X$9265 \$20087 \$20209 gf180mcu_fd_sc_mcu9t5v0__filltie
X$9266 \$20087 \$20209 gf180mcu_fd_sc_mcu9t5v0__filltie
X$9267 \$20342 \$20091 \$20092 \$20209 \$20087 gf180mcu_fd_sc_mcu9t5v0__dffq_2
X$9268 \$20226 \$20230 \$20392 \$20209 \$20087 \$20229
+ gf180mcu_fd_sc_mcu9t5v0__mux2_1
X$9269 \$20087 \$20209 gf180mcu_fd_sc_mcu9t5v0__endcap
X$9270 \$20341 \$20092 \$20343 \$20209 \$20383 \$20091
+ gf180mcu_fd_sc_mcu9t5v0__mux2_1
X$9271 \$20401 \$20209 \$20383 \$20093 gf180mcu_fd_sc_mcu9t5v0__clkinv_1
X$9272 \$21158 \$21157 \$21184 \$21011 \$20094 gf180mcu_fd_sc_mcu9t5v0__xnor2_1
X$9273 \$21025 \$20889 \$20094 \$20881 \$21011 \$20588
+ gf180mcu_fd_sc_mcu9t5v0__aoi21_1
X$9274 \$21025 \$20889 \$20094 \$20881 \$21011 \$20890
+ gf180mcu_fd_sc_mcu9t5v0__nand3_1
X$9275 \$20532 \$20531 \$20515 \$20718 \$20095 gf180mcu_fd_sc_mcu9t5v0__xnor2_1
X$9276 \$20095 \$20348 \$20351 \$20209 \$20383 \$20350
+ gf180mcu_fd_sc_mcu9t5v0__oai21_1
X$9277 \$20530 \$20588 \$20095 \$20515 \$20383 \$20404
+ gf180mcu_fd_sc_mcu9t5v0__oai21_1
X$9278 \$20530 \$20588 \$20095 \$20529 \$20515 \$20718 \$20405
+ gf180mcu_fd_sc_mcu9t5v0__oai31_1
X$9279 \$20406 \$20404 \$20352 \$20209 \$20383 \$20097
+ gf180mcu_fd_sc_mcu9t5v0__nand3_1
X$9280 \$20534 \$20355 \$20515 \$20383 \$20099 gf180mcu_fd_sc_mcu9t5v0__nand2_1
X$9281 \$20535 \$20100 \$20209 \$20383 \$20358 gf180mcu_fd_sc_mcu9t5v0__nor2_1
X$9282 \$21390 \$21498 \$21308 \$20101 gf180mcu_fd_sc_mcu9t5v0__clkinv_1
X$9283 \$20330 \$20373 \$20209 \$20383 \$20199 gf180mcu_fd_sc_mcu9t5v0__nand2_1
X$9284 \$20560 \$20200 \$20829 \$20828 \$20881 \$20718 \$20830
+ gf180mcu_fd_sc_mcu9t5v0__oai22_1
X$9285 \$20372 \$20329 \$20366 \$20209 \$20383 \$20200
+ gf180mcu_fd_sc_mcu9t5v0__nand3_1
X$9286 \$23802 \$20202 \$23620 \$23807 \$23617 gf180mcu_fd_sc_mcu9t5v0__nand2_1
X$9287 \$20204 \$24846 \$24228 \$23587 \$24877 \$24721 \$24718
+ gf180mcu_fd_sc_mcu9t5v0__aoi211_1
X$9288 \$20571 \$20570 \$20515 \$20718 \$20205 gf180mcu_fd_sc_mcu9t5v0__nor2_1
X$9289 \$22438 \$22387 \$22440 \$20206 gf180mcu_fd_sc_mcu9t5v0__buf_8
X$9290 \$20714 \$20337 \$20209 \$20383 \$20207 gf180mcu_fd_sc_mcu9t5v0__nand2_1
X$9291 \$20209 \$20383 \$20339 gf180mcu_fd_sc_mcu9t5v0__tiel
X$9292 \$20356 \$20852 \$20209 \$20383 \$20409 gf180mcu_fd_sc_mcu9t5v0__or2_1
X$9293 \$20542 \$20361 \$20543 \$20209 \$20383 \$20605
+ gf180mcu_fd_sc_mcu9t5v0__and3_1
X$9294 \$20406 \$20404 \$20352 \$20209 \$20383 \$20353
+ gf180mcu_fd_sc_mcu9t5v0__aoi21_1
X$9295 \$20865 \$20327 \$20328 \$20209 \$20383 \$20325
+ gf180mcu_fd_sc_mcu9t5v0__oai21_1
X$9296 \$20370 \$20209 \$20383 \$20329 gf180mcu_fd_sc_mcu9t5v0__buf_8
X$9297 \$20210 \$20382 \$20209 \$20383 \$20338 gf180mcu_fd_sc_mcu9t5v0__nor2_1
X$9298 \$20357 \$20209 \$20383 \$20223 gf180mcu_fd_sc_mcu9t5v0__clkinv_1
X$9299 \$20602 \$20209 \$20383 \$20415 gf180mcu_fd_sc_mcu9t5v0__clkinv_1
X$9300 \$20335 \$20209 \$20383 \$20380 gf180mcu_fd_sc_mcu9t5v0__clkinv_1
X$9301 \$20331 \$20327 \$20209 \$20383 \$20374 gf180mcu_fd_sc_mcu9t5v0__nand2_1
X$9302 \$20865 \$20326 \$20209 \$20383 \$20328 gf180mcu_fd_sc_mcu9t5v0__nand2_1
X$9303 \$20325 \$20369 \$21000 \$20209 \$20383 \$20324
+ gf180mcu_fd_sc_mcu9t5v0__mux2_1
X$9304 \$20383 \$20209 gf180mcu_fd_sc_mcu9t5v0__filltie
X$9305 \$20383 \$20209 gf180mcu_fd_sc_mcu9t5v0__filltie
X$9306 \$20383 \$20209 gf180mcu_fd_sc_mcu9t5v0__filltie
X$9307 \$20383 \$20209 gf180mcu_fd_sc_mcu9t5v0__filltie
X$9308 \$20383 \$20209 gf180mcu_fd_sc_mcu9t5v0__filltie
X$9309 \$20383 \$20209 gf180mcu_fd_sc_mcu9t5v0__filltie
X$9310 \$20383 \$20209 gf180mcu_fd_sc_mcu9t5v0__endcap
X$9311 \$20210 \$20382 \$20515 \$20718 \$20716 gf180mcu_fd_sc_mcu9t5v0__nand2_1
X$9312 \$20212 \$21009 \$21184 \$21308 \$21309 gf180mcu_fd_sc_mcu9t5v0__xnor2_1
X$9313 \$30611 \$30564 \$30625 \$20212 gf180mcu_fd_sc_mcu9t5v0__clkbuf_8
X$9314 \$20215 \$29089 \$29088 \$29087 \$29123 \$28971 \$28814
+ gf180mcu_fd_sc_mcu9t5v0__nor4_1
X$9315 \$29632 \$29780 \$29847 \$20216 gf180mcu_fd_sc_mcu9t5v0__clkinv_1
X$9316 \$25466 \$20216 \$30251 \$30185 \$30254 gf180mcu_fd_sc_mcu9t5v0__nand2_1
X$9317 \$20851 \$20593 \$20881 \$20718 \$20222 gf180mcu_fd_sc_mcu9t5v0__xnor2_1
X$9318 \$20400 \$23317 \$20226 \$23446 \$23183 \$23454 \$23318
+ gf180mcu_fd_sc_mcu9t5v0__nand4_1
X$9319 \$20400 \$23317 \$20226 \$23446 \$23926 \$24109 \$23921
+ gf180mcu_fd_sc_mcu9t5v0__nor4_1
X$9320 \$20226 \$28038 \$25343 \$27913 \$28089 \$28083
+ gf180mcu_fd_sc_mcu9t5v0__mux2_1
X$9321 \$20226 \$30039 \$29436 \$30054 \$30185 \$30179
+ gf180mcu_fd_sc_mcu9t5v0__mux2_1
X$9322 \$20226 \$22829 \$21656 \$23027 \$22837 \$23024
+ gf180mcu_fd_sc_mcu9t5v0__mux2_1
X$9323 \$20226 \$29073 \$26339 \$29290 \$29270 \$29227
+ gf180mcu_fd_sc_mcu9t5v0__mux2_1
X$9324 \$20226 \$27461 \$27658 \$27637 \$27449 \$27591
+ gf180mcu_fd_sc_mcu9t5v0__mux2_1
X$9325 \$20233 \$21184 \$21308 gf180mcu_fd_sc_mcu9t5v0__inv_3
X$9326 \$21200 \$21184 \$21308 \$20233 gf180mcu_fd_sc_mcu9t5v0__clkbuf_8
X$9327 \$21044 \$20548 \$20235 \$20420 \$20515 \$20383 \$20421
+ gf180mcu_fd_sc_mcu9t5v0__nand4_1
X$9328 \$21341 \$21201 \$21184 \$21308 \$20236 \$21179
+ gf180mcu_fd_sc_mcu9t5v0__xnor3_1
X$9329 \$20911 \$21050 \$21184 \$21011 \$20238 \$20912
+ gf180mcu_fd_sc_mcu9t5v0__xnor3_1
X$9330 \$20369 \$20515 \$20383 \$20507 \$20326 gf180mcu_fd_sc_mcu9t5v0__xor2_1
X$9331 \$21978 pad_din_ready_o \$I20747 \$I20756 \$I20765 \$I20774 \$I20783
+ \$I20792 \$I20801 \$I20810 \$I20819 \$I20828 \$I20837 \$I20846 \$I20855
+ \$I20864 \$I20873 \$I20882 \$I20891 \$I20900 \$I20909 \$I20918 \$I20927
+ \$I20936 \$I20945 \$I20954 \$I20963 \$I20972 \$I20981 \$I20990 \$I20999
+ \$I21008 \$I21017 \$I21026 \$I21035 \$I21044 \$I21053 \$I21062 \$I21071
+ \$I21080 \$I21089 \$I21098 \$I21107 \$I21116 \$I21125 \$I21134 \$I21143
+ \$I21152 \$I21161 \$I21170 \$I21179 \$I21188 \$I21197 \$I21206 \$I21215
+ \$I21224 \$I21233 \$I21242 \$I21251 \$I21260 \$I21269 \$I21278 \$I21287
+ \$I21296 \$I21305 \$I21314 \$20553 \$I21323 \$I21332 \$I21341 \$I21350
+ \$I21359 \$I21368 \$I21377 \$I21386 \$I21395 \$I21404 \$I21413 \$I21422
+ \$I21431 \$I21440 \$I21449 \$I21458 \$I21467 \$I21476 \$I21485 \$I21494
+ \$I21503 \$I21512 \$I21521 \$I21530 \$I21539 \$I21548 \$I21557 \$I21566
+ \$I21575 \$I21584 \$I21593 \$I21602 \$20506 \$I21611 \$I21620 \$I21629
+ \$I21638 \$I21647 \$I21656 \$I21665 \$I21674 \$20506 \$20506 \$20553 \$20506
+ \$20506 \$20329 \$20553 gf180mcu_fd_io__bi_t
X$9332 \$21135 \$20368 \$20330 \$21184 \$21308 \$21347
+ gf180mcu_fd_sc_mcu9t5v0__oai21_1
X$9333 \$20372 \$20508 \$20370 \$20515 \$20383 \$20330
+ gf180mcu_fd_sc_mcu9t5v0__nand3_1
X$9334 \$20332 \$20834 \$20708 \$21299 \$21184 \$21308 \$21356
+ gf180mcu_fd_sc_mcu9t5v0__oai31_1
X$9335 \$21620 \$20512 \$20333 \$21498 \$21308 \$21358
+ gf180mcu_fd_sc_mcu9t5v0__nand3_1
X$9336 \$20337 \$20382 \$20573 \$20515 \$20718 \$20572
+ gf180mcu_fd_sc_mcu9t5v0__oai21_1
X$9337 \$20715 \$20515 \$20718 \$20337 gf180mcu_fd_sc_mcu9t5v0__clkinv_1
X$9338 \$34467 pad_clk \$I18268 \$I18278 \$I18288 \$I18298 \$I18308 \$I18318
+ \$I18328 \$I18338 \$I18348 \$I18358 \$I18368 \$I18378 \$I18388 \$I18398
+ \$I18408 \$I18418 \$I18428 \$I18438 \$I18448 \$I18458 \$I18468 \$I18478
+ \$I18488 \$I18498 \$I18508 \$I18518 \$I18528 \$I18538 \$I18548 \$I18558
+ \$I18568 \$I18578 \$I18588 \$I18598 \$I18608 \$I18618 \$I18628 \$I18638
+ \$I18648 \$I18658 \$I18668 \$I18678 \$I18688 \$I18698 \$I18708 \$I18718
+ \$I18728 \$I18738 \$I18748 \$I18758 \$I18768 \$I18778 \$I18788 \$I18798
+ \$I18808 \$I18818 \$I18828 \$I18838 \$I18848 \$I18858 \$I18868 \$I18878
+ \$I18888 \$I18898 \$I18908 \$I18918 \$I18928 \$I18938 \$I18948 \$I18958
+ \$I18968 \$I18978 \$I18988 \$I18998 \$I19008 \$I19018 \$I19028 \$I19038
+ \$I19048 \$I19058 \$I19068 \$I19078 \$I19088 \$I19098 \$I19108 \$I19118
+ \$I19128 \$I19138 \$I19148 \$I19158 \$I19168 \$I19178 \$I19188 \$I19198
+ \$I19208 \$I19218 \$I19228 \$I19238 \$I19248 \$I19258 \$20339 \$I19268
+ \$I19278 \$I19288 \$I19298 \$20339 \$34298 gf180mcu_fd_io__in_c
X$9339 \$20342 \$21184 \$21308 gf180mcu_fd_sc_mcu9t5v0__clkbuf_4
X$9340 \$20342 \$21669 \$21955 \$21661 \$21946 gf180mcu_fd_sc_mcu9t5v0__dffq_2
X$9341 \$20342 \$20520 \$20390 \$20515 \$20383 gf180mcu_fd_sc_mcu9t5v0__dffq_2
X$9342 \$20342 \$21811 \$21668 \$21661 \$21622 gf180mcu_fd_sc_mcu9t5v0__dffq_2
X$9343 \$20342 \$22136 \$22447 \$22713 \$22440 gf180mcu_fd_sc_mcu9t5v0__dffq_2
X$9344 \$20343 \$24242 \$24593 \$24428 \$24429 gf180mcu_fd_sc_mcu9t5v0__or2_1
X$9345 \$25466 \$20343 \$24310 \$25462 \$25347 \$25351
+ gf180mcu_fd_sc_mcu9t5v0__aoi21_1
X$9346 \$20343 \$24300 \$24238 \$24231 \$24109 \$24237
+ gf180mcu_fd_sc_mcu9t5v0__oai21_1
X$9347 \$20343 \$23930 \$23593 \$23620 \$23454 \$23627
+ gf180mcu_fd_sc_mcu9t5v0__oai21_1
X$9348 \$20343 \$24115 \$23595 \$23620 \$23454 \$23632
+ gf180mcu_fd_sc_mcu9t5v0__oai21_1
X$9349 \$20343 \$24851 \$25058 \$24877 \$24721 \$24852
+ gf180mcu_fd_sc_mcu9t5v0__oai21_1
X$9350 \$22842 \$20343 \$21809 \$22841 \$22713 \$22837 \$22137
+ gf180mcu_fd_sc_mcu9t5v0__aoi22_1
X$9351 \$21668 \$20343 \$21809 \$21503 \$21661 \$21622 \$21667
+ gf180mcu_fd_sc_mcu9t5v0__aoi22_1
X$9352 \$22278 \$20343 \$21809 \$22449 \$22387 \$22272 \$22450
+ gf180mcu_fd_sc_mcu9t5v0__aoi22_1
X$9353 \$21955 \$20343 \$21809 \$21810 \$22074 \$21946 \$21812
+ gf180mcu_fd_sc_mcu9t5v0__aoi22_1
X$9354 \$24600 \$20343 \$24593 \$24721 \$24735 gf180mcu_fd_sc_mcu9t5v0__nand2_1
X$9355 \$25196 \$20343 \$25191 \$25347 \$25352 gf180mcu_fd_sc_mcu9t5v0__nand2_1
X$9356 \$23628 \$20343 \$23620 \$23454 \$23593 gf180mcu_fd_sc_mcu9t5v0__nand2_1
X$9357 \$24853 \$20343 \$25191 \$24997 \$25058 gf180mcu_fd_sc_mcu9t5v0__nand2_1
X$9358 \$24302 \$20343 \$24593 \$24428 \$24238 gf180mcu_fd_sc_mcu9t5v0__nand2_1
X$9359 \$25468 \$20343 \$25462 \$25347 \$25195 gf180mcu_fd_sc_mcu9t5v0__nand2_1
X$9360 \$22905 \$20343 \$23926 \$23807 \$23595 gf180mcu_fd_sc_mcu9t5v0__nand2_1
X$9361 \$24247 \$20343 \$24231 \$24109 \$24246 gf180mcu_fd_sc_mcu9t5v0__nand2_1
X$9362 \$21364 \$21184 \$21308 \$20343 gf180mcu_fd_sc_mcu9t5v0__buf_8
X$9363 \$25307 \$25924 \$20343 \$25797 \$25918 \$25969
+ gf180mcu_fd_sc_mcu9t5v0__mux2_1
X$9364 \$24304 \$24537 \$20343 \$24231 \$24428 \$24306
+ gf180mcu_fd_sc_mcu9t5v0__mux2_1
X$9365 \$20721 \$20394 \$20343 \$20515 \$20718 \$20521
+ gf180mcu_fd_sc_mcu9t5v0__mux2_1
X$9366 \$20583 \$20390 \$20343 \$20515 \$20718 \$20520
+ gf180mcu_fd_sc_mcu9t5v0__mux2_1
X$9367 \$28568 \$28357 \$20343 \$28211 \$28381 \$28384
+ gf180mcu_fd_sc_mcu9t5v0__mux2_1
X$9368 \$28383 \$28510 \$20343 \$28534 \$28381 \$28569
+ gf180mcu_fd_sc_mcu9t5v0__mux2_1
X$9369 \$27801 \$27803 \$20343 \$27913 \$27776 \$27802
+ gf180mcu_fd_sc_mcu9t5v0__mux2_1
X$9370 \$27166 \$27293 \$20343 \$27315 \$27153 \$27167
+ gf180mcu_fd_sc_mcu9t5v0__mux2_1
X$9371 \$24305 \$24250 \$20343 \$24231 \$24109 \$24249
+ gf180mcu_fd_sc_mcu9t5v0__mux2_1
X$9372 \$25309 \$25060 \$20343 \$25191 \$24997 \$25059
+ gf180mcu_fd_sc_mcu9t5v0__mux2_1
X$9373 \$24114 \$24879 \$20343 \$24877 \$24721 \$25001
+ gf180mcu_fd_sc_mcu9t5v0__mux2_1
X$9374 \$24732 \$24999 \$20343 \$25191 \$24997 \$25061
+ gf180mcu_fd_sc_mcu9t5v0__mux2_1
X$9375 \$24107 \$20344 \$24106 \$24231 \$24109 \$24293
+ gf180mcu_fd_sc_mcu9t5v0__mux2_1
X$9376 \$20532 \$20531 \$20515 \$20383 \$20351 gf180mcu_fd_sc_mcu9t5v0__nand2_1
X$9377 \$20533 \$20591 \$20515 \$20383 \$20352 gf180mcu_fd_sc_mcu9t5v0__xnor2_1
X$9378 \$20592 \$20591 \$20515 \$20718 \$20354 gf180mcu_fd_sc_mcu9t5v0__nor2_1
X$9379 \$20356 \$20881 \$21011 \$21028 \$20851 gf180mcu_fd_sc_mcu9t5v0__xor2_1
X$9380 \$20356 \$21498 \$21622 \$20594 gf180mcu_fd_sc_mcu9t5v0__clkinv_1
X$9381 \$20356 \$21386 \$20528 \$21498 \$21308 \$21190
+ gf180mcu_fd_sc_mcu9t5v0__mux2_1
X$9382 \$20542 \$20361 \$20543 \$20515 \$20383 \$20541
+ gf180mcu_fd_sc_mcu9t5v0__aoi21_1
X$9383 \$21834 \$21832 \$21835 \$21661 \$21946 \$20361
+ gf180mcu_fd_sc_mcu9t5v0__oai21_1
X$9384 \$21043 \$20906 \$21184 \$21011 \$20365 gf180mcu_fd_sc_mcu9t5v0__nor2_1
X$9385 \$20368 \$20509 \$20510 \$20515 \$20383 \$20367
+ gf180mcu_fd_sc_mcu9t5v0__aoi21_1
X$9386 \$20368 \$20510 \$21297 \$21184 \$21308 \$21352
+ gf180mcu_fd_sc_mcu9t5v0__aoi21_1
X$9387 \$21495 \$20368 \$21005 \$21298 \$21184 \$21308 \$21297
+ gf180mcu_fd_sc_mcu9t5v0__oai211_1
X$9388 \$20368 \$20510 \$21293 \$20865 \$21296 \$21184 \$21308 \$20831
+ gf180mcu_fd_sc_mcu9t5v0__aoi221_1
X$9389 \$20368 \$20875 \$20881 \$21011 \$21005 gf180mcu_fd_sc_mcu9t5v0__nand2_1
X$9390 \$20368 \$20833 \$20881 \$20718 \$20708 gf180mcu_fd_sc_mcu9t5v0__nand2_1
X$9391 \$20368 \$20515 \$20718 \$20563 gf180mcu_fd_sc_mcu9t5v0__clkinv_1
X$9392 \$20559 \$20557 \$20369 \$20869 \$20881 \$21011 \$20871
+ gf180mcu_fd_sc_mcu9t5v0__nor4_1
X$9393 \$21291 \$20369 \$20869 \$21490 \$21184 \$21308 \$21290
+ gf180mcu_fd_sc_mcu9t5v0__nor4_1
X$9394 \$20559 \$20557 \$20369 \$20869 \$20881 \$20718 \$20870
+ gf180mcu_fd_sc_mcu9t5v0__oai31_1
X$9395 \$20372 \$20370 \$20515 \$20383 \$20510 gf180mcu_fd_sc_mcu9t5v0__nand2_1
X$9396 \$21303 \$21302 \$20372 \$21498 \$21622 \$21496
+ gf180mcu_fd_sc_mcu9t5v0__oai21_1
X$9397 \$21303 \$20372 \$25048 \$25047 \$25191 \$24997 \$25046
+ gf180mcu_fd_sc_mcu9t5v0__aoi22_1
X$9398 \$20571 \$20372 \$20515 \$20718 \$20712 gf180mcu_fd_sc_mcu9t5v0__nand2_1
X$9399 \$20570 \$20372 \$20881 \$21011 \$22270 gf180mcu_fd_sc_mcu9t5v0__nand2_1
X$9400 \$20372 \$20881 \$21011 \$20569 gf180mcu_fd_sc_mcu9t5v0__clkinv_1
X$9401 \$21007 \$21302 \$20372 \$21184 \$21011 \$21139
+ gf180mcu_fd_sc_mcu9t5v0__mux2_1
X$9402 \$21620 \$20375 \$21357 \$21498 \$21622 \$21497
+ gf180mcu_fd_sc_mcu9t5v0__nand3_1
X$9403 \$20876 \$20376 \$20708 \$20568 \$20515 \$20718 \$20710
+ gf180mcu_fd_sc_mcu9t5v0__oai31_1
X$9404 \$25585 \$23802 \$25462 \$25632 \$20379 gf180mcu_fd_sc_mcu9t5v0__nor2_1
X$9405 \$20528 \$20404 \$20515 \$20383 \$20529 gf180mcu_fd_sc_mcu9t5v0__and2_1
X$9406 \$20537 \$20603 \$20604 \$20536 \$20515 \$20383 \$20417
+ gf180mcu_fd_sc_mcu9t5v0__oai211_1
X$9407 \$20533 \$20591 \$20515 \$20383 \$20407 gf180mcu_fd_sc_mcu9t5v0__nor2_1
X$9408 \$20612 \$20613 \$20515 \$20383 \$20547 gf180mcu_fd_sc_mcu9t5v0__nor2_1
X$9409 \$20563 \$20509 \$20515 \$20383 \$20508 gf180mcu_fd_sc_mcu9t5v0__nor2_1
X$9410 \$20383 \$20515 gf180mcu_fd_sc_mcu9t5v0__filltie
X$9411 \$20383 \$20515 gf180mcu_fd_sc_mcu9t5v0__filltie
X$9412 \$20383 \$20515 gf180mcu_fd_sc_mcu9t5v0__filltie
X$9413 \$20383 \$20515 gf180mcu_fd_sc_mcu9t5v0__filltie
X$9414 \$20383 \$20515 gf180mcu_fd_sc_mcu9t5v0__filltie
X$9415 \$20383 \$20515 gf180mcu_fd_sc_mcu9t5v0__filltie
X$9416 \$20705 \$20556 \$21000 \$20515 \$20383 \$20555
+ gf180mcu_fd_sc_mcu9t5v0__mux2_1
X$9417 \$23446 \$20602 \$20392 \$20515 \$20383 \$20601
+ gf180mcu_fd_sc_mcu9t5v0__mux2_1
X$9418 \$24221 \$20522 \$20392 \$20515 \$20383 \$20586
+ gf180mcu_fd_sc_mcu9t5v0__mux2_1
X$9419 \$20517 \$20391 \$20392 \$20515 \$20383 \$20584
+ gf180mcu_fd_sc_mcu9t5v0__mux2_1
X$9420 \$20383 \$20515 gf180mcu_fd_sc_mcu9t5v0__endcap
X$9421 \$28974 \$28810 \$28971 \$20392 gf180mcu_fd_sc_mcu9t5v0__buf_8
X$9422 \$23180 \$23812 \$20392 \$23620 \$23807 \$23811
+ gf180mcu_fd_sc_mcu9t5v0__mux2_1
X$9423 \$22833 \$21826 \$20392 \$21661 \$21946 \$21964
+ gf180mcu_fd_sc_mcu9t5v0__mux2_1
X$9424 \$23317 \$22865 \$20392 \$22713 \$22837 \$22863
+ gf180mcu_fd_sc_mcu9t5v0__mux2_1
X$9425 \$20400 \$20732 \$20392 \$20881 \$21011 \$20854
+ gf180mcu_fd_sc_mcu9t5v0__mux2_1
X$9426 \$23445 \$21390 \$20392 \$21498 \$21308 \$21512
+ gf180mcu_fd_sc_mcu9t5v0__mux2_1
X$9427 \$23922 \$21686 \$20392 \$21661 \$21622 \$21685
+ gf180mcu_fd_sc_mcu9t5v0__mux2_1
X$9428 \$22887 \$22897 \$20392 \$23027 \$22837 \$23031
+ gf180mcu_fd_sc_mcu9t5v0__mux2_1
X$9429 \$21366 \$21187 \$20392 \$21184 \$21011 \$21149
+ gf180mcu_fd_sc_mcu9t5v0__mux2_1
X$9430 \$22279 \$22391 \$20392 \$22387 \$22272 \$22392
+ gf180mcu_fd_sc_mcu9t5v0__mux2_1
X$9431 \$20400 \$28506 \$27658 \$29123 \$29270 \$29302
+ gf180mcu_fd_sc_mcu9t5v0__mux2_1
X$9432 \$20400 \$23584 \$21656 \$23620 \$23454 \$23753
+ gf180mcu_fd_sc_mcu9t5v0__mux2_1
X$9433 \$20400 \$29931 \$29436 \$29954 \$29847 \$29793
+ gf180mcu_fd_sc_mcu9t5v0__mux2_1
X$9434 \$20400 \$28523 \$26339 \$28534 \$28381 \$28524
+ gf180mcu_fd_sc_mcu9t5v0__mux2_1
X$9435 \$20400 \$28329 \$25343 \$28810 \$28689 \$28526
+ gf180mcu_fd_sc_mcu9t5v0__mux2_1
X$9436 \$20728 \$20531 \$20515 \$20718 \$20406 gf180mcu_fd_sc_mcu9t5v0__nand2_1
X$9437 \$20853 \$20881 \$20718 \$20411 gf180mcu_fd_sc_mcu9t5v0__clkinv_1
X$9438 \$20559 \$20557 \$20515 \$20718 \$20507 gf180mcu_fd_sc_mcu9t5v0__nor2_1
X$9439 \$20562 \$20515 \$20718 \$20509 gf180mcu_fd_sc_mcu9t5v0__clkinv_1
X$9440 \$20562 \$20510 \$20881 \$20718 \$20833 gf180mcu_fd_sc_mcu9t5v0__nor2_1
X$9441 \$20730 \$20729 \$20850 \$20515 \$20718 \$20593
+ gf180mcu_fd_sc_mcu9t5v0__aoi21_1
X$9442 \$20537 \$20603 \$20604 \$20515 \$20718 \$20538
+ gf180mcu_fd_sc_mcu9t5v0__oai21_1
X$9443 \$20617 \$20862 \$20618 \$20515 \$20718 \$20551
+ gf180mcu_fd_sc_mcu9t5v0__oai21_1
X$9444 \$20592 \$20515 \$20718 \$20533 gf180mcu_fd_sc_mcu9t5v0__clkinv_1
X$9445 \$20890 \$20589 \$20515 \$20718 \$20527 gf180mcu_fd_sc_mcu9t5v0__nand2_1
X$9446 \$20570 \$20569 \$20515 \$20718 \$20568 gf180mcu_fd_sc_mcu9t5v0__nand2_1
X$9447 \$20558 \$20557 \$21000 \$20515 \$20718 \$20706
+ gf180mcu_fd_sc_mcu9t5v0__mux2_1
X$9448 \$20718 \$20515 gf180mcu_fd_sc_mcu9t5v0__filltie
X$9449 \$20718 \$20515 gf180mcu_fd_sc_mcu9t5v0__filltie
X$9450 \$20718 \$20515 gf180mcu_fd_sc_mcu9t5v0__filltie
X$9451 \$20718 \$20515 gf180mcu_fd_sc_mcu9t5v0__filltie
X$9452 \$20718 \$20515 gf180mcu_fd_sc_mcu9t5v0__filltie
X$9453 \$20718 \$20515 gf180mcu_fd_sc_mcu9t5v0__filltie
X$9454 \$I488 \$20515 gf180mcu_fd_sc_mcu9t5v0__endcap
X$9455 \$20718 \$20515 gf180mcu_fd_sc_mcu9t5v0__endcap
X$9456 \$20718 \$20515 gf180mcu_fd_sc_mcu9t5v0__endcap
X$9457 \$20517 \$22888 \$23183 \$23454 \$23132 gf180mcu_fd_sc_mcu9t5v0__nand2_1
X$9458 \$20517 \$26078 \$25343 \$26088 \$26220 \$25961
+ gf180mcu_fd_sc_mcu9t5v0__mux2_1
X$9459 \$20517 \$29435 \$27658 \$29290 \$29424 \$29434
+ gf180mcu_fd_sc_mcu9t5v0__mux2_1
X$9460 \$20517 \$26635 \$26339 \$26401 \$26521 \$26507
+ gf180mcu_fd_sc_mcu9t5v0__mux2_1
X$9461 \$20517 \$29961 \$29436 \$29954 \$29847 \$29960
+ gf180mcu_fd_sc_mcu9t5v0__mux2_1
X$9462 \$20517 \$21799 \$21656 \$21661 \$21622 \$21655
+ gf180mcu_fd_sc_mcu9t5v0__mux2_1
X$9463 \$21156 \$21155 \$21184 \$21011 \$20525 gf180mcu_fd_sc_mcu9t5v0__xnor2_1
X$9464 \$20528 \$21829 \$22465 \$22404 \$21832 \$22387 \$22440 \$22155
+ gf180mcu_fd_sc_mcu9t5v0__oai32_1
X$9465 \$20528 \$20889 \$21498 \$21308 \$21374 gf180mcu_fd_sc_mcu9t5v0__and2_1
X$9466 \$20729 \$20847 \$20528 \$20881 \$20718 \$20848
+ gf180mcu_fd_sc_mcu9t5v0__aoi21_1
X$9467 \$21631 \$22400 \$22399 \$20528 \$22387 \$22272 \$21675
+ gf180mcu_fd_sc_mcu9t5v0__oai22_1
X$9468 \$22463 \$22405 \$20528 \$22387 \$22272 \$22404
+ gf180mcu_fd_sc_mcu9t5v0__oai21_1
X$9469 \$22592 \$22593 \$20528 \$22713 \$22440 \$22400
+ gf180mcu_fd_sc_mcu9t5v0__oai21_1
X$9470 \$20528 \$21676 \$21679 \$21677 \$21661 \$21622 \$20722
+ gf180mcu_fd_sc_mcu9t5v0__oai31_1
X$9471 \$20528 \$21027 \$21184 \$21011 \$21159 gf180mcu_fd_sc_mcu9t5v0__nor2_1
X$9472 \$22461 \$22387 \$22440 \$20528 gf180mcu_fd_sc_mcu9t5v0__buf_8
X$9473 \$20896 \$21330 \$20528 \$21184 \$21308 \$21170
+ gf180mcu_fd_sc_mcu9t5v0__mux2_1
X$9474 \$21680 \$22848 \$20528 \$22387 \$22440 \$22398
+ gf180mcu_fd_sc_mcu9t5v0__mux2_1
X$9475 \$20728 \$21960 \$20528 \$21661 \$21946 \$21189
+ gf180mcu_fd_sc_mcu9t5v0__mux2_1
X$9476 \$21320 \$22083 \$20528 \$22074 \$21946 \$21188
+ gf180mcu_fd_sc_mcu9t5v0__mux2_1
X$9477 \$20592 \$22457 \$20528 \$22074 \$21946 \$21636
+ gf180mcu_fd_sc_mcu9t5v0__mux2_1
X$9478 \$21026 \$20881 \$21011 \$20530 gf180mcu_fd_sc_mcu9t5v0__clkinv_1
X$9479 \$21153 \$22086 \$21661 \$21946 \$20531 \$21823
+ gf180mcu_fd_sc_mcu9t5v0__xnor3_1
X$9480 \$21153 \$20532 \$21027 \$20881 \$21011 \$20729
+ gf180mcu_fd_sc_mcu9t5v0__aoi21_1
X$9481 \$20728 \$20881 \$20718 \$20532 gf180mcu_fd_sc_mcu9t5v0__clkinv_1
X$9482 \$20725 \$20533 \$20881 \$20718 \$20730 gf180mcu_fd_sc_mcu9t5v0__nand2_1
X$9483 \$20594 \$20852 \$20881 \$20718 \$20534 gf180mcu_fd_sc_mcu9t5v0__or2_1
X$9484 \$21169 \$21170 \$21184 \$21011 \$20537 gf180mcu_fd_sc_mcu9t5v0__and2_1
X$9485 \$20901 \$20898 \$20881 \$21011 \$20539 \$20734
+ gf180mcu_fd_sc_mcu9t5v0__xnor3_1
X$9486 \$21690 \$21642 \$22098 \$22074 \$21946 \$20542
+ gf180mcu_fd_sc_mcu9t5v0__nand3_1
X$9487 \$20901 \$21391 \$21184 \$21011 \$20543 \$21174
+ gf180mcu_fd_sc_mcu9t5v0__xnor3_1
X$9488 \$21690 \$21196 \$21836 \$21835 \$21837 \$21661 \$21946 \$20544
+ gf180mcu_fd_sc_mcu9t5v0__oai32_1
X$9489 \$20556 \$20881 \$21011 \$20864 \$20823 gf180mcu_fd_sc_mcu9t5v0__xor2_1
X$9490 \$21137 \$21002 \$20556 \$21184 \$21011 \$21003
+ gf180mcu_fd_sc_mcu9t5v0__nor3_1
X$9491 \$20557 \$20881 \$21011 \$20868 gf180mcu_fd_sc_mcu9t5v0__clkinv_1
X$9492 \$20559 \$20868 \$21003 \$21290 \$21184 \$21308 \$21181
+ gf180mcu_fd_sc_mcu9t5v0__nand4_1
X$9493 \$20559 \$21135 \$21184 \$21308 \$21289 gf180mcu_fd_sc_mcu9t5v0__nor2_1
X$9494 \$20559 \$20868 \$20881 \$21011 \$20867 gf180mcu_fd_sc_mcu9t5v0__nor2_1
X$9495 \$20559 \$20868 \$20881 \$21011 \$20866 gf180mcu_fd_sc_mcu9t5v0__nand2_1
X$9496 \$21289 \$20559 \$21000 \$21184 \$21308 \$21288
+ gf180mcu_fd_sc_mcu9t5v0__mux2_1
X$9497 \$20865 \$20561 \$21498 \$21308 \$21492 gf180mcu_fd_sc_mcu9t5v0__nor2_1
X$9498 \$20565 \$20881 \$20718 \$20835 gf180mcu_fd_sc_mcu9t5v0__dlyc_1
X$9499 \$20566 \$21184 \$21011 \$20875 gf180mcu_fd_sc_mcu9t5v0__dlyc_1
X$9500 \$21302 \$20569 \$21184 \$21308 \$21299 gf180mcu_fd_sc_mcu9t5v0__nand2_1
X$9501 \$21303 \$20569 \$21184 \$21308 \$21300 gf180mcu_fd_sc_mcu9t5v0__nand2_1
X$9502 \$20571 \$20569 \$20881 \$20718 \$20836 gf180mcu_fd_sc_mcu9t5v0__nand2_1
X$9503 \$27166 \$20573 \$27015 \$27153 \$27042 gf180mcu_fd_sc_mcu9t5v0__nand2_1
X$9504 \$27801 \$20573 \$27637 \$27776 \$27799 gf180mcu_fd_sc_mcu9t5v0__nand2_1
X$9505 \$28383 \$20573 \$28211 \$28089 \$28227 gf180mcu_fd_sc_mcu9t5v0__nand2_1
X$9506 \$28568 \$20573 \$28534 \$28381 \$28508 gf180mcu_fd_sc_mcu9t5v0__nand2_1
X$9507 \$20574 \$21498 \$21622 \$21621 gf180mcu_fd_sc_mcu9t5v0__buf_8
X$9508 \$20587 \$20881 \$20718 \$20727 gf180mcu_fd_sc_mcu9t5v0__clkinv_1
X$9509 \$21323 \$21381 \$21498 \$21308 \$20591 \$21386
+ gf180mcu_fd_sc_mcu9t5v0__xnor3_1
X$9510 \$21323 \$20592 \$21184 \$21011 \$20849 gf180mcu_fd_sc_mcu9t5v0__nand2_1
X$9511 \$20595 \$20894 \$21163 \$21194 \$20881 \$21011 \$21030
+ gf180mcu_fd_sc_mcu9t5v0__aoi22_1
X$9512 \$21686 \$21661 \$21622 \$20600 gf180mcu_fd_sc_mcu9t5v0__clkinv_1
X$9513 \$21966 \$21827 \$21661 \$21946 \$20603 gf180mcu_fd_sc_mcu9t5v0__nand2_1
X$9514 \$21169 \$21170 \$20881 \$20718 \$20604 gf180mcu_fd_sc_mcu9t5v0__or2_1
X$9515 \$20900 \$20899 \$20896 \$20881 \$21011 \$20606
+ gf180mcu_fd_sc_mcu9t5v0__aoi21_1
X$9516 \$20608 \$21393 \$21328 \$21498 \$21622 \$21394
+ gf180mcu_fd_sc_mcu9t5v0__mux2_1
X$9517 \$20859 \$20858 \$20881 \$20718 \$20610 gf180mcu_fd_sc_mcu9t5v0__nand2_1
X$9518 \$20859 \$20858 \$20881 \$20718 \$20611 gf180mcu_fd_sc_mcu9t5v0__xnor2_1
X$9519 \$21041 \$20903 \$20881 \$21011 \$20612 gf180mcu_fd_sc_mcu9t5v0__nor2_1
X$9520 \$21175 \$21042 \$21184 \$21011 \$20613 gf180mcu_fd_sc_mcu9t5v0__and2_1
X$9521 \$31547 \$27913 \$28089 \$20615 gf180mcu_fd_sc_mcu9t5v0__buf_8
X$9522 \$23215 \$20615 \$21197 \$23027 \$23139 \$23166
+ gf180mcu_fd_sc_mcu9t5v0__mux2_1
X$9523 \$20615 \$28069 \$23348 \$27913 \$28089 \$27943
+ gf180mcu_fd_sc_mcu9t5v0__mux2_1
X$9524 \$20615 \$26835 \$23479 \$26675 \$26856 \$26877
+ gf180mcu_fd_sc_mcu9t5v0__mux2_1
X$9525 \$20615 \$24130 \$22928 \$24593 \$24428 \$24090
+ gf180mcu_fd_sc_mcu9t5v0__mux2_1
X$9526 \$20615 \$23222 \$22930 \$23183 \$23139 \$23356
+ gf180mcu_fd_sc_mcu9t5v0__mux2_1
X$9527 \$23652 \$20616 \$22930 \$23183 \$23454 \$23478
+ gf180mcu_fd_sc_mcu9t5v0__mux2_1
X$9528 \$20908 \$20907 \$20881 \$21011 \$20617 gf180mcu_fd_sc_mcu9t5v0__nor2_1
X$9529 \$20908 \$20907 \$20881 \$21011 \$20618 gf180mcu_fd_sc_mcu9t5v0__nand2_1
X$9530 \$21000 \$20707 \$20827 \$20881 \$20718 \$20873
+ gf180mcu_fd_sc_mcu9t5v0__oai21_1
X$9531 \$21615 \$21354 \$20708 \$20875 \$21498 \$21308 \$21355
+ gf180mcu_fd_sc_mcu9t5v0__oai22_1
X$9532 \$20838 \$21184 \$21011 \$20714 gf180mcu_fd_sc_mcu9t5v0__clkinv_1
X$9533 \$20908 \$20862 \$20881 \$20718 \$20909 \$20907
+ gf180mcu_fd_sc_mcu9t5v0__xnor3_1
X$9534 \$20730 \$20729 \$20850 \$20851 \$20881 \$20718 \$20731
+ gf180mcu_fd_sc_mcu9t5v0__aoi211_1
X$9535 \$20896 \$20734 \$20881 \$20718 \$20855 gf180mcu_fd_sc_mcu9t5v0__nor2_1
X$9536 \$20832 \$20831 \$20881 \$20718 \$20874 gf180mcu_fd_sc_mcu9t5v0__nand2_1
X$9537 \$20730 \$20849 \$20881 \$20718 \$20847 gf180mcu_fd_sc_mcu9t5v0__nand2_1
X$9538 \$20718 \$20881 gf180mcu_fd_sc_mcu9t5v0__filltie
X$9539 \$20718 \$20881 gf180mcu_fd_sc_mcu9t5v0__filltie
X$9540 \$20718 \$20881 gf180mcu_fd_sc_mcu9t5v0__filltie
X$9541 \$20718 \$20881 gf180mcu_fd_sc_mcu9t5v0__filltie
X$9542 \$20718 \$20881 gf180mcu_fd_sc_mcu9t5v0__filltie
X$9543 \$20718 \$20881 gf180mcu_fd_sc_mcu9t5v0__filltie
X$9544 \$20718 \$20881 gf180mcu_fd_sc_mcu9t5v0__endcap
X$9545 \$20718 \$20881 gf180mcu_fd_sc_mcu9t5v0__endcap
X$9546 \$20725 \$21636 \$21498 \$21622 \$21510 gf180mcu_fd_sc_mcu9t5v0__or2_1
X$9547 \$20725 \$21636 \$21498 \$21622 \$21383 gf180mcu_fd_sc_mcu9t5v0__nand2_1
X$9548 \$20725 \$21184 \$21308 \$21323 gf180mcu_fd_sc_mcu9t5v0__clkinv_1
X$9549 \$21153 \$21498 \$21622 \$20728 \$21635 gf180mcu_fd_sc_mcu9t5v0__xor2_1
X$9550 \$21169 \$21184 \$21011 \$20734 gf180mcu_fd_sc_mcu9t5v0__clkinv_1
X$9551 \$20734 \$21171 \$21184 \$21011 \$21173 gf180mcu_fd_sc_mcu9t5v0__nor2_1
X$9552 \$20734 \$21171 \$21184 \$21011 \$21033 gf180mcu_fd_sc_mcu9t5v0__nand2_1
X$9553 \$20896 \$20734 \$20881 \$21011 \$20897 gf180mcu_fd_sc_mcu9t5v0__nand2_1
X$9554 \$20865 \$20866 \$20881 \$21011 \$20824 gf180mcu_fd_sc_mcu9t5v0__nand2_1
X$9555 \$20826 \$21184 \$21011 gf180mcu_fd_sc_mcu9t5v0__clkinv_3
X$9556 \$20869 \$21000 \$21184 \$21011 \$20827 gf180mcu_fd_sc_mcu9t5v0__nand2_1
X$9557 \$21135 \$20828 \$21347 \$21498 \$21308 \$21349
+ gf180mcu_fd_sc_mcu9t5v0__oai21_1
X$9558 \$21004 \$21181 \$21184 \$21011 \$20828 gf180mcu_fd_sc_mcu9t5v0__nor2_1
X$9559 \$21347 \$20829 \$21184 \$21308 \$21292 gf180mcu_fd_sc_mcu9t5v0__and2_1
X$9560 \$20865 \$21138 \$21184 \$21011 \$20829 gf180mcu_fd_sc_mcu9t5v0__nand2_1
X$9561 \$21006 \$21184 \$21011 \$20834 gf180mcu_fd_sc_mcu9t5v0__dlyc_1
X$9562 \$20835 \$20881 \$21011 \$20876 gf180mcu_fd_sc_mcu9t5v0__clkinv_1
X$9563 \$20845 \$22387 \$22272 gf180mcu_fd_sc_mcu9t5v0__inv_4
X$9564 \$20849 \$20881 \$21011 \$20850 gf180mcu_fd_sc_mcu9t5v0__clkinv_1
X$9565 \$21193 \$21184 \$21308 \$21192 \$20852 gf180mcu_fd_sc_mcu9t5v0__xor2_1
X$9566 \$20858 \$21040 \$21199 \$20881 \$21011 \$20857
+ gf180mcu_fd_sc_mcu9t5v0__mux2_1
X$9567 \$20906 \$20905 \$20881 \$21011 \$20860 gf180mcu_fd_sc_mcu9t5v0__xnor2_1
X$9568 \$20911 \$20912 \$20910 \$20881 \$21011 \$20862
+ gf180mcu_fd_sc_mcu9t5v0__oai21_1
X$9569 \$21137 \$21002 \$21136 \$21184 \$21011 \$20864
+ gf180mcu_fd_sc_mcu9t5v0__nor3_1
X$9570 \$20865 \$21345 \$21492 \$21346 \$21498 \$21308 \$21654
+ gf180mcu_fd_sc_mcu9t5v0__aoi211_1
X$9571 \$20865 \$20870 \$20881 \$21011 \$20872 gf180mcu_fd_sc_mcu9t5v0__nand2_1
X$9572 \$20865 \$21004 \$21498 \$21308 \$21348 gf180mcu_fd_sc_mcu9t5v0__nand2_1
X$9573 \$20865 \$21184 \$21308 \$21135 gf180mcu_fd_sc_mcu9t5v0__clkinv_1
X$9574 \$21491 \$20871 \$21498 \$21622 \$21345 gf180mcu_fd_sc_mcu9t5v0__xnor2_1
X$9575 \$21491 \$20871 \$21498 \$21622 \$21612 gf180mcu_fd_sc_mcu9t5v0__nand2_1
X$9576 \$22268 \$22123 \$22267 \$22387 \$22272 \$20877
+ gf180mcu_fd_sc_mcu9t5v0__aoi21_1
X$9577 \$20902 \$21198 \$21037 \$20881 \$21011 \$21038
+ gf180mcu_fd_sc_mcu9t5v0__and3_1
X$9578 \$21044 \$20881 \$21011 \$21045 gf180mcu_fd_sc_mcu9t5v0__clkinv_1
X$9579 \$20911 \$20912 \$20881 \$21011 \$20913 gf180mcu_fd_sc_mcu9t5v0__nand2_1
X$9580 \$20913 \$21050 \$20881 \$21011 \$20910 gf180mcu_fd_sc_mcu9t5v0__nand2_1
X$9581 \$21011 \$20881 gf180mcu_fd_sc_mcu9t5v0__filltie
X$9582 \$21011 \$20881 gf180mcu_fd_sc_mcu9t5v0__filltie
X$9583 \$21011 \$20881 gf180mcu_fd_sc_mcu9t5v0__filltie
X$9584 \$21011 \$20881 gf180mcu_fd_sc_mcu9t5v0__filltie
X$9585 \$21011 \$20881 gf180mcu_fd_sc_mcu9t5v0__filltie
X$9586 \$21011 \$20881 gf180mcu_fd_sc_mcu9t5v0__filltie
X$9587 \$21011 \$20881 gf180mcu_fd_sc_mcu9t5v0__endcap
X$9588 \$21011 \$20881 gf180mcu_fd_sc_mcu9t5v0__endcap
X$9589 \$21630 \$21631 \$21376 \$21498 \$21622 \$20889
+ gf180mcu_fd_sc_mcu9t5v0__oai21_1
X$9590 \$21320 \$21157 \$21184 \$21308 \$20891 gf180mcu_fd_sc_mcu9t5v0__nor2_1
X$9591 \$20894 \$21184 \$21308 \$21195 gf180mcu_fd_sc_mcu9t5v0__clkinv_1
X$9592 \$20896 \$21184 \$21011 \$20901 gf180mcu_fd_sc_mcu9t5v0__clkinv_1
X$9593 \$21392 \$21690 \$21687 \$21661 \$21622 \$20898
+ gf180mcu_fd_sc_mcu9t5v0__oai21_1
X$9594 \$21392 \$21330 \$21642 \$21391 \$21498 \$21622 \$20899
+ gf180mcu_fd_sc_mcu9t5v0__oai211_1
X$9595 \$21034 \$21196 \$21332 \$21184 \$21308 \$20900
+ gf180mcu_fd_sc_mcu9t5v0__oai21_1
X$9596 \$20902 \$21498 \$21622 \$21335 \$21643 gf180mcu_fd_sc_mcu9t5v0__xor2_1
X$9597 \$20902 \$22387 \$22440 \$22286 \$22409 gf180mcu_fd_sc_mcu9t5v0__xor2_1
X$9598 \$20902 \$22074 \$21946 \$21839 \$21840 gf180mcu_fd_sc_mcu9t5v0__xor2_1
X$9599 \$20902 \$21037 \$21184 \$21011 \$21039 \$21036
+ gf180mcu_fd_sc_mcu9t5v0__xnor3_1
X$9600 \$20902 \$22603 \$22713 \$22837 \$22874 gf180mcu_fd_sc_mcu9t5v0__xnor2_1
X$9601 \$20902 \$21198 \$21037 \$21184 \$21308 \$21336
+ gf180mcu_fd_sc_mcu9t5v0__nor3_1
X$9602 \$20902 \$22603 \$22408 \$22387 \$22440 \$22410
+ gf180mcu_fd_sc_mcu9t5v0__aoi21_1
X$9603 \$22603 \$22286 \$20902 \$22387 \$22440 \$21693
+ gf180mcu_fd_sc_mcu9t5v0__oai21_1
X$9604 \$20902 \$23348 \$23183 \$23454 \$23349 gf180mcu_fd_sc_mcu9t5v0__nand2_1
X$9605 \$20902 \$21839 \$21661 \$21946 \$21692 gf180mcu_fd_sc_mcu9t5v0__nand2_1
X$9606 \$20902 \$21335 \$21661 \$21622 \$21691 gf180mcu_fd_sc_mcu9t5v0__nand2_1
X$9607 \$20903 \$22413 \$22387 \$22272 \$22287 gf180mcu_fd_sc_mcu9t5v0__nand2_1
X$9608 \$21041 \$20903 \$21184 \$21308 \$21175 gf180mcu_fd_sc_mcu9t5v0__nand2_1
X$9609 \$21044 \$21043 \$21184 \$21011 \$20905 gf180mcu_fd_sc_mcu9t5v0__nand2_1
X$9610 \$22173 \$20908 \$22930 \$22713 \$22440 \$22472
+ gf180mcu_fd_sc_mcu9t5v0__mux2_1
X$9611 \$20911 \$22930 \$21498 \$21622 \$21522 gf180mcu_fd_sc_mcu9t5v0__nand2_1
X$9612 \$21135 \$21000 \$21001 \$20999 \$21184 \$21011 \$20998
+ gf180mcu_fd_sc_mcu9t5v0__oai31_1
X$9613 \$21002 \$21000 \$21498 \$21308 \$20999 gf180mcu_fd_sc_mcu9t5v0__nand2_1
X$9614 \$21491 \$21000 \$21654 \$21661 \$21622 \$21794
+ gf180mcu_fd_sc_mcu9t5v0__aoi21_1
X$9615 \$21135 \$21000 \$21608 \$21344 \$21498 \$21622 \$21609
+ gf180mcu_fd_sc_mcu9t5v0__oai31_1
X$9616 \$21135 \$21000 \$21653 \$21610 \$21661 \$21622 \$21611
+ gf180mcu_fd_sc_mcu9t5v0__oai31_1
X$9617 \$21490 \$21000 \$21498 \$21622 \$21610 gf180mcu_fd_sc_mcu9t5v0__nand2_1
X$9618 \$21137 \$21000 \$21498 \$21308 \$21344 gf180mcu_fd_sc_mcu9t5v0__nand2_1
X$9619 \$21346 \$21498 \$21622 \$21000 gf180mcu_fd_sc_mcu9t5v0__buf_8
X$9620 \$21002 \$21287 \$21184 \$21308 \$21001 gf180mcu_fd_sc_mcu9t5v0__xnor2_1
X$9621 \$21004 \$21181 \$21138 \$21184 \$21308 \$21293
+ gf180mcu_fd_sc_mcu9t5v0__oai21_1
X$9622 \$21158 \$21157 \$21184 \$21011 \$21026 gf180mcu_fd_sc_mcu9t5v0__or2_1
X$9623 \$21161 \$21381 \$21191 \$21193 \$21184 \$21011 \$21194
+ gf180mcu_fd_sc_mcu9t5v0__oai211_1
X$9624 \$21162 \$21184 \$21011 \$21029 gf180mcu_fd_sc_mcu9t5v0__clkinv_1
X$9625 \$21028 \$21029 \$21184 \$21011 \$21163 gf180mcu_fd_sc_mcu9t5v0__nand2_1
X$9626 \$21011 \$21184 gf180mcu_fd_sc_mcu9t5v0__filltie
X$9627 \$21011 \$21184 gf180mcu_fd_sc_mcu9t5v0__filltie
X$9628 \$21011 \$21184 gf180mcu_fd_sc_mcu9t5v0__filltie
X$9629 \$21011 \$21184 gf180mcu_fd_sc_mcu9t5v0__filltie
X$9630 \$21011 \$21184 gf180mcu_fd_sc_mcu9t5v0__filltie
X$9631 \$21011 \$21184 gf180mcu_fd_sc_mcu9t5v0__filltie
X$9632 \$21942 \$21015 \$21016 \$21184 \$21011 gf180mcu_fd_sc_mcu9t5v0__dffq_2
X$9633 \$21011 \$21184 gf180mcu_fd_sc_mcu9t5v0__endcap
X$9634 \$21011 \$21184 gf180mcu_fd_sc_mcu9t5v0__endcap
X$9635 \$21958 \$21661 \$21622 \$21024 gf180mcu_fd_sc_mcu9t5v0__clkinv_1
X$9636 \$21680 \$21378 \$21498 \$21622 \$21025 gf180mcu_fd_sc_mcu9t5v0__nand2_1
X$9637 \$21633 \$21681 \$21634 \$21635 \$21498 \$21622 \$21027
+ gf180mcu_fd_sc_mcu9t5v0__aoi211_1
X$9638 \$21028 \$21190 \$21184 \$21308 \$21322 gf180mcu_fd_sc_mcu9t5v0__xnor2_1
X$9639 \$21028 \$21162 \$21184 \$21308 \$21193 gf180mcu_fd_sc_mcu9t5v0__xnor2_1
X$9640 \$21392 \$21330 \$21498 \$21308 \$21034 gf180mcu_fd_sc_mcu9t5v0__nor2_1
X$9641 \$21034 \$21196 \$21184 \$21308 \$21174 gf180mcu_fd_sc_mcu9t5v0__nor2_1
X$9642 \$21036 \$21184 \$21308 \$21198 gf180mcu_fd_sc_mcu9t5v0__clkinv_1
X$9643 \$21691 \$21692 \$21694 \$21693 \$21661 \$21622 \$21037
+ gf180mcu_fd_sc_mcu9t5v0__and4_1
X$9644 \$21038 \$21336 \$21184 \$21308 \$21337 gf180mcu_fd_sc_mcu9t5v0__nor2_1
X$9645 \$22409 \$22410 \$22387 \$22272 \$21040 gf180mcu_fd_sc_mcu9t5v0__xnor2_1
X$9646 \$22415 \$22604 \$22469 \$22713 \$22837 \$21042
+ gf180mcu_fd_sc_mcu9t5v0__aoi21_1
X$9647 \$21649 \$21397 \$21498 \$21622 \$21043 gf180mcu_fd_sc_mcu9t5v0__nand2_1
X$9648 \$21045 \$21399 \$21498 \$21308 \$21397 gf180mcu_fd_sc_mcu9t5v0__nor2_1
X$9649 \$30181 \$29801 \$30054 \$30185 \$21048 gf180mcu_fd_sc_mcu9t5v0__xnor2_1
X$9650 \$24563 \$21048 \$21197 \$24593 \$24428 \$24613
+ gf180mcu_fd_sc_mcu9t5v0__mux2_1
X$9651 \$21048 \$24870 \$22930 \$24877 \$24721 \$24896
+ gf180mcu_fd_sc_mcu9t5v0__mux2_1
X$9652 \$21048 \$28986 \$23479 \$29123 \$28971 \$28957
+ gf180mcu_fd_sc_mcu9t5v0__mux2_1
X$9653 \$21048 \$22615 \$22928 \$22713 \$22440 \$22731
+ gf180mcu_fd_sc_mcu9t5v0__mux2_1
X$9654 \$21048 \$28956 \$23348 \$29290 \$29270 \$29257
+ gf180mcu_fd_sc_mcu9t5v0__mux2_1
X$9655 \$21706 \$22289 \$22420 \$22074 \$22272 \$21050
+ gf180mcu_fd_sc_mcu9t5v0__aoi21_1
X$9656 \$21137 \$21498 \$21622 \$21136 \$21608 gf180mcu_fd_sc_mcu9t5v0__xor2_1
X$9657 \$21490 \$21612 \$21498 \$21308 \$21136 gf180mcu_fd_sc_mcu9t5v0__or2_1
X$9658 \$21137 \$21136 \$21184 \$21308 \$21287 gf180mcu_fd_sc_mcu9t5v0__nor2_1
X$9659 \$23176 \$23614 \$23183 \$23139 \$21138 gf180mcu_fd_sc_mcu9t5v0__nand2_1
X$9660 \$22121 \$21141 \$22827 \$21800 \$22118 \$21799 \$22074 \$22272 \$22123
+ gf180mcu_fd_sc_mcu9t5v0__aoi222_1
X$9661 \$21497 \$21145 \$21498 \$21622 \$22388 gf180mcu_fd_sc_mcu9t5v0__nand2_1
X$9662 \$21153 \$21189 \$21184 \$21308 \$21156 gf180mcu_fd_sc_mcu9t5v0__xnor2_1
X$9663 \$21153 \$21189 \$21318 \$21184 \$21308 \$21319
+ gf180mcu_fd_sc_mcu9t5v0__aoi21_1
X$9664 \$21153 \$21823 \$22074 \$21946 \$21961 gf180mcu_fd_sc_mcu9t5v0__nor2_1
X$9665 \$21153 \$21823 \$22074 \$22272 \$22088 gf180mcu_fd_sc_mcu9t5v0__nand2_1
X$9666 \$21317 \$21316 \$21372 \$21498 \$21308 \$21155
+ gf180mcu_fd_sc_mcu9t5v0__aoi21_1
X$9667 \$21317 \$21316 \$21372 \$21156 \$21184 \$21308 \$21318
+ gf180mcu_fd_sc_mcu9t5v0__aoi211_1
X$9668 \$21959 \$22085 \$22074 \$21946 \$21157 \$21960
+ gf180mcu_fd_sc_mcu9t5v0__xnor3_1
X$9669 \$21158 \$21681 \$21661 \$21622 \$21682 \$21507
+ gf180mcu_fd_sc_mcu9t5v0__xnor3_1
X$9670 \$21320 \$21184 \$21308 \$21158 gf180mcu_fd_sc_mcu9t5v0__clkinv_1
X$9671 \$21158 \$21507 \$21498 \$21622 \$21634 gf180mcu_fd_sc_mcu9t5v0__nor2_1
X$9672 \$21158 \$21507 \$21498 \$21622 \$21633 gf180mcu_fd_sc_mcu9t5v0__nand2_1
X$9673 \$21635 \$21633 \$21380 \$21661 \$21622 \$21160
+ gf180mcu_fd_sc_mcu9t5v0__nand3_1
X$9674 \$21161 \$21381 \$21191 \$21498 \$21308 \$21192
+ gf180mcu_fd_sc_mcu9t5v0__oai21_1
X$9675 \$21323 \$21386 \$21498 \$21622 \$21161 gf180mcu_fd_sc_mcu9t5v0__nor2_1
X$9676 \$21163 \$21194 \$21184 \$21308 \$21164 gf180mcu_fd_sc_mcu9t5v0__nand2_1
X$9677 \$21168 \$21327 \$21328 \$21184 \$21308 \$21167
+ gf180mcu_fd_sc_mcu9t5v0__mux2_1
X$9678 \$21169 \$21171 \$21498 \$21308 \$21391 gf180mcu_fd_sc_mcu9t5v0__xnor2_1
X$9679 \$21341 \$21179 \$21400 \$21498 \$21308 \$21518
+ gf180mcu_fd_sc_mcu9t5v0__oai21_1
X$9680 \$21341 \$21179 \$21498 \$21308 \$21401 gf180mcu_fd_sc_mcu9t5v0__nand2_1
X$9681 \$24425 \$22706 \$23916 \$23926 \$24109 \$21182
+ gf180mcu_fd_sc_mcu9t5v0__nor3_1
X$9682 \$23803 \$21182 \$23926 \$23807 \$23923 gf180mcu_fd_sc_mcu9t5v0__nor2_1
X$9683 \$21391 \$21184 \$21308 \$21332 gf180mcu_fd_sc_mcu9t5v0__clkinv_1
X$9684 \$21510 \$21184 \$21308 \$21385 gf180mcu_fd_sc_mcu9t5v0__clkinv_1
X$9685 \$21341 \$22928 \$21184 \$21308 \$21343 gf180mcu_fd_sc_mcu9t5v0__nand2_1
X$9686 \$21323 \$21386 \$21184 \$21308 \$21191 gf180mcu_fd_sc_mcu9t5v0__nand2_1
X$9687 \$21298 \$22068 \$21184 \$21308 \$21296 gf180mcu_fd_sc_mcu9t5v0__nand2_1
X$9688 \$21308 \$21184 gf180mcu_fd_sc_mcu9t5v0__filltie
X$9689 \$21308 \$21184 gf180mcu_fd_sc_mcu9t5v0__filltie
X$9690 \$21308 \$21184 gf180mcu_fd_sc_mcu9t5v0__filltie
X$9691 \$21308 \$21184 gf180mcu_fd_sc_mcu9t5v0__filltie
X$9692 \$21308 \$21184 gf180mcu_fd_sc_mcu9t5v0__filltie
X$9693 \$21308 \$21184 gf180mcu_fd_sc_mcu9t5v0__filltie
X$9694 \$21308 \$21184 gf180mcu_fd_sc_mcu9t5v0__endcap
X$9695 \$21308 \$21184 gf180mcu_fd_sc_mcu9t5v0__endcap
X$9696 \$21507 \$21188 \$21498 \$21308 \$21372 gf180mcu_fd_sc_mcu9t5v0__nor2_1
X$9697 \$21507 \$21188 \$21498 \$21622 \$21317 gf180mcu_fd_sc_mcu9t5v0__nand2_1
X$9698 \$22467 \$22466 \$22159 \$22387 \$22440 \$21196
+ gf180mcu_fd_sc_mcu9t5v0__aoi21_1
X$9699 \$21197 \$29094 \$29123 \$28971 \$28821 gf180mcu_fd_sc_mcu9t5v0__nand2_1
X$9700 \$29095 \$29123 \$29270 \$21197 gf180mcu_fd_sc_mcu9t5v0__buf_8
X$9701 \$27179 \$27344 \$21197 \$27015 \$27153 \$27178
+ gf180mcu_fd_sc_mcu9t5v0__mux2_1
X$9702 \$23824 \$21844 \$21197 \$23926 \$23807 \$23949
+ gf180mcu_fd_sc_mcu9t5v0__mux2_1
X$9703 \$25644 \$23481 \$21197 \$25797 \$25632 \$25816
+ gf180mcu_fd_sc_mcu9t5v0__mux2_1
X$9704 \$25091 \$22607 \$21197 \$25191 \$24997 \$25204
+ gf180mcu_fd_sc_mcu9t5v0__mux2_1
X$9705 \$26419 \$26246 \$21197 \$26401 \$26220 \$26418
+ gf180mcu_fd_sc_mcu9t5v0__mux2_1
X$9706 \$21199 \$29296 \$29290 \$29270 \$29092 gf180mcu_fd_sc_mcu9t5v0__nor2_1
X$9707 \$21199 \$21695 \$21661 \$21946 \$21970 gf180mcu_fd_sc_mcu9t5v0__nand2_1
X$9708 \$21199 \$27015 \$26856 \$22413 gf180mcu_fd_sc_mcu9t5v0__clkinv_1
X$9709 \$28367 \$28956 \$21199 \$28810 \$28971 \$28985
+ gf180mcu_fd_sc_mcu9t5v0__mux2_1
X$9710 \$24078 \$24077 \$21199 \$23926 \$24109 \$24126
+ gf180mcu_fd_sc_mcu9t5v0__mux2_1
X$9711 \$28074 \$28073 \$21199 \$27913 \$28089 \$28118
+ gf180mcu_fd_sc_mcu9t5v0__mux2_1
X$9712 \$28365 \$28586 \$21199 \$28211 \$28381 \$28391
+ gf180mcu_fd_sc_mcu9t5v0__mux2_1
X$9713 \$22604 \$23218 \$21199 \$23027 \$23139 \$23045
+ gf180mcu_fd_sc_mcu9t5v0__mux2_1
X$9714 \$27612 \$28582 \$21199 \$28211 \$28381 \$28390
+ gf180mcu_fd_sc_mcu9t5v0__mux2_1
X$9715 \$27614 \$28069 \$21199 \$27913 \$28089 \$27671
+ gf180mcu_fd_sc_mcu9t5v0__mux2_1
X$9716 \$27945 \$27618 \$21199 \$27637 \$27449 \$27675
+ gf180mcu_fd_sc_mcu9t5v0__mux2_1
X$9717 \$28515 \$28587 \$21199 \$28534 \$28381 \$28588
+ gf180mcu_fd_sc_mcu9t5v0__mux2_1
X$9718 \$27302 \$26836 \$21199 \$27315 \$27153 \$27058
+ gf180mcu_fd_sc_mcu9t5v0__mux2_1
X$9719 \$29112 \$29111 \$21199 \$29123 \$28971 \$29141
+ gf180mcu_fd_sc_mcu9t5v0__mux2_1
X$9720 \$25096 \$25095 \$21199 \$25191 \$24997 \$25205
+ gf180mcu_fd_sc_mcu9t5v0__mux2_1
X$9721 \$28067 \$28065 \$21199 \$28211 \$28089 \$28236
+ gf180mcu_fd_sc_mcu9t5v0__mux2_1
X$9722 \$25779 \$25777 \$21199 \$26088 \$25918 \$25778
+ gf180mcu_fd_sc_mcu9t5v0__mux2_1
X$9723 \$24567 \$24565 \$21199 \$24593 \$24428 \$24618
+ gf180mcu_fd_sc_mcu9t5v0__mux2_1
X$9724 \$26115 \$25918 \$25797 \$21200 gf180mcu_fd_sc_mcu9t5v0__clkbuf_16
X$9725 \$21200 \$24231 \$24428 \$23609 gf180mcu_fd_sc_mcu9t5v0__clkbuf_8
X$9726 \$21200 \$25462 \$25632 \$25022 gf180mcu_fd_sc_mcu9t5v0__clkbuf_8
X$9727 \$21200 \$27015 \$27153 \$26417 gf180mcu_fd_sc_mcu9t5v0__clkbuf_8
X$9728 \$21200 \$28534 \$28689 \$27942 gf180mcu_fd_sc_mcu9t5v0__clkbuf_8
X$9729 \$21200 \$24877 \$24997 \$24127 gf180mcu_fd_sc_mcu9t5v0__clkbuf_8
X$9730 \$21200 \$28534 \$28689 \$28511 gf180mcu_fd_sc_mcu9t5v0__clkbuf_8
X$9731 \$21200 \$23620 \$23454 \$23214 gf180mcu_fd_sc_mcu9t5v0__clkbuf_8
X$9732 \$21200 \$26675 \$26521 \$25951 gf180mcu_fd_sc_mcu9t5v0__clkbuf_8
X$9733 \$21200 \$26675 \$26521 \$25491 gf180mcu_fd_sc_mcu9t5v0__clkbuf_8
X$9734 \$21200 \$28810 \$28689 \$28948 gf180mcu_fd_sc_mcu9t5v0__clkbuf_8
X$9735 \$21200 \$22713 \$22440 \$21519 gf180mcu_fd_sc_mcu9t5v0__clkbuf_8
X$9736 \$21200 \$25797 \$25632 \$24612 gf180mcu_fd_sc_mcu9t5v0__clkbuf_8
X$9737 \$22608 \$22606 \$22609 \$22713 \$22440 \$21201
+ gf180mcu_fd_sc_mcu9t5v0__aoi21_1
X$9738 \$21401 \$21201 \$21498 \$21308 \$21400 gf180mcu_fd_sc_mcu9t5v0__nand2_1
X$9739 \$21291 \$21498 \$21622 \$21491 gf180mcu_fd_sc_mcu9t5v0__clkinv_1
X$9740 \$23176 \$22713 \$22837 \$21295 gf180mcu_fd_sc_mcu9t5v0__clkinv_1
X$9741 \$21495 \$21354 \$21498 \$21308 \$21298 gf180mcu_fd_sc_mcu9t5v0__nand2_1
X$9742 \$21634 \$21681 \$21498 \$21308 \$21380 gf180mcu_fd_sc_mcu9t5v0__or2_1
X$9743 \$21383 \$21319 \$21385 \$21498 \$21308 \$21321
+ gf180mcu_fd_sc_mcu9t5v0__aoi21_1
X$9744 \$21352 \$21351 \$21353 \$21498 \$21308 \$21350
+ gf180mcu_fd_sc_mcu9t5v0__aoi21_1
X$9745 \$21383 \$21319 \$21385 \$21322 \$21498 \$21308 \$21384
+ gf180mcu_fd_sc_mcu9t5v0__aoi211_1
X$9746 \$21379 \$21378 \$21498 \$21308 \$21377 gf180mcu_fd_sc_mcu9t5v0__nand2_1
X$9747 \$21348 \$21347 \$21498 \$21308 \$21346 gf180mcu_fd_sc_mcu9t5v0__nand2_1
X$9748 \$21308 \$21498 gf180mcu_fd_sc_mcu9t5v0__filltie
X$9749 \$21308 \$21498 gf180mcu_fd_sc_mcu9t5v0__filltie
X$9750 \$21308 \$21498 gf180mcu_fd_sc_mcu9t5v0__filltie
X$9751 \$21308 \$21498 gf180mcu_fd_sc_mcu9t5v0__filltie
X$9752 \$21308 \$21498 gf180mcu_fd_sc_mcu9t5v0__filltie
X$9753 \$21308 \$21498 gf180mcu_fd_sc_mcu9t5v0__filltie
X$9754 \$21308 \$21498 gf180mcu_fd_sc_mcu9t5v0__endcap
X$9755 \$21308 \$21498 gf180mcu_fd_sc_mcu9t5v0__endcap
X$9756 \$22143 \$22142 \$22074 \$22272 \$21316 gf180mcu_fd_sc_mcu9t5v0__and2_1
X$9757 \$28821 \$27015 \$27153 \$21328 gf180mcu_fd_sc_mcu9t5v0__inv_1
X$9758 \$25772 \$26112 \$21328 \$25797 \$25918 \$25771
+ gf180mcu_fd_sc_mcu9t5v0__mux2_1
X$9759 \$25617 \$25986 \$21328 \$25462 \$25632 \$25480
+ gf180mcu_fd_sc_mcu9t5v0__mux2_1
X$9760 \$25360 \$25481 \$21328 \$25462 \$25347 \$25482
+ gf180mcu_fd_sc_mcu9t5v0__mux2_1
X$9761 \$22096 \$21330 \$22074 \$22272 \$22158 gf180mcu_fd_sc_mcu9t5v0__xnor2_1
X$9762 \$21644 \$21337 \$21498 \$21622 \$21515 gf180mcu_fd_sc_mcu9t5v0__xnor2_1
X$9763 \$21643 \$21498 \$21622 \$21514 \$21338 gf180mcu_fd_sc_mcu9t5v0__xor2_1
X$9764 \$22928 \$21520 \$21343 \$21498 \$21622 \$21404
+ gf180mcu_fd_sc_mcu9t5v0__oai21_1
X$9765 \$21492 \$21795 \$21349 \$21661 \$21946 \$21934
+ gf180mcu_fd_sc_mcu9t5v0__mux2_1
X$9766 \$21614 \$21495 \$21494 \$21498 \$21622 \$21351
+ gf180mcu_fd_sc_mcu9t5v0__nand3_1
X$9767 \$21614 \$21352 \$21661 \$21622 \$21353 gf180mcu_fd_sc_mcu9t5v0__nor2_1
X$9768 \$21936 \$21797 \$21352 \$21661 \$21946 \$21935
+ gf180mcu_fd_sc_mcu9t5v0__mux2_1
X$9769 \$21937 \$22066 \$21352 \$22074 \$21946 \$22114
+ gf180mcu_fd_sc_mcu9t5v0__mux2_1
X$9770 \$21614 \$21494 \$21498 \$21622 \$21354 gf180mcu_fd_sc_mcu9t5v0__nor2_1
X$9771 \$21358 \$21359 \$21661 \$21946 \$21947 gf180mcu_fd_sc_mcu9t5v0__nand2_1
X$9772 \$23032 \$21361 \$21498 \$21622 \$21628 gf180mcu_fd_sc_mcu9t5v0__nor2_1
X$9773 \$21620 \$21364 \$21661 \$21622 \$21666 gf180mcu_fd_sc_mcu9t5v0__nor2_1
X$9774 \$21366 \$22888 \$24593 \$24721 \$24585 gf180mcu_fd_sc_mcu9t5v0__nand2_1
X$9775 \$21366 \$23023 \$21656 \$23027 \$23139 \$22891
+ gf180mcu_fd_sc_mcu9t5v0__mux2_1
X$9776 \$21366 \$29925 \$29436 \$29780 \$29847 \$29854
+ gf180mcu_fd_sc_mcu9t5v0__mux2_1
X$9777 \$21366 \$25457 \$25343 \$25462 \$25347 \$25580
+ gf180mcu_fd_sc_mcu9t5v0__mux2_1
X$9778 \$21366 \$26395 \$26339 \$26675 \$26521 \$26637
+ gf180mcu_fd_sc_mcu9t5v0__mux2_1
X$9779 \$21366 \$28382 \$27658 \$28534 \$28381 \$28550
+ gf180mcu_fd_sc_mcu9t5v0__mux2_1
X$9780 \$21369 \$22387 \$22272 gf180mcu_fd_sc_mcu9t5v0__clkbuf_4
X$9781 \$21369 \$23627 \$23628 \$23620 \$23807 gf180mcu_fd_sc_mcu9t5v0__dffq_2
X$9782 \$21369 \$22138 \$22842 \$22713 \$22837 gf180mcu_fd_sc_mcu9t5v0__dffq_2
X$9783 \$21369 \$22277 \$22278 \$22074 \$22272 gf180mcu_fd_sc_mcu9t5v0__dffq_2
X$9784 \$21369 \$23146 \$23147 \$23183 \$23139 gf180mcu_fd_sc_mcu9t5v0__dffq_2
X$9785 \$21630 \$21631 \$21376 \$21374 \$21498 \$21622 \$21677
+ gf180mcu_fd_sc_mcu9t5v0__oai31_1
X$9786 \$22591 \$22590 \$22854 \$22713 \$22837 \$21375
+ gf180mcu_fd_sc_mcu9t5v0__aoi21_1
X$9787 \$21379 \$21378 \$21498 \$21622 \$21376 gf180mcu_fd_sc_mcu9t5v0__xnor2_1
X$9788 \$22144 \$22148 \$22074 \$22272 \$21378 \$22149
+ gf180mcu_fd_sc_mcu9t5v0__xnor3_1
X$9789 \$21379 \$22144 \$21676 \$21661 \$21622 \$21681
+ gf180mcu_fd_sc_mcu9t5v0__aoi21_1
X$9790 \$21680 \$21661 \$21622 \$21379 gf180mcu_fd_sc_mcu9t5v0__clkinv_1
X$9791 \$21961 \$22086 \$22088 \$22074 \$21946 \$21381
+ gf180mcu_fd_sc_mcu9t5v0__oai21_1
X$9792 \$21383 \$21510 \$21498 \$21622 \$21382 gf180mcu_fd_sc_mcu9t5v0__nand2_1
X$9793 \$21825 \$21498 \$21622 \$21389 gf180mcu_fd_sc_mcu9t5v0__clkinv_1
X$9794 \$21392 \$22095 \$22074 \$21946 \$21965 gf180mcu_fd_sc_mcu9t5v0__xnor2_1
X$9795 \$22096 \$22074 \$21946 \$21392 gf180mcu_fd_sc_mcu9t5v0__clkinv_1
X$9796 \$21649 \$21397 \$21661 \$21622 \$21650 gf180mcu_fd_sc_mcu9t5v0__nor2_1
X$9797 \$21650 \$21398 \$21517 \$21498 \$21622 \$21516
+ gf180mcu_fd_sc_mcu9t5v0__oai21_1
X$9798 \$21490 \$21661 \$21622 \$21612 \$21653 gf180mcu_fd_sc_mcu9t5v0__xor2_1
X$9799 \$22824 \$22065 \$22268 \$22823 \$22713 \$22440 \$21493
+ gf180mcu_fd_sc_mcu9t5v0__aoi211_1
X$9800 \$21936 \$21937 \$21661 \$21946 \$21494 gf180mcu_fd_sc_mcu9t5v0__nand2_1
X$9801 \$21616 \$22827 \$22124 \$21495 \$22074 \$21946 \$21617
+ gf180mcu_fd_sc_mcu9t5v0__aoi211_1
X$9802 \$21936 \$21937 \$21495 \$22074 \$22272 \$22067
+ gf180mcu_fd_sc_mcu9t5v0__oai21_1
X$9803 \$21495 \$22827 \$22387 \$22272 \$22385 gf180mcu_fd_sc_mcu9t5v0__nor2_1
X$9804 \$21614 \$21495 \$22121 \$21798 \$22074 \$22272 \$22117
+ gf180mcu_fd_sc_mcu9t5v0__aoi22_1
X$9805 \$21495 \$21498 \$21622 \$21615 gf180mcu_fd_sc_mcu9t5v0__clkinv_1
X$9806 \$21520 \$22930 \$21522 \$21498 \$21622 \$21521
+ gf180mcu_fd_sc_mcu9t5v0__oai21_1
X$9807 \$23317 \$21616 \$21656 \$21498 \$21622 \$21618
+ gf180mcu_fd_sc_mcu9t5v0__mux2_1
X$9808 \$21622 \$21498 gf180mcu_fd_sc_mcu9t5v0__filltie
X$9809 \$21622 \$21498 gf180mcu_fd_sc_mcu9t5v0__filltie
X$9810 \$21622 \$21498 gf180mcu_fd_sc_mcu9t5v0__filltie
X$9811 \$21622 \$21498 gf180mcu_fd_sc_mcu9t5v0__filltie
X$9812 \$21622 \$21498 gf180mcu_fd_sc_mcu9t5v0__filltie
X$9813 \$21622 \$21498 gf180mcu_fd_sc_mcu9t5v0__filltie
X$9814 \$21622 \$21498 gf180mcu_fd_sc_mcu9t5v0__endcap
X$9815 \$21622 \$21498 gf180mcu_fd_sc_mcu9t5v0__endcap
X$9816 \$21942 \$21499 \$21501 \$21661 \$21622 gf180mcu_fd_sc_mcu9t5v0__dffq_2
X$9817 \$21507 \$21661 \$21946 \$21959 gf180mcu_fd_sc_mcu9t5v0__clkinv_1
X$9818 \$21692 \$21695 \$21661 \$21622 \$21514 gf180mcu_fd_sc_mcu9t5v0__nand2_1
X$9819 \$21519 \$22387 \$22440 gf180mcu_fd_sc_mcu9t5v0__clkinv_3
X$9820 \$21520 \$23348 \$24614 \$24593 \$24721 \$24564
+ gf180mcu_fd_sc_mcu9t5v0__oai21_1
X$9821 \$21520 \$23479 \$24270 \$24231 \$24109 \$24269
+ gf180mcu_fd_sc_mcu9t5v0__oai21_1
X$9822 \$32778 \$32853 \$32765 \$21520 gf180mcu_fd_sc_mcu9t5v0__buf_8
X$9823 \$21614 \$21936 \$21615 \$21938 \$22074 \$21946 \$21939
+ gf180mcu_fd_sc_mcu9t5v0__oai31_1
X$9824 \$21614 \$22074 \$21946 \$22115 gf180mcu_fd_sc_mcu9t5v0__clkinv_1
X$9825 \$21937 \$21615 \$22074 \$21946 \$22066 gf180mcu_fd_sc_mcu9t5v0__nor2_1
X$9826 \$21621 \$24307 \$25462 \$25347 \$25354 gf180mcu_fd_sc_mcu9t5v0__nand2_1
X$9827 \$24732 \$24598 \$21621 \$24593 \$24721 \$24731
+ gf180mcu_fd_sc_mcu9t5v0__mux2_1
X$9828 \$23138 \$22572 \$21621 \$23027 \$23139 \$23137
+ gf180mcu_fd_sc_mcu9t5v0__mux2_1
X$9829 \$23030 \$22388 \$21621 \$22713 \$22837 \$22839
+ gf180mcu_fd_sc_mcu9t5v0__mux2_1
X$9830 \$25309 \$24726 \$21621 \$25191 \$25347 \$25349
+ gf180mcu_fd_sc_mcu9t5v0__mux2_1
X$9831 \$25307 \$24533 \$21621 \$25191 \$25347 \$25348
+ gf180mcu_fd_sc_mcu9t5v0__mux2_1
X$9832 \$22580 \$21947 \$21621 \$22713 \$22440 \$22717
+ gf180mcu_fd_sc_mcu9t5v0__mux2_1
X$9833 \$24114 \$24059 \$21621 \$24231 \$24109 \$24061
+ gf180mcu_fd_sc_mcu9t5v0__mux2_1
X$9834 \$21700 \$21843 \$21661 \$21622 \$21698 gf180mcu_fd_sc_mcu9t5v0__or2_1
X$9835 \$21699 \$21701 \$21661 \$21622 \$21651 gf180mcu_fd_sc_mcu9t5v0__nor2_1
X$9836 \$21812 \$21661 \$21622 \$21669 gf180mcu_fd_sc_mcu9t5v0__clkinv_1
X$9837 \$21706 \$22930 \$21661 \$21622 \$21847 gf180mcu_fd_sc_mcu9t5v0__nand2_1
X$9838 \$21699 \$21701 \$21661 \$21622 \$21702 gf180mcu_fd_sc_mcu9t5v0__nand2_1
X$9839 \$21622 \$21661 gf180mcu_fd_sc_mcu9t5v0__filltie
X$9840 \$21622 \$21661 gf180mcu_fd_sc_mcu9t5v0__filltie
X$9841 \$21622 \$21661 gf180mcu_fd_sc_mcu9t5v0__filltie
X$9842 \$21622 \$21661 gf180mcu_fd_sc_mcu9t5v0__filltie
X$9843 \$21622 \$21661 gf180mcu_fd_sc_mcu9t5v0__filltie
X$9844 \$21622 \$21661 gf180mcu_fd_sc_mcu9t5v0__filltie
X$9845 \$21942 \$21806 \$21807 \$21661 \$21622 gf180mcu_fd_sc_mcu9t5v0__dffq_2
X$9846 \$21942 \$21623 \$21805 \$21661 \$21622 gf180mcu_fd_sc_mcu9t5v0__dffq_2
X$9847 \$21622 \$21661 gf180mcu_fd_sc_mcu9t5v0__endcap
X$9848 \$21622 \$21661 gf180mcu_fd_sc_mcu9t5v0__endcap
X$9849 \$21948 \$21809 \$22074 \$21946 \$21624 gf180mcu_fd_sc_mcu9t5v0__nand2_1
X$9850 \$22907 \$22853 \$22145 \$22713 \$22837 \$21630
+ gf180mcu_fd_sc_mcu9t5v0__aoi21_1
X$9851 \$22592 \$22593 \$22713 \$22440 \$21631 gf180mcu_fd_sc_mcu9t5v0__and2_1
X$9852 \$22284 \$22406 \$22158 \$22387 \$22272 \$21642
+ gf180mcu_fd_sc_mcu9t5v0__oai21_1
X$9853 \$21841 \$21643 \$21840 \$21661 \$21946 \$21694
+ gf180mcu_fd_sc_mcu9t5v0__nand3_1
X$9854 \$21644 \$27809 \$27913 \$28089 \$27668 gf180mcu_fd_sc_mcu9t5v0__nand2_1
X$9855 \$21971 \$22165 \$22101 \$22074 \$21946 \$21646
+ gf180mcu_fd_sc_mcu9t5v0__nand3_1
X$9856 \$22171 \$22417 \$22102 \$22074 \$22272 \$21649
+ gf180mcu_fd_sc_mcu9t5v0__oai21_1
X$9857 \$21656 \$22713 \$22837 \$22826 gf180mcu_fd_sc_mcu9t5v0__clkinv_1
X$9858 \$25190 \$25191 \$24997 \$21656 gf180mcu_fd_sc_mcu9t5v0__buf_8
X$9859 \$22887 \$23025 \$21656 \$23027 \$23139 \$22892
+ gf180mcu_fd_sc_mcu9t5v0__mux2_1
X$9860 \$22833 \$22831 \$21656 \$22713 \$22837 \$22832
+ gf180mcu_fd_sc_mcu9t5v0__mux2_1
X$9861 \$23315 \$21800 \$21656 \$21661 \$21946 \$21657
+ gf180mcu_fd_sc_mcu9t5v0__mux2_1
X$9862 \$23446 \$23135 \$21656 \$23027 \$23139 \$22889
+ gf180mcu_fd_sc_mcu9t5v0__mux2_1
X$9863 \$24221 \$24046 \$21656 \$23926 \$24109 \$24226
+ gf180mcu_fd_sc_mcu9t5v0__mux2_1
X$9864 \$23021 \$22070 \$21656 \$21661 \$21946 \$21941
+ gf180mcu_fd_sc_mcu9t5v0__mux2_1
X$9865 \$23314 \$24286 \$21656 \$24231 \$24428 \$24222
+ gf180mcu_fd_sc_mcu9t5v0__mux2_1
X$9866 \$23922 \$24844 \$21656 \$25462 \$25632 \$25739
+ gf180mcu_fd_sc_mcu9t5v0__mux2_1
X$9867 \$23445 \$23319 \$21656 \$23183 \$23139 \$23181
+ gf180mcu_fd_sc_mcu9t5v0__mux2_1
X$9868 \$22279 \$24223 \$21656 \$24231 \$24109 \$24287
+ gf180mcu_fd_sc_mcu9t5v0__mux2_1
X$9869 \$23180 \$23178 \$21656 \$23183 \$23139 \$23177
+ gf180mcu_fd_sc_mcu9t5v0__mux2_1
X$9870 \$21658 \$22387 \$22440 \$I54838 gf180mcu_fd_sc_mcu9t5v0__clkinv_1
X$9871 \$21680 \$21661 \$21946 \$22144 \$21820 gf180mcu_fd_sc_mcu9t5v0__xor2_1
X$9872 \$21833 \$21661 \$21946 \$21835 \$21689 gf180mcu_fd_sc_mcu9t5v0__xor2_1
X$9873 \$21791 \$21661 \$21946 gf180mcu_fd_sc_mcu9t5v0__clkbuf_4
X$9874 \$21831 \$21829 \$21828 \$21661 \$21946 \$21830
+ gf180mcu_fd_sc_mcu9t5v0__nor3_1
X$9875 \$21820 \$22146 \$21819 \$21661 \$21946 \$21679
+ gf180mcu_fd_sc_mcu9t5v0__and3_1
X$9876 \$21841 \$22099 \$21840 \$21661 \$21946 \$21695
+ gf180mcu_fd_sc_mcu9t5v0__oai21_1
X$9877 \$21831 \$21829 \$21828 \$21661 \$21946 \$21687
+ gf180mcu_fd_sc_mcu9t5v0__oai21_1
X$9878 \$21666 \$21661 \$21946 \$21809 gf180mcu_fd_sc_mcu9t5v0__buf_8
X$9879 \$21932 \$21793 \$21661 \$21946 \$21933 gf180mcu_fd_sc_mcu9t5v0__nor2_1
X$9880 \$22104 \$21845 \$21661 \$21946 \$21974 gf180mcu_fd_sc_mcu9t5v0__nor2_1
X$9881 \$21667 \$21661 \$21946 \$21811 gf180mcu_fd_sc_mcu9t5v0__clkinv_1
X$9882 \$21946 \$21661 gf180mcu_fd_sc_mcu9t5v0__filltie
X$9883 \$21946 \$21661 gf180mcu_fd_sc_mcu9t5v0__filltie
X$9884 \$21946 \$21661 gf180mcu_fd_sc_mcu9t5v0__filltie
X$9885 \$21946 \$21661 gf180mcu_fd_sc_mcu9t5v0__filltie
X$9886 \$21946 \$21661 gf180mcu_fd_sc_mcu9t5v0__filltie
X$9887 \$21946 \$21661 gf180mcu_fd_sc_mcu9t5v0__filltie
X$9888 \$21946 \$21661 gf180mcu_fd_sc_mcu9t5v0__endcap
X$9889 \$21946 \$21661 gf180mcu_fd_sc_mcu9t5v0__endcap
X$9890 \$23033 \$23183 \$23139 \$21663 gf180mcu_fd_sc_mcu9t5v0__buf_8
X$9891 \$21666 \$22074 \$21946 \$24310 gf180mcu_fd_sc_mcu9t5v0__buf_8
X$9892 \$22146 \$21819 \$21820 \$22074 \$21946 \$21676
+ gf180mcu_fd_sc_mcu9t5v0__aoi21_1
X$9893 \$21690 \$22158 \$22074 \$22272 \$21835 \$22160
+ gf180mcu_fd_sc_mcu9t5v0__xnor3_1
X$9894 \$22096 \$21690 \$22074 \$21946 \$21828 gf180mcu_fd_sc_mcu9t5v0__xnor2_1
X$9895 \$21690 \$22464 \$22461 \$22387 \$22440 \$22095
+ gf180mcu_fd_sc_mcu9t5v0__mux2_1
X$9896 \$21693 \$22074 \$21946 \$22099 gf180mcu_fd_sc_mcu9t5v0__clkinv_1
X$9897 \$22173 \$21699 \$22928 \$22074 \$22272 \$22172
+ gf180mcu_fd_sc_mcu9t5v0__mux2_1
X$9898 \$22105 \$21704 \$22074 \$21946 \$21700 gf180mcu_fd_sc_mcu9t5v0__or2_1
X$9899 \$23354 \$23791 \$23486 \$23183 \$23454 \$21704
+ gf180mcu_fd_sc_mcu9t5v0__and3_1
X$9900 \$23791 \$23486 \$23354 \$23620 \$23807 \$21705
+ gf180mcu_fd_sc_mcu9t5v0__aoi21_1
X$9901 \$21706 \$22289 \$22387 \$22272 \$22421 gf180mcu_fd_sc_mcu9t5v0__xnor2_1
X$9902 \$21932 \$22063 \$22074 \$21946 \$21792 gf180mcu_fd_sc_mcu9t5v0__nor2_1
X$9903 \$22064 \$22107 \$22074 \$22272 \$21793 gf180mcu_fd_sc_mcu9t5v0__xnor2_1
X$9904 \$22827 \$24844 \$21796 \$22434 \$24877 \$24721 \$24586
+ gf180mcu_fd_sc_mcu9t5v0__aoi211_1
X$9905 \$24717 \$21796 \$23755 \$24586 \$24593 \$24721 \$24587
+ gf180mcu_fd_sc_mcu9t5v0__aoi22_1
X$9906 \$21936 \$21937 \$22067 \$22074 \$21946 \$21797
+ gf180mcu_fd_sc_mcu9t5v0__aoi21_1
X$9907 \$21802 \$23311 \$23804 \$23926 \$23807 \$23805
+ gf180mcu_fd_sc_mcu9t5v0__mux2_1
X$9908 \$21950 \$22074 \$21946 \$21806 gf180mcu_fd_sc_mcu9t5v0__clkinv_1
X$9909 \$22275 \$21809 \$22387 \$22272 \$22276 gf180mcu_fd_sc_mcu9t5v0__nand2_1
X$9910 \$22455 \$22145 \$22147 \$22074 \$22272 \$21819
+ gf180mcu_fd_sc_mcu9t5v0__oai21_1
X$9911 \$21822 \$23816 \$23933 \$23932 \$23926 \$23807 \$23150
+ gf180mcu_fd_sc_mcu9t5v0__oai22_1
X$9912 \$21822 \$24065 \$23926 \$24109 \$23932 gf180mcu_fd_sc_mcu9t5v0__nand2_1
X$9913 \$24747 \$24593 \$24721 \$21822 gf180mcu_fd_sc_mcu9t5v0__buf_8
X$9914 \$24064 \$23769 \$21822 \$23926 \$24109 \$23813
+ gf180mcu_fd_sc_mcu9t5v0__mux2_1
X$9915 \$25314 \$24316 \$21822 \$25191 \$25347 \$25068
+ gf180mcu_fd_sc_mcu9t5v0__mux2_1
X$9916 \$25002 \$25072 \$21822 \$25191 \$24997 \$23815
+ gf180mcu_fd_sc_mcu9t5v0__mux2_1
X$9917 \$24606 \$24741 \$21822 \$24877 \$24721 \$24739
+ gf180mcu_fd_sc_mcu9t5v0__mux2_1
X$9918 \$22903 \$22589 \$21822 \$23027 \$22837 \$22397
+ gf180mcu_fd_sc_mcu9t5v0__mux2_1
X$9919 \$22457 \$22074 \$22272 \$21823 gf180mcu_fd_sc_mcu9t5v0__clkinv_1
X$9920 \$22157 \$22156 \$21965 \$22074 \$22272 \$21827
+ gf180mcu_fd_sc_mcu9t5v0__oai21_1
X$9921 \$22598 \$22870 \$22871 \$22713 \$22837 \$21829
+ gf180mcu_fd_sc_mcu9t5v0__aoi21_1
X$9922 \$23163 \$22600 \$23027 \$23139 \$21831 gf180mcu_fd_sc_mcu9t5v0__nor2_1
X$9923 \$22463 \$22405 \$22387 \$22440 \$21832 gf180mcu_fd_sc_mcu9t5v0__and2_1
X$9924 \$21834 \$21832 \$22074 \$21946 \$21833 gf180mcu_fd_sc_mcu9t5v0__nor2_1
X$9925 \$23649 \$22406 \$23164 \$23027 \$23139 \$21834
+ gf180mcu_fd_sc_mcu9t5v0__nor3_1
X$9926 \$22284 \$22406 \$22158 \$22387 \$22272 \$21836
+ gf180mcu_fd_sc_mcu9t5v0__nor3_1
X$9927 \$22920 \$22919 \$23165 \$23027 \$22837 \$21837
+ gf180mcu_fd_sc_mcu9t5v0__aoi21_1
X$9928 \$21841 \$21840 \$22099 \$22074 \$21946 \$21969
+ gf180mcu_fd_sc_mcu9t5v0__nor3_1
X$9929 \$22408 \$22409 \$22387 \$22272 \$21841 gf180mcu_fd_sc_mcu9t5v0__and2_1
X$9930 \$21969 \$21970 \$22100 \$22074 \$21946 \$21842
+ gf180mcu_fd_sc_mcu9t5v0__oai21_1
X$9931 \$22104 \$22074 \$21946 \$22103 \$21843 gf180mcu_fd_sc_mcu9t5v0__xor2_1
X$9932 \$31424 \$31399 \$31376 \$31465 \$21844 gf180mcu_fd_sc_mcu9t5v0__xnor2_1
X$9933 \$21844 \$23357 \$22930 \$23183 \$23454 \$23489
+ gf180mcu_fd_sc_mcu9t5v0__mux2_1
X$9934 \$21844 \$28586 \$23348 \$28534 \$28689 \$28585
+ gf180mcu_fd_sc_mcu9t5v0__mux2_1
X$9935 \$21844 \$28721 \$23479 \$28810 \$28689 \$28720
+ gf180mcu_fd_sc_mcu9t5v0__mux2_1
X$9936 \$21844 \$24278 \$22928 \$24231 \$24109 \$24277
+ gf180mcu_fd_sc_mcu9t5v0__mux2_1
X$9937 \$22103 \$22074 \$22272 \$21845 gf180mcu_fd_sc_mcu9t5v0__clkinv_1
X$9938 \$22104 \$21845 \$22074 \$22272 \$21975 gf180mcu_fd_sc_mcu9t5v0__nand2_1
X$9939 \$21932 \$24099 \$24098 \$23926 \$24109 \$24044
+ gf180mcu_fd_sc_mcu9t5v0__nor3_1
X$9940 \$22426 \$22427 \$21932 \$22387 \$22440 \$22374
+ gf180mcu_fd_sc_mcu9t5v0__aoi21_1
X$9941 \$24281 \$22428 \$21932 \$24231 \$24109 \$23580
+ gf180mcu_fd_sc_mcu9t5v0__aoi21_1
X$9942 \$21932 \$23749 \$23750 \$23620 \$23807 \$23798
+ gf180mcu_fd_sc_mcu9t5v0__oai21_1
X$9943 \$21932 \$22428 \$22564 \$22387 \$22440 \$22262
+ gf180mcu_fd_sc_mcu9t5v0__oai21_1
X$9944 \$21932 \$22818 \$23131 \$23027 \$23139 \$22883
+ gf180mcu_fd_sc_mcu9t5v0__oai21_1
X$9945 \$21932 \$22565 \$23750 \$22713 \$22837 \$22819
+ gf180mcu_fd_sc_mcu9t5v0__oai21_1
X$9946 \$21932 \$23577 \$23750 \$23620 \$23454 \$23578
+ gf180mcu_fd_sc_mcu9t5v0__oai21_1
X$9947 \$21932 \$23746 \$23620 \$23807 \$23794 gf180mcu_fd_sc_mcu9t5v0__nor2_1
X$9948 \$21932 \$24219 \$24231 \$24109 \$23799 gf180mcu_fd_sc_mcu9t5v0__nor2_1
X$9949 \$21932 \$22379 \$22387 \$22272 \$22108 gf180mcu_fd_sc_mcu9t5v0__nor2_1
X$9950 \$21932 \$24424 \$24593 \$24428 \$24423 gf180mcu_fd_sc_mcu9t5v0__nor2_1
X$9951 \$21932 \$22560 \$22713 \$22440 \$22701 gf180mcu_fd_sc_mcu9t5v0__nor2_1
X$9952 \$21932 \$23169 \$23183 \$23139 \$23168 gf180mcu_fd_sc_mcu9t5v0__nor2_1
X$9953 \$21932 \$22428 \$23183 \$23139 \$22885 gf180mcu_fd_sc_mcu9t5v0__nor2_1
X$9954 \$22110 \$21932 \$22387 \$22440 \$23750 gf180mcu_fd_sc_mcu9t5v0__nand2_1
X$9955 \$23020 \$21932 \$23027 \$23139 \$23131 gf180mcu_fd_sc_mcu9t5v0__nand2_1
X$9956 \$24288 \$24231 \$24428 \$21932 gf180mcu_fd_sc_mcu9t5v0__buf_8
X$9957 \$22115 \$21936 \$22066 \$22074 \$22272 \$22116
+ gf180mcu_fd_sc_mcu9t5v0__nand3_1
X$9958 \$22121 \$22828 \$22827 \$23135 \$22118 \$23178 \$23027 \$23139 \$21938
+ gf180mcu_fd_sc_mcu9t5v0__aoi222_1
X$9959 \$21942 \$22387 \$22440 gf180mcu_fd_sc_mcu9t5v0__inv_3
X$9960 \$21942 \$22715 \$22575 \$22713 \$22837 gf180mcu_fd_sc_mcu9t5v0__dffq_2
X$9961 \$21942 \$21951 \$22077 \$22074 \$22272 gf180mcu_fd_sc_mcu9t5v0__dffq_2
X$9962 \$21942 \$22581 \$22443 \$22713 \$22440 gf180mcu_fd_sc_mcu9t5v0__dffq_2
X$9963 \$21942 \$22835 \$22716 \$23027 \$22837 gf180mcu_fd_sc_mcu9t5v0__dffq_2
X$9964 \$21942 \$21943 \$21944 \$22074 \$21946 gf180mcu_fd_sc_mcu9t5v0__dffq_2
X$9965 \$21942 \$22274 \$22133 \$22387 \$22272 gf180mcu_fd_sc_mcu9t5v0__dffq_2
X$9966 \$22282 \$22085 \$22087 \$22074 \$21946 \$22086
+ gf180mcu_fd_sc_mcu9t5v0__oai21_1
X$9967 \$22144 \$22149 \$22074 \$21946 \$22084 gf180mcu_fd_sc_mcu9t5v0__nor2_1
X$9968 \$22072 \$22074 \$21946 \$22073 gf180mcu_fd_sc_mcu9t5v0__buf_8
X$9969 \$22135 \$22074 \$21946 \$22136 gf180mcu_fd_sc_mcu9t5v0__clkinv_1
X$9970 \$22096 \$22095 \$22074 \$21946 \$21966 gf180mcu_fd_sc_mcu9t5v0__nand2_1
X$9971 \$22416 \$22170 \$22074 \$21946 \$22102 gf180mcu_fd_sc_mcu9t5v0__nand2_1
X$9972 \$21946 \$22074 gf180mcu_fd_sc_mcu9t5v0__filltie
X$9973 \$21946 \$22074 gf180mcu_fd_sc_mcu9t5v0__filltie
X$9974 \$21946 \$22074 gf180mcu_fd_sc_mcu9t5v0__filltie
X$9975 \$21946 \$22074 gf180mcu_fd_sc_mcu9t5v0__filltie
X$9976 \$21946 \$22074 gf180mcu_fd_sc_mcu9t5v0__filltie
X$9977 \$21946 \$22074 gf180mcu_fd_sc_mcu9t5v0__filltie
X$9978 \$21948 \$21947 \$22073 \$22074 \$21946 \$22131
+ gf180mcu_fd_sc_mcu9t5v0__mux2_1
X$9979 \$21946 \$22074 gf180mcu_fd_sc_mcu9t5v0__endcap
X$9980 \$21946 \$22074 gf180mcu_fd_sc_mcu9t5v0__endcap
X$9981 \$21959 \$21960 \$22387 \$22272 \$22282 gf180mcu_fd_sc_mcu9t5v0__nor2_1
X$9982 \$21959 \$21960 \$22387 \$22272 \$22087 gf180mcu_fd_sc_mcu9t5v0__nand2_1
X$9983 \$21971 \$22165 \$22101 \$22074 \$22272 \$22167
+ gf180mcu_fd_sc_mcu9t5v0__aoi21_1
X$9984 \$21971 \$22101 \$22470 \$22468 \$22387 \$22440 \$22469
+ gf180mcu_fd_sc_mcu9t5v0__aoi211_1
X$9985 \$22926 \$24078 \$23027 \$22837 \$21971 gf180mcu_fd_sc_mcu9t5v0__nand2_1
X$9986 \$21971 \$22101 \$22387 \$22272 \$22164 gf180mcu_fd_sc_mcu9t5v0__nand2_1
X$9987 \$22421 \$22474 \$22475 \$22387 \$22440 \$21977
+ gf180mcu_fd_sc_mcu9t5v0__and3_1
X$9988 \$22376 \$22074 \$22272 \$22262 \$22063 gf180mcu_fd_sc_mcu9t5v0__xor2_1
X$9989 \$22064 \$22263 \$22264 \$22266 \$22387 \$22272 \$22564
+ gf180mcu_fd_sc_mcu9t5v0__nor4_1
X$9990 \$22064 \$22264 \$22265 \$22263 \$22387 \$22272 \$22377
+ gf180mcu_fd_sc_mcu9t5v0__oai31_1
X$9991 \$25795 \$25910 \$22065 \$25797 \$25918 \$23133
+ gf180mcu_fd_sc_mcu9t5v0__aoi21_1
X$9992 \$25737 \$26207 \$22065 \$25797 \$25918 \$24584
+ gf180mcu_fd_sc_mcu9t5v0__aoi21_1
X$9993 \$25737 \$25911 \$22065 \$25797 \$25632 \$25455
+ gf180mcu_fd_sc_mcu9t5v0__aoi21_1
X$9994 \$25737 \$25738 \$22065 \$25797 \$25632 \$25300
+ gf180mcu_fd_sc_mcu9t5v0__aoi21_1
X$9995 \$25737 \$25736 \$22065 \$25797 \$25632 \$25037
+ gf180mcu_fd_sc_mcu9t5v0__aoi21_1
X$9996 \$25454 \$25453 \$22065 \$25462 \$25347 \$22566
+ gf180mcu_fd_sc_mcu9t5v0__aoi21_1
X$9997 \$25963 \$25962 \$22065 \$26088 \$25918 \$22823
+ gf180mcu_fd_sc_mcu9t5v0__aoi21_1
X$9998 \$22065 \$23175 \$22268 \$23133 \$23027 \$23139 \$22267
+ gf180mcu_fd_sc_mcu9t5v0__aoi211_1
X$9999 \$22065 \$24715 \$25301 \$25455 \$23582 \$25191 \$25347 \$22269
+ gf180mcu_fd_sc_mcu9t5v0__aoi221_1
X$10000 \$22065 \$24101 \$25036 \$24584 \$23582 \$24593 \$24721 \$23444
+ gf180mcu_fd_sc_mcu9t5v0__aoi221_1
X$10001 \$22065 \$24713 \$25188 \$25300 \$23582 \$25191 \$25347 \$22380
+ gf180mcu_fd_sc_mcu9t5v0__aoi221_1
X$10002 \$22065 \$24711 \$25038 \$25037 \$23582 \$25191 \$24997 \$22113
+ gf180mcu_fd_sc_mcu9t5v0__aoi221_1
X$10003 \$22117 \$22067 \$22381 \$22387 \$22272 \$22382
+ gf180mcu_fd_sc_mcu9t5v0__nand3_1
X$10004 \$22434 \$22121 \$22118 \$22387 \$22440 \$22068
+ gf180mcu_fd_sc_mcu9t5v0__nor3_1
X$10005 \$22120 \$22121 \$22070 \$22118 \$22074 \$22272 \$22119
+ gf180mcu_fd_sc_mcu9t5v0__aoi22_1
X$10006 \$22071 \$24291 \$23804 \$23926 \$24109 \$24052
+ gf180mcu_fd_sc_mcu9t5v0__mux2_1
X$10007 \$24730 \$24598 \$22073 \$24593 \$24721 \$24729
+ gf180mcu_fd_sc_mcu9t5v0__mux2_1
X$10008 \$24060 \$24059 \$22073 \$23926 \$24109 \$24243
+ gf180mcu_fd_sc_mcu9t5v0__mux2_1
X$10009 \$24727 \$24726 \$22073 \$24593 \$24721 \$24850
+ gf180mcu_fd_sc_mcu9t5v0__mux2_1
X$10010 \$25599 \$24307 \$22073 \$25462 \$25632 \$25635
+ gf180mcu_fd_sc_mcu9t5v0__mux2_1
X$10011 \$24734 \$24307 \$22073 \$24593 \$24721 \$24733
+ gf180mcu_fd_sc_mcu9t5v0__mux2_1
X$10012 \$24309 \$24307 \$22073 \$24231 \$24428 \$24308
+ gf180mcu_fd_sc_mcu9t5v0__mux2_1
X$10013 \$22573 \$22572 \$22073 \$22713 \$22440 \$22712
+ gf180mcu_fd_sc_mcu9t5v0__mux2_1
X$10014 \$22275 \$22388 \$22073 \$22387 \$22272 \$22444
+ gf180mcu_fd_sc_mcu9t5v0__mux2_1
X$10015 \$25063 \$24307 \$22073 \$25191 \$24997 \$25193
+ gf180mcu_fd_sc_mcu9t5v0__mux2_1
X$10016 \$24723 \$24533 \$22073 \$24877 \$24721 \$24998
+ gf180mcu_fd_sc_mcu9t5v0__mux2_1
X$10017 \$22281 \$22141 \$22074 \$22272 \$22139 gf180mcu_fd_sc_mcu9t5v0__xnor2_1
X$10018 \$22168 \$22166 \$22074 \$22272 \$22163 gf180mcu_fd_sc_mcu9t5v0__xnor2_1
X$10019 \$22084 \$22148 \$22150 \$22074 \$22272 \$22085
+ gf180mcu_fd_sc_mcu9t5v0__oai21_1
X$10020 \$22264 \$22265 \$22074 \$22272 \$22107 gf180mcu_fd_sc_mcu9t5v0__nor2_1
X$10021 \$22157 \$22156 \$22074 \$22272 \$22094 gf180mcu_fd_sc_mcu9t5v0__nor2_1
X$10022 \$22137 \$22074 \$22272 \$22138 gf180mcu_fd_sc_mcu9t5v0__clkinv_1
X$10023 \$22083 \$22074 \$22272 \$22149 gf180mcu_fd_sc_mcu9t5v0__clkinv_1
X$10024 \$22160 \$22159 \$22074 \$22272 \$22098 gf180mcu_fd_sc_mcu9t5v0__nand2_1
X$10025 \$22165 \$22164 \$22074 \$22272 \$22166 gf180mcu_fd_sc_mcu9t5v0__nand2_1
X$10026 \$22268 \$22119 \$22074 \$22272 \$22124 gf180mcu_fd_sc_mcu9t5v0__nand2_1
X$10027 \$22455 \$22145 \$22074 \$22272 \$22146 gf180mcu_fd_sc_mcu9t5v0__nand2_1
X$10028 \$22272 \$22074 gf180mcu_fd_sc_mcu9t5v0__filltie
X$10029 \$22272 \$22074 gf180mcu_fd_sc_mcu9t5v0__filltie
X$10030 \$22272 \$22074 gf180mcu_fd_sc_mcu9t5v0__filltie
X$10031 \$22272 \$22074 gf180mcu_fd_sc_mcu9t5v0__filltie
X$10032 \$22272 \$22074 gf180mcu_fd_sc_mcu9t5v0__filltie
X$10033 \$22272 \$22074 gf180mcu_fd_sc_mcu9t5v0__filltie
X$10034 \$22272 \$22074 gf180mcu_fd_sc_mcu9t5v0__endcap
X$10035 \$22272 \$22074 gf180mcu_fd_sc_mcu9t5v0__endcap
X$10036 \$24568 \$24567 \$24569 \$24593 \$24428 \$22101
+ gf180mcu_fd_sc_mcu9t5v0__aoi21_1
X$10037 \$23485 \$23353 \$23183 \$23454 \$22105 gf180mcu_fd_sc_mcu9t5v0__nor2_1
X$10038 \$22116 \$22436 \$22435 \$22387 \$22440 \$22383
+ gf180mcu_fd_sc_mcu9t5v0__nand3_1
X$10039 \$22121 \$22708 \$22827 \$22831 \$22118 \$23025 \$22713 \$22837 \$22709
+ gf180mcu_fd_sc_mcu9t5v0__aoi222_1
X$10040 \$22118 \$24046 \$22434 \$23926 \$23807 \$23759
+ gf180mcu_fd_sc_mcu9t5v0__aoi21_1
X$10041 \$22827 \$22829 \$22118 \$23023 \$22713 \$22837 \$22436
+ gf180mcu_fd_sc_mcu9t5v0__aoi22_1
X$10042 \$22118 \$23584 \$23754 \$22121 \$23620 \$23807 \$23755
+ gf180mcu_fd_sc_mcu9t5v0__aoi22_1
X$10043 \$22827 \$24286 \$22118 \$24223 \$22434 \$24231 \$24109 \$22381
+ gf180mcu_fd_sc_mcu9t5v0__aoi221_1
X$10044 \$22121 \$22437 \$22434 \$22387 \$22440 \$22435
+ gf180mcu_fd_sc_mcu9t5v0__aoi21_1
X$10045 \$22121 \$23585 \$22827 \$23319 \$23620 \$23454 \$23618
+ gf180mcu_fd_sc_mcu9t5v0__aoi22_1
X$10046 \$22126 \$24103 \$23804 \$24231 \$24109 \$24229
+ gf180mcu_fd_sc_mcu9t5v0__mux2_1
X$10047 \$22132 \$22713 \$22837 \$22274 gf180mcu_fd_sc_mcu9t5v0__clkinv_1
X$10048 \$22280 \$22395 \$22396 \$22387 \$22272 \$22141
+ gf180mcu_fd_sc_mcu9t5v0__oai21_1
X$10049 \$22280 \$22395 \$22396 \$22281 \$22387 \$22272 \$22142
+ gf180mcu_fd_sc_mcu9t5v0__oai211_1
X$10050 \$22144 \$22398 \$22387 \$22272 \$22143 gf180mcu_fd_sc_mcu9t5v0__nand2_1
X$10051 \$22144 \$22387 \$22272 \$22398 \$22281 gf180mcu_fd_sc_mcu9t5v0__xor2_1
X$10052 \$22144 \$22149 \$22387 \$22272 \$22150 gf180mcu_fd_sc_mcu9t5v0__nand2_1
X$10053 \$22455 \$22147 \$22387 \$22272 \$22399 \$22145
+ gf180mcu_fd_sc_mcu9t5v0__xnor3_1
X$10054 \$22145 \$22906 \$22713 \$22837 \$22591 \$22909
+ gf180mcu_fd_sc_mcu9t5v0__xnor3_1
X$10055 \$22589 \$22713 \$22440 \$22145 gf180mcu_fd_sc_mcu9t5v0__clkinv_1
X$10056 \$23770 \$23769 \$24065 \$23620 \$23807 \$22147
+ gf180mcu_fd_sc_mcu9t5v0__oai21_1
X$10057 \$22850 \$22851 \$22852 \$22849 \$22713 \$22837 \$22148
+ gf180mcu_fd_sc_mcu9t5v0__oai31_1
X$10058 \$23344 \$23183 \$23454 \$22152 gf180mcu_fd_sc_mcu9t5v0__clkbuf_8
X$10059 \$22152 \$23620 \$23454 \$I54561 gf180mcu_fd_sc_mcu9t5v0__clkinv_1
X$10060 \$22157 \$23208 \$23161 \$23183 \$23454 \$22156
+ gf180mcu_fd_sc_mcu9t5v0__nor3_1
X$10061 \$22157 \$23161 \$23027 \$23139 \$23160 gf180mcu_fd_sc_mcu9t5v0__or2_1
X$10062 \$23475 \$22461 \$23604 \$22600 \$23620 \$23454 \$22157
+ gf180mcu_fd_sc_mcu9t5v0__aoi211_1
X$10063 \$22158 \$22387 \$22440 \$22159 gf180mcu_fd_sc_mcu9t5v0__clkinv_1
X$10064 \$22284 \$22406 \$22387 \$22272 \$22160 gf180mcu_fd_sc_mcu9t5v0__nor2_1
X$10065 \$22470 \$22387 \$22440 \$22165 gf180mcu_fd_sc_mcu9t5v0__clkinv_1
X$10066 \$22468 \$22387 \$22272 \$22168 gf180mcu_fd_sc_mcu9t5v0__clkinv_1
X$10067 \$22416 \$22171 \$22387 \$22440 \$22471 \$22170
+ gf180mcu_fd_sc_mcu9t5v0__xnor3_1
X$10068 \$22416 \$22170 \$22387 \$22272 \$22417 gf180mcu_fd_sc_mcu9t5v0__nor2_1
X$10069 \$23608 \$23167 \$23826 \$23620 \$23454 \$22171
+ gf180mcu_fd_sc_mcu9t5v0__aoi21_1
X$10070 \$28575 \$28534 \$28381 \$22173 gf180mcu_fd_sc_mcu9t5v0__buf_8
X$10071 \$22173 \$23789 \$23348 \$23620 \$23807 \$23788
+ gf180mcu_fd_sc_mcu9t5v0__mux2_1
X$10072 \$22173 \$23608 \$23479 \$23620 \$23454 \$23656
+ gf180mcu_fd_sc_mcu9t5v0__mux2_1
X$10073 \$22376 \$22425 \$22262 \$22375 \$22387 \$22440 \$22426
+ gf180mcu_fd_sc_mcu9t5v0__oai31_1
X$10074 \$22376 \$22262 \$22387 \$22272 \$22561 gf180mcu_fd_sc_mcu9t5v0__nor2_1
X$10075 \$22703 \$22262 \$22377 \$22387 \$22272 \$22378
+ gf180mcu_fd_sc_mcu9t5v0__nand3_1
X$10076 \$22264 \$22713 \$22837 \$22265 \$22818 gf180mcu_fd_sc_mcu9t5v0__xor2_1
X$10077 \$22429 \$22428 \$22387 \$22440 \$22265 gf180mcu_fd_sc_mcu9t5v0__nand2_1
X$10078 \$22431 \$22430 \$22387 \$22440 \$22266 gf180mcu_fd_sc_mcu9t5v0__or2_1
X$10079 \$23582 \$23620 \$23454 \$22268 gf180mcu_fd_sc_mcu9t5v0__buf_8
X$10080 \$22270 \$23183 \$23454 \$23448 gf180mcu_fd_sc_mcu9t5v0__clkinv_1
X$10081 \$22431 \$22428 \$22387 \$22272 \$22379 gf180mcu_fd_sc_mcu9t5v0__xnor2_1
X$10082 \$22455 \$22397 \$22387 \$22272 \$22396 gf180mcu_fd_sc_mcu9t5v0__or2_1
X$10083 \$22413 \$22408 \$22411 \$22287 \$22387 \$22272 \$22412
+ gf180mcu_fd_sc_mcu9t5v0__oai31_1
X$10084 \$22272 \$22387 gf180mcu_fd_sc_mcu9t5v0__filltie
X$10085 \$22272 \$22387 gf180mcu_fd_sc_mcu9t5v0__filltie
X$10086 \$22272 \$22387 gf180mcu_fd_sc_mcu9t5v0__filltie
X$10087 \$22272 \$22387 gf180mcu_fd_sc_mcu9t5v0__filltie
X$10088 \$22272 \$22387 gf180mcu_fd_sc_mcu9t5v0__filltie
X$10089 \$22272 \$22387 gf180mcu_fd_sc_mcu9t5v0__filltie
X$10090 \$22272 \$22387 gf180mcu_fd_sc_mcu9t5v0__endcap
X$10091 \$22272 \$22387 gf180mcu_fd_sc_mcu9t5v0__endcap
X$10092 \$22450 \$23027 \$23139 \$22277 gf180mcu_fd_sc_mcu9t5v0__clkinv_1
X$10093 \$22279 \$22888 \$24593 \$24428 \$24524 gf180mcu_fd_sc_mcu9t5v0__nand2_1
X$10094 \$22279 \$27436 \$26339 \$27637 \$27776 \$27306
+ gf180mcu_fd_sc_mcu9t5v0__mux2_1
X$10095 \$22279 \$25579 \$25343 \$25462 \$25632 \$25450
+ gf180mcu_fd_sc_mcu9t5v0__mux2_1
X$10096 \$22279 \$29786 \$29436 \$29780 \$29847 \$29853
+ gf180mcu_fd_sc_mcu9t5v0__mux2_1
X$10097 \$22279 \$28055 \$27658 \$27913 \$28089 \$28093
+ gf180mcu_fd_sc_mcu9t5v0__mux2_1
X$10098 \$22455 \$22397 \$22387 \$22440 \$22280 gf180mcu_fd_sc_mcu9t5v0__and2_1
X$10099 \$22283 \$24433 \$24593 \$24428 \$24552 gf180mcu_fd_sc_mcu9t5v0__nand2_1
X$10100 \$22600 \$22464 \$22713 \$22440 \$22284 gf180mcu_fd_sc_mcu9t5v0__nor2_1
X$10101 \$22611 \$22876 \$22610 \$22713 \$22837 \$22288
+ gf180mcu_fd_sc_mcu9t5v0__and3_1
X$10102 \$22425 \$22375 \$22387 \$22440 \$22424 gf180mcu_fd_sc_mcu9t5v0__nor2_1
X$10103 \$22376 \$22882 \$22713 \$22440 \$22563 gf180mcu_fd_sc_mcu9t5v0__nor2_1
X$10104 \$22386 \$22714 \$22713 \$22837 \$22572 gf180mcu_fd_sc_mcu9t5v0__nand2_1
X$10105 \$22386 \$22439 \$22713 \$22440 \$22574 gf180mcu_fd_sc_mcu9t5v0__nand2_1
X$10106 \$22474 \$22475 \$22421 \$22387 \$22440 \$22420
+ gf180mcu_fd_sc_mcu9t5v0__aoi21_1
X$10107 \$22431 \$22430 \$22387 \$22440 \$22429 gf180mcu_fd_sc_mcu9t5v0__nor2_1
X$10108 \$22441 \$22387 \$22440 \$23140 gf180mcu_fd_sc_mcu9t5v0__clkinv_1
X$10109 \$22440 \$22387 gf180mcu_fd_sc_mcu9t5v0__filltie
X$10110 \$22440 \$22387 gf180mcu_fd_sc_mcu9t5v0__filltie
X$10111 \$22440 \$22387 gf180mcu_fd_sc_mcu9t5v0__filltie
X$10112 \$22440 \$22387 gf180mcu_fd_sc_mcu9t5v0__filltie
X$10113 \$22440 \$22387 gf180mcu_fd_sc_mcu9t5v0__filltie
X$10114 \$22440 \$22387 gf180mcu_fd_sc_mcu9t5v0__filltie
X$10115 \$22440 \$22387 gf180mcu_fd_sc_mcu9t5v0__endcap
X$10116 \$22440 \$22387 gf180mcu_fd_sc_mcu9t5v0__endcap
X$10117 \$22720 \$22395 \$22713 \$22837 \$22588 \$22397
+ gf180mcu_fd_sc_mcu9t5v0__xnor3_1
X$10118 \$23767 \$23768 \$23814 \$23620 \$23807 \$22395
+ gf180mcu_fd_sc_mcu9t5v0__oai21_1
X$10119 \$23163 \$23212 \$23183 \$23454 \$22405 \$23345
+ gf180mcu_fd_sc_mcu9t5v0__xnor3_1
X$10120 \$23163 \$22406 \$23164 \$23027 \$23139 \$23165
+ gf180mcu_fd_sc_mcu9t5v0__nor3_1
X$10121 \$22870 \$23162 \$23211 \$23183 \$23454 \$22406
+ gf180mcu_fd_sc_mcu9t5v0__aoi21_1
X$10122 \$22925 \$22924 \$22874 \$23027 \$22837 \$22408
+ gf180mcu_fd_sc_mcu9t5v0__aoi21_1
X$10123 \$22874 \$22925 \$22924 \$23027 \$22837 \$22411
+ gf180mcu_fd_sc_mcu9t5v0__and3_1
X$10124 \$22413 \$27049 \$27050 \$27015 \$27153 \$26998
+ gf180mcu_fd_sc_mcu9t5v0__oai21_1
X$10125 \$22413 \$26379 \$26666 \$26247 \$26401 \$26220 \$26421
+ gf180mcu_fd_sc_mcu9t5v0__oai31_1
X$10126 \$27051 \$22413 \$27015 \$27153 \$27050 gf180mcu_fd_sc_mcu9t5v0__nand2_1
X$10127 \$26380 \$22413 \$26401 \$26220 \$26247 gf180mcu_fd_sc_mcu9t5v0__nand2_1
X$10128 \$22415 \$22604 \$22713 \$22440 \$22468 gf180mcu_fd_sc_mcu9t5v0__xnor2_1
X$10129 \$23652 \$22416 \$23479 \$24231 \$24109 \$24268
+ gf180mcu_fd_sc_mcu9t5v0__mux2_1
X$10130 \$22564 \$22424 \$22563 \$22713 \$22440 \$22704
+ gf180mcu_fd_sc_mcu9t5v0__nand3_1
X$10131 \$22424 \$22561 \$22713 \$22440 \$22427 gf180mcu_fd_sc_mcu9t5v0__nand2_1
X$10132 \$22425 \$22561 \$22713 \$22440 \$22560 gf180mcu_fd_sc_mcu9t5v0__xnor2_1
X$10133 \$22882 \$22427 \$22713 \$22837 \$22817 gf180mcu_fd_sc_mcu9t5v0__nand2_1
X$10134 \$23801 \$24281 \$22428 \$24099 \$24231 \$24109 \$24220
+ gf180mcu_fd_sc_mcu9t5v0__nand4_1
X$10135 \$24281 \$22428 \$23580 \$24593 \$24428 \$24426
+ gf180mcu_fd_sc_mcu9t5v0__oai21_1
X$10136 \$26351 \$25043 \$26401 \$26220 \$22428 gf180mcu_fd_sc_mcu9t5v0__nor2_1
X$10137 \$24281 \$22428 \$24231 \$24428 \$24282 gf180mcu_fd_sc_mcu9t5v0__nand2_1
X$10138 \$22431 \$22713 \$22440 \$22430 \$22565 gf180mcu_fd_sc_mcu9t5v0__xor2_1
X$10139 \$22819 \$22430 \$22885 \$23027 \$22837 \$23019
+ gf180mcu_fd_sc_mcu9t5v0__mux2_1
X$10140 \$22705 \$22706 \$22822 \$22821 \$22713 \$22837 \$22432
+ gf180mcu_fd_sc_mcu9t5v0__aoi22_1
X$10141 \$22433 \$22713 \$22440 \$22705 gf180mcu_fd_sc_mcu9t5v0__clkinv_1
X$10142 \$22713 \$22440 \$22562 gf180mcu_fd_sc_mcu9t5v0__tiel
X$10143 \$22598 \$22599 \$22713 \$22440 \$22463 gf180mcu_fd_sc_mcu9t5v0__and2_1
X$10144 \$22600 \$22464 \$22713 \$22440 \$22467 gf180mcu_fd_sc_mcu9t5v0__or2_1
X$10145 \$22876 \$22610 \$22611 \$22713 \$22440 \$22609
+ gf180mcu_fd_sc_mcu9t5v0__aoi21_1
X$10146 \$22613 \$22614 \$22713 \$22440 \$22730 gf180mcu_fd_sc_mcu9t5v0__nor2_1
X$10147 \$22598 \$22599 \$22713 \$22440 \$22462 gf180mcu_fd_sc_mcu9t5v0__nor2_1
X$10148 \$22569 \$22706 \$22568 \$22822 \$22713 \$22440 \$22567
+ gf180mcu_fd_sc_mcu9t5v0__aoi22_1
X$10149 \$22442 \$22713 \$22440 \$22581 gf180mcu_fd_sc_mcu9t5v0__clkinv_1
X$10150 \$22455 \$22713 \$22440 \$22720 gf180mcu_fd_sc_mcu9t5v0__clkinv_1
X$10151 \$22440 \$22713 gf180mcu_fd_sc_mcu9t5v0__filltie
X$10152 \$22440 \$22713 gf180mcu_fd_sc_mcu9t5v0__filltie
X$10153 \$22440 \$22713 gf180mcu_fd_sc_mcu9t5v0__filltie
X$10154 \$22440 \$22713 gf180mcu_fd_sc_mcu9t5v0__filltie
X$10155 \$22440 \$22713 gf180mcu_fd_sc_mcu9t5v0__filltie
X$10156 \$22440 \$22713 gf180mcu_fd_sc_mcu9t5v0__filltie
X$10157 \$22440 \$22713 gf180mcu_fd_sc_mcu9t5v0__endcap
X$10158 \$22440 \$22713 gf180mcu_fd_sc_mcu9t5v0__endcap
X$10159 \$25634 \$25462 \$25632 \$22448 gf180mcu_fd_sc_mcu9t5v0__clkinv_1
X$10160 \$22455 \$22848 \$22713 \$22837 \$22906 gf180mcu_fd_sc_mcu9t5v0__xnor2_1
X$10161 \$23946 \$23945 \$23926 \$23807 \$22461 gf180mcu_fd_sc_mcu9t5v0__and2_1
X$10162 \$23162 \$22461 \$23786 \$23210 \$23620 \$23807 \$23161
+ gf180mcu_fd_sc_mcu9t5v0__aoi211_1
X$10163 \$22598 \$22461 \$22917 \$23027 \$22837 \$22724
+ gf180mcu_fd_sc_mcu9t5v0__oai21_1
X$10164 \$22598 \$22461 \$22917 \$22597 \$23183 \$23139 \$23208
+ gf180mcu_fd_sc_mcu9t5v0__oai211_1
X$10165 \$23210 \$23183 \$23139 \$22464 \$23211 gf180mcu_fd_sc_mcu9t5v0__xor2_1
X$10166 \$23210 \$22464 \$23620 \$23807 \$23212 gf180mcu_fd_sc_mcu9t5v0__xnor2_1
X$10167 \$22598 \$22870 \$22871 \$22713 \$22837 \$22465
+ gf180mcu_fd_sc_mcu9t5v0__and3_1
X$10168 \$22597 \$23475 \$23212 \$23183 \$23454 \$22466
+ gf180mcu_fd_sc_mcu9t5v0__oai21_1
X$10169 \$22926 \$24078 \$23027 \$22837 \$22470 gf180mcu_fd_sc_mcu9t5v0__nor2_1
X$10170 \$22613 \$22614 \$23027 \$22837 \$22474 gf180mcu_fd_sc_mcu9t5v0__nand2_1
X$10171 \$22730 \$22878 \$22713 \$22837 \$22475 gf180mcu_fd_sc_mcu9t5v0__or2_1
X$10172 \$34468 pad_rst_n \$I18268 \$I18278 \$I18288 \$I18298 \$I18308 \$I18318
+ \$I18328 \$I18338 \$I18348 \$I18358 \$I18368 \$I18378 \$I18388 \$I18398
+ \$I18408 \$I18418 \$I18428 \$I18438 \$I18448 \$I18458 \$I18468 \$I18478
+ \$I18488 \$I18498 \$I18508 \$I18518 \$I18528 \$I18538 \$I18548 \$I18558
+ \$I18568 \$I18578 \$I18588 \$I18598 \$I18608 \$I18618 \$I18628 \$I18638
+ \$I18648 \$I18658 \$I18668 \$I18678 \$I18688 \$I18698 \$I18708 \$I18718
+ \$I18728 \$I18738 \$I18748 \$I18758 \$I18768 \$I18778 \$I18788 \$I18798
+ \$I18808 \$I18818 \$I18828 \$I18838 \$I18848 \$I18858 \$I18868 \$I18878
+ \$I18888 \$I18898 \$I18908 \$I18918 \$I18928 \$I18938 \$I18948 \$I18958
+ \$I18968 \$I18978 \$I18988 \$I18998 \$I19008 \$I19018 \$I19028 \$I19038
+ \$I19048 \$I19058 \$I19068 \$I19078 \$I19088 \$I19098 \$I19108 \$I19118
+ \$I19128 \$I19138 \$I19148 \$I19158 \$I19168 \$I19178 \$I19188 \$I19198
+ \$I19208 \$I19218 \$I19228 \$I19238 \$I19248 \$I19258 \$22562 \$I19268
+ \$I19278 \$I19288 \$I19298 \$22562 \$34299 gf180mcu_fd_io__in_c
X$10173 \$23021 \$22888 \$23027 \$22837 \$22568 gf180mcu_fd_sc_mcu9t5v0__nand2_1
X$10174 \$22824 \$23027 \$22837 \$22569 gf180mcu_fd_sc_mcu9t5v0__clkinv_1
X$10175 \$22570 \$24218 \$23804 \$24231 \$24109 \$24230
+ gf180mcu_fd_sc_mcu9t5v0__mux2_1
X$10176 \$22846 \$22586 \$23027 \$22837 \$23034 gf180mcu_fd_sc_mcu9t5v0__xnor2_1
X$10177 \$22589 \$22906 \$23027 \$22837 \$22593 \$22909
+ gf180mcu_fd_sc_mcu9t5v0__xnor3_1
X$10178 \$22907 \$22853 \$22589 \$23027 \$22837 \$22854
+ gf180mcu_fd_sc_mcu9t5v0__aoi21_1
X$10179 \$23636 \$23334 \$23597 \$23620 \$23454 \$22590
+ gf180mcu_fd_sc_mcu9t5v0__oai21_1
X$10180 \$23936 \$23774 \$23638 \$23620 \$23807 \$22592
+ gf180mcu_fd_sc_mcu9t5v0__oai21_1
X$10181 \$22597 \$23027 \$23139 \$23162 \$22599 gf180mcu_fd_sc_mcu9t5v0__xor2_1
X$10182 \$22597 \$23475 \$23212 \$23183 \$23139 \$23164
+ gf180mcu_fd_sc_mcu9t5v0__nor3_1
X$10183 \$22597 \$23475 \$23620 \$23454 \$23345 gf180mcu_fd_sc_mcu9t5v0__nor2_1
X$10184 \$23785 \$23620 \$23807 \$22597 gf180mcu_fd_sc_mcu9t5v0__buf_8
X$10185 \$22598 \$23027 \$22837 \$22918 gf180mcu_fd_sc_mcu9t5v0__clkinv_1
X$10186 \$22918 \$22599 \$23027 \$22837 \$22919 gf180mcu_fd_sc_mcu9t5v0__or2_1
X$10187 \$23210 \$23183 \$23454 \$22600 gf180mcu_fd_sc_mcu9t5v0__clkinv_1
X$10188 \$22608 \$22606 \$22713 \$22837 \$22611 gf180mcu_fd_sc_mcu9t5v0__xnor2_1
X$10189 \$29717 \$29634 \$29720 \$29327 \$22607 gf180mcu_fd_sc_mcu9t5v0__xor2_1
X$10190 \$22607 \$25339 \$22930 \$25191 \$25347 \$25338
+ gf180mcu_fd_sc_mcu9t5v0__mux2_1
X$10191 \$22607 \$25793 \$22928 \$25797 \$25632 \$25821
+ gf180mcu_fd_sc_mcu9t5v0__mux2_1
X$10192 \$22607 \$27185 \$23479 \$27315 \$27153 \$27300
+ gf180mcu_fd_sc_mcu9t5v0__mux2_1
X$10193 \$22607 \$27618 \$23348 \$27637 \$27449 \$27674
+ gf180mcu_fd_sc_mcu9t5v0__mux2_1
X$10194 \$22608 \$22928 \$23027 \$22837 \$22612 gf180mcu_fd_sc_mcu9t5v0__nand2_1
X$10195 \$23220 \$23221 \$23183 \$23139 \$22610 gf180mcu_fd_sc_mcu9t5v0__or2_1
X$10196 \$22613 \$22878 \$23027 \$23139 \$23355 \$22614
+ gf180mcu_fd_sc_mcu9t5v0__xnor3_1
X$10197 \$23804 \$24225 \$24231 \$24109 \$22703 gf180mcu_fd_sc_mcu9t5v0__or2_1
X$10198 \$24527 \$22703 \$24290 \$24593 \$24428 \$24427
+ gf180mcu_fd_sc_mcu9t5v0__and3_1
X$10199 \$23311 \$23751 \$22703 \$23620 \$23807 \$23443
+ gf180mcu_fd_sc_mcu9t5v0__oai21_1
X$10200 \$24096 \$22706 \$24520 \$22703 \$24593 \$24428 \$24521
+ gf180mcu_fd_sc_mcu9t5v0__oai211_1
X$10201 \$24873 \$22703 \$24710 \$24593 \$24721 \$24709
+ gf180mcu_fd_sc_mcu9t5v0__nand3_1
X$10202 \$23170 \$22703 \$22706 \$23620 \$23454 \$23172
+ gf180mcu_fd_sc_mcu9t5v0__nand3_1
X$10203 \$22703 \$22817 \$22713 \$22837 \$22816 gf180mcu_fd_sc_mcu9t5v0__nand2_1
X$10204 \$22703 \$24048 \$23926 \$24109 \$24227 gf180mcu_fd_sc_mcu9t5v0__nand2_1
X$10205 \$22703 \$23309 \$23183 \$23454 \$23442 gf180mcu_fd_sc_mcu9t5v0__nand2_1
X$10206 \$22703 \$24292 \$24593 \$24428 \$24528 gf180mcu_fd_sc_mcu9t5v0__nand2_1
X$10207 \$22703 \$24525 \$24593 \$24428 \$24588 gf180mcu_fd_sc_mcu9t5v0__nand2_1
X$10208 \$22703 \$22706 \$23926 \$23807 \$23918 gf180mcu_fd_sc_mcu9t5v0__nand2_1
X$10209 \$23804 \$22704 \$25191 \$24997 \$25043 gf180mcu_fd_sc_mcu9t5v0__nand2_1
X$10210 \$24520 \$24096 \$22706 \$24593 \$24428 \$24710
+ gf180mcu_fd_sc_mcu9t5v0__or3_1
X$10211 \$24425 \$24096 \$22706 \$24231 \$24109 \$23748
+ gf180mcu_fd_sc_mcu9t5v0__or3_1
X$10212 \$23170 \$22706 \$23172 \$23183 \$23139 \$23171
+ gf180mcu_fd_sc_mcu9t5v0__oai21_1
X$10213 \$22706 \$23920 \$24231 \$24109 \$22822 gf180mcu_fd_sc_mcu9t5v0__nor2_1
X$10214 \$24713 \$22706 \$22822 \$24524 \$24593 \$24721 \$24712
+ gf180mcu_fd_sc_mcu9t5v0__aoi22_1
X$10215 \$24101 \$22706 \$22822 \$24045 \$23926 \$24109 \$24100
+ gf180mcu_fd_sc_mcu9t5v0__aoi22_1
X$10216 \$23134 \$22706 \$22822 \$23132 \$23027 \$23139 \$23174
+ gf180mcu_fd_sc_mcu9t5v0__aoi22_1
X$10217 \$24715 \$22706 \$22822 \$24585 \$24593 \$24721 \$24714
+ gf180mcu_fd_sc_mcu9t5v0__aoi22_1
X$10218 \$24711 \$22706 \$22822 \$24523 \$24593 \$24428 \$24522
+ gf180mcu_fd_sc_mcu9t5v0__aoi22_1
X$10219 \$23804 \$25302 \$25191 \$25347 \$22706 gf180mcu_fd_sc_mcu9t5v0__nand2_1
X$10220 \$22706 \$22713 \$22837 \$22820 gf180mcu_fd_sc_mcu9t5v0__clkinv_1
X$10221 \$23922 \$25040 \$22706 \$25462 \$25347 \$25039
+ gf180mcu_fd_sc_mcu9t5v0__mux2_1
X$10222 \$22720 \$22848 \$22713 \$22837 \$22850 gf180mcu_fd_sc_mcu9t5v0__nor2_1
X$10223 \$22725 \$22864 \$22713 \$22837 \$22872 gf180mcu_fd_sc_mcu9t5v0__nand2_1
X$10224 \$22720 \$22848 \$22713 \$22837 \$22849 gf180mcu_fd_sc_mcu9t5v0__nand2_1
X$10225 \$22837 \$22713 gf180mcu_fd_sc_mcu9t5v0__filltie
X$10226 \$22837 \$22713 gf180mcu_fd_sc_mcu9t5v0__filltie
X$10227 \$22837 \$22713 gf180mcu_fd_sc_mcu9t5v0__filltie
X$10228 \$22837 \$22713 gf180mcu_fd_sc_mcu9t5v0__filltie
X$10229 \$22837 \$22713 gf180mcu_fd_sc_mcu9t5v0__filltie
X$10230 \$22837 \$22713 gf180mcu_fd_sc_mcu9t5v0__filltie
X$10231 \$22837 \$22713 gf180mcu_fd_sc_mcu9t5v0__endcap
X$10232 \$22837 \$22713 gf180mcu_fd_sc_mcu9t5v0__endcap
X$10233 \$24248 \$22722 \$24231 \$24428 \$24319 gf180mcu_fd_sc_mcu9t5v0__nand2_1
X$10234 \$22887 \$22888 \$23027 \$22837 \$22821 gf180mcu_fd_sc_mcu9t5v0__nand2_1
X$10235 \$22833 \$23315 \$23445 \$23314 \$23183 \$23454 \$23316
+ gf180mcu_fd_sc_mcu9t5v0__nand4_1
X$10236 \$22833 \$23315 \$23445 \$23314 \$23926 \$24109 \$23919
+ gf180mcu_fd_sc_mcu9t5v0__nor4_1
X$10237 \$22833 \$30691 \$29436 \$30696 \$30763 \$30769
+ gf180mcu_fd_sc_mcu9t5v0__mux2_1
X$10238 \$22833 \$29264 \$25343 \$29123 \$29270 \$29263
+ gf180mcu_fd_sc_mcu9t5v0__mux2_1
X$10239 \$22833 \$29075 \$26339 \$29290 \$29270 \$29228
+ gf180mcu_fd_sc_mcu9t5v0__mux2_1
X$10240 \$22833 \$28706 \$27658 \$28810 \$28689 \$28826
+ gf180mcu_fd_sc_mcu9t5v0__mux2_1
X$10241 \$22834 \$24281 \$23804 \$24593 \$24428 \$24590
+ gf180mcu_fd_sc_mcu9t5v0__mux2_1
X$10242 \$22851 \$22852 \$22908 \$23027 \$22837 \$22907
+ gf180mcu_fd_sc_mcu9t5v0__oai21_1
X$10243 \$22928 \$23347 \$22929 \$23027 \$22837 \$22927
+ gf180mcu_fd_sc_mcu9t5v0__oai21_1
X$10244 \$22930 \$23347 \$22931 \$23027 \$22837 \$23046
+ gf180mcu_fd_sc_mcu9t5v0__oai21_1
X$10245 \$22851 \$22852 \$23027 \$22837 \$22909 gf180mcu_fd_sc_mcu9t5v0__nor2_1
X$10246 \$22906 \$23027 \$22837 \$22908 gf180mcu_fd_sc_mcu9t5v0__clkinv_1
X$10247 \$23143 \$22894 \$23027 \$22837 \$22895 gf180mcu_fd_sc_mcu9t5v0__nand2_1
X$10248 \$22837 \$23027 gf180mcu_fd_sc_mcu9t5v0__filltie
X$10249 \$22837 \$23027 gf180mcu_fd_sc_mcu9t5v0__filltie
X$10250 \$22837 \$23027 gf180mcu_fd_sc_mcu9t5v0__filltie
X$10251 \$22837 \$23027 gf180mcu_fd_sc_mcu9t5v0__filltie
X$10252 \$22837 \$23027 gf180mcu_fd_sc_mcu9t5v0__filltie
X$10253 \$22837 \$23027 gf180mcu_fd_sc_mcu9t5v0__filltie
X$10254 \$22837 \$23027 gf180mcu_fd_sc_mcu9t5v0__endcap
X$10255 \$22837 \$23027 gf180mcu_fd_sc_mcu9t5v0__endcap
X$10256 \$23323 \$23140 \$22838 \$23027 \$23139 gf180mcu_fd_sc_mcu9t5v0__dffq_2
X$10257 \$23770 \$22903 \$23027 \$23139 \$22851 gf180mcu_fd_sc_mcu9t5v0__nor2_1
X$10258 \$24256 \$24255 \$24254 \$24231 \$24109 \$22852
+ gf180mcu_fd_sc_mcu9t5v0__aoi21_1
X$10259 \$23770 \$22903 \$23151 \$22906 \$23027 \$23139 \$22853
+ gf180mcu_fd_sc_mcu9t5v0__oai211_1
X$10260 \$23785 \$23620 \$23454 \$22870 gf180mcu_fd_sc_mcu9t5v0__clkinv_1
X$10261 \$23163 \$23027 \$23139 \$23210 \$22871 gf180mcu_fd_sc_mcu9t5v0__xor2_1
X$10262 \$24867 \$24622 \$24877 \$24721 \$22875 \$24892
+ gf180mcu_fd_sc_mcu9t5v0__xnor3_1
X$10263 \$23219 \$23351 \$23183 \$23139 \$22876 gf180mcu_fd_sc_mcu9t5v0__nand2_1
X$10264 \$24869 \$24757 \$25033 \$24877 \$24721 \$22878
+ gf180mcu_fd_sc_mcu9t5v0__aoi21_1
X$10265 \$22880 \$23027 \$23139 \$24338 gf180mcu_fd_sc_mcu9t5v0__clkinv_1
X$10266 \$22887 \$25960 \$26339 \$26401 \$26220 \$26393
+ gf180mcu_fd_sc_mcu9t5v0__mux2_1
X$10267 \$22887 \$25297 \$25343 \$25462 \$25347 \$25296
+ gf180mcu_fd_sc_mcu9t5v0__mux2_1
X$10268 \$22887 \$26981 \$27658 \$27637 \$27449 \$27643
+ gf180mcu_fd_sc_mcu9t5v0__mux2_1
X$10269 \$22887 \$29637 \$29436 \$29634 \$29424 \$29636
+ gf180mcu_fd_sc_mcu9t5v0__mux2_1
X$10270 \$23318 \$23316 \$23922 \$23183 \$23454 \$22888
+ gf180mcu_fd_sc_mcu9t5v0__oai21_1
X$10271 \$24221 \$22888 \$24231 \$24109 \$24045 gf180mcu_fd_sc_mcu9t5v0__nand2_1
X$10272 \$23180 \$22888 \$24877 \$24721 \$24523 gf180mcu_fd_sc_mcu9t5v0__nand2_1
X$10273 \$23596 \$24231 \$24109 \$22903 \$24254 gf180mcu_fd_sc_mcu9t5v0__xor2_1
X$10274 \$23596 \$22903 \$23620 \$23807 \$23771 gf180mcu_fd_sc_mcu9t5v0__xnor2_1
X$10275 \$23765 \$23632 \$22905 \$23620 \$23807 gf180mcu_fd_sc_mcu9t5v0__dffq_2
X$10276 \$23033 \$23027 \$23139 \$22910 gf180mcu_fd_sc_mcu9t5v0__buf_8
X$10277 \$23032 \$22911 \$23027 \$23139 \$23037 gf180mcu_fd_sc_mcu9t5v0__nor2_1
X$10278 \$23946 \$23945 \$23944 \$23926 \$23807 \$22917
+ gf180mcu_fd_sc_mcu9t5v0__nand3_1
X$10279 \$23649 \$23212 \$23620 \$23454 \$22920 \$23345
+ gf180mcu_fd_sc_mcu9t5v0__xnor3_1
X$10280 \$24749 \$24619 \$24593 \$24721 \$22923 gf180mcu_fd_sc_mcu9t5v0__xnor2_1
X$10281 \$23217 \$23215 \$23216 \$23183 \$23139 \$22924
+ gf180mcu_fd_sc_mcu9t5v0__oai21_1
X$10282 \$23217 \$23215 \$23027 \$23139 \$22925 gf180mcu_fd_sc_mcu9t5v0__nand2_1
X$10283 \$29110 \$29123 \$28971 \$22928 gf180mcu_fd_sc_mcu9t5v0__buf_8
X$10284 \$27344 \$28078 \$22928 \$27913 \$28089 \$28120
+ gf180mcu_fd_sc_mcu9t5v0__mux2_1
X$10285 \$23481 \$25822 \$22928 \$25797 \$25918 \$25956
+ gf180mcu_fd_sc_mcu9t5v0__mux2_1
X$10286 \$26391 \$27060 \$22928 \$27015 \$27153 \$27059
+ gf180mcu_fd_sc_mcu9t5v0__mux2_1
X$10287 \$26246 \$28517 \$22928 \$28534 \$28381 \$28592
+ gf180mcu_fd_sc_mcu9t5v0__mux2_1
X$10288 \$29256 \$29123 \$29270 \$22930 gf180mcu_fd_sc_mcu9t5v0__buf_8
X$10289 \$23481 \$26251 \$22930 \$26088 \$26220 \$26392
+ gf180mcu_fd_sc_mcu9t5v0__mux2_1
X$10290 \$26391 \$27476 \$22930 \$27315 \$27449 \$27475
+ gf180mcu_fd_sc_mcu9t5v0__mux2_1
X$10291 \$26246 \$26668 \$22930 \$26675 \$26521 \$26699
+ gf180mcu_fd_sc_mcu9t5v0__mux2_1
X$10292 \$27344 \$27678 \$22930 \$27637 \$27449 \$27677
+ gf180mcu_fd_sc_mcu9t5v0__mux2_1
X$10293 \$23020 \$23183 \$23139 \$23173 gf180mcu_fd_sc_mcu9t5v0__clkinv_1
X$10294 \$23021 \$26786 \$26339 \$27015 \$27153 \$27147
+ gf180mcu_fd_sc_mcu9t5v0__mux2_1
X$10295 \$23021 \$26209 \$25343 \$26088 \$26220 \$26208
+ gf180mcu_fd_sc_mcu9t5v0__mux2_1
X$10296 \$23021 \$29927 \$29436 \$29780 \$29720 \$29789
+ gf180mcu_fd_sc_mcu9t5v0__mux2_1
X$10297 \$23021 \$28941 \$27658 \$29290 \$29270 \$29299
+ gf180mcu_fd_sc_mcu9t5v0__mux2_1
X$10298 \$23032 \$23029 \$23027 \$23139 \$23145 gf180mcu_fd_sc_mcu9t5v0__nor2_1
X$10299 \$23175 \$23027 \$23139 \$23134 gf180mcu_fd_sc_mcu9t5v0__clkinv_1
X$10300 \$23139 \$23027 gf180mcu_fd_sc_mcu9t5v0__filltie
X$10301 \$23139 \$23027 gf180mcu_fd_sc_mcu9t5v0__filltie
X$10302 \$23139 \$23027 gf180mcu_fd_sc_mcu9t5v0__filltie
X$10303 \$23139 \$23027 gf180mcu_fd_sc_mcu9t5v0__filltie
X$10304 \$23139 \$23027 gf180mcu_fd_sc_mcu9t5v0__filltie
X$10305 \$23139 \$23027 gf180mcu_fd_sc_mcu9t5v0__filltie
X$10306 \$23139 \$23027 gf180mcu_fd_sc_mcu9t5v0__endcap
X$10307 \$23139 \$23027 gf180mcu_fd_sc_mcu9t5v0__endcap
X$10308 \$24070 \$23941 \$23032 \$23926 \$24109 \$24069
+ gf180mcu_fd_sc_mcu9t5v0__aoi21_1
X$10309 \$23032 \$23328 \$23191 \$23183 \$23139 \$23192
+ gf180mcu_fd_sc_mcu9t5v0__oai21_1
X$10310 \$23032 \$23196 \$25000 \$24877 \$24721 \$24882
+ gf180mcu_fd_sc_mcu9t5v0__oai21_1
X$10311 \$23032 \$27581 \$29954 \$29847 \$30403 gf180mcu_fd_sc_mcu9t5v0__nand2_1
X$10312 \$29781 \$29780 \$29847 \$23032 gf180mcu_fd_sc_mcu9t5v0__buf_8
X$10313 \$23152 \$23037 \$23183 \$23139 \$23200 gf180mcu_fd_sc_mcu9t5v0__nand2_1
X$10314 \$23471 \$23470 \$23339 \$23183 \$23454 \$23038
+ gf180mcu_fd_sc_mcu9t5v0__nand3_1
X$10315 \$24710 \$24521 \$23131 \$24877 \$24721 \$24580
+ gf180mcu_fd_sc_mcu9t5v0__nand3_1
X$10316 \$23131 \$23750 \$23926 \$23807 \$23613 gf180mcu_fd_sc_mcu9t5v0__nand2_1
X$10317 \$23804 \$23136 \$24877 \$24721 \$25586 gf180mcu_fd_sc_mcu9t5v0__nor2_1
X$10318 \$23217 \$23216 \$23183 \$23139 \$23215 \$23218
+ gf180mcu_fd_sc_mcu9t5v0__xor3_1
X$10319 \$23194 \$23330 \$23144 \$23183 \$23139 \$23193 \$23195
+ gf180mcu_fd_sc_mcu9t5v0__nand4_2
X$10320 \$23144 \$23193 \$23183 \$23139 \$23329 gf180mcu_fd_sc_mcu9t5v0__and2_1
X$10321 \$23208 \$23160 \$23183 \$23139 \$23159 gf180mcu_fd_sc_mcu9t5v0__and2_1
X$10322 \$23139 \$23183 gf180mcu_fd_sc_mcu9t5v0__filltie
X$10323 \$23139 \$23183 gf180mcu_fd_sc_mcu9t5v0__filltie
X$10324 \$23139 \$23183 gf180mcu_fd_sc_mcu9t5v0__filltie
X$10325 \$23139 \$23183 gf180mcu_fd_sc_mcu9t5v0__filltie
X$10326 \$23139 \$23183 gf180mcu_fd_sc_mcu9t5v0__filltie
X$10327 \$23139 \$23183 gf180mcu_fd_sc_mcu9t5v0__filltie
X$10328 \$23323 \$23141 \$23142 \$23183 \$23139 gf180mcu_fd_sc_mcu9t5v0__dffq_2
X$10329 \$23139 \$23183 gf180mcu_fd_sc_mcu9t5v0__endcap
X$10330 \$23139 \$23183 gf180mcu_fd_sc_mcu9t5v0__endcap
X$10331 \$23935 \$23934 \$23771 \$23926 \$23807 \$23151
+ gf180mcu_fd_sc_mcu9t5v0__oai21_1
X$10332 \$23773 \$23151 \$23637 \$23926 \$23807 \$23597
+ gf180mcu_fd_sc_mcu9t5v0__nand3_1
X$10333 \$23769 \$23151 \$23637 \$23620 \$23454 \$23638
+ gf180mcu_fd_sc_mcu9t5v0__nand3_1
X$10334 \$23341 \$23340 \$23183 \$23454 \$23153 gf180mcu_fd_sc_mcu9t5v0__nand2_1
X$10335 \$23157 \$30403 \$31518 \$31607 \$31733 \$31683
+ gf180mcu_fd_sc_mcu9t5v0__aoi21_1
X$10336 \$23162 \$23620 \$23454 \$23475 gf180mcu_fd_sc_mcu9t5v0__clkinv_1
X$10337 \$23946 \$23945 \$23163 \$23926 \$23807 \$23604
+ gf180mcu_fd_sc_mcu9t5v0__aoi21_1
X$10338 \$23163 \$23620 \$23807 \$23649 gf180mcu_fd_sc_mcu9t5v0__clkinv_1
X$10339 \$23608 \$23167 \$23620 \$23454 \$23790 gf180mcu_fd_sc_mcu9t5v0__xnor2_1
X$10340 \$23576 \$23611 \$23620 \$23454 \$23169 gf180mcu_fd_sc_mcu9t5v0__xnor2_1
X$10341 \$23797 \$23620 \$23807 \$23170 \$23749 gf180mcu_fd_sc_mcu9t5v0__xor2_1
X$10342 \$23797 \$23170 \$23926 \$24109 \$24096 gf180mcu_fd_sc_mcu9t5v0__or2_1
X$10343 \$23796 \$23170 \$23795 \$23926 \$23807 \$23916
+ gf180mcu_fd_sc_mcu9t5v0__nand3_1
X$10344 \$23173 \$23750 \$23613 \$23312 \$23620 \$23454 \$23579
+ gf180mcu_fd_sc_mcu9t5v0__oai22_1
X$10345 \$23176 \$25763 \$25797 \$25632 \$25597 gf180mcu_fd_sc_mcu9t5v0__nand2_1
X$10346 \$23180 \$26784 \$26339 \$26675 \$26856 \$26841
+ gf180mcu_fd_sc_mcu9t5v0__mux2_1
X$10347 \$23180 \$27324 \$27658 \$27315 \$27449 \$27582
+ gf180mcu_fd_sc_mcu9t5v0__mux2_1
X$10348 \$23180 \$29433 \$29436 \$29290 \$29424 \$29432
+ gf180mcu_fd_sc_mcu9t5v0__mux2_1
X$10349 \$23180 \$25342 \$25343 \$25462 \$25347 \$25449
+ gf180mcu_fd_sc_mcu9t5v0__mux2_1
X$10350 \$23219 \$23221 \$23183 \$23454 \$23352 \$23351
+ gf180mcu_fd_sc_mcu9t5v0__xnor3_1
X$10351 \$23310 \$23612 \$23183 \$23454 \$23309 gf180mcu_fd_sc_mcu9t5v0__xnor2_1
X$10352 \$23338 \$23337 \$23336 \$23183 \$23454 \$23339
+ gf180mcu_fd_sc_mcu9t5v0__and3_1
X$10353 \$23311 \$23751 \$23443 \$23183 \$23454 \$23312
+ gf180mcu_fd_sc_mcu9t5v0__aoi21_1
X$10354 \$23348 \$23347 \$23349 \$23183 \$23454 \$23476
+ gf180mcu_fd_sc_mcu9t5v0__oai21_1
X$10355 \$23219 \$23351 \$23183 \$23454 \$23220 gf180mcu_fd_sc_mcu9t5v0__nor2_1
X$10356 \$23464 \$23195 \$23183 \$23454 \$23335 gf180mcu_fd_sc_mcu9t5v0__nor2_1
X$10357 \$23484 \$23183 \$23454 \$23485 gf180mcu_fd_sc_mcu9t5v0__clkinv_1
X$10358 \$23332 \$23183 \$23454 \$23464 gf180mcu_fd_sc_mcu9t5v0__clkinv_1
X$10359 \$23343 \$23340 \$23183 \$23454 \$23474 gf180mcu_fd_sc_mcu9t5v0__nand2_1
X$10360 \$23330 \$23329 \$23183 \$23454 \$23460 gf180mcu_fd_sc_mcu9t5v0__nand2_1
X$10361 \$23337 \$23336 \$23183 \$23454 \$23469 gf180mcu_fd_sc_mcu9t5v0__nand2_1
X$10362 \$23652 \$23217 \$23348 \$23183 \$23454 \$23477
+ gf180mcu_fd_sc_mcu9t5v0__mux2_1
X$10363 \$23323 \$23184 \$23185 \$23183 \$23454 gf180mcu_fd_sc_mcu9t5v0__dffq_2
X$10364 \$23323 \$23186 \$23325 \$23183 \$23454 gf180mcu_fd_sc_mcu9t5v0__dffq_2
X$10365 \$23323 \$23189 \$23190 \$23183 \$23454 gf180mcu_fd_sc_mcu9t5v0__dffq_2
X$10366 \$23323 \$23456 \$23457 \$23183 \$23454 gf180mcu_fd_sc_mcu9t5v0__dffq_2
X$10367 \$23454 \$23183 gf180mcu_fd_sc_mcu9t5v0__filltie
X$10368 \$23454 \$23183 gf180mcu_fd_sc_mcu9t5v0__filltie
X$10369 \$23454 \$23183 gf180mcu_fd_sc_mcu9t5v0__filltie
X$10370 \$23454 \$23183 gf180mcu_fd_sc_mcu9t5v0__filltie
X$10371 \$23454 \$23183 gf180mcu_fd_sc_mcu9t5v0__filltie
X$10372 \$23454 \$23183 gf180mcu_fd_sc_mcu9t5v0__filltie
X$10373 \$23454 \$23183 gf180mcu_fd_sc_mcu9t5v0__endcap
X$10374 \$23454 \$23183 gf180mcu_fd_sc_mcu9t5v0__endcap
X$10375 \$28549 \$23190 \$28344 \$28534 \$28689 \$28699
+ gf180mcu_fd_sc_mcu9t5v0__mux2_1
X$10376 \$28816 \$23190 \$29240 \$29123 \$29270 \$29272
+ gf180mcu_fd_sc_mcu9t5v0__mux2_1
X$10377 \$29090 \$23190 \$29091 \$29123 \$28971 \$29128
+ gf180mcu_fd_sc_mcu9t5v0__mux2_1
X$10378 \$23205 \$24433 \$24593 \$24721 \$24745 gf180mcu_fd_sc_mcu9t5v0__nand2_1
X$10379 \$23784 \$23340 \$23620 \$23807 \$23206 gf180mcu_fd_sc_mcu9t5v0__nand2_1
X$10380 \$23214 \$23620 \$23454 gf180mcu_fd_sc_mcu9t5v0__clkinv_3
X$10381 \$23651 \$23950 \$23951 \$23926 \$23807 \$23216
+ gf180mcu_fd_sc_mcu9t5v0__oai21_1
X$10382 \$24575 \$24574 \$24576 \$24593 \$24428 \$23221
+ gf180mcu_fd_sc_mcu9t5v0__aoi21_1
X$10383 \$23308 \$23926 \$24109 gf180mcu_fd_sc_mcu9t5v0__inv_4
X$10384 \$23747 \$23576 \$23310 \$23620 \$23807 \$23795
+ gf180mcu_fd_sc_mcu9t5v0__nor3_1
X$10385 \$24218 \$23311 \$23751 \$24231 \$24109 \$24099
+ gf180mcu_fd_sc_mcu9t5v0__and3_1
X$10386 \$23311 \$23751 \$24218 \$24231 \$24109 \$24098
+ gf180mcu_fd_sc_mcu9t5v0__aoi21_1
X$10387 \$23311 \$23580 \$23620 \$23454 \$23581 gf180mcu_fd_sc_mcu9t5v0__nand2_1
X$10388 \$23580 \$23579 \$23581 \$23620 \$23454 \$23313
+ gf180mcu_fd_sc_mcu9t5v0__oai21_1
X$10389 \$23314 \$29072 \$26339 \$29123 \$29270 \$29259
+ gf180mcu_fd_sc_mcu9t5v0__mux2_1
X$10390 \$23314 \$30354 \$29436 \$30564 \$30485 \$30623
+ gf180mcu_fd_sc_mcu9t5v0__mux2_1
X$10391 \$23314 \$28829 \$27658 \$28810 \$28689 \$28828
+ gf180mcu_fd_sc_mcu9t5v0__mux2_1
X$10392 \$23314 \$29261 \$25343 \$29290 \$29270 \$29077
+ gf180mcu_fd_sc_mcu9t5v0__mux2_1
X$10393 \$23315 \$29076 \$26339 \$29123 \$28971 \$29117
+ gf180mcu_fd_sc_mcu9t5v0__mux2_1
X$10394 \$23315 \$28101 \$27658 \$28211 \$28089 \$28058
+ gf180mcu_fd_sc_mcu9t5v0__mux2_1
X$10395 \$23315 \$28084 \$25343 \$28211 \$28089 \$28039
+ gf180mcu_fd_sc_mcu9t5v0__mux2_1
X$10396 \$23315 \$30071 \$29436 \$30054 \$30027 \$30069
+ gf180mcu_fd_sc_mcu9t5v0__mux2_1
X$10397 \$23317 \$27439 \$26339 \$27315 \$27449 \$27438
+ gf180mcu_fd_sc_mcu9t5v0__mux2_1
X$10398 \$23317 \$28041 \$25343 \$27913 \$28089 \$27906
+ gf180mcu_fd_sc_mcu9t5v0__mux2_1
X$10399 \$23317 \$28707 \$27658 \$28534 \$28689 \$28943
+ gf180mcu_fd_sc_mcu9t5v0__mux2_1
X$10400 \$23317 \$29319 \$29436 \$29290 \$29270 \$29318
+ gf180mcu_fd_sc_mcu9t5v0__mux2_1
X$10401 \$23759 \$23618 \$23620 \$23807 \$23320 gf180mcu_fd_sc_mcu9t5v0__nand2_1
X$10402 \$23321 \$24877 \$24997 gf180mcu_fd_sc_mcu9t5v0__inv_4
X$10403 \$23323 \$23620 \$23807 gf180mcu_fd_sc_mcu9t5v0__clkbuf_4
X$10404 \$23323 \$24724 \$24725 \$24593 \$24721 gf180mcu_fd_sc_mcu9t5v0__dffq_2
X$10405 \$23323 \$24057 \$24111 \$24231 \$24109 gf180mcu_fd_sc_mcu9t5v0__dffq_2
X$10406 \$24315 \$24314 \$24431 \$24231 \$24428 \$23334
+ gf180mcu_fd_sc_mcu9t5v0__aoi21_1
X$10407 \$23470 \$23339 \$23620 \$23454 \$23641 gf180mcu_fd_sc_mcu9t5v0__nand2_1
X$10408 \$29707 \$23340 \$29634 \$29720 \$29792 gf180mcu_fd_sc_mcu9t5v0__nand2_1
X$10409 \$25614 \$23340 \$25462 \$25632 \$25358 gf180mcu_fd_sc_mcu9t5v0__nand2_1
X$10410 \$24326 \$23340 \$24231 \$24428 \$24074 gf180mcu_fd_sc_mcu9t5v0__nand2_1
X$10411 \$24073 \$23340 \$23926 \$24109 \$24072 gf180mcu_fd_sc_mcu9t5v0__nand2_1
X$10412 \$30318 \$23340 \$30251 \$30339 \$30317 gf180mcu_fd_sc_mcu9t5v0__nand2_1
X$10413 \$30477 \$23340 \$30402 \$30485 \$30348 gf180mcu_fd_sc_mcu9t5v0__nand2_1
X$10414 \$30756 \$23340 \$30402 \$30485 \$30476 gf180mcu_fd_sc_mcu9t5v0__nand2_1
X$10415 \$26539 \$23340 \$26401 \$26521 \$26239 gf180mcu_fd_sc_mcu9t5v0__nand2_1
X$10416 \$29964 \$23340 \$29780 \$29847 \$29791 gf180mcu_fd_sc_mcu9t5v0__nand2_1
X$10417 \$23782 \$23340 \$23620 \$23807 \$23783 gf180mcu_fd_sc_mcu9t5v0__nand2_1
X$10418 \$29708 \$23340 \$29634 \$29424 \$29538 gf180mcu_fd_sc_mcu9t5v0__nand2_1
X$10419 \$29967 \$23340 \$29954 \$29847 \$29928 gf180mcu_fd_sc_mcu9t5v0__nand2_1
X$10420 \$29706 \$23340 \$29634 \$29424 \$29638 gf180mcu_fd_sc_mcu9t5v0__nand2_1
X$10421 \$24746 \$23340 \$24877 \$24721 \$24556 gf180mcu_fd_sc_mcu9t5v0__nand2_1
X$10422 \$23340 \$30251 \$30185 \$30167 gf180mcu_fd_sc_mcu9t5v0__clkinv_1
X$10423 \$30168 \$30054 \$30185 \$23340 gf180mcu_fd_sc_mcu9t5v0__buf_8
X$10424 \$26823 \$23341 \$26675 \$26856 \$26869 gf180mcu_fd_sc_mcu9t5v0__or2_1
X$10425 \$26691 \$23341 \$24433 \$26675 \$26521 \$26693
+ gf180mcu_fd_sc_mcu9t5v0__aoi21_1
X$10426 \$26823 \$23341 \$26675 \$26521 \$26692 gf180mcu_fd_sc_mcu9t5v0__nand2_1
X$10427 \$23343 \$30494 \$30564 \$30625 \$30558 gf180mcu_fd_sc_mcu9t5v0__xnor2_1
X$10428 \$23343 \$30494 \$30493 \$30564 \$30485 \$29730
+ gf180mcu_fd_sc_mcu9t5v0__aoi21_1
X$10429 \$23343 \$30622 \$30564 \$30625 \$30497 gf180mcu_fd_sc_mcu9t5v0__nor2_1
X$10430 \$23344 \$25797 \$25918 \$23781 gf180mcu_fd_sc_mcu9t5v0__clkbuf_8
X$10431 \$23344 \$32543 \$32629 \$31827 gf180mcu_fd_sc_mcu9t5v0__clkbuf_8
X$10432 \$23344 \$29780 \$29847 \$28350 gf180mcu_fd_sc_mcu9t5v0__clkbuf_8
X$10433 \$23344 \$29780 \$29847 \$28566 gf180mcu_fd_sc_mcu9t5v0__clkbuf_8
X$10434 \$23344 \$31100 \$31175 \$30858 gf180mcu_fd_sc_mcu9t5v0__clkbuf_8
X$10435 \$23344 \$26088 \$25918 \$24742 gf180mcu_fd_sc_mcu9t5v0__clkbuf_8
X$10436 \$23344 \$26088 \$25918 \$24320 gf180mcu_fd_sc_mcu9t5v0__clkbuf_8
X$10437 \$23344 \$31967 \$31886 \$31089 gf180mcu_fd_sc_mcu9t5v0__clkbuf_8
X$10438 \$23344 \$30971 \$30900 \$30838 gf180mcu_fd_sc_mcu9t5v0__clkbuf_8
X$10439 \$23344 \$28810 \$28689 \$27935 gf180mcu_fd_sc_mcu9t5v0__clkbuf_8
X$10440 \$23479 \$23347 \$23607 \$23620 \$23454 \$23606
+ gf180mcu_fd_sc_mcu9t5v0__oai21_1
X$10441 \$27294 \$27315 \$27153 \$23347 gf180mcu_fd_sc_mcu9t5v0__buf_8
X$10442 \$24615 \$23348 \$24593 \$24721 \$24614 gf180mcu_fd_sc_mcu9t5v0__nand2_1
X$10443 \$25329 \$23348 \$25191 \$25347 \$25328 gf180mcu_fd_sc_mcu9t5v0__nand2_1
X$10444 \$29254 \$29123 \$29270 \$23348 gf180mcu_fd_sc_mcu9t5v0__buf_8
X$10445 \$23481 \$26836 \$23348 \$26675 \$26856 \$26878
+ gf180mcu_fd_sc_mcu9t5v0__mux2_1
X$10446 \$26391 \$29111 \$23348 \$29123 \$29270 \$29283
+ gf180mcu_fd_sc_mcu9t5v0__mux2_1
X$10447 \$27344 \$28587 \$23348 \$28534 \$28689 \$28722
+ gf180mcu_fd_sc_mcu9t5v0__mux2_1
X$10448 \$26246 \$28073 \$23348 \$28211 \$28089 \$28238
+ gf180mcu_fd_sc_mcu9t5v0__mux2_1
X$10449 \$23484 \$23353 \$23620 \$23454 \$23354 gf180mcu_fd_sc_mcu9t5v0__xnor2_1
X$10450 \$23445 \$28333 \$25343 \$28211 \$28381 \$28375
+ gf180mcu_fd_sc_mcu9t5v0__mux2_1
X$10451 \$23445 \$29797 \$29436 \$29780 \$29847 \$29936
+ gf180mcu_fd_sc_mcu9t5v0__mux2_1
X$10452 \$23445 \$28037 \$26339 \$27913 \$27776 \$27902
+ gf180mcu_fd_sc_mcu9t5v0__mux2_1
X$10453 \$23445 \$28059 \$27658 \$28211 \$28089 \$28223
+ gf180mcu_fd_sc_mcu9t5v0__mux2_1
X$10454 \$23446 \$28325 \$26339 \$28211 \$28381 \$28324
+ gf180mcu_fd_sc_mcu9t5v0__mux2_1
X$10455 \$23446 \$30634 \$29436 \$30819 \$30763 \$30839
+ gf180mcu_fd_sc_mcu9t5v0__mux2_1
X$10456 \$23446 \$28978 \$27658 \$29123 \$28971 \$29133
+ gf180mcu_fd_sc_mcu9t5v0__mux2_1
X$10457 \$23446 \$29262 \$25343 \$29290 \$29270 \$29230
+ gf180mcu_fd_sc_mcu9t5v0__mux2_1
X$10458 \$23586 \$23450 \$23620 \$23454 \$23619 gf180mcu_fd_sc_mcu9t5v0__nor2_1
X$10459 \$23451 \$23801 \$23804 \$23926 \$23807 \$23924
+ gf180mcu_fd_sc_mcu9t5v0__mux2_1
X$10460 \$23452 \$24589 \$23804 \$24593 \$24428 \$24591
+ gf180mcu_fd_sc_mcu9t5v0__mux2_1
X$10461 \$23601 \$23472 \$23620 \$23454 \$23644 gf180mcu_fd_sc_mcu9t5v0__and2_1
X$10462 \$23596 \$23620 \$23454 \$23770 gf180mcu_fd_sc_mcu9t5v0__clkinv_1
X$10463 \$23454 \$23620 gf180mcu_fd_sc_mcu9t5v0__filltie
X$10464 \$23454 \$23620 gf180mcu_fd_sc_mcu9t5v0__filltie
X$10465 \$23454 \$23620 gf180mcu_fd_sc_mcu9t5v0__filltie
X$10466 \$23454 \$23620 gf180mcu_fd_sc_mcu9t5v0__filltie
X$10467 \$23454 \$23620 gf180mcu_fd_sc_mcu9t5v0__filltie
X$10468 \$23454 \$23620 gf180mcu_fd_sc_mcu9t5v0__filltie
X$10469 \$23454 \$23620 gf180mcu_fd_sc_mcu9t5v0__endcap
X$10470 \$23454 \$23620 gf180mcu_fd_sc_mcu9t5v0__endcap
X$10471 \$27464 \$29701 \$23458 \$29702 \$29634 \$29720 \$29703
+ gf180mcu_fd_sc_mcu9t5v0__oai31_1
X$10472 \$25030 \$23479 \$24877 \$24997 \$25029 gf180mcu_fd_sc_mcu9t5v0__nand2_1
X$10473 \$24271 \$23479 \$24231 \$24109 \$24270 gf180mcu_fd_sc_mcu9t5v0__nand2_1
X$10474 \$29282 \$29290 \$29270 \$23479 gf180mcu_fd_sc_mcu9t5v0__buf_8
X$10475 \$23481 \$27349 \$23479 \$27315 \$27449 \$27303
+ gf180mcu_fd_sc_mcu9t5v0__mux2_1
X$10476 \$26391 \$29113 \$23479 \$29123 \$28971 \$29142
+ gf180mcu_fd_sc_mcu9t5v0__mux2_1
X$10477 \$26246 \$28395 \$23479 \$28534 \$28381 \$28369
+ gf180mcu_fd_sc_mcu9t5v0__mux2_1
X$10478 \$27344 \$29284 \$23479 \$29290 \$29270 \$29258
+ gf180mcu_fd_sc_mcu9t5v0__mux2_1
X$10479 \$29327 \$29280 \$29123 \$29270 \$23481 gf180mcu_fd_sc_mcu9t5v0__nor2_1
X$10480 \$24089 \$24088 \$24086 \$24084 \$24087 \$23926 \$24109 \$23486
+ gf180mcu_fd_sc_mcu9t5v0__oai221_1
X$10481 \$23491 \$23620 \$23807 \$23793 gf180mcu_fd_sc_mcu9t5v0__clkinv_1
X$10482 \$23747 \$23576 \$23748 \$23620 \$23807 \$23612
+ gf180mcu_fd_sc_mcu9t5v0__nor3_1
X$10483 \$24283 \$24282 \$24231 \$24428 \$23577 gf180mcu_fd_sc_mcu9t5v0__xnor2_1
X$10484 \$23580 \$24097 \$24285 \$24231 \$24428 \$24284
+ gf180mcu_fd_sc_mcu9t5v0__oai21_1
X$10485 \$23580 \$23613 \$23799 \$23752 \$23926 \$23807 \$23800
+ gf180mcu_fd_sc_mcu9t5v0__oai31_1
X$10486 \$24218 \$23580 \$24231 \$24428 \$24285 gf180mcu_fd_sc_mcu9t5v0__nand2_1
X$10487 \$23801 \$23580 \$23620 \$23807 \$23752 gf180mcu_fd_sc_mcu9t5v0__nand2_1
X$10488 \$23804 \$23586 \$23926 \$23807 \$23803 gf180mcu_fd_sc_mcu9t5v0__nor2_1
X$10489 \$23596 \$23767 \$23620 \$23807 \$23635 \$23813
+ gf180mcu_fd_sc_mcu9t5v0__xnor3_1
X$10490 \$23596 \$23769 \$24231 \$24428 \$24252 gf180mcu_fd_sc_mcu9t5v0__xnor2_1
X$10491 \$23596 \$23813 \$23926 \$23807 \$23768 gf180mcu_fd_sc_mcu9t5v0__nor2_1
X$10492 \$23596 \$23813 \$23926 \$23807 \$23814 gf180mcu_fd_sc_mcu9t5v0__nand2_1
X$10493 \$23940 \$23819 \$23926 \$23807 \$23600 gf180mcu_fd_sc_mcu9t5v0__nand2_1
X$10494 \$23609 \$24231 \$24109 gf180mcu_fd_sc_mcu9t5v0__inv_3
X$10495 \$23747 \$23748 \$23620 \$23807 \$23611 gf180mcu_fd_sc_mcu9t5v0__nor2_1
X$10496 \$23613 \$24044 \$23926 \$24109 \$24097 gf180mcu_fd_sc_mcu9t5v0__nor2_1
X$10497 \$23615 \$24877 \$24997 gf180mcu_fd_sc_mcu9t5v0__clkbuf_4
X$10498 \$23616 \$23926 \$24109 gf180mcu_fd_sc_mcu9t5v0__inv_4
X$10499 \$23747 \$23620 \$23807 \$23748 \$23746 gf180mcu_fd_sc_mcu9t5v0__xor2_1
X$10500 \$23769 \$23771 \$23620 \$23807 \$23636 \$23772
+ gf180mcu_fd_sc_mcu9t5v0__xnor3_1
X$10501 \$23773 \$23771 \$23620 \$23807 \$23774 \$23772
+ gf180mcu_fd_sc_mcu9t5v0__xnor3_1
X$10502 \$24079 \$23655 \$23790 \$23620 \$23807 \$23827
+ gf180mcu_fd_sc_mcu9t5v0__and3_1
X$10503 \$23789 \$23824 \$23620 \$23807 \$23651 gf180mcu_fd_sc_mcu9t5v0__nor2_1
X$10504 \$23807 \$23620 gf180mcu_fd_sc_mcu9t5v0__filltie
X$10505 \$23807 \$23620 gf180mcu_fd_sc_mcu9t5v0__filltie
X$10506 \$23807 \$23620 gf180mcu_fd_sc_mcu9t5v0__filltie
X$10507 \$23807 \$23620 gf180mcu_fd_sc_mcu9t5v0__filltie
X$10508 \$23807 \$23620 gf180mcu_fd_sc_mcu9t5v0__filltie
X$10509 \$23807 \$23620 gf180mcu_fd_sc_mcu9t5v0__filltie
X$10510 \$23807 \$23620 gf180mcu_fd_sc_mcu9t5v0__endcap
X$10511 \$23807 \$23620 gf180mcu_fd_sc_mcu9t5v0__endcap
X$10512 \$24256 \$24255 \$24254 \$24231 \$24109 \$23637
+ gf180mcu_fd_sc_mcu9t5v0__nand3_1
X$10513 \$23820 \$23644 \$23926 \$23807 \$23941 gf180mcu_fd_sc_mcu9t5v0__nand2_1
X$10514 \$23946 \$23945 \$23649 \$23926 \$23807 \$23786
+ gf180mcu_fd_sc_mcu9t5v0__aoi21_1
X$10515 \$24327 \$24231 \$24428 \$23652 gf180mcu_fd_sc_mcu9t5v0__buf_8
X$10516 \$24079 \$23655 \$23790 \$23926 \$24109 \$23826
+ gf180mcu_fd_sc_mcu9t5v0__aoi21_1
X$10517 \$24750 \$24866 \$24571 \$24593 \$24721 \$23655
+ gf180mcu_fd_sc_mcu9t5v0__oai21_1
X$10518 \$24086 \$23926 \$24109 \$24084 \$23657 gf180mcu_fd_sc_mcu9t5v0__xor2_1
X$10519 \$23748 \$24216 \$24231 \$24109 \$24217 gf180mcu_fd_sc_mcu9t5v0__nand2_1
X$10520 \$23751 \$24231 \$24428 \$24283 gf180mcu_fd_sc_mcu9t5v0__clkinv_1
X$10521 \$23756 \$24991 \$24877 \$24721 \$24992 gf180mcu_fd_sc_mcu9t5v0__nand2_1
X$10522 \$24993 \$24877 \$24997 \$23756 gf180mcu_fd_sc_mcu9t5v0__buf_8
X$10523 \$23757 \$29632 \$24719 \$29634 \$29424 \$29635
+ gf180mcu_fd_sc_mcu9t5v0__nor3_1
X$10524 \$23757 \$29632 \$29634 \$29424 \$29536 gf180mcu_fd_sc_mcu9t5v0__nor2_1
X$10525 \$25051 \$25054 \$24877 \$24997 \$24529 \$23761
+ gf180mcu_fd_sc_mcu9t5v0__xnor3_1
X$10526 \$25748 \$25747 \$25462 \$25632 \$23761 \$25749
+ gf180mcu_fd_sc_mcu9t5v0__xnor3_1
X$10527 \$25051 \$23761 \$25191 \$24997 \$25052 gf180mcu_fd_sc_mcu9t5v0__nor2_1
X$10528 \$25051 \$23761 \$25191 \$25347 \$25053 gf180mcu_fd_sc_mcu9t5v0__nand2_1
X$10529 \$23765 \$24249 \$24250 \$24231 \$24428 gf180mcu_fd_sc_mcu9t5v0__dffq_2
X$10530 \$23765 \$24599 \$24247 \$24231 \$24428 gf180mcu_fd_sc_mcu9t5v0__dffq_2
X$10531 \$23765 \$25001 \$24879 \$24877 \$24997 gf180mcu_fd_sc_mcu9t5v0__dffq_2
X$10532 \$23765 \$24736 \$24600 \$24877 \$24721 gf180mcu_fd_sc_mcu9t5v0__dffq_2
X$10533 \$23765 \$25467 \$25196 \$25462 \$25347 gf180mcu_fd_sc_mcu9t5v0__dffq_2
X$10534 \$24604 \$24603 \$24605 \$24593 \$24721 \$23767
+ gf180mcu_fd_sc_mcu9t5v0__aoi21_1
X$10535 \$23769 \$23926 \$23807 \$23773 gf180mcu_fd_sc_mcu9t5v0__clkinv_1
X$10536 \$23935 \$23934 \$23926 \$23807 \$23772 gf180mcu_fd_sc_mcu9t5v0__nor2_1
X$10537 \$23936 \$23774 \$23926 \$23807 \$23816 gf180mcu_fd_sc_mcu9t5v0__xnor2_1
X$10538 \$23781 \$25797 \$25632 \$I54517 gf180mcu_fd_sc_mcu9t5v0__clkinv_1
X$10539 \$23781 \$27802 \$27803 \$27637 \$27776 gf180mcu_fd_sc_mcu9t5v0__dffq_2
X$10540 \$23781 \$27167 \$27293 \$27015 \$27153 gf180mcu_fd_sc_mcu9t5v0__dffq_2
X$10541 \$23782 \$29859 \$30054 \$30185 \$30333 gf180mcu_fd_sc_mcu9t5v0__or2_1
X$10542 \$23782 \$29859 \$30054 \$30185 \$30191 gf180mcu_fd_sc_mcu9t5v0__nand2_1
X$10543 \$23782 \$30037 \$30251 \$30185 \$30267 gf180mcu_fd_sc_mcu9t5v0__nand2_1
X$10544 \$27807 \$27637 \$27776 \$23784 \$28109 gf180mcu_fd_sc_mcu9t5v0__xor2_1
X$10545 \$27341 \$23784 \$27315 \$27449 \$27469 gf180mcu_fd_sc_mcu9t5v0__nor2_1
X$10546 \$27807 \$23784 \$27637 \$27449 \$27470 gf180mcu_fd_sc_mcu9t5v0__nand2_1
X$10547 \$23789 \$23950 \$23926 \$24109 \$24077 \$23824
+ gf180mcu_fd_sc_mcu9t5v0__xnor3_1
X$10548 \$23789 \$23824 \$23926 \$23807 \$23951 gf180mcu_fd_sc_mcu9t5v0__nand2_1
X$10549 \$24089 \$24088 \$23926 \$24109 \$23791 gf180mcu_fd_sc_mcu9t5v0__nand2_1
X$10550 \$24095 \$23793 \$23959 \$24094 \$24093 \$23926 \$24109 \$24083
+ gf180mcu_fd_sc_mcu9t5v0__oai221_1
X$10551 \$24095 \$23793 \$23959 \$24094 \$23926 \$23807 \$23958
+ gf180mcu_fd_sc_mcu9t5v0__oai22_1
X$10552 \$24095 \$23793 \$23926 \$24109 \$24131 gf180mcu_fd_sc_mcu9t5v0__nand2_1
X$10553 \$23797 \$23926 \$23807 \$23796 gf180mcu_fd_sc_mcu9t5v0__clkinv_1
X$10554 \$23797 \$23798 \$23918 \$23926 \$23807 \$23917
+ gf180mcu_fd_sc_mcu9t5v0__mux2_1
X$10555 \$23801 \$23926 \$24109 \$24099 \$24219 gf180mcu_fd_sc_mcu9t5v0__xor2_1
X$10556 \$23804 \$24283 \$25585 \$25586 \$25462 \$25632 \$25631
+ gf180mcu_fd_sc_mcu9t5v0__aoi211_1
X$10557 \$23804 \$24225 \$24231 \$24428 \$24288 gf180mcu_fd_sc_mcu9t5v0__nor2_1
X$10558 \$23804 \$25585 \$25462 \$25632 \$25588 gf180mcu_fd_sc_mcu9t5v0__nor2_1
X$10559 \$26085 \$25797 \$25632 \$23804 gf180mcu_fd_sc_mcu9t5v0__buf_8
X$10560 \$23806 \$23925 \$24106 \$23926 \$24109 \$24053
+ gf180mcu_fd_sc_mcu9t5v0__mux2_1
X$10561 \$24093 \$23958 \$23926 \$23807 \$23829 gf180mcu_fd_sc_mcu9t5v0__xnor2_1
X$10562 \$23921 \$23919 \$23922 \$23926 \$23807 \$23920
+ gf180mcu_fd_sc_mcu9t5v0__aoi21_1
X$10563 \$23939 \$23819 \$23926 \$23807 \$23818 gf180mcu_fd_sc_mcu9t5v0__nand2_1
X$10564 \$23807 \$23926 gf180mcu_fd_sc_mcu9t5v0__filltie
X$10565 \$23807 \$23926 gf180mcu_fd_sc_mcu9t5v0__filltie
X$10566 \$23807 \$23926 gf180mcu_fd_sc_mcu9t5v0__filltie
X$10567 \$23807 \$23926 gf180mcu_fd_sc_mcu9t5v0__filltie
X$10568 \$23807 \$23926 gf180mcu_fd_sc_mcu9t5v0__filltie
X$10569 \$23807 \$23926 gf180mcu_fd_sc_mcu9t5v0__filltie
X$10570 \$23807 \$23926 gf180mcu_fd_sc_mcu9t5v0__endcap
X$10571 \$23807 \$23926 gf180mcu_fd_sc_mcu9t5v0__endcap
X$10572 \$24260 \$23819 \$24231 \$24109 \$23817 gf180mcu_fd_sc_mcu9t5v0__nand2_1
X$10573 \$25931 \$23819 \$25797 \$25918 \$25605 gf180mcu_fd_sc_mcu9t5v0__nand2_1
X$10574 \$27031 \$23819 \$27015 \$27153 \$27158 gf180mcu_fd_sc_mcu9t5v0__nand2_1
X$10575 \$26650 \$23819 \$26401 \$26521 \$26648 gf180mcu_fd_sc_mcu9t5v0__nand2_1
X$10576 \$24322 \$23819 \$24231 \$24428 \$24121 gf180mcu_fd_sc_mcu9t5v0__nand2_1
X$10577 \$27030 \$23819 \$27015 \$27153 \$27156 gf180mcu_fd_sc_mcu9t5v0__nand2_1
X$10578 \$24259 \$23819 \$24231 \$24428 \$24066 gf180mcu_fd_sc_mcu9t5v0__nand2_1
X$10579 \$24068 \$23819 \$23926 \$24109 \$24067 gf180mcu_fd_sc_mcu9t5v0__nand2_1
X$10580 \$26102 \$23819 \$26088 \$25918 \$25977 gf180mcu_fd_sc_mcu9t5v0__nand2_1
X$10581 \$25930 \$23819 \$26088 \$25918 \$25976 gf180mcu_fd_sc_mcu9t5v0__nand2_1
X$10582 \$24744 \$23819 \$24593 \$24428 \$24553 gf180mcu_fd_sc_mcu9t5v0__nand2_1
X$10583 \$26097 \$23819 \$26088 \$25918 \$25971 gf180mcu_fd_sc_mcu9t5v0__nand2_1
X$10584 \$26409 \$23819 \$26401 \$26220 \$26364 gf180mcu_fd_sc_mcu9t5v0__nand2_1
X$10585 \$26681 \$23819 \$26675 \$26521 \$26647 gf180mcu_fd_sc_mcu9t5v0__nand2_1
X$10586 \$30472 \$23819 \$30564 \$30485 \$30473 gf180mcu_fd_sc_mcu9t5v0__nand2_1
X$10587 \$30544 \$30402 \$30485 \$23819 gf180mcu_fd_sc_mcu9t5v0__buf_8
X$10588 \$25097 \$24864 \$25191 \$25347 \$23823 \$25096
+ gf180mcu_fd_sc_mcu9t5v0__xnor3_1
X$10589 \$24081 \$24083 \$24082 \$23926 \$24109 \$23830
+ gf180mcu_fd_sc_mcu9t5v0__aoi21_1
X$10590 \$24753 \$24573 \$23830 \$24752 \$24593 \$24721 \$24084
+ gf180mcu_fd_sc_mcu9t5v0__oai31_1
X$10591 \$24573 \$23830 \$24593 \$24721 \$24622 gf180mcu_fd_sc_mcu9t5v0__nor2_1
X$10592 \$23915 \$25797 \$25632 gf180mcu_fd_sc_mcu9t5v0__clkbuf_4
X$10593 \$23922 \$29315 \$29436 \$29290 \$29424 \$29647
+ gf180mcu_fd_sc_mcu9t5v0__mux2_1
X$10594 \$23922 \$27148 \$26339 \$27015 \$27153 \$27274
+ gf180mcu_fd_sc_mcu9t5v0__mux2_1
X$10595 \$23922 \$29438 \$27658 \$29290 \$29424 \$29437
+ gf180mcu_fd_sc_mcu9t5v0__mux2_1
X$10596 \$23922 \$27149 \$25343 \$27315 \$27153 \$27006
+ gf180mcu_fd_sc_mcu9t5v0__mux2_1
X$10597 \$24103 \$23926 \$24109 \$24047 \$24048 gf180mcu_fd_sc_mcu9t5v0__xor2_1
X$10598 \$24091 \$23957 \$23926 \$24109 \$24093 gf180mcu_fd_sc_mcu9t5v0__xnor2_1
X$10599 \$24081 \$24083 \$24082 \$23926 \$24109 \$24080
+ gf180mcu_fd_sc_mcu9t5v0__and3_1
X$10600 \$24070 \$23941 \$24069 \$23926 \$24109 \$24071
+ gf180mcu_fd_sc_mcu9t5v0__oai21_1
X$10601 \$24541 \$24064 \$23926 \$24109 \$23935 gf180mcu_fd_sc_mcu9t5v0__nor2_1
X$10602 \$24102 \$23926 \$24109 \$24101 gf180mcu_fd_sc_mcu9t5v0__clkinv_1
X$10603 \$23957 \$23926 \$24109 \$24092 gf180mcu_fd_sc_mcu9t5v0__clkinv_1
X$10604 \$24091 \$24092 \$23926 \$24109 \$24081 gf180mcu_fd_sc_mcu9t5v0__nand2_1
X$10605 \$24109 \$23926 gf180mcu_fd_sc_mcu9t5v0__filltie
X$10606 \$24109 \$23926 gf180mcu_fd_sc_mcu9t5v0__filltie
X$10607 \$24109 \$23926 gf180mcu_fd_sc_mcu9t5v0__filltie
X$10608 \$24109 \$23926 gf180mcu_fd_sc_mcu9t5v0__filltie
X$10609 \$24109 \$23926 gf180mcu_fd_sc_mcu9t5v0__filltie
X$10610 \$24109 \$23926 gf180mcu_fd_sc_mcu9t5v0__filltie
X$10611 \$24109 \$23926 gf180mcu_fd_sc_mcu9t5v0__endcap
X$10612 \$24109 \$23926 gf180mcu_fd_sc_mcu9t5v0__endcap
X$10613 \$24303 \$23930 \$24593 \$24428 \$24598 gf180mcu_fd_sc_mcu9t5v0__nand2_1
X$10614 \$24253 \$24312 \$24252 \$24231 \$24109 \$23933
+ gf180mcu_fd_sc_mcu9t5v0__nor3_1
X$10615 \$24542 \$23934 \$24544 \$24593 \$24428 \$24431
+ gf180mcu_fd_sc_mcu9t5v0__nor3_1
X$10616 \$24741 \$23934 \$24544 \$24877 \$24721 \$24885
+ gf180mcu_fd_sc_mcu9t5v0__nor3_1
X$10617 \$25070 \$25074 \$25075 \$25191 \$24997 \$23934
+ gf180mcu_fd_sc_mcu9t5v0__aoi21_1
X$10618 \$23934 \$24544 \$24741 \$24593 \$24721 \$24607
+ gf180mcu_fd_sc_mcu9t5v0__oai21_1
X$10619 \$25004 \$24607 \$24885 \$24877 \$24721 \$23936
+ gf180mcu_fd_sc_mcu9t5v0__aoi21_1
X$10620 \$25011 \$23939 \$24877 \$24997 \$25010 gf180mcu_fd_sc_mcu9t5v0__nand2_1
X$10621 \$23939 \$24877 \$24997 \$25009 gf180mcu_fd_sc_mcu9t5v0__clkinv_1
X$10622 \$26690 \$23940 \$26401 \$26220 \$26236 gf180mcu_fd_sc_mcu9t5v0__xnor2_1
X$10623 \$26690 \$23940 \$26110 \$26088 \$26220 \$26237
+ gf180mcu_fd_sc_mcu9t5v0__aoi21_1
X$10624 \$23940 \$26401 \$26220 \$26375 gf180mcu_fd_sc_mcu9t5v0__clkinv_1
X$10625 \$25017 \$24877 \$24997 \$23944 gf180mcu_fd_sc_mcu9t5v0__clkinv_1
X$10626 \$24862 \$23945 \$24877 \$24721 \$24747 gf180mcu_fd_sc_mcu9t5v0__nand2_1
X$10627 \$24862 \$24231 \$24109 \$23946 gf180mcu_fd_sc_mcu9t5v0__buf_8
X$10628 \$24615 \$24563 \$24617 \$24593 \$24721 \$23950
+ gf180mcu_fd_sc_mcu9t5v0__oai21_1
X$10629 \$24338 \$24758 \$26881 \$25101 \$25102 \$25191 \$24997 \$23959
+ gf180mcu_fd_sc_mcu9t5v0__aoi221_1
X$10630 \$24291 \$24289 \$24593 \$24428 \$24047 gf180mcu_fd_sc_mcu9t5v0__nand2_1
X$10631 \$24532 \$24056 \$24593 \$24428 \$24533 gf180mcu_fd_sc_mcu9t5v0__nand2_1
X$10632 \$24242 \$24113 \$24115 \$24231 \$24428 \$24059
+ gf180mcu_fd_sc_mcu9t5v0__nand3_1
X$10633 \$24881 \$25191 \$25347 \$24064 \$25075 gf180mcu_fd_sc_mcu9t5v0__xor2_1
X$10634 \$24881 \$24064 \$24877 \$24997 \$25003 gf180mcu_fd_sc_mcu9t5v0__xnor2_1
X$10635 \$24541 \$24064 \$24231 \$24428 \$24256 gf180mcu_fd_sc_mcu9t5v0__or2_1
X$10636 \$24253 \$24312 \$24252 \$24231 \$24428 \$24065
+ gf180mcu_fd_sc_mcu9t5v0__oai21_1
X$10637 \$25007 \$24068 \$24877 \$24997 \$24887 gf180mcu_fd_sc_mcu9t5v0__xnor2_1
X$10638 \$25007 \$24068 \$24877 \$24997 \$24859 gf180mcu_fd_sc_mcu9t5v0__and2_1
X$10639 \$24068 \$24877 \$24997 \$25008 gf180mcu_fd_sc_mcu9t5v0__clkinv_1
X$10640 \$26827 \$26675 \$26856 \$24073 \$26829 gf180mcu_fd_sc_mcu9t5v0__xor2_1
X$10641 \$26661 \$24073 \$26695 \$26675 \$26521 \$26694
+ gf180mcu_fd_sc_mcu9t5v0__oai21_1
X$10642 \$26827 \$24073 \$26675 \$26856 \$26828 gf180mcu_fd_sc_mcu9t5v0__nand2_1
X$10643 \$24245 \$24265 \$24231 \$24109 \$24075 gf180mcu_fd_sc_mcu9t5v0__nand2_1
X$10644 \$24271 \$24332 \$24231 \$24428 \$24079 gf180mcu_fd_sc_mcu9t5v0__nand2_1
X$10645 \$24128 \$24231 \$24428 \$25336 \$24082 gf180mcu_fd_sc_mcu9t5v0__xor2_1
X$10646 \$24086 \$24084 \$24087 \$24231 \$24428 \$24334
+ gf180mcu_fd_sc_mcu9t5v0__oai21_1
X$10647 \$24085 \$24575 \$24877 \$24721 \$24754 \$24893
+ gf180mcu_fd_sc_mcu9t5v0__xor3_1
X$10648 \$24085 \$24754 \$24593 \$24721 \$24576 gf180mcu_fd_sc_mcu9t5v0__and2_1
X$10649 \$24085 \$24754 \$24593 \$24721 \$24574 gf180mcu_fd_sc_mcu9t5v0__or2_1
X$10650 \$24579 \$24593 \$24428 \$24577 \$24086 gf180mcu_fd_sc_mcu9t5v0__xor2_1
X$10651 \$24578 \$24577 \$24593 \$24428 \$24087 gf180mcu_fd_sc_mcu9t5v0__nand2_1
X$10652 \$24274 \$24231 \$24109 \$24088 gf180mcu_fd_sc_mcu9t5v0__clkinv_1
X$10653 \$24089 \$24334 \$24231 \$24109 \$24272 \$24274
+ gf180mcu_fd_sc_mcu9t5v0__xnor3_1
X$10654 \$24338 \$24758 \$24131 \$24231 \$24428 \$24094
+ gf180mcu_fd_sc_mcu9t5v0__oai21_1
X$10655 \$24291 \$24103 \$24289 \$24231 \$24428 \$24290
+ gf180mcu_fd_sc_mcu9t5v0__nand3_1
X$10656 \$25595 \$24106 \$25462 \$25632 \$25596 gf180mcu_fd_sc_mcu9t5v0__nor2_1
X$10657 \$25192 \$24106 \$25191 \$25347 \$25308 gf180mcu_fd_sc_mcu9t5v0__nor2_1
X$10658 \$26092 \$26221 \$26088 \$26220 \$24106 gf180mcu_fd_sc_mcu9t5v0__nand2_1
X$10659 \$25921 \$25761 \$24106 \$26088 \$25918 \$26091
+ gf180mcu_fd_sc_mcu9t5v0__mux2_1
X$10660 \$24241 \$24240 \$24231 \$24109 \$24242 gf180mcu_fd_sc_mcu9t5v0__nand2_1
X$10661 \$24242 \$24115 \$24231 \$24109 \$24307 gf180mcu_fd_sc_mcu9t5v0__nand2_1
X$10662 \$24109 \$24231 gf180mcu_fd_sc_mcu9t5v0__filltie
X$10663 \$24109 \$24231 gf180mcu_fd_sc_mcu9t5v0__filltie
X$10664 \$24109 \$24231 gf180mcu_fd_sc_mcu9t5v0__filltie
X$10665 \$24109 \$24231 gf180mcu_fd_sc_mcu9t5v0__filltie
X$10666 \$24109 \$24231 gf180mcu_fd_sc_mcu9t5v0__filltie
X$10667 \$24109 \$24231 gf180mcu_fd_sc_mcu9t5v0__filltie
X$10668 \$24109 \$24231 gf180mcu_fd_sc_mcu9t5v0__endcap
X$10669 \$24109 \$24231 gf180mcu_fd_sc_mcu9t5v0__endcap
X$10670 \$24242 \$24244 \$24113 \$24231 \$24428 \$24305
+ gf180mcu_fd_sc_mcu9t5v0__nand3_1
X$10671 \$24127 \$24877 \$24997 gf180mcu_fd_sc_mcu9t5v0__inv_3
X$10672 \$24128 \$24572 \$24593 \$24428 \$24573 gf180mcu_fd_sc_mcu9t5v0__nor2_1
X$10673 \$24280 \$24423 \$24231 \$24428 \$24216 gf180mcu_fd_sc_mcu9t5v0__nand2_1
X$10674 \$24526 \$24220 \$24593 \$24428 \$24525 gf180mcu_fd_sc_mcu9t5v0__xnor2_1
X$10675 \$24526 \$24220 \$24231 \$24428 \$24289 gf180mcu_fd_sc_mcu9t5v0__nor2_1
X$10676 \$24221 \$28940 \$27658 \$29290 \$29424 \$29298
+ gf180mcu_fd_sc_mcu9t5v0__mux2_1
X$10677 \$24221 \$29926 \$29436 \$29780 \$29847 \$29856
+ gf180mcu_fd_sc_mcu9t5v0__mux2_1
X$10678 \$24221 \$25452 \$25343 \$25462 \$25347 \$25451
+ gf180mcu_fd_sc_mcu9t5v0__mux2_1
X$10679 \$24221 \$27563 \$26339 \$27637 \$27449 \$27623
+ gf180mcu_fd_sc_mcu9t5v0__mux2_1
X$10680 \$24719 \$29088 \$29427 \$29290 \$29424 \$24228
+ gf180mcu_fd_sc_mcu9t5v0__or3_1
X$10681 \$24228 \$30953 \$31967 \$31886 \$32016 gf180mcu_fd_sc_mcu9t5v0__and2_1
X$10682 \$24228 \$31031 \$29425 \$31100 \$31175 \$31156
+ gf180mcu_fd_sc_mcu9t5v0__aoi21_1
X$10683 \$28535 \$29083 \$24228 \$29123 \$29270 \$29084
+ gf180mcu_fd_sc_mcu9t5v0__oai21_1
X$10684 \$25595 \$26360 \$24228 \$26645 \$26401 \$26220 \$26802
+ gf180mcu_fd_sc_mcu9t5v0__oai211_1
X$10685 \$27285 \$24228 \$26859 \$27315 \$27153 \$26642
+ gf180mcu_fd_sc_mcu9t5v0__nand3_1
X$10686 \$24228 \$28378 \$28211 \$28381 \$26212 gf180mcu_fd_sc_mcu9t5v0__nand2_1
X$10687 \$24228 \$31154 \$31967 \$31886 \$31943 gf180mcu_fd_sc_mcu9t5v0__nand2_1
X$10688 \$30679 \$24228 \$30696 \$30625 \$30678 gf180mcu_fd_sc_mcu9t5v0__nand2_1
X$10689 \$24291 \$24289 \$24231 \$24428 \$24292 gf180mcu_fd_sc_mcu9t5v0__xnor2_1
X$10690 \$24318 \$24231 \$24428 \$24317 gf180mcu_fd_sc_mcu9t5v0__clkinv_1
X$10691 \$24323 \$24262 \$24231 \$24428 \$24324 gf180mcu_fd_sc_mcu9t5v0__nand2_1
X$10692 \$24734 \$24310 \$24231 \$24428 \$24311 gf180mcu_fd_sc_mcu9t5v0__nand2_1
X$10693 \$24316 \$24317 \$24231 \$24428 \$24314 gf180mcu_fd_sc_mcu9t5v0__nand2_1
X$10694 \$24240 \$24236 \$24231 \$24428 \$24303 gf180mcu_fd_sc_mcu9t5v0__nand2_1
X$10695 \$24301 \$24237 \$24302 \$24231 \$24428 gf180mcu_fd_sc_mcu9t5v0__dffq_2
X$10696 \$24428 \$24231 gf180mcu_fd_sc_mcu9t5v0__filltie
X$10697 \$24428 \$24231 gf180mcu_fd_sc_mcu9t5v0__filltie
X$10698 \$24428 \$24231 gf180mcu_fd_sc_mcu9t5v0__filltie
X$10699 \$24428 \$24231 gf180mcu_fd_sc_mcu9t5v0__filltie
X$10700 \$24428 \$24231 gf180mcu_fd_sc_mcu9t5v0__filltie
X$10701 \$24428 \$24231 gf180mcu_fd_sc_mcu9t5v0__filltie
X$10702 \$24428 \$24231 gf180mcu_fd_sc_mcu9t5v0__endcap
X$10703 \$24428 \$24231 gf180mcu_fd_sc_mcu9t5v0__endcap
X$10704 \$25756 \$25592 \$25757 \$25797 \$25632 \$24232
+ gf180mcu_fd_sc_mcu9t5v0__aoi21_1
X$10705 \$24531 \$24233 \$24593 \$24428 \$24532 gf180mcu_fd_sc_mcu9t5v0__nand2_1
X$10706 \$24429 \$24246 \$24311 \$24593 \$24721 \$24599
+ gf180mcu_fd_sc_mcu9t5v0__nand3_1
X$10707 \$24541 \$24542 \$24593 \$24428 \$24253 gf180mcu_fd_sc_mcu9t5v0__nor2_1
X$10708 \$24740 \$24606 \$25003 \$24593 \$24721 \$24255
+ gf180mcu_fd_sc_mcu9t5v0__oai21_1
X$10709 \$27164 \$24259 \$27315 \$27449 \$27463 gf180mcu_fd_sc_mcu9t5v0__nand2_1
X$10710 \$24259 \$27315 \$27449 \$27462 gf180mcu_fd_sc_mcu9t5v0__clkinv_1
X$10711 \$25471 \$25462 \$25347 \$24260 \$25355 gf180mcu_fd_sc_mcu9t5v0__xor2_1
X$10712 \$25316 \$24260 \$25191 \$25347 \$25317 gf180mcu_fd_sc_mcu9t5v0__nor2_1
X$10713 \$25471 \$24260 \$25191 \$24997 \$25079 gf180mcu_fd_sc_mcu9t5v0__nand2_1
X$10714 \$24271 \$24593 \$24428 \$24332 \$24571 gf180mcu_fd_sc_mcu9t5v0__xor2_1
X$10715 \$24873 \$24519 \$24520 \$24280 \$24593 \$24428 \$24425
+ gf180mcu_fd_sc_mcu9t5v0__or4_1
X$10716 \$24847 \$24530 \$24877 \$24721 \$24296 \$25055
+ gf180mcu_fd_sc_mcu9t5v0__xnor3_1
X$10717 \$24597 \$24300 \$24593 \$24721 \$24726 gf180mcu_fd_sc_mcu9t5v0__nand2_1
X$10718 \$24301 \$25191 \$24997 gf180mcu_fd_sc_mcu9t5v0__inv_3
X$10719 \$24301 \$25061 \$24999 \$24877 \$24997 gf180mcu_fd_sc_mcu9t5v0__dffq_2
X$10720 \$24301 \$25465 \$25466 \$25797 \$25918 gf180mcu_fd_sc_mcu9t5v0__dffq_2
X$10721 \$24301 \$25059 \$25060 \$25191 \$25347 gf180mcu_fd_sc_mcu9t5v0__dffq_2
X$10722 \$24301 \$24852 \$24853 \$24877 \$24997 gf180mcu_fd_sc_mcu9t5v0__dffq_2
X$10723 \$24301 \$24306 \$24537 \$24593 \$24428 gf180mcu_fd_sc_mcu9t5v0__dffq_2
X$10724 \$24303 \$24536 \$24593 \$24428 \$24304 gf180mcu_fd_sc_mcu9t5v0__nand2_1
X$10725 \$24309 \$24310 \$24593 \$24428 \$24538 gf180mcu_fd_sc_mcu9t5v0__nand2_1
X$10726 \$25599 \$24310 \$25191 \$25347 \$25194 gf180mcu_fd_sc_mcu9t5v0__nand2_1
X$10727 \$25063 \$24310 \$25191 \$24997 \$25064 gf180mcu_fd_sc_mcu9t5v0__nand2_1
X$10728 \$25070 \$24316 \$25071 \$25191 \$24997 \$24312
+ gf180mcu_fd_sc_mcu9t5v0__aoi21_1
X$10729 \$24542 \$25003 \$25191 \$24997 \$24315 \$25076
+ gf180mcu_fd_sc_mcu9t5v0__xnor3_1
X$10730 \$25004 \$24315 \$24877 \$24997 \$25002 gf180mcu_fd_sc_mcu9t5v0__xnor2_1
X$10731 \$24316 \$24318 \$24877 \$24997 \$25004 gf180mcu_fd_sc_mcu9t5v0__and2_1
X$10732 \$25070 \$24316 \$25191 \$25347 \$25315 gf180mcu_fd_sc_mcu9t5v0__nand2_1
X$10733 \$24740 \$25191 \$24997 \$25074 \$24318 gf180mcu_fd_sc_mcu9t5v0__xor2_1
X$10734 \$24320 \$26401 \$26220 gf180mcu_fd_sc_mcu9t5v0__inv_4
X$10735 \$24550 \$24551 \$24552 \$24593 \$24428 \$24321
+ gf180mcu_fd_sc_mcu9t5v0__oai21_1
X$10736 \$26233 \$25797 \$25632 \$24322 \$25767 gf180mcu_fd_sc_mcu9t5v0__xor2_1
X$10737 \$26233 \$24322 \$25797 \$25918 \$25811 gf180mcu_fd_sc_mcu9t5v0__nand2_1
X$10738 \$24322 \$25797 \$25918 \$25938 gf180mcu_fd_sc_mcu9t5v0__clkinv_1
X$10739 \$27340 \$24326 \$27315 \$27153 \$27342 gf180mcu_fd_sc_mcu9t5v0__xnor2_1
X$10740 \$27340 \$24326 \$27015 \$26856 \$26995 gf180mcu_fd_sc_mcu9t5v0__and2_1
X$10741 \$27171 \$24326 \$27468 \$27015 \$27153 \$26872
+ gf180mcu_fd_sc_mcu9t5v0__oai21_1
X$10742 \$30862 \$30840 \$30819 \$30900 \$24327 gf180mcu_fd_sc_mcu9t5v0__nor2_4
X$10743 \$24868 \$24869 \$24877 \$24721 \$24756 \$24335
+ gf180mcu_fd_sc_mcu9t5v0__xor3_1
X$10744 \$24423 \$24843 \$24877 \$24721 \$24707 gf180mcu_fd_sc_mcu9t5v0__nand2_1
X$10745 \$24519 \$24708 \$24593 \$24428 \$24424 gf180mcu_fd_sc_mcu9t5v0__nor2_1
X$10746 \$24426 \$24593 \$24428 \$24582 gf180mcu_fd_sc_mcu9t5v0__clkinv_1
X$10747 \$24545 \$24546 \$24547 \$24593 \$24428 \$24608
+ gf180mcu_fd_sc_mcu9t5v0__oai21_1
X$10748 \$24589 \$24593 \$24428 \$24526 gf180mcu_fd_sc_mcu9t5v0__clkinv_1
X$10749 \$24579 \$24593 \$24428 \$24578 gf180mcu_fd_sc_mcu9t5v0__clkinv_1
X$10750 \$25336 \$24593 \$24428 \$24572 gf180mcu_fd_sc_mcu9t5v0__clkinv_1
X$10751 \$24548 \$24433 \$24593 \$24428 \$24547 gf180mcu_fd_sc_mcu9t5v0__nand2_1
X$10752 \$24428 \$24593 gf180mcu_fd_sc_mcu9t5v0__filltie
X$10753 \$24428 \$24593 gf180mcu_fd_sc_mcu9t5v0__filltie
X$10754 \$24428 \$24593 gf180mcu_fd_sc_mcu9t5v0__filltie
X$10755 \$24428 \$24593 gf180mcu_fd_sc_mcu9t5v0__filltie
X$10756 \$24428 \$24593 gf180mcu_fd_sc_mcu9t5v0__filltie
X$10757 \$24428 \$24593 gf180mcu_fd_sc_mcu9t5v0__filltie
X$10758 \$24428 \$24593 gf180mcu_fd_sc_mcu9t5v0__endcap
X$10759 \$24428 \$24593 gf180mcu_fd_sc_mcu9t5v0__endcap
X$10760 \$24429 \$24735 \$24538 \$24877 \$24721 \$24736
+ gf180mcu_fd_sc_mcu9t5v0__nand3_1
X$10761 \$24429 \$25352 \$25064 \$25462 \$25347 \$25467
+ gf180mcu_fd_sc_mcu9t5v0__nand3_1
X$10762 \$25195 \$25194 \$24429 \$25191 \$24997 \$25065
+ gf180mcu_fd_sc_mcu9t5v0__nand3_1
X$10763 \$27807 \$26370 \$24433 \$28534 \$28689 \$28572
+ gf180mcu_fd_sc_mcu9t5v0__aoi21_1
X$10764 \$28107 \$26370 \$24433 \$28211 \$28381 \$28571
+ gf180mcu_fd_sc_mcu9t5v0__aoi21_1
X$10765 \$27340 \$26370 \$24433 \$27315 \$27449 \$27467
+ gf180mcu_fd_sc_mcu9t5v0__aoi21_1
X$10766 \$25809 \$25473 \$24433 \$25797 \$25918 \$25932
+ gf180mcu_fd_sc_mcu9t5v0__aoi21_1
X$10767 \$26233 \$26370 \$24433 \$26088 \$26220 \$26234
+ gf180mcu_fd_sc_mcu9t5v0__aoi21_1
X$10768 \$25809 \$25642 \$24433 \$25797 \$25918 \$25936
+ gf180mcu_fd_sc_mcu9t5v0__aoi21_1
X$10769 \$25083 \$26370 \$24433 \$28211 \$28089 \$28224
+ gf180mcu_fd_sc_mcu9t5v0__aoi21_1
X$10770 \$25471 \$26370 \$24433 \$26401 \$26220 \$26371
+ gf180mcu_fd_sc_mcu9t5v0__aoi21_1
X$10771 \$28946 \$26370 \$24433 \$29954 \$29847 \$29980
+ gf180mcu_fd_sc_mcu9t5v0__aoi21_1
X$10772 \$27596 \$26237 \$26537 \$24433 \$26401 \$26521 \$26414
+ gf180mcu_fd_sc_mcu9t5v0__aoi211_1
X$10773 \$27593 \$26370 \$24433 \$27595 \$27637 \$27776 \$28709
+ gf180mcu_fd_sc_mcu9t5v0__aoi211_1
X$10774 \$26691 \$26370 \$24433 \$26871 \$27015 \$27153 \$27169
+ gf180mcu_fd_sc_mcu9t5v0__aoi211_1
X$10775 \$29715 \$26370 \$24433 \$30072 \$30054 \$30027 \$29796
+ gf180mcu_fd_sc_mcu9t5v0__aoi211_1
X$10776 \$24433 \$26987 \$26989 \$27015 \$26856 \$26988
+ gf180mcu_fd_sc_mcu9t5v0__oai21_1
X$10777 \$24433 \$25066 \$25067 \$25191 \$24997 \$25313
+ gf180mcu_fd_sc_mcu9t5v0__oai21_1
X$10778 \$24433 \$25077 \$25078 \$25191 \$24997 \$25005
+ gf180mcu_fd_sc_mcu9t5v0__oai21_1
X$10779 \$24433 \$26830 \$27172 \$26873 \$27015 \$27153 \$27045
+ gf180mcu_fd_sc_mcu9t5v0__oai31_1
X$10780 \$24433 \$29445 \$29731 \$29277 \$29290 \$29424 \$29322
+ gf180mcu_fd_sc_mcu9t5v0__oai31_1
X$10781 \$24433 \$27931 \$28505 \$28557 \$28534 \$28689 \$28704
+ gf180mcu_fd_sc_mcu9t5v0__oai31_1
X$10782 \$24433 \$30707 \$30832 \$30905 \$30819 \$30900 \$30854
+ gf180mcu_fd_sc_mcu9t5v0__oai31_1
X$10783 \$24433 \$26685 \$26225 \$26224 \$26088 \$26220 \$25974
+ gf180mcu_fd_sc_mcu9t5v0__oai31_1
X$10784 \$24433 \$27331 \$27334 \$27161 \$27015 \$27153 \$27162
+ gf180mcu_fd_sc_mcu9t5v0__oai31_1
X$10785 \$24433 \$27034 \$26814 \$26813 \$26675 \$26856 \$26866
+ gf180mcu_fd_sc_mcu9t5v0__oai31_1
X$10786 \$24433 \$30329 \$30353 \$30264 \$30402 \$30339 \$30331
+ gf180mcu_fd_sc_mcu9t5v0__oai31_1
X$10787 \$24433 \$26110 \$25812 \$25769 \$26088 \$25918 \$25982
+ gf180mcu_fd_sc_mcu9t5v0__oai31_1
X$10788 \$24433 \$30616 \$30834 \$30775 \$30819 \$30763 \$30835
+ gf180mcu_fd_sc_mcu9t5v0__oai31_1
X$10789 \$24433 \$28112 \$28839 \$28715 \$28810 \$28689 \$28716
+ gf180mcu_fd_sc_mcu9t5v0__oai31_1
X$10790 \$24433 \$24857 \$25006 \$24858 \$24877 \$24721 \$24549
+ gf180mcu_fd_sc_mcu9t5v0__oai31_1
X$10791 \$24433 \$26103 \$27040 \$26992 \$27015 \$26856 \$26816
+ gf180mcu_fd_sc_mcu9t5v0__oai31_1
X$10792 \$24433 \$26659 \$26660 \$26658 \$26675 \$26521 \$26825
+ gf180mcu_fd_sc_mcu9t5v0__oai31_1
X$10793 \$24433 \$30493 \$30495 \$30692 \$30696 \$30625 \$30693
+ gf180mcu_fd_sc_mcu9t5v0__oai31_1
X$10794 \$24433 \$26663 \$26675 \$26521 \$26540 gf180mcu_fd_sc_mcu9t5v0__nor2_1
X$10795 \$26535 \$24433 \$26534 \$26371 \$26401 \$26521 \$26410
+ gf180mcu_fd_sc_mcu9t5v0__aoi22_1
X$10796 \$25937 \$24433 \$25935 \$25936 \$25797 \$25918 \$25934
+ gf180mcu_fd_sc_mcu9t5v0__aoi22_1
X$10797 \$26415 \$24433 \$26664 \$26540 \$26401 \$26521 \$26416
+ gf180mcu_fd_sc_mcu9t5v0__aoi22_1
X$10798 \$28714 \$24433 \$28385 \$28572 \$28534 \$28689 \$28835
+ gf180mcu_fd_sc_mcu9t5v0__aoi22_1
X$10799 \$27805 \$24433 \$26869 \$27169 \$27637 \$27776 \$27804
+ gf180mcu_fd_sc_mcu9t5v0__aoi22_1
X$10800 \$28105 \$24433 \$26824 \$27169 \$28211 \$28089 \$28228
+ gf180mcu_fd_sc_mcu9t5v0__aoi22_1
X$10801 \$28104 \$24433 \$28103 \$28224 \$28211 \$28089 \$28225
+ gf180mcu_fd_sc_mcu9t5v0__aoi22_1
X$10802 \$28711 \$24433 \$27594 \$28709 \$28810 \$28689 \$28832
+ gf180mcu_fd_sc_mcu9t5v0__aoi22_1
X$10803 \$29103 \$24433 \$28982 \$28571 \$29123 \$28971 \$29102
+ gf180mcu_fd_sc_mcu9t5v0__aoi22_1
X$10804 \$26373 \$24433 \$25810 \$26234 \$26401 \$26220 \$26657
+ gf180mcu_fd_sc_mcu9t5v0__aoi22_1
X$10805 \$27602 \$24433 \$27601 \$27467 \$27637 \$27449 \$27661
+ gf180mcu_fd_sc_mcu9t5v0__aoi22_1
X$10806 \$30249 \$24433 \$30248 \$29980 \$30251 \$30185 \$30270
+ gf180mcu_fd_sc_mcu9t5v0__aoi22_1
X$10807 \$28710 \$24433 \$28226 \$28709 \$28810 \$28689 \$28831
+ gf180mcu_fd_sc_mcu9t5v0__aoi22_1
X$10808 \$25980 \$24433 \$25979 \$25932 \$26088 \$25918 \$26106
+ gf180mcu_fd_sc_mcu9t5v0__aoi22_1
X$10809 \$26377 \$24433 \$26664 \$26693 \$26675 \$26521 \$26697
+ gf180mcu_fd_sc_mcu9t5v0__aoi22_1
X$10810 \$24433 \$31262 \$31232 \$31310 \$31314 gf180mcu_fd_sc_mcu9t5v0__nand2_1
X$10811 \$27037 \$24433 \$27015 \$27153 \$27161 gf180mcu_fd_sc_mcu9t5v0__nand2_1
X$10812 \$29274 \$24433 \$29123 \$29270 \$29300 gf180mcu_fd_sc_mcu9t5v0__nand2_1
X$10813 \$25088 \$24433 \$24877 \$24997 \$25019 gf180mcu_fd_sc_mcu9t5v0__nand2_1
X$10814 \$29795 \$24433 \$31100 \$31175 \$31266 gf180mcu_fd_sc_mcu9t5v0__nand2_1
X$10815 \$30176 \$24433 \$30054 \$30185 \$30246 gf180mcu_fd_sc_mcu9t5v0__nand2_1
X$10816 \$28838 \$24433 \$30696 \$30763 \$30692 gf180mcu_fd_sc_mcu9t5v0__nand2_1
X$10817 \$29278 \$24433 \$29123 \$29270 \$29277 gf180mcu_fd_sc_mcu9t5v0__nand2_1
X$10818 \$25601 \$24433 \$25797 \$25918 \$26224 gf180mcu_fd_sc_mcu9t5v0__nand2_1
X$10819 \$31263 \$24433 \$31232 \$31310 \$31526 gf180mcu_fd_sc_mcu9t5v0__nand2_1
X$10820 \$24434 \$24433 \$24593 \$24721 \$24858 gf180mcu_fd_sc_mcu9t5v0__nand2_1
X$10821 \$26833 \$24433 \$26675 \$26856 \$26873 gf180mcu_fd_sc_mcu9t5v0__nand2_1
X$10822 \$29709 \$24433 \$29780 \$29847 \$29860 gf180mcu_fd_sc_mcu9t5v0__nand2_1
X$10823 \$29307 \$24433 \$30696 \$30763 \$30860 gf180mcu_fd_sc_mcu9t5v0__nand2_1
X$10824 \$30557 \$24433 \$30564 \$30485 \$30569 gf180mcu_fd_sc_mcu9t5v0__nand2_1
X$10825 \$26986 \$24433 \$27015 \$26856 \$26813 gf180mcu_fd_sc_mcu9t5v0__nand2_1
X$10826 \$28556 \$24433 \$28534 \$28381 \$28504 gf180mcu_fd_sc_mcu9t5v0__nand2_1
X$10827 \$30038 \$24433 \$30054 \$30027 \$29974 gf180mcu_fd_sc_mcu9t5v0__nand2_1
X$10828 \$28712 \$24433 \$30251 \$30185 \$30264 gf180mcu_fd_sc_mcu9t5v0__nand2_1
X$10829 \$29934 \$24433 \$30696 \$30625 \$30837 gf180mcu_fd_sc_mcu9t5v0__nand2_1
X$10830 \$25939 \$24433 \$30971 \$30900 \$30905 gf180mcu_fd_sc_mcu9t5v0__nand2_1
X$10831 \$30710 \$24433 \$30819 \$30763 \$30776 gf180mcu_fd_sc_mcu9t5v0__nand2_1
X$10832 \$28115 \$24433 \$28810 \$28689 \$28715 gf180mcu_fd_sc_mcu9t5v0__nand2_1
X$10833 \$24856 \$24433 \$24877 \$24721 \$25078 gf180mcu_fd_sc_mcu9t5v0__nand2_1
X$10834 \$27173 \$24433 \$27637 \$27449 \$27606 gf180mcu_fd_sc_mcu9t5v0__nand2_1
X$10835 \$26994 \$24433 \$27015 \$26856 \$26658 gf180mcu_fd_sc_mcu9t5v0__nand2_1
X$10836 \$24738 \$24433 \$25191 \$24997 \$25067 gf180mcu_fd_sc_mcu9t5v0__nand2_1
X$10837 \$26817 \$24433 \$27015 \$26856 \$26992 gf180mcu_fd_sc_mcu9t5v0__nand2_1
X$10838 \$28558 \$24433 \$28534 \$28381 \$28557 gf180mcu_fd_sc_mcu9t5v0__nand2_1
X$10839 \$25770 \$24433 \$25797 \$25632 \$25769 gf180mcu_fd_sc_mcu9t5v0__nand2_1
X$10840 \$29643 \$24433 \$29634 \$29424 \$29539 gf180mcu_fd_sc_mcu9t5v0__nand2_1
X$10841 \$31240 \$24433 \$31232 \$31175 \$31241 gf180mcu_fd_sc_mcu9t5v0__nand2_1
X$10842 \$30859 \$24433 \$30819 \$30763 \$30775 gf180mcu_fd_sc_mcu9t5v0__nand2_1
X$10843 \$29726 \$24433 \$29634 \$29424 \$29537 gf180mcu_fd_sc_mcu9t5v0__nand2_1
X$10844 \$31168 \$24433 \$31100 \$31032 \$31108 gf180mcu_fd_sc_mcu9t5v0__nand2_1
X$10845 \$28578 \$24433 \$28534 \$28381 \$28576 gf180mcu_fd_sc_mcu9t5v0__nand2_1
X$10846 \$31109 \$24433 \$31100 \$31032 \$31170 gf180mcu_fd_sc_mcu9t5v0__nand2_1
X$10847 \$26990 \$24433 \$27015 \$26856 \$26989 gf180mcu_fd_sc_mcu9t5v0__nand2_1
X$10848 \$31258 \$31232 \$31310 \$24433 gf180mcu_fd_sc_mcu9t5v0__buf_8
X$10849 \$31261 \$31322 \$24433 \$31232 \$31310 \$31313
+ gf180mcu_fd_sc_mcu9t5v0__mux2_1
X$10850 \$26370 \$25986 \$24433 \$26088 \$26220 \$25985
+ gf180mcu_fd_sc_mcu9t5v0__mux2_1
X$10851 \$30701 \$30712 \$24433 \$30696 \$30763 \$30770
+ gf180mcu_fd_sc_mcu9t5v0__mux2_1
X$10852 \$24519 \$24708 \$24877 \$24721 \$24843 gf180mcu_fd_sc_mcu9t5v0__nand2_1
X$10853 \$25753 \$25752 \$25797 \$25632 \$24530 gf180mcu_fd_sc_mcu9t5v0__xnor2_1
X$10854 \$24881 \$24593 \$24721 \$24541 gf180mcu_fd_sc_mcu9t5v0__clkinv_1
X$10855 \$24541 \$24739 \$24593 \$24721 \$24605 gf180mcu_fd_sc_mcu9t5v0__nor2_1
X$10856 \$24881 \$25462 \$25347 \$24542 \$25071 gf180mcu_fd_sc_mcu9t5v0__xor2_1
X$10857 \$24542 \$24877 \$24721 \$24741 gf180mcu_fd_sc_mcu9t5v0__clkinv_1
X$10858 \$24740 \$24606 \$25003 \$24877 \$24721 \$24544
+ gf180mcu_fd_sc_mcu9t5v0__nor3_1
X$10859 \$25355 \$25978 \$26103 \$26088 \$25918 \$24545
+ gf180mcu_fd_sc_mcu9t5v0__nor3_1
X$10860 \$24743 \$24859 \$24857 \$24877 \$24721 \$24550
+ gf180mcu_fd_sc_mcu9t5v0__nor3_1
X$10861 \$25618 \$25817 \$25462 \$25632 \$24561 gf180mcu_fd_sc_mcu9t5v0__nand2_1
X$10862 \$24615 \$25093 \$24877 \$24721 \$24565 \$24563
+ gf180mcu_fd_sc_mcu9t5v0__xnor3_1
X$10863 \$24615 \$24563 \$24593 \$24721 \$24616 gf180mcu_fd_sc_mcu9t5v0__nand2_1
X$10864 \$24568 \$24567 \$24593 \$24721 \$24749 gf180mcu_fd_sc_mcu9t5v0__xnor2_1
X$10865 \$24865 \$24864 \$25027 \$24749 \$24877 \$24721 \$24569
+ gf180mcu_fd_sc_mcu9t5v0__aoi211_1
X$10866 \$24621 \$24571 \$24593 \$24721 \$24620 gf180mcu_fd_sc_mcu9t5v0__xnor2_1
X$10867 \$25786 \$25621 \$25622 \$25462 \$25632 \$24575
+ gf180mcu_fd_sc_mcu9t5v0__oai21_1
X$10868 \$24583 \$24593 \$24721 \$24711 gf180mcu_fd_sc_mcu9t5v0__clkinv_1
X$10869 \$24881 \$24739 \$24593 \$24721 \$24603 gf180mcu_fd_sc_mcu9t5v0__xnor2_1
X$10870 \$24604 \$24603 \$24593 \$24721 \$24602 gf180mcu_fd_sc_mcu9t5v0__xnor2_1
X$10871 \$24868 \$24756 \$24593 \$24721 \$24757 gf180mcu_fd_sc_mcu9t5v0__or2_1
X$10872 \$24716 \$24593 \$24721 \$24715 gf180mcu_fd_sc_mcu9t5v0__clkinv_1
X$10873 \$24616 \$25093 \$24593 \$24721 \$24617 gf180mcu_fd_sc_mcu9t5v0__nand2_1
X$10874 \$24721 \$24593 gf180mcu_fd_sc_mcu9t5v0__filltie
X$10875 \$24721 \$24593 gf180mcu_fd_sc_mcu9t5v0__filltie
X$10876 \$24721 \$24593 gf180mcu_fd_sc_mcu9t5v0__filltie
X$10877 \$24721 \$24593 gf180mcu_fd_sc_mcu9t5v0__filltie
X$10878 \$24721 \$24593 gf180mcu_fd_sc_mcu9t5v0__filltie
X$10879 \$24721 \$24593 gf180mcu_fd_sc_mcu9t5v0__filltie
X$10880 \$24721 \$24593 gf180mcu_fd_sc_mcu9t5v0__endcap
X$10881 \$24721 \$24593 gf180mcu_fd_sc_mcu9t5v0__endcap
X$10882 \$24597 \$24728 \$24877 \$24721 \$24851 gf180mcu_fd_sc_mcu9t5v0__and2_1
X$10883 \$24740 \$25068 \$25191 \$24997 \$24604 gf180mcu_fd_sc_mcu9t5v0__and2_1
X$10884 \$25074 \$24877 \$24997 \$24606 gf180mcu_fd_sc_mcu9t5v0__clkinv_1
X$10885 \$24612 \$25797 \$25918 gf180mcu_fd_sc_mcu9t5v0__inv_3
X$10886 \$24865 \$24864 \$25027 \$24877 \$24997 \$24619
+ gf180mcu_fd_sc_mcu9t5v0__aoi21_1
X$10887 \$24750 \$24866 \$24877 \$24721 \$24621 gf180mcu_fd_sc_mcu9t5v0__nor2_1
X$10888 \$24873 \$24710 \$24877 \$24721 \$24708 gf180mcu_fd_sc_mcu9t5v0__or2_1
X$10889 \$24708 \$24709 \$24877 \$24721 \$24872 gf180mcu_fd_sc_mcu9t5v0__nand2_1
X$10890 \$24874 \$24877 \$24997 \$24713 gf180mcu_fd_sc_mcu9t5v0__clkinv_1
X$10891 \$26344 \$26088 \$26220 \$24717 gf180mcu_fd_sc_mcu9t5v0__clkinv_1
X$10892 \$30955 \$24991 \$24718 \$30971 \$30900 \$30954
+ gf180mcu_fd_sc_mcu9t5v0__aoi21_1
X$10893 \$24719 \$29088 \$29427 \$29290 \$29424 \$29293
+ gf180mcu_fd_sc_mcu9t5v0__nor3_1
X$10894 \$24719 \$29429 \$29428 \$29290 \$29424 \$29087
+ gf180mcu_fd_sc_mcu9t5v0__nand3_1
X$10895 \$25030 \$25335 \$24877 \$24721 \$24750 gf180mcu_fd_sc_mcu9t5v0__and2_1
X$10896 \$25079 \$24855 \$24887 \$24877 \$24721 \$24857
+ gf180mcu_fd_sc_mcu9t5v0__aoi21_1
X$10897 \$24859 \$24857 \$24743 \$24877 \$24721 \$24888
+ gf180mcu_fd_sc_mcu9t5v0__oai21_1
X$10898 \$25089 \$24877 \$24721 \$24862 gf180mcu_fd_sc_mcu9t5v0__clkinv_1
X$10899 \$24889 \$24861 \$24877 \$24721 \$25086 gf180mcu_fd_sc_mcu9t5v0__nand2_1
X$10900 \$24721 \$24877 gf180mcu_fd_sc_mcu9t5v0__filltie
X$10901 \$24721 \$24877 gf180mcu_fd_sc_mcu9t5v0__filltie
X$10902 \$24721 \$24877 gf180mcu_fd_sc_mcu9t5v0__filltie
X$10903 \$24721 \$24877 gf180mcu_fd_sc_mcu9t5v0__filltie
X$10904 \$24721 \$24877 gf180mcu_fd_sc_mcu9t5v0__filltie
X$10905 \$24721 \$24877 gf180mcu_fd_sc_mcu9t5v0__filltie
X$10906 \$24721 \$24877 gf180mcu_fd_sc_mcu9t5v0__endcap
X$10907 \$24721 \$24877 gf180mcu_fd_sc_mcu9t5v0__endcap
X$10908 \$24740 \$25068 \$25191 \$24997 \$25069 gf180mcu_fd_sc_mcu9t5v0__nor2_1
X$10909 \$25638 \$25797 \$25632 \$24740 gf180mcu_fd_sc_mcu9t5v0__buf_8
X$10910 \$24743 \$25081 \$25191 \$25347 \$25198 gf180mcu_fd_sc_mcu9t5v0__xnor2_1
X$10911 \$25010 \$25082 \$25191 \$24997 \$24743 gf180mcu_fd_sc_mcu9t5v0__nand2_1
X$10912 \$25321 \$24744 \$25191 \$25347 \$25320 gf180mcu_fd_sc_mcu9t5v0__xnor2_1
X$10913 \$25357 \$24744 \$25462 \$25347 \$25476 gf180mcu_fd_sc_mcu9t5v0__nor2_1
X$10914 \$25321 \$24744 \$25191 \$25347 \$25322 gf180mcu_fd_sc_mcu9t5v0__nand2_1
X$10915 \$25013 \$25014 \$24745 \$24877 \$24997 \$24860
+ gf180mcu_fd_sc_mcu9t5v0__oai21_1
X$10916 \$29715 \$24746 \$29780 \$29847 \$29866 gf180mcu_fd_sc_mcu9t5v0__xnor2_1
X$10917 \$29715 \$24746 \$29634 \$29720 \$29716 gf180mcu_fd_sc_mcu9t5v0__and2_1
X$10918 \$24746 \$29954 \$29847 \$29977 gf180mcu_fd_sc_mcu9t5v0__clkinv_1
X$10919 \$24867 \$24892 \$24877 \$24997 \$24752 gf180mcu_fd_sc_mcu9t5v0__nand2_1
X$10920 \$24867 \$24892 \$24877 \$24997 \$24753 gf180mcu_fd_sc_mcu9t5v0__nor2_1
X$10921 \$24868 \$24756 \$24877 \$24997 \$25033 gf180mcu_fd_sc_mcu9t5v0__and2_1
X$10922 \$25049 \$25048 \$25191 \$24997 \$24845 gf180mcu_fd_sc_mcu9t5v0__nand2_1
X$10923 \$24847 \$26520 \$26216 \$26401 \$26521 \$26400
+ gf180mcu_fd_sc_mcu9t5v0__nand3_1
X$10924 \$26674 \$28487 \$28533 \$28534 \$28381 \$24847
+ gf180mcu_fd_sc_mcu9t5v0__nand3_1
X$10925 \$25461 \$25304 \$25191 \$25347 \$24848 \$25345
+ gf180mcu_fd_sc_mcu9t5v0__xnor3_1
X$10926 \$27280 \$27448 \$27315 \$27449 \$24849 \$27279
+ gf180mcu_fd_sc_mcu9t5v0__xnor3_1
X$10927 \$24887 \$25079 \$24855 \$24877 \$24997 \$25006
+ gf180mcu_fd_sc_mcu9t5v0__and3_1
X$10928 \$25978 \$26103 \$25355 \$26088 \$25918 \$24855
+ gf180mcu_fd_sc_mcu9t5v0__oai21_1
X$10929 \$25487 \$25618 \$25462 \$25347 \$24864 gf180mcu_fd_sc_mcu9t5v0__and2_1
X$10930 \$25097 \$25096 \$25191 \$24997 \$24865 gf180mcu_fd_sc_mcu9t5v0__nand2_1
X$10931 \$25488 \$25098 \$25099 \$25462 \$25347 \$24866
+ gf180mcu_fd_sc_mcu9t5v0__aoi21_1
X$10932 \$25953 \$25191 \$24997 \$24867 gf180mcu_fd_sc_mcu9t5v0__clkinv_1
X$10933 \$25646 \$25791 \$25792 \$25797 \$25632 \$24869
+ gf180mcu_fd_sc_mcu9t5v0__oai21_1
X$10934 \$24875 \$24991 \$24992 \$24877 \$24997 \$24876
+ gf180mcu_fd_sc_mcu9t5v0__oai21_1
X$10935 \$25011 \$25009 \$24888 \$24877 \$24997 \$25012
+ gf180mcu_fd_sc_mcu9t5v0__oai21_1
X$10936 \$25084 \$25012 \$24877 \$24997 \$25013 gf180mcu_fd_sc_mcu9t5v0__nor2_1
X$10937 \$25019 \$25018 \$24877 \$24997 \$25020 gf180mcu_fd_sc_mcu9t5v0__nand2_1
X$10938 \$25452 \$24984 \$25733 \$24877 \$24997 \$24983
+ gf180mcu_fd_sc_mcu9t5v0__mux2_1
X$10939 \$24997 \$24877 gf180mcu_fd_sc_mcu9t5v0__filltie
X$10940 \$24997 \$24877 gf180mcu_fd_sc_mcu9t5v0__filltie
X$10941 \$24997 \$24877 gf180mcu_fd_sc_mcu9t5v0__filltie
X$10942 \$24997 \$24877 gf180mcu_fd_sc_mcu9t5v0__filltie
X$10943 \$24997 \$24877 gf180mcu_fd_sc_mcu9t5v0__filltie
X$10944 \$24997 \$24877 gf180mcu_fd_sc_mcu9t5v0__filltie
X$10945 \$24997 \$24877 gf180mcu_fd_sc_mcu9t5v0__endcap
X$10946 \$24997 \$24877 gf180mcu_fd_sc_mcu9t5v0__endcap
X$10947 \$30174 \$29858 \$29954 \$29847 \$24884 gf180mcu_fd_sc_mcu9t5v0__xnor2_1
X$10948 \$24887 \$25318 \$25462 \$25347 \$25473 gf180mcu_fd_sc_mcu9t5v0__xnor2_1
X$10949 \$25317 \$26105 \$24887 \$25191 \$25347 \$25197
+ gf180mcu_fd_sc_mcu9t5v0__oai21_1
X$10950 \$25297 \$25035 \$25733 \$25191 \$24997 \$24982
+ gf180mcu_fd_sc_mcu9t5v0__mux2_1
X$10951 \$24984 \$25298 \$25299 \$25191 \$24997 \$25036
+ gf180mcu_fd_sc_mcu9t5v0__oai21_1
X$10952 \$25733 \$25191 \$24997 \$24985 gf180mcu_fd_sc_mcu9t5v0__clkinv_1
X$10953 \$28341 \$29721 \$30055 \$29635 \$29780 \$29720 \$24991
+ gf180mcu_fd_sc_mcu9t5v0__nand4_1
X$10954 \$28337 \$24991 \$28378 \$28211 \$28381 \$28380
+ gf180mcu_fd_sc_mcu9t5v0__and3_1
X$10955 \$24991 \$31031 \$31100 \$31175 \$31155 gf180mcu_fd_sc_mcu9t5v0__nand2_1
X$10956 \$24991 \$27639 \$27637 \$27776 \$26858 gf180mcu_fd_sc_mcu9t5v0__nand2_1
X$10957 \$24991 \$31229 \$31232 \$31175 \$31230 gf180mcu_fd_sc_mcu9t5v0__nand2_1
X$10958 \$24993 \$26361 \$26401 \$26521 \$26524 gf180mcu_fd_sc_mcu9t5v0__nand2_1
X$10959 \$25099 \$25488 \$25098 \$25191 \$24997 \$25207
+ gf180mcu_fd_sc_mcu9t5v0__and3_1
X$10960 \$25329 \$25091 \$25094 \$25191 \$24997 \$25093
+ gf180mcu_fd_sc_mcu9t5v0__aoi21_1
X$10961 \$25054 \$25052 \$25053 \$25191 \$24997 \$25055
+ gf180mcu_fd_sc_mcu9t5v0__oai21_1
X$10962 \$25461 \$25345 \$25191 \$24997 \$25056 gf180mcu_fd_sc_mcu9t5v0__nor2_1
X$10963 \$25097 \$25096 \$25191 \$24997 \$25027 gf180mcu_fd_sc_mcu9t5v0__nor2_1
X$10964 \$25320 \$25191 \$24997 \$25084 gf180mcu_fd_sc_mcu9t5v0__clkinv_1
X$10965 \$25083 \$25191 \$24997 \$25011 gf180mcu_fd_sc_mcu9t5v0__clkinv_1
X$10966 \$25046 \$25191 \$24997 \$25189 gf180mcu_fd_sc_mcu9t5v0__clkinv_1
X$10967 \$25080 \$25197 \$25191 \$24997 \$25081 gf180mcu_fd_sc_mcu9t5v0__nand2_1
X$10968 \$25007 \$25008 \$25191 \$24997 \$25080 gf180mcu_fd_sc_mcu9t5v0__nand2_1
X$10969 \$25084 \$25012 \$25191 \$24997 \$25085 gf180mcu_fd_sc_mcu9t5v0__nand2_1
X$10970 \$25083 \$25009 \$25191 \$24997 \$25082 gf180mcu_fd_sc_mcu9t5v0__nand2_1
X$10971 \$24997 \$25191 gf180mcu_fd_sc_mcu9t5v0__filltie
X$10972 \$24997 \$25191 gf180mcu_fd_sc_mcu9t5v0__filltie
X$10973 \$24997 \$25191 gf180mcu_fd_sc_mcu9t5v0__filltie
X$10974 \$24997 \$25191 gf180mcu_fd_sc_mcu9t5v0__filltie
X$10975 \$24997 \$25191 gf180mcu_fd_sc_mcu9t5v0__filltie
X$10976 \$24997 \$25191 gf180mcu_fd_sc_mcu9t5v0__filltie
X$10977 \$24997 \$25191 gf180mcu_fd_sc_mcu9t5v0__endcap
X$10978 \$24997 \$25191 gf180mcu_fd_sc_mcu9t5v0__endcap
X$10979 \$25007 \$25933 \$25797 \$25918 \$25979 gf180mcu_fd_sc_mcu9t5v0__nand2_1
X$10980 \$25007 \$25607 \$25472 \$25462 \$25347 \$25474
+ gf180mcu_fd_sc_mcu9t5v0__mux2_1
X$10981 \$25320 \$25010 \$25319 \$25191 \$25347 \$25610
+ gf180mcu_fd_sc_mcu9t5v0__and3_1
X$10982 \$25010 \$25319 \$25320 \$25191 \$25347 \$25609
+ gf180mcu_fd_sc_mcu9t5v0__aoi21_1
X$10983 \$25022 \$25462 \$25347 gf180mcu_fd_sc_mcu9t5v0__clkbuf_4
X$10984 \$25030 \$25335 \$25191 \$25347 \$25099 gf180mcu_fd_sc_mcu9t5v0__xnor2_1
X$10985 \$25579 \$25295 \$25733 \$25191 \$25347 \$25034
+ gf180mcu_fd_sc_mcu9t5v0__mux2_1
X$10986 \$25035 \$25298 \$25299 \$25191 \$25347 \$25454
+ gf180mcu_fd_sc_mcu9t5v0__oai21_1
X$10987 \$25187 \$25298 \$25299 \$25191 \$25347 \$25038
+ gf180mcu_fd_sc_mcu9t5v0__oai21_1
X$10988 \$26847 \$26088 \$26220 \$25041 gf180mcu_fd_sc_mcu9t5v0__clkinv_1
X$10989 \$26084 \$25966 \$25043 \$25585 \$26401 \$26220 \$26352
+ gf180mcu_fd_sc_mcu9t5v0__oai22_1
X$10990 \$25044 \$28810 \$28689 \$28809 gf180mcu_fd_sc_mcu9t5v0__clkinv_1
X$10991 \$25047 \$25303 \$25049 \$25462 \$25632 \$26350
+ gf180mcu_fd_sc_mcu9t5v0__or3_2
X$10992 \$25047 \$25049 \$25191 \$25347 \$25966 gf180mcu_fd_sc_mcu9t5v0__nor2_1
X$10993 \$30184 \$31678 \$31679 \$26969 \$31607 \$31733 \$25050
+ gf180mcu_fd_sc_mcu9t5v0__oai211_1
X$10994 \$25753 \$25051 \$26401 \$26220 \$26356 gf180mcu_fd_sc_mcu9t5v0__xnor2_1
X$10995 \$28686 \$28487 \$28533 \$28534 \$28381 \$25051
+ gf180mcu_fd_sc_mcu9t5v0__nor3_1
X$10996 \$26218 \$25051 \$26675 \$26521 \$26520 gf180mcu_fd_sc_mcu9t5v0__nand2_1
X$10997 \$25305 \$25304 \$25056 \$25191 \$25347 \$25054
+ gf180mcu_fd_sc_mcu9t5v0__aoi21_1
X$10998 \$25805 \$25065 \$25468 \$25462 \$25632 gf180mcu_fd_sc_mcu9t5v0__dffq_2
X$10999 \$26865 \$26655 \$26675 \$26521 \$25066 gf180mcu_fd_sc_mcu9t5v0__nand2_1
X$11000 \$25638 \$25462 \$25632 \$25070 gf180mcu_fd_sc_mcu9t5v0__clkinv_1
X$11001 \$25070 \$25074 \$25191 \$25347 \$25076 gf180mcu_fd_sc_mcu9t5v0__nand2_1
X$11002 \$25315 \$25071 \$25191 \$25347 \$25072 gf180mcu_fd_sc_mcu9t5v0__xnor2_1
X$11003 \$27163 \$27291 \$27315 \$27153 \$25077 gf180mcu_fd_sc_mcu9t5v0__nand2_1
X$11004 \$25082 \$25080 \$25197 \$25191 \$25347 \$25319
+ gf180mcu_fd_sc_mcu9t5v0__nand3_1
X$11005 \$25083 \$26818 \$25472 \$26675 \$26856 \$26867
+ gf180mcu_fd_sc_mcu9t5v0__mux2_1
X$11006 \$25322 \$25085 \$25191 \$25347 \$25613 gf180mcu_fd_sc_mcu9t5v0__nand2_1
X$11007 \$25988 \$26117 \$26088 \$25918 \$25090 gf180mcu_fd_sc_mcu9t5v0__xnor2_1
X$11008 \$25329 \$25091 \$25191 \$25347 \$25330 gf180mcu_fd_sc_mcu9t5v0__xnor2_1
X$11009 \$25485 \$25486 \$25362 \$25330 \$25462 \$25347 \$25094
+ gf180mcu_fd_sc_mcu9t5v0__aoi211_1
X$11010 \$25330 \$25331 \$25191 \$25347 \$25095 gf180mcu_fd_sc_mcu9t5v0__xnor2_1
X$11011 \$25784 \$26667 \$25797 \$25632 \$25098 gf180mcu_fd_sc_mcu9t5v0__or2_1
X$11012 \$25341 \$25494 \$25647 \$25958 \$25462 \$25632 \$25101
+ gf180mcu_fd_sc_mcu9t5v0__aoi22_1
X$11013 \$25341 \$25494 \$25191 \$25347 \$25102 gf180mcu_fd_sc_mcu9t5v0__nor2_1
X$11014 \$25342 \$25187 \$25733 \$25462 \$25347 \$25293
+ gf180mcu_fd_sc_mcu9t5v0__mux2_1
X$11015 \$25295 \$25298 \$25299 \$25191 \$25347 \$25188
+ gf180mcu_fd_sc_mcu9t5v0__oai21_1
X$11016 \$25317 \$26105 \$25191 \$25347 \$25318 gf180mcu_fd_sc_mcu9t5v0__nor2_1
X$11017 \$25471 \$25191 \$25347 \$25316 gf180mcu_fd_sc_mcu9t5v0__clkinv_1
X$11018 \$25347 \$25191 gf180mcu_fd_sc_mcu9t5v0__filltie
X$11019 \$25347 \$25191 gf180mcu_fd_sc_mcu9t5v0__filltie
X$11020 \$25347 \$25191 gf180mcu_fd_sc_mcu9t5v0__filltie
X$11021 \$25347 \$25191 gf180mcu_fd_sc_mcu9t5v0__filltie
X$11022 \$25347 \$25191 gf180mcu_fd_sc_mcu9t5v0__filltie
X$11023 \$25347 \$25191 gf180mcu_fd_sc_mcu9t5v0__filltie
X$11024 \$25347 \$25191 gf180mcu_fd_sc_mcu9t5v0__endcap
X$11025 \$25347 \$25191 gf180mcu_fd_sc_mcu9t5v0__endcap
X$11026 \$25192 \$26642 \$26675 \$26521 \$26404 gf180mcu_fd_sc_mcu9t5v0__and2_1
X$11027 \$25192 \$26642 \$26522 \$26675 \$26856 \$26643
+ gf180mcu_fd_sc_mcu9t5v0__oai21_1
X$11028 \$25192 \$26360 \$25797 \$25918 \$25802 gf180mcu_fd_sc_mcu9t5v0__nor2_1
X$11029 \$25192 \$26088 \$25918 \$25595 gf180mcu_fd_sc_mcu9t5v0__clkinv_1
X$11030 \$25923 \$25797 \$25632 \$25192 gf180mcu_fd_sc_mcu9t5v0__buf_8
X$11031 \$25809 \$25198 \$28211 \$28089 \$28103 gf180mcu_fd_sc_mcu9t5v0__nand2_1
X$11032 \$27627 \$27565 \$26847 \$27637 \$27449 \$25298
+ gf180mcu_fd_sc_mcu9t5v0__aoi21_1
X$11033 \$25623 \$25298 \$25299 \$25797 \$25632 \$25795
+ gf180mcu_fd_sc_mcu9t5v0__oai21_1
X$11034 \$25344 \$25298 \$25299 \$25462 \$25347 \$25301
+ gf180mcu_fd_sc_mcu9t5v0__oai21_1
X$11035 \$25964 \$25298 \$25299 \$26088 \$25918 \$25963
+ gf180mcu_fd_sc_mcu9t5v0__oai21_1
X$11036 \$25302 \$28044 \$27275 \$27913 \$28089 \$27909
+ gf180mcu_fd_sc_mcu9t5v0__nand3_1
X$11037 \$27908 \$25302 \$27275 \$28211 \$28089 \$28206
+ gf180mcu_fd_sc_mcu9t5v0__nand3_1
X$11038 \$25302 \$27275 \$27913 \$28089 \$28085 gf180mcu_fd_sc_mcu9t5v0__nand2_1
X$11039 \$25302 \$27913 \$28089 \$26211 gf180mcu_fd_sc_mcu9t5v0__clkinv_1
X$11040 \$26211 \$26084 \$25303 \$26088 \$26220 \$26083
+ gf180mcu_fd_sc_mcu9t5v0__oai21_1
X$11041 \$25755 \$25754 \$25797 \$25632 \$25304 gf180mcu_fd_sc_mcu9t5v0__nand2_1
X$11042 \$25461 \$25345 \$25462 \$25347 \$25305 gf180mcu_fd_sc_mcu9t5v0__nand2_1
X$11043 \$25310 \$26407 \$26675 \$26521 \$26646 gf180mcu_fd_sc_mcu9t5v0__nor2_1
X$11044 \$25311 \$25462 \$25347 \$25464 gf180mcu_fd_sc_mcu9t5v0__inv_1
X$11045 \$25321 \$25933 \$25797 \$25918 \$25935 gf180mcu_fd_sc_mcu9t5v0__nand2_1
X$11046 \$25321 \$25462 \$25347 \$25357 gf180mcu_fd_sc_mcu9t5v0__clkinv_1
X$11047 \$25321 \$25356 \$25472 \$25462 \$25632 \$25641
+ gf180mcu_fd_sc_mcu9t5v0__mux2_1
X$11048 \$25612 \$25613 \$25462 \$25632 \$25324 gf180mcu_fd_sc_mcu9t5v0__xnor2_1
X$11049 \$25485 \$25486 \$25362 \$25462 \$25347 \$25331
+ gf180mcu_fd_sc_mcu9t5v0__aoi21_1
X$11050 \$25340 \$25462 \$25632 \$25494 gf180mcu_fd_sc_mcu9t5v0__clkinv_1
X$11051 \$26672 \$25343 \$26640 \$26675 \$26521 \$26349
+ gf180mcu_fd_sc_mcu9t5v0__aoi21_1
X$11052 \$27909 \$28810 \$28689 \$25343 gf180mcu_fd_sc_mcu9t5v0__buf_8
X$11053 \$26786 \$26346 \$25343 \$26675 \$26856 \$26845
+ gf180mcu_fd_sc_mcu9t5v0__mux2_1
X$11054 \$27148 \$26787 \$25343 \$26675 \$26856 \$26846
+ gf180mcu_fd_sc_mcu9t5v0__mux2_1
X$11055 \$28325 \$28031 \$25343 \$27913 \$28089 \$28081
+ gf180mcu_fd_sc_mcu9t5v0__mux2_1
X$11056 \$26635 \$26785 \$25343 \$26675 \$26856 \$26844
+ gf180mcu_fd_sc_mcu9t5v0__mux2_1
X$11057 \$27436 \$27437 \$25343 \$27315 \$27449 \$27562
+ gf180mcu_fd_sc_mcu9t5v0__mux2_1
X$11058 \$26784 \$26843 \$25343 \$26675 \$26856 \$26842
+ gf180mcu_fd_sc_mcu9t5v0__mux2_1
X$11059 \$29076 \$28962 \$25343 \$29123 \$29270 \$29260
+ gf180mcu_fd_sc_mcu9t5v0__mux2_1
X$11060 \$28523 \$28684 \$25343 \$28534 \$28689 \$28683
+ gf180mcu_fd_sc_mcu9t5v0__mux2_1
X$11061 \$27439 \$27904 \$25343 \$27637 \$27776 \$27903
+ gf180mcu_fd_sc_mcu9t5v0__mux2_1
X$11062 \$25960 \$26077 \$25343 \$26088 \$25918 \$26076
+ gf180mcu_fd_sc_mcu9t5v0__mux2_1
X$11063 \$26395 \$26343 \$25343 \$26401 \$26220 \$26342
+ gf180mcu_fd_sc_mcu9t5v0__mux2_1
X$11064 \$27563 \$26639 \$25343 \$27315 \$27153 \$27004
+ gf180mcu_fd_sc_mcu9t5v0__mux2_1
X$11065 \$29072 \$28928 \$25343 \$29123 \$28971 \$28959
+ gf180mcu_fd_sc_mcu9t5v0__mux2_1
X$11066 \$29073 \$28960 \$25343 \$29123 \$28971 \$29116
+ gf180mcu_fd_sc_mcu9t5v0__mux2_1
X$11067 \$29075 \$28682 \$25343 \$29123 \$28971 \$29074
+ gf180mcu_fd_sc_mcu9t5v0__mux2_1
X$11068 \$28037 \$27764 \$25343 \$27913 \$27776 \$27763
+ gf180mcu_fd_sc_mcu9t5v0__mux2_1
X$11069 \$25457 \$25344 \$25733 \$25462 \$25347 \$25456
+ gf180mcu_fd_sc_mcu9t5v0__mux2_1
X$11070 \$25748 \$26088 \$26220 \$25345 \$26213 gf180mcu_fd_sc_mcu9t5v0__xor2_1
X$11071 \$26674 \$26518 \$26401 \$26220 \$25345 gf180mcu_fd_sc_mcu9t5v0__nand2_1
X$11072 \$25351 \$25462 \$25347 \$25465 gf180mcu_fd_sc_mcu9t5v0__clkinv_1
X$11073 \$25347 \$25462 gf180mcu_fd_sc_mcu9t5v0__filltie
X$11074 \$25347 \$25462 gf180mcu_fd_sc_mcu9t5v0__filltie
X$11075 \$25347 \$25462 gf180mcu_fd_sc_mcu9t5v0__filltie
X$11076 \$25347 \$25462 gf180mcu_fd_sc_mcu9t5v0__filltie
X$11077 \$25347 \$25462 gf180mcu_fd_sc_mcu9t5v0__filltie
X$11078 \$25347 \$25462 gf180mcu_fd_sc_mcu9t5v0__filltie
X$11079 \$25471 \$25606 \$25472 \$25462 \$25347 \$25470
+ gf180mcu_fd_sc_mcu9t5v0__mux2_1
X$11080 \$25347 \$25462 gf180mcu_fd_sc_mcu9t5v0__endcap
X$11081 \$25347 \$25462 gf180mcu_fd_sc_mcu9t5v0__endcap
X$11082 \$25354 \$27042 \$27015 \$27153 \$27165 gf180mcu_fd_sc_mcu9t5v0__nand2_1
X$11083 \$25354 \$28227 \$28211 \$28089 \$28356 gf180mcu_fd_sc_mcu9t5v0__nand2_1
X$11084 \$25354 \$28508 \$28534 \$28381 \$28567 gf180mcu_fd_sc_mcu9t5v0__nand2_1
X$11085 \$27799 \$25354 \$27913 \$27776 \$27800 gf180mcu_fd_sc_mcu9t5v0__nand2_1
X$11086 \$26368 \$26104 \$25355 \$26088 \$26220 \$26105
+ gf180mcu_fd_sc_mcu9t5v0__aoi21_1
X$11087 \$25355 \$26368 \$26104 \$26401 \$26220 \$26369
+ gf180mcu_fd_sc_mcu9t5v0__nand3_1
X$11088 \$25776 \$25644 \$25797 \$25632 \$25362 gf180mcu_fd_sc_mcu9t5v0__nor2_1
X$11089 \$25734 \$25909 \$25737 \$25797 \$25918 \$25453
+ gf180mcu_fd_sc_mcu9t5v0__oai21_1
X$11090 \$25745 \$25591 \$25462 \$25632 \$25461 \$25590
+ gf180mcu_fd_sc_mcu9t5v0__xnor3_1
X$11091 \$25476 \$25610 \$25612 \$25462 \$25632 \$25477
+ gf180mcu_fd_sc_mcu9t5v0__oai21_1
X$11092 \$25610 \$25609 \$25462 \$25632 \$25642 gf180mcu_fd_sc_mcu9t5v0__nor2_1
X$11093 \$25476 \$25610 \$25462 \$25632 \$25611 gf180mcu_fd_sc_mcu9t5v0__nor2_1
X$11094 \$25767 \$25462 \$25632 \$25612 gf180mcu_fd_sc_mcu9t5v0__clkinv_1
X$11095 \$25619 \$25779 \$25462 \$25632 \$25487 gf180mcu_fd_sc_mcu9t5v0__nand2_1
X$11096 \$25756 \$25592 \$25462 \$25632 \$25754 gf180mcu_fd_sc_mcu9t5v0__nand2_1
X$11097 \$25581 \$25625 \$25462 \$25632 \$25582 gf180mcu_fd_sc_mcu9t5v0__nand2_1
X$11098 \$25582 \$25583 \$25462 \$25632 \$25629 gf180mcu_fd_sc_mcu9t5v0__nand2_1
X$11099 \$25632 \$25462 gf180mcu_fd_sc_mcu9t5v0__filltie
X$11100 \$25632 \$25462 gf180mcu_fd_sc_mcu9t5v0__filltie
X$11101 \$25632 \$25462 gf180mcu_fd_sc_mcu9t5v0__filltie
X$11102 \$25632 \$25462 gf180mcu_fd_sc_mcu9t5v0__filltie
X$11103 \$25632 \$25462 gf180mcu_fd_sc_mcu9t5v0__filltie
X$11104 \$25632 \$25462 gf180mcu_fd_sc_mcu9t5v0__filltie
X$11105 \$25632 \$25462 gf180mcu_fd_sc_mcu9t5v0__endcap
X$11106 \$25632 \$25462 gf180mcu_fd_sc_mcu9t5v0__endcap
X$11107 \$25466 \$30313 \$30402 \$30339 \$30404 gf180mcu_fd_sc_mcu9t5v0__nand2_1
X$11108 \$25466 \$30251 \$30185 \$30238 gf180mcu_fd_sc_mcu9t5v0__clkinv_1
X$11109 \$28501 \$25466 \$29240 \$29290 \$29424 \$29430
+ gf180mcu_fd_sc_mcu9t5v0__mux2_1
X$11110 \$28343 \$25466 \$28344 \$28211 \$28381 \$28092
+ gf180mcu_fd_sc_mcu9t5v0__mux2_1
X$11111 \$28819 \$25466 \$29091 \$29123 \$28971 \$29129
+ gf180mcu_fd_sc_mcu9t5v0__mux2_1
X$11112 \$30972 \$30971 \$31032 \$25472 gf180mcu_fd_sc_mcu9t5v0__buf_8
X$11113 \$27336 \$28354 \$25472 \$27913 \$28089 \$28097
+ gf180mcu_fd_sc_mcu9t5v0__mux2_1
X$11114 \$26690 \$26820 \$25472 \$26675 \$26856 \$26868
+ gf180mcu_fd_sc_mcu9t5v0__mux2_1
X$11115 \$26652 \$26683 \$25472 \$26675 \$26521 \$26684
+ gf180mcu_fd_sc_mcu9t5v0__mux2_1
X$11116 \$27652 \$28216 \$25472 \$28211 \$28089 \$28218
+ gf180mcu_fd_sc_mcu9t5v0__mux2_1
X$11117 \$26231 \$28219 \$25472 \$28211 \$28089 \$28220
+ gf180mcu_fd_sc_mcu9t5v0__mux2_1
X$11118 \$27286 \$27327 \$25472 \$27315 \$27153 \$27329
+ gf180mcu_fd_sc_mcu9t5v0__mux2_1
X$11119 \$26233 \$26411 \$25472 \$26401 \$26220 \$26107
+ gf180mcu_fd_sc_mcu9t5v0__mux2_1
X$11120 \$28101 \$27315 \$27449 \$27338 \$25475 gf180mcu_fd_sc_mcu9t5v0__xor2_1
X$11121 \$26108 \$25477 \$26088 \$25918 \$26109 gf180mcu_fd_sc_mcu9t5v0__and2_1
X$11122 \$25809 \$25477 \$25766 \$25797 \$25918 \$25810
+ gf180mcu_fd_sc_mcu9t5v0__nand3_1
X$11123 \$25481 \$26401 \$26220 \$26377 gf180mcu_fd_sc_mcu9t5v0__clkinv_1
X$11124 \$25776 \$25644 \$25797 \$25632 \$25485 gf180mcu_fd_sc_mcu9t5v0__nand2_1
X$11125 \$25776 \$25486 \$25797 \$25632 \$25777 \$25644
+ gf180mcu_fd_sc_mcu9t5v0__xnor3_1
X$11126 \$26543 \$26419 \$26379 \$26401 \$26220 \$25486
+ gf180mcu_fd_sc_mcu9t5v0__aoi21_1
X$11127 \$25783 \$25782 \$25797 \$25632 \$25488 gf180mcu_fd_sc_mcu9t5v0__nand2_1
X$11128 \$25789 \$25797 \$25632 \$25790 \$25489 gf180mcu_fd_sc_mcu9t5v0__xor2_1
X$11129 \$25788 \$25786 \$25797 \$25632 \$25490 \$25787
+ gf180mcu_fd_sc_mcu9t5v0__xnor3_1
X$11130 \$26084 \$26350 \$25584 \$26401 \$26521 \$26351
+ gf180mcu_fd_sc_mcu9t5v0__oai21_4
X$11131 \$27282 \$25584 \$27021 \$27015 \$27153 \$27022
+ gf180mcu_fd_sc_mcu9t5v0__nand3_1
X$11132 \$25584 \$26675 \$26856 \$26672 gf180mcu_fd_sc_mcu9t5v0__clkinv_1
X$11133 \$26085 \$25585 \$26088 \$26220 \$26084 gf180mcu_fd_sc_mcu9t5v0__or2_2
X$11134 \$25585 \$27315 \$27153 \$27282 gf180mcu_fd_sc_mcu9t5v0__buf_8
X$11135 \$25585 \$28211 \$28089 \$28213 gf180mcu_fd_sc_mcu9t5v0__buf_8
X$11136 \$30184 \$31676 \$31677 \$26969 \$31607 \$31733 \$25589
+ gf180mcu_fd_sc_mcu9t5v0__oai211_1
X$11137 \$25590 \$26641 \$27015 \$26856 \$27012 gf180mcu_fd_sc_mcu9t5v0__xnor2_1
X$11138 \$25745 \$25590 \$25797 \$25632 \$25746 gf180mcu_fd_sc_mcu9t5v0__and2_1
X$11139 \$25745 \$25590 \$25797 \$25918 \$25917 gf180mcu_fd_sc_mcu9t5v0__or2_1
X$11140 \$25590 \$26641 \$26855 \$26675 \$26521 \$26354
+ gf180mcu_fd_sc_mcu9t5v0__aoi21_1
X$11141 \$25590 \$26793 \$26794 \$26675 \$26856 \$26792
+ gf180mcu_fd_sc_mcu9t5v0__oai21_1
X$11142 \$25917 \$25591 \$25746 \$25797 \$25632 \$25747
+ gf180mcu_fd_sc_mcu9t5v0__aoi21_1
X$11143 \$27014 \$27013 \$26970 \$27015 \$27153 \$25591
+ gf180mcu_fd_sc_mcu9t5v0__aoi21_1
X$11144 \$25755 \$25756 \$25592 \$25797 \$25632 \$25757
+ gf180mcu_fd_sc_mcu9t5v0__aoi21_1
X$11145 \$26089 \$27017 \$26797 \$27015 \$26856 \$25592
+ gf180mcu_fd_sc_mcu9t5v0__oai21_1
X$11146 \$25759 \$25593 \$25797 \$25632 \$25742 gf180mcu_fd_sc_mcu9t5v0__nand2_1
X$11147 \$26221 \$25595 \$26092 \$26088 \$26220 \$25968
+ gf180mcu_fd_sc_mcu9t5v0__oai21_1
X$11148 \$28052 \$28054 \$28053 \$28051 \$27913 \$28089 \$25598
+ gf180mcu_fd_sc_mcu9t5v0__oai31_4
X$11149 \$28829 \$28565 \$28534 \$28689 \$25608 gf180mcu_fd_sc_mcu9t5v0__xnor2_1
X$11150 \$25767 \$25611 \$25797 \$25632 \$25766 gf180mcu_fd_sc_mcu9t5v0__nand2_1
X$11151 \$25767 \$25613 \$25797 \$25632 \$25940 gf180mcu_fd_sc_mcu9t5v0__nand2_1
X$11152 \$28107 \$25614 \$28211 \$28089 \$28111 gf180mcu_fd_sc_mcu9t5v0__and2_1
X$11153 \$27937 \$25614 \$28211 \$28089 \$28108 gf180mcu_fd_sc_mcu9t5v0__or2_1
X$11154 \$27937 \$25614 \$28534 \$28381 \$28386 gf180mcu_fd_sc_mcu9t5v0__nor2_1
X$11155 \$27937 \$25614 \$27913 \$28089 \$28360 gf180mcu_fd_sc_mcu9t5v0__nand2_1
X$11156 \$25990 \$25988 \$26116 \$25947 \$26088 \$25918 \$25618
+ gf180mcu_fd_sc_mcu9t5v0__oai211_1
X$11157 \$25619 \$25779 \$25797 \$25632 \$25780 gf180mcu_fd_sc_mcu9t5v0__xnor2_1
X$11158 \$25788 \$25787 \$25797 \$25918 \$25621 gf180mcu_fd_sc_mcu9t5v0__nor2_1
X$11159 \$25788 \$25787 \$25797 \$25918 \$25622 gf180mcu_fd_sc_mcu9t5v0__nand2_1
X$11160 \$26078 \$25623 \$25733 \$25797 \$25632 \$25794
+ gf180mcu_fd_sc_mcu9t5v0__mux2_1
X$11161 \$25741 \$26849 \$26789 \$26675 \$26856 \$25625
+ gf180mcu_fd_sc_mcu9t5v0__nor3_1
X$11162 \$25625 \$27015 \$27153 \$27009 gf180mcu_fd_sc_mcu9t5v0__clkinv_1
X$11163 \$25627 \$28810 \$28689 \$28808 gf180mcu_fd_sc_mcu9t5v0__clkinv_1
X$11164 \$25629 \$25797 \$25918 \$25915 gf180mcu_fd_sc_mcu9t5v0__buf_8
X$11165 \$25630 \$25965 \$26088 \$25918 \$26082 gf180mcu_fd_sc_mcu9t5v0__nor2_1
X$11166 \$25747 \$25751 \$25750 \$25797 \$25632 \$25752
+ gf180mcu_fd_sc_mcu9t5v0__oai21_1
X$11167 \$25748 \$25749 \$25797 \$25632 \$25751 gf180mcu_fd_sc_mcu9t5v0__nor2_1
X$11168 \$25748 \$25749 \$25797 \$25632 \$25750 gf180mcu_fd_sc_mcu9t5v0__nand2_1
X$11169 \$25632 \$25797 gf180mcu_fd_sc_mcu9t5v0__filltie
X$11170 \$25632 \$25797 gf180mcu_fd_sc_mcu9t5v0__filltie
X$11171 \$25632 \$25797 gf180mcu_fd_sc_mcu9t5v0__filltie
X$11172 \$25632 \$25797 gf180mcu_fd_sc_mcu9t5v0__filltie
X$11173 \$25632 \$25797 gf180mcu_fd_sc_mcu9t5v0__filltie
X$11174 \$25632 \$25797 gf180mcu_fd_sc_mcu9t5v0__filltie
X$11175 \$26077 \$25734 \$25733 \$25797 \$25632 \$25732
+ gf180mcu_fd_sc_mcu9t5v0__mux2_1
X$11176 \$25632 \$25797 gf180mcu_fd_sc_mcu9t5v0__endcap
X$11177 \$25632 \$25797 gf180mcu_fd_sc_mcu9t5v0__endcap
X$11178 \$25954 \$25646 \$25797 \$25918 \$25820 \$25955
+ gf180mcu_fd_sc_mcu9t5v0__xnor3_1
X$11179 \$25789 \$25790 \$25797 \$25918 \$25646 gf180mcu_fd_sc_mcu9t5v0__nand2_1
X$11180 \$26253 \$25797 \$25918 \$25647 gf180mcu_fd_sc_mcu9t5v0__clkinv_1
X$11181 \$27631 \$27913 \$27776 \$25733 gf180mcu_fd_sc_mcu9t5v0__buf_8
X$11182 \$28038 \$27766 \$25733 \$27637 \$27776 \$27765
+ gf180mcu_fd_sc_mcu9t5v0__mux2_1
X$11183 \$26787 \$26344 \$25733 \$26401 \$26521 \$26348
+ gf180mcu_fd_sc_mcu9t5v0__mux2_1
X$11184 \$27149 \$26847 \$25733 \$27015 \$27153 \$26966
+ gf180mcu_fd_sc_mcu9t5v0__mux2_1
X$11185 \$28333 \$28331 \$25733 \$28211 \$28381 \$28374
+ gf180mcu_fd_sc_mcu9t5v0__mux2_1
X$11186 \$28329 \$28328 \$25733 \$28211 \$28381 \$28373
+ gf180mcu_fd_sc_mcu9t5v0__mux2_1
X$11187 \$28041 \$27768 \$25733 \$27913 \$28089 \$27629
+ gf180mcu_fd_sc_mcu9t5v0__mux2_1
X$11188 \$29262 \$28330 \$25733 \$28810 \$28971 \$28963
+ gf180mcu_fd_sc_mcu9t5v0__mux2_1
X$11189 \$28084 \$27625 \$25733 \$27637 \$27776 \$27767
+ gf180mcu_fd_sc_mcu9t5v0__mux2_1
X$11190 \$28031 \$28033 \$25733 \$27913 \$28089 \$28082
+ gf180mcu_fd_sc_mcu9t5v0__mux2_1
X$11191 \$28928 \$28680 \$25733 \$28534 \$28689 \$28679
+ gf180mcu_fd_sc_mcu9t5v0__mux2_1
X$11192 \$28960 \$28681 \$25733 \$28534 \$28689 \$28807
+ gf180mcu_fd_sc_mcu9t5v0__mux2_1
X$11193 \$27904 \$28480 \$25733 \$28211 \$28381 \$28371
+ gf180mcu_fd_sc_mcu9t5v0__mux2_1
X$11194 \$28962 \$28519 \$25733 \$28810 \$28971 \$28961
+ gf180mcu_fd_sc_mcu9t5v0__mux2_1
X$11195 \$28684 \$28520 \$25733 \$28534 \$28689 \$28521
+ gf180mcu_fd_sc_mcu9t5v0__mux2_1
X$11196 \$29264 \$28332 \$25733 \$28810 \$28971 \$28964
+ gf180mcu_fd_sc_mcu9t5v0__mux2_1
X$11197 \$28682 \$28327 \$25733 \$28534 \$28689 \$28326
+ gf180mcu_fd_sc_mcu9t5v0__mux2_1
X$11198 \$27437 \$27308 \$25733 \$27315 \$27153 \$27307
+ gf180mcu_fd_sc_mcu9t5v0__mux2_1
X$11199 \$26639 \$26638 \$25733 \$26675 \$26521 \$26670
+ gf180mcu_fd_sc_mcu9t5v0__mux2_1
X$11200 \$27764 \$27900 \$25733 \$27913 \$27776 \$28035
+ gf180mcu_fd_sc_mcu9t5v0__mux2_1
X$11201 \$26785 \$27003 \$25733 \$27315 \$27153 \$27002
+ gf180mcu_fd_sc_mcu9t5v0__mux2_1
X$11202 \$26843 \$26341 \$25733 \$26401 \$26220 \$26340
+ gf180mcu_fd_sc_mcu9t5v0__mux2_1
X$11203 \$26209 \$25964 \$25733 \$26401 \$26220 \$26079
+ gf180mcu_fd_sc_mcu9t5v0__mux2_1
X$11204 \$26346 \$26345 \$25733 \$26401 \$26220 \$26508
+ gf180mcu_fd_sc_mcu9t5v0__mux2_1
X$11205 \$26343 \$25908 \$25733 \$26088 \$25918 \$25907
+ gf180mcu_fd_sc_mcu9t5v0__mux2_1
X$11206 \$29261 \$27626 \$25733 \$29290 \$29270 \$29229
+ gf180mcu_fd_sc_mcu9t5v0__mux2_1
X$11207 \$26341 \$25909 \$26401 \$26220 \$25736 gf180mcu_fd_sc_mcu9t5v0__or2_1
X$11208 \$26345 \$25909 \$25737 \$26088 \$25918 \$25962
+ gf180mcu_fd_sc_mcu9t5v0__oai21_1
X$11209 \$27003 \$25909 \$25737 \$26401 \$26220 \$25910
+ gf180mcu_fd_sc_mcu9t5v0__oai21_1
X$11210 \$27308 \$25909 \$27015 \$27153 \$25738 gf180mcu_fd_sc_mcu9t5v0__or2_1
X$11211 \$25741 \$27315 \$27153 \$26399 gf180mcu_fd_sc_mcu9t5v0__buf_8
X$11212 \$27908 \$26512 \$26399 \$26675 \$26521 \$25743
+ gf180mcu_fd_sc_mcu9t5v0__nor3_1
X$11213 \$26083 \$25744 \$26088 \$25918 \$26081 gf180mcu_fd_sc_mcu9t5v0__nand2_1
X$11214 \$25745 \$28529 \$28534 \$28689 \$28530 gf180mcu_fd_sc_mcu9t5v0__xnor2_1
X$11215 \$27152 \$25749 \$25745 \$28336 \$28211 \$28381 \$28377
+ gf180mcu_fd_sc_mcu9t5v0__nand4_1
X$11216 \$25745 \$27770 \$25749 \$28211 \$28381 \$28335
+ gf180mcu_fd_sc_mcu9t5v0__aoi21_1
X$11217 \$25745 \$27770 \$27771 \$27913 \$27776 \$27769
+ gf180mcu_fd_sc_mcu9t5v0__aoi21_1
X$11218 \$25745 \$27770 \$27444 \$27913 \$27776 \$27771
+ gf180mcu_fd_sc_mcu9t5v0__oai21_1
X$11219 \$26674 \$26518 \$25748 \$26401 \$26521 \$26516
+ gf180mcu_fd_sc_mcu9t5v0__aoi21_1
X$11220 \$25748 \$26674 \$26518 \$26675 \$26521 \$26355
+ gf180mcu_fd_sc_mcu9t5v0__nand3_1
X$11221 \$25748 \$27444 \$26401 \$26521 \$26086 gf180mcu_fd_sc_mcu9t5v0__nand2_1
X$11222 \$25749 \$28533 \$28685 \$28686 \$28534 \$28689 \$28531
+ gf180mcu_fd_sc_mcu9t5v0__aoi211_1
X$11223 \$28686 \$28685 \$25749 \$28810 \$28689 \$28532
+ gf180mcu_fd_sc_mcu9t5v0__oai21_1
X$11224 \$25749 \$27780 \$28481 \$28377 \$28534 \$28381 \$28334
+ gf180mcu_fd_sc_mcu9t5v0__aoi22_1
X$11225 \$25753 \$27444 \$26212 \$26402 \$26088 \$26220 \$26217
+ gf180mcu_fd_sc_mcu9t5v0__aoi211_1
X$11226 \$26218 \$26088 \$26220 \$25753 gf180mcu_fd_sc_mcu9t5v0__clkinv_1
X$11227 \$25798 \$26641 \$25797 \$25918 \$25755 gf180mcu_fd_sc_mcu9t5v0__nand2_1
X$11228 \$25798 \$26641 \$25797 \$25918 \$25756 gf180mcu_fd_sc_mcu9t5v0__or2_1
X$11229 \$30184 \$31735 \$31603 \$26969 \$31535 \$31584 \$25759
+ gf180mcu_fd_sc_mcu9t5v0__oai211_1
X$11230 \$25780 \$25946 \$25989 \$25797 \$25918 \$25817
+ gf180mcu_fd_sc_mcu9t5v0__nand3_1
X$11231 \$25780 \$25797 \$25918 \$25947 gf180mcu_fd_sc_mcu9t5v0__clkinv_1
X$11232 \$25783 \$26667 \$25797 \$25918 \$25949 \$25782
+ gf180mcu_fd_sc_mcu9t5v0__xnor3_1
X$11233 \$25783 \$25782 \$26088 \$25918 \$25784 gf180mcu_fd_sc_mcu9t5v0__nor2_1
X$11234 \$26119 \$26118 \$26088 \$25918 \$25786 gf180mcu_fd_sc_mcu9t5v0__nand2_1
X$11235 \$25954 \$25955 \$25797 \$25918 \$25791 gf180mcu_fd_sc_mcu9t5v0__nor2_1
X$11236 \$25954 \$25955 \$26088 \$25918 \$25792 gf180mcu_fd_sc_mcu9t5v0__nand2_1
X$11237 \$25908 \$25909 \$25797 \$25918 \$25911 gf180mcu_fd_sc_mcu9t5v0__or2_1
X$11238 \$26236 \$25811 \$25940 \$25797 \$25918 \$25812
+ gf180mcu_fd_sc_mcu9t5v0__and3_1
X$11239 \$25811 \$25940 \$26236 \$25797 \$25918 \$26110
+ gf180mcu_fd_sc_mcu9t5v0__aoi21_1
X$11240 \$25918 \$25797 gf180mcu_fd_sc_mcu9t5v0__filltie
X$11241 \$25918 \$25797 gf180mcu_fd_sc_mcu9t5v0__filltie
X$11242 \$25918 \$25797 gf180mcu_fd_sc_mcu9t5v0__filltie
X$11243 \$25918 \$25797 gf180mcu_fd_sc_mcu9t5v0__filltie
X$11244 \$25918 \$25797 gf180mcu_fd_sc_mcu9t5v0__filltie
X$11245 \$25918 \$25797 gf180mcu_fd_sc_mcu9t5v0__filltie
X$11246 \$25918 \$25797 gf180mcu_fd_sc_mcu9t5v0__endcap
X$11247 \$25918 \$25797 gf180mcu_fd_sc_mcu9t5v0__endcap
X$11248 \$27152 \$27013 \$27015 \$27153 \$25798 \$27314
+ gf180mcu_fd_sc_mcu9t5v0__xnor3_1
X$11249 \$25799 \$27637 \$27449 gf180mcu_fd_sc_mcu9t5v0__inv_4
X$11250 \$25799 \$25969 \$25924 \$26088 \$25918 gf180mcu_fd_sc_mcu9t5v0__dffq_2
X$11251 \$26404 \$26643 \$26675 \$26521 \$25800 gf180mcu_fd_sc_mcu9t5v0__nor2_1
X$11252 \$26408 \$25804 \$26526 \$26401 \$26521 \$26407
+ gf180mcu_fd_sc_mcu9t5v0__aoi21_1
X$11253 \$25805 \$26401 \$26521 \$I54573 gf180mcu_fd_sc_mcu9t5v0__clkinv_1
X$11254 \$25809 \$27468 \$27637 \$27449 \$27603 gf180mcu_fd_sc_mcu9t5v0__and2_1
X$11255 \$30351 \$30261 \$25809 \$30251 \$30339 \$30325
+ gf180mcu_fd_sc_mcu9t5v0__oai21_1
X$11256 \$30621 \$30482 \$25809 \$30696 \$30625 \$30711
+ gf180mcu_fd_sc_mcu9t5v0__oai21_1
X$11257 \$25809 \$27596 \$26412 \$27637 \$27776 \$28226
+ gf180mcu_fd_sc_mcu9t5v0__nand3_1
X$11258 \$25809 \$26870 \$26694 \$26675 \$26856 \$26824
+ gf180mcu_fd_sc_mcu9t5v0__nand3_1
X$11259 \$27588 \$25809 \$28534 \$28381 \$28505 gf180mcu_fd_sc_mcu9t5v0__nor2_1
X$11260 \$26827 \$25809 \$27015 \$26856 \$26660 gf180mcu_fd_sc_mcu9t5v0__nor2_1
X$11261 \$25809 \$27798 \$27913 \$28089 \$28100 gf180mcu_fd_sc_mcu9t5v0__nand2_1
X$11262 \$25809 \$28945 \$28810 \$28971 \$28982 gf180mcu_fd_sc_mcu9t5v0__nand2_1
X$11263 \$25809 \$27644 \$27637 \$27776 \$27786 gf180mcu_fd_sc_mcu9t5v0__nand2_1
X$11264 \$25809 \$30768 \$30819 \$30900 \$30903 gf180mcu_fd_sc_mcu9t5v0__nand2_1
X$11265 \$25809 \$30855 \$30819 \$30900 \$30856 gf180mcu_fd_sc_mcu9t5v0__nand2_1
X$11266 \$25809 \$30257 \$30251 \$30339 \$30321 gf180mcu_fd_sc_mcu9t5v0__nand2_1
X$11267 \$25809 \$30556 \$30564 \$30625 \$30630 gf180mcu_fd_sc_mcu9t5v0__nand2_1
X$11268 \$25809 \$27645 \$27913 \$27776 \$27930 gf180mcu_fd_sc_mcu9t5v0__nand2_1
X$11269 \$25809 \$30247 \$30564 \$30485 \$30481 gf180mcu_fd_sc_mcu9t5v0__nand2_1
X$11270 \$25809 \$27933 \$28211 \$28089 \$28351 gf180mcu_fd_sc_mcu9t5v0__nand2_1
X$11271 \$25809 \$28096 \$29123 \$28971 \$29099 gf180mcu_fd_sc_mcu9t5v0__nand2_1
X$11272 \$25809 \$26538 \$26675 \$26521 \$26822 gf180mcu_fd_sc_mcu9t5v0__nand2_1
X$11273 \$30412 \$30402 \$30339 \$25809 gf180mcu_fd_sc_mcu9t5v0__buf_8
X$11274 \$27336 \$27934 \$25809 \$27913 \$28089 \$28098
+ gf180mcu_fd_sc_mcu9t5v0__mux2_1
X$11275 \$26682 \$26654 \$25809 \$26675 \$26856 \$26863
+ gf180mcu_fd_sc_mcu9t5v0__mux2_1
X$11276 \$30037 \$30421 \$25809 \$30402 \$30339 \$30420
+ gf180mcu_fd_sc_mcu9t5v0__mux2_1
X$11277 \$29704 \$26241 \$25809 \$30054 \$30027 \$30067
+ gf180mcu_fd_sc_mcu9t5v0__mux2_1
X$11278 \$26638 \$25909 \$26675 \$26521 \$26207 gf180mcu_fd_sc_mcu9t5v0__or2_1
X$11279 \$27901 \$27564 \$26344 \$27637 \$27449 \$25909
+ gf180mcu_fd_sc_mcu9t5v0__aoi21_1
X$11280 \$25914 \$28810 \$28971 \$28965 gf180mcu_fd_sc_mcu9t5v0__clkinv_1
X$11281 \$30184 \$31801 \$31802 \$26969 \$31810 \$31733 \$25916
+ gf180mcu_fd_sc_mcu9t5v0__oai211_1
X$11282 \$25981 \$26088 \$25918 \$25980 gf180mcu_fd_sc_mcu9t5v0__clkinv_1
X$11283 \$26116 \$25988 \$26088 \$25918 \$25989 gf180mcu_fd_sc_mcu9t5v0__nand2_1
X$11284 \$26233 \$25938 \$26088 \$25918 \$26108 gf180mcu_fd_sc_mcu9t5v0__nand2_1
X$11285 \$25918 \$26088 gf180mcu_fd_sc_mcu9t5v0__filltie
X$11286 \$25918 \$26088 gf180mcu_fd_sc_mcu9t5v0__filltie
X$11287 \$25918 \$26088 gf180mcu_fd_sc_mcu9t5v0__filltie
X$11288 \$25918 \$26088 gf180mcu_fd_sc_mcu9t5v0__filltie
X$11289 \$25918 \$26088 gf180mcu_fd_sc_mcu9t5v0__filltie
X$11290 \$25918 \$26088 gf180mcu_fd_sc_mcu9t5v0__filltie
X$11291 \$25918 \$26088 gf180mcu_fd_sc_mcu9t5v0__endcap
X$11292 \$25918 \$26088 gf180mcu_fd_sc_mcu9t5v0__endcap
X$11293 \$27576 \$27315 \$27153 \$25920 \$25922 gf180mcu_fd_sc_mcu9t5v0__xor2_1
X$11294 \$28337 \$28211 \$28381 \$28930 \$25920 gf180mcu_fd_sc_mcu9t5v0__xor2_1
X$11295 \$27576 \$25920 \$27637 \$27449 \$27448 gf180mcu_fd_sc_mcu9t5v0__nand2_1
X$11296 \$26092 \$26359 \$25923 \$26401 \$26220 \$26361
+ gf180mcu_fd_sc_mcu9t5v0__and3_1
X$11297 \$27654 \$25930 \$27637 \$27776 \$27333 gf180mcu_fd_sc_mcu9t5v0__xnor2_1
X$11298 \$27654 \$25930 \$27637 \$27776 \$27460 gf180mcu_fd_sc_mcu9t5v0__and2_1
X$11299 \$25930 \$27913 \$27776 \$27793 gf180mcu_fd_sc_mcu9t5v0__clkinv_1
X$11300 \$27336 \$27637 \$27449 \$25931 \$27335 gf180mcu_fd_sc_mcu9t5v0__xor2_1
X$11301 \$27589 \$25931 \$27637 \$27449 \$27590 gf180mcu_fd_sc_mcu9t5v0__nor2_1
X$11302 \$27336 \$25931 \$27315 \$27153 \$27038 gf180mcu_fd_sc_mcu9t5v0__nand2_1
X$11303 \$27589 \$25931 \$27637 \$27449 \$27655 gf180mcu_fd_sc_mcu9t5v0__nand2_1
X$11304 \$25933 \$28947 \$30269 \$30251 \$30185 \$30248
+ gf180mcu_fd_sc_mcu9t5v0__or3_1
X$11305 \$25933 \$26870 \$26694 \$27015 \$26856 \$26871
+ gf180mcu_fd_sc_mcu9t5v0__nor3_1
X$11306 \$25933 \$27596 \$26412 \$27637 \$27449 \$27595
+ gf180mcu_fd_sc_mcu9t5v0__nor3_1
X$11307 \$30617 \$30479 \$25933 \$30564 \$30625 \$30618
+ gf180mcu_fd_sc_mcu9t5v0__aoi21_1
X$11308 \$26695 \$26826 \$25933 \$26675 \$26856 \$26659
+ gf180mcu_fd_sc_mcu9t5v0__aoi21_1
X$11309 \$27789 \$27788 \$25933 \$27913 \$27776 \$27931
+ gf180mcu_fd_sc_mcu9t5v0__aoi21_1
X$11310 \$25933 \$27646 \$27648 \$27649 \$27637 \$27776 \$27787
+ gf180mcu_fd_sc_mcu9t5v0__oai31_1
X$11311 \$25933 \$26105 \$26088 \$26220 \$26232 gf180mcu_fd_sc_mcu9t5v0__nor2_1
X$11312 \$25933 \$27662 \$28211 \$28089 \$28232 gf180mcu_fd_sc_mcu9t5v0__nor2_1
X$11313 \$30701 \$30700 \$30696 \$30625 \$25933 gf180mcu_fd_sc_mcu9t5v0__nand2_1
X$11314 \$27330 \$25933 \$27637 \$27449 \$27649 gf180mcu_fd_sc_mcu9t5v0__nand2_1
X$11315 \$26372 \$26088 \$26220 \$25937 gf180mcu_fd_sc_mcu9t5v0__clkinv_1
X$11316 \$26381 \$26380 \$26401 \$26220 \$25946 gf180mcu_fd_sc_mcu9t5v0__nand2_1
X$11317 \$25946 \$26116 \$26088 \$26220 \$26117 gf180mcu_fd_sc_mcu9t5v0__nand2_1
X$11318 \$25946 \$26088 \$26220 \$25990 gf180mcu_fd_sc_mcu9t5v0__clkinv_1
X$11319 \$25951 \$27015 \$26856 \$I54348 gf180mcu_fd_sc_mcu9t5v0__clkinv_1
X$11320 \$26119 \$26088 \$26220 \$26118 \$25952 gf180mcu_fd_sc_mcu9t5v0__xor2_1
X$11321 \$25958 \$26088 \$26220 \$26254 gf180mcu_fd_sc_mcu9t5v0__clkinv_1
X$11322 \$26095 \$26098 \$26088 \$26220 \$25972 gf180mcu_fd_sc_mcu9t5v0__nand2_1
X$11323 \$26231 \$26102 \$26088 \$26220 \$25978 gf180mcu_fd_sc_mcu9t5v0__and2_1
X$11324 \$25981 \$29109 \$29305 \$29274 \$29306 \$29709 \$29634 \$29720 \$30035
+ gf180mcu_fd_sc_mcu9t5v0__aoi222_1
X$11325 \$26999 \$27297 \$27298 \$27180 \$27315 \$27153 \$25988
+ gf180mcu_fd_sc_mcu9t5v0__oai31_1
X$11326 \$28040 \$27628 \$26847 \$27637 \$27776 \$26080
+ gf180mcu_fd_sc_mcu9t5v0__oai21_1
X$11327 \$26082 \$27315 \$27449 \$27310 gf180mcu_fd_sc_mcu9t5v0__buf_8
X$11328 \$26084 \$26350 \$26401 \$26220 \$26640 gf180mcu_fd_sc_mcu9t5v0__or2_1
X$11329 \$26084 \$26350 \$26401 \$26220 \$27275 gf180mcu_fd_sc_mcu9t5v0__nor2_1
X$11330 \$26087 \$26086 \$26212 \$26088 \$26220 \$26353
+ gf180mcu_fd_sc_mcu9t5v0__aoi21_1
X$11331 \$26516 \$26354 \$26517 \$26793 \$26401 \$26521 \$26087
+ gf180mcu_fd_sc_mcu9t5v0__oai211_1
X$11332 \$26356 \$26214 \$26088 \$26220 \$26216 gf180mcu_fd_sc_mcu9t5v0__nand2_1
X$11333 \$26220 \$26088 gf180mcu_fd_sc_mcu9t5v0__filltie
X$11334 \$26220 \$26088 gf180mcu_fd_sc_mcu9t5v0__filltie
X$11335 \$26220 \$26088 gf180mcu_fd_sc_mcu9t5v0__filltie
X$11336 \$26220 \$26088 gf180mcu_fd_sc_mcu9t5v0__filltie
X$11337 \$26220 \$26088 gf180mcu_fd_sc_mcu9t5v0__filltie
X$11338 \$26220 \$26088 gf180mcu_fd_sc_mcu9t5v0__filltie
X$11339 \$26220 \$26088 gf180mcu_fd_sc_mcu9t5v0__endcap
X$11340 \$26220 \$26088 gf180mcu_fd_sc_mcu9t5v0__endcap
X$11341 \$27635 \$27575 \$27637 \$27449 \$26089 \$27573
+ gf180mcu_fd_sc_mcu9t5v0__xnor3_1
X$11342 \$26089 \$27277 \$27015 \$27153 \$27018 gf180mcu_fd_sc_mcu9t5v0__xnor2_1
X$11343 \$28540 \$26092 \$27023 \$27022 \$27015 \$27153 \$27020
+ gf180mcu_fd_sc_mcu9t5v0__nor4_1
X$11344 \$26359 \$26404 \$26092 \$26401 \$26521 \$26523
+ gf180mcu_fd_sc_mcu9t5v0__aoi21_1
X$11345 \$26092 \$27281 \$26644 \$27315 \$27153 \$27318
+ gf180mcu_fd_sc_mcu9t5v0__nand3_1
X$11346 \$26092 \$26359 \$26401 \$26220 \$26360 gf180mcu_fd_sc_mcu9t5v0__nand2_1
X$11347 \$26094 \$30403 \$31233 \$31535 \$31465 \$31517
+ gf180mcu_fd_sc_mcu9t5v0__aoi21_1
X$11348 \$27330 \$27315 \$27449 \$26097 \$26812 gf180mcu_fd_sc_mcu9t5v0__xor2_1
X$11349 \$27328 \$26097 \$27637 \$27776 \$27647 gf180mcu_fd_sc_mcu9t5v0__nor2_1
X$11350 \$27330 \$26097 \$27315 \$27153 \$27288 gf180mcu_fd_sc_mcu9t5v0__nand2_1
X$11351 \$26231 \$26102 \$26401 \$26521 \$27039 gf180mcu_fd_sc_mcu9t5v0__xnor2_1
X$11352 \$26102 \$26401 \$26220 \$26367 gf180mcu_fd_sc_mcu9t5v0__clkinv_1
X$11353 \$27038 \$27163 \$27039 \$27015 \$27153 \$26103
+ gf180mcu_fd_sc_mcu9t5v0__aoi21_1
X$11354 \$27590 \$27796 \$27039 \$27655 \$27637 \$27449 \$26104
+ gf180mcu_fd_sc_mcu9t5v0__oai211_1
X$11355 \$26235 \$26109 \$26401 \$26521 \$26538 gf180mcu_fd_sc_mcu9t5v0__xnor2_1
X$11356 \$26235 \$26109 \$26413 \$26401 \$26220 \$26412
+ gf180mcu_fd_sc_mcu9t5v0__oai21_1
X$11357 \$26376 \$26414 \$26401 \$26220 \$26111 gf180mcu_fd_sc_mcu9t5v0__nor2_1
X$11358 \$26115 \$28381 \$28534 \$28230 gf180mcu_fd_sc_mcu9t5v0__clkbuf_16
X$11359 \$26381 \$26380 \$26401 \$26220 \$26116 gf180mcu_fd_sc_mcu9t5v0__or2_1
X$11360 \$29078 \$26211 \$27275 \$29123 \$28971 \$28967
+ gf180mcu_fd_sc_mcu9t5v0__nor3_1
X$11361 \$27312 \$27311 \$26212 \$27315 \$27449 \$27443
+ gf180mcu_fd_sc_mcu9t5v0__aoi21_1
X$11362 \$26212 \$26792 \$26675 \$26856 \$26854 gf180mcu_fd_sc_mcu9t5v0__nor2_1
X$11363 \$26212 \$28088 \$27913 \$27776 \$27911 gf180mcu_fd_sc_mcu9t5v0__nor2_1
X$11364 \$26354 \$26213 \$26355 \$26401 \$26220 \$26214
+ gf180mcu_fd_sc_mcu9t5v0__oai21_1
X$11365 \$26354 \$26213 \$26401 \$26220 \$26517 gf180mcu_fd_sc_mcu9t5v0__nand2_1
X$11366 \$26356 \$26214 \$26401 \$26220 \$26215 gf180mcu_fd_sc_mcu9t5v0__or2_1
X$11367 \$26216 \$26215 \$27444 \$26401 \$26521 \$26402
+ gf180mcu_fd_sc_mcu9t5v0__aoi21_1
X$11368 \$26386 \$26387 \$26401 \$26220 \$26422 \$26383
+ gf180mcu_fd_sc_mcu9t5v0__xor3_1
X$11369 \$27596 \$26237 \$26401 \$26220 \$26238 gf180mcu_fd_sc_mcu9t5v0__xnor2_1
X$11370 \$26236 \$26401 \$26220 \$26235 gf180mcu_fd_sc_mcu9t5v0__clkinv_1
X$11371 \$26359 \$26401 \$26220 \$26221 gf180mcu_fd_sc_mcu9t5v0__clkinv_1
X$11372 \$26244 \$26401 \$26220 \$26415 gf180mcu_fd_sc_mcu9t5v0__clkinv_1
X$11373 \$26369 \$26232 \$26401 \$26220 \$26534 gf180mcu_fd_sc_mcu9t5v0__nand2_1
X$11374 \$26231 \$26367 \$26401 \$26220 \$26368 gf180mcu_fd_sc_mcu9t5v0__nand2_1
X$11375 \$26220 \$26401 gf180mcu_fd_sc_mcu9t5v0__filltie
X$11376 \$26220 \$26401 gf180mcu_fd_sc_mcu9t5v0__filltie
X$11377 \$26220 \$26401 gf180mcu_fd_sc_mcu9t5v0__filltie
X$11378 \$26220 \$26401 gf180mcu_fd_sc_mcu9t5v0__filltie
X$11379 \$26220 \$26401 gf180mcu_fd_sc_mcu9t5v0__filltie
X$11380 \$26220 \$26401 gf180mcu_fd_sc_mcu9t5v0__filltie
X$11381 \$26220 \$26401 gf180mcu_fd_sc_mcu9t5v0__endcap
X$11382 \$26220 \$26401 gf180mcu_fd_sc_mcu9t5v0__endcap
X$11383 \$26221 \$26404 \$26401 \$26521 \$26403 gf180mcu_fd_sc_mcu9t5v0__xnor2_1
X$11384 \$26811 \$26810 \$26653 \$26675 \$26521 \$26225
+ gf180mcu_fd_sc_mcu9t5v0__and3_1
X$11385 \$29704 \$29954 \$29847 \$29707 \$26241 gf180mcu_fd_sc_mcu9t5v0__xor2_1
X$11386 \$29321 \$29444 \$29290 \$29270 \$26246 \$29446
+ gf180mcu_fd_sc_mcu9t5v0__xnor3_1
X$11387 \$26254 \$26253 \$26838 \$26839 \$26675 \$26856 \$26840
+ gf180mcu_fd_sc_mcu9t5v0__aoi22_1
X$11388 \$26339 \$28086 \$28211 \$28089 \$28207 gf180mcu_fd_sc_mcu9t5v0__nand2_1
X$11389 \$28206 \$28534 \$28689 \$26339 gf180mcu_fd_sc_mcu9t5v0__buf_8
X$11390 \$26351 \$26524 \$26644 \$26675 \$26521 \$26678
+ gf180mcu_fd_sc_mcu9t5v0__oai21_1
X$11391 \$26522 \$26403 \$26401 \$26521 \$26357 gf180mcu_fd_sc_mcu9t5v0__and2_1
X$11392 \$26361 \$26401 \$26521 \$26405 gf180mcu_fd_sc_mcu9t5v0__buf_8
X$11393 \$30550 \$30971 \$31032 \$26370 gf180mcu_fd_sc_mcu9t5v0__buf_8
X$11394 \$26372 \$29109 \$29305 \$29303 \$29306 \$29795 \$29290 \$29424 \$29439
+ gf180mcu_fd_sc_mcu9t5v0__aoi222_1
X$11395 \$26689 \$26401 \$26521 \$26373 gf180mcu_fd_sc_mcu9t5v0__clkinv_1
X$11396 \$26690 \$26375 \$26401 \$26521 \$26413 gf180mcu_fd_sc_mcu9t5v0__nand2_1
X$11397 \$26545 \$26420 \$26401 \$26521 \$26379 gf180mcu_fd_sc_mcu9t5v0__nor2_1
X$11398 \$26386 \$26422 \$26401 \$26521 \$26547 gf180mcu_fd_sc_mcu9t5v0__and2_1
X$11399 \$26386 \$26422 \$26401 \$26521 \$26546 gf180mcu_fd_sc_mcu9t5v0__or2_1
X$11400 \$26387 \$26546 \$26547 \$26675 \$26521 \$26667
+ gf180mcu_fd_sc_mcu9t5v0__aoi21_1
X$11401 \$26876 \$27056 \$27001 \$27015 \$26856 \$26387
+ gf180mcu_fd_sc_mcu9t5v0__oai21_1
X$11402 \$29331 \$29290 \$29270 \$26391 gf180mcu_fd_sc_mcu9t5v0__buf_8
X$11403 \$26391 \$28580 \$27809 \$28211 \$28381 \$28389
+ gf180mcu_fd_sc_mcu9t5v0__mux2_1
X$11404 \$26394 \$27015 \$26856 gf180mcu_fd_sc_mcu9t5v0__clkbuf_4
X$11405 \$28687 \$26400 \$27572 \$27636 \$27637 \$27776 \$27773
+ gf180mcu_fd_sc_mcu9t5v0__oai31_1
X$11406 \$28485 \$26400 \$28534 \$28689 \$28688 gf180mcu_fd_sc_mcu9t5v0__nand2_1
X$11407 \$26543 \$26419 \$26401 \$26521 \$26420 gf180mcu_fd_sc_mcu9t5v0__xnor2_1
X$11408 \$26687 \$26401 \$26521 \$26535 gf180mcu_fd_sc_mcu9t5v0__clkinv_1
X$11409 \$26513 \$26401 \$26521 \$26512 gf180mcu_fd_sc_mcu9t5v0__clkinv_1
X$11410 \$26526 \$26527 \$26401 \$26521 \$26528 gf180mcu_fd_sc_mcu9t5v0__nand2_1
X$11411 \$26521 \$26401 gf180mcu_fd_sc_mcu9t5v0__filltie
X$11412 \$26521 \$26401 gf180mcu_fd_sc_mcu9t5v0__filltie
X$11413 \$26521 \$26401 gf180mcu_fd_sc_mcu9t5v0__filltie
X$11414 \$26521 \$26401 gf180mcu_fd_sc_mcu9t5v0__filltie
X$11415 \$26521 \$26401 gf180mcu_fd_sc_mcu9t5v0__filltie
X$11416 \$26521 \$26401 gf180mcu_fd_sc_mcu9t5v0__filltie
X$11417 \$26521 \$26401 gf180mcu_fd_sc_mcu9t5v0__endcap
X$11418 \$26521 \$26401 gf180mcu_fd_sc_mcu9t5v0__endcap
X$11419 \$26405 \$30950 \$28496 \$30952 \$30971 \$30900 \$30953
+ gf180mcu_fd_sc_mcu9t5v0__nand4_1
X$11420 \$26405 \$28497 \$28693 \$28534 \$28689 \$28539
+ gf180mcu_fd_sc_mcu9t5v0__and3_1
X$11421 \$26405 \$30950 \$30951 \$30971 \$30900 \$28934
+ gf180mcu_fd_sc_mcu9t5v0__aoi21_1
X$11422 \$26405 \$27317 \$27919 \$27637 \$27776 \$27921
+ gf180mcu_fd_sc_mcu9t5v0__nand3_1
X$11423 \$26405 \$26975 \$27321 \$27315 \$27153 \$27025
+ gf180mcu_fd_sc_mcu9t5v0__nand3_1
X$11424 \$26405 \$28496 \$30819 \$30900 \$29239 gf180mcu_fd_sc_mcu9t5v0__nand2_1
X$11425 \$26405 \$27317 \$27637 \$27449 \$27639 gf180mcu_fd_sc_mcu9t5v0__nand2_1
X$11426 \$26408 \$27637 \$27449 \$27578 gf180mcu_fd_sc_mcu9t5v0__clkinv_1
X$11427 \$26652 \$26409 \$26675 \$26856 \$26811 gf180mcu_fd_sc_mcu9t5v0__xnor2_1
X$11428 \$26652 \$26409 \$27015 \$26856 \$26864 gf180mcu_fd_sc_mcu9t5v0__and2_1
X$11429 \$26409 \$27015 \$27153 \$27160 gf180mcu_fd_sc_mcu9t5v0__clkinv_1
X$11430 \$26417 \$27015 \$26856 gf180mcu_fd_sc_mcu9t5v0__inv_3
X$11431 \$26545 \$26420 \$26675 \$26521 \$26666 gf180mcu_fd_sc_mcu9t5v0__and2_1
X$11432 \$26511 \$28810 \$28971 \$28966 gf180mcu_fd_sc_mcu9t5v0__clkinv_2
X$11433 \$27908 \$26513 \$26675 \$26856 \$26789 gf180mcu_fd_sc_mcu9t5v0__nor2_1
X$11434 \$28487 \$28535 \$28534 \$28689 \$26518 gf180mcu_fd_sc_mcu9t5v0__nor2_1
X$11435 \$28686 \$26518 \$28534 \$28381 \$28529 gf180mcu_fd_sc_mcu9t5v0__nor2_1
X$11436 \$31732 \$31938 \$31804 \$26969 \$31810 \$31733 \$26519
+ gf180mcu_fd_sc_mcu9t5v0__oai211_1
X$11437 \$26682 \$26675 \$26521 \$26650 \$26654 gf180mcu_fd_sc_mcu9t5v0__xor2_1
X$11438 \$26812 \$26864 \$26685 \$26675 \$26521 \$26655
+ gf180mcu_fd_sc_mcu9t5v0__or3_1
X$11439 \$26831 \$26870 \$26828 \$26675 \$26521 \$26664
+ gf180mcu_fd_sc_mcu9t5v0__nand3_1
X$11440 \$26682 \$26651 \$26675 \$26521 \$26983 gf180mcu_fd_sc_mcu9t5v0__nand2_1
X$11441 \$26682 \$26650 \$26675 \$26521 \$26686 gf180mcu_fd_sc_mcu9t5v0__nand2_1
X$11442 \$26696 \$26662 \$26675 \$26521 \$26832 gf180mcu_fd_sc_mcu9t5v0__nand2_1
X$11443 \$26521 \$26675 gf180mcu_fd_sc_mcu9t5v0__filltie
X$11444 \$26521 \$26675 gf180mcu_fd_sc_mcu9t5v0__filltie
X$11445 \$26521 \$26675 gf180mcu_fd_sc_mcu9t5v0__filltie
X$11446 \$26521 \$26675 gf180mcu_fd_sc_mcu9t5v0__filltie
X$11447 \$26521 \$26675 gf180mcu_fd_sc_mcu9t5v0__filltie
X$11448 \$26521 \$26675 gf180mcu_fd_sc_mcu9t5v0__filltie
X$11449 \$26521 \$26675 gf180mcu_fd_sc_mcu9t5v0__endcap
X$11450 \$26521 \$26675 gf180mcu_fd_sc_mcu9t5v0__endcap
X$11451 \$26977 \$28687 \$26642 \$27637 \$27449 \$26522
+ gf180mcu_fd_sc_mcu9t5v0__oai21_1
X$11452 \$26522 \$28045 \$27913 \$28089 \$28090 gf180mcu_fd_sc_mcu9t5v0__nand2_1
X$11453 \$26522 \$29086 \$29123 \$28971 \$28933 gf180mcu_fd_sc_mcu9t5v0__nand2_1
X$11454 \$26642 \$26802 \$26523 \$26675 \$26856 \$26801
+ gf180mcu_fd_sc_mcu9t5v0__aoi21_1
X$11455 \$26526 \$26675 \$26856 \$26860 gf180mcu_fd_sc_mcu9t5v0__clkinv_1
X$11456 \$28051 \$28211 \$28089 \$26526 gf180mcu_fd_sc_mcu9t5v0__buf_8
X$11457 \$28698 \$28818 \$28817 \$28810 \$28689 \$26527
+ gf180mcu_fd_sc_mcu9t5v0__nand3_1
X$11458 \$26984 \$26686 \$26675 \$26856 \$26529 gf180mcu_fd_sc_mcu9t5v0__xnor2_1
X$11459 \$28059 \$28211 \$28089 \$28102 \$26536 gf180mcu_fd_sc_mcu9t5v0__xor2_1
X$11460 \$27164 \$27462 \$27315 \$27449 \$26537 gf180mcu_fd_sc_mcu9t5v0__nor2_1
X$11461 \$28946 \$29123 \$29270 \$26539 \$29279 gf180mcu_fd_sc_mcu9t5v0__xor2_1
X$11462 \$28946 \$26539 \$28810 \$28971 \$28837 gf180mcu_fd_sc_mcu9t5v0__nand2_1
X$11463 \$26539 \$28810 \$28689 \$28836 gf180mcu_fd_sc_mcu9t5v0__clkinv_1
X$11464 \$26999 \$27053 \$27015 \$26856 \$26541 gf180mcu_fd_sc_mcu9t5v0__xnor2_1
X$11465 \$27295 \$27179 \$27048 \$27015 \$27153 \$26545
+ gf180mcu_fd_sc_mcu9t5v0__aoi21_1
X$11466 \$27184 \$27673 \$27637 \$27776 \$26548 \$27614
+ gf180mcu_fd_sc_mcu9t5v0__xnor3_1
X$11467 \$26674 \$27016 \$27015 \$27153 \$26641 gf180mcu_fd_sc_mcu9t5v0__nor2_1
X$11468 \$26857 \$26803 \$26644 \$26675 \$26856 \$26679
+ gf180mcu_fd_sc_mcu9t5v0__oai21_1
X$11469 \$26645 \$27917 \$27921 \$27913 \$28089 \$28091
+ gf180mcu_fd_sc_mcu9t5v0__nor3_1
X$11470 \$27923 \$27921 \$28047 \$26645 \$27913 \$28089 \$28048
+ gf180mcu_fd_sc_mcu9t5v0__oai22_1
X$11471 \$26977 \$27913 \$27776 \$26645 gf180mcu_fd_sc_mcu9t5v0__clkinv_1
X$11472 \$28049 \$26645 \$28211 \$28089 \$27285 gf180mcu_fd_sc_mcu9t5v0__nand2_1
X$11473 \$26646 \$26979 \$27015 \$26856 \$27028 gf180mcu_fd_sc_mcu9t5v0__or2_1
X$11474 \$26682 \$26650 \$26984 \$27015 \$26856 \$26653
+ gf180mcu_fd_sc_mcu9t5v0__nand3_1
X$11475 \$26650 \$26675 \$26856 \$26862 gf180mcu_fd_sc_mcu9t5v0__clkinv_1
X$11476 \$27328 \$26651 \$27457 \$27315 \$27449 \$27458
+ gf180mcu_fd_sc_mcu9t5v0__aoi21_1
X$11477 \$26651 \$28346 \$28349 \$28211 \$28381 \$28348
+ gf180mcu_fd_sc_mcu9t5v0__oai21_1
X$11478 \$26651 \$28977 \$29098 \$29123 \$28971 \$29097
+ gf180mcu_fd_sc_mcu9t5v0__oai21_1
X$11479 \$26651 \$26982 \$26983 \$27015 \$26856 \$26807
+ gf180mcu_fd_sc_mcu9t5v0__oai21_1
X$11480 \$30974 \$31019 \$26651 \$30971 \$31032 \$31037
+ gf180mcu_fd_sc_mcu9t5v0__oai21_1
X$11481 \$27164 \$26651 \$28708 \$27292 \$27315 \$27153 \$27339
+ gf180mcu_fd_sc_mcu9t5v0__aoi22_1
X$11482 \$27654 \$26651 \$28810 \$28971 \$29098 gf180mcu_fd_sc_mcu9t5v0__nand2_1
X$11483 \$27588 \$26651 \$28211 \$28381 \$28349 gf180mcu_fd_sc_mcu9t5v0__nand2_1
X$11484 \$26651 \$30971 \$31032 \$30972 gf180mcu_fd_sc_mcu9t5v0__clkinv_1
X$11485 \$31014 \$30971 \$31032 \$26651 gf180mcu_fd_sc_mcu9t5v0__buf_8
X$11486 \$26652 \$27160 \$27315 \$27449 \$27585 gf180mcu_fd_sc_mcu9t5v0__nand2_1
X$11487 \$26810 \$26653 \$26811 \$26675 \$26856 \$26685
+ gf180mcu_fd_sc_mcu9t5v0__aoi21_1
X$11488 \$26827 \$27015 \$26856 \$26661 gf180mcu_fd_sc_mcu9t5v0__clkinv_1
X$11489 \$26995 \$26830 \$27015 \$26856 \$26662 gf180mcu_fd_sc_mcu9t5v0__nor2_1
X$11490 \$26831 \$26828 \$26870 \$26675 \$26856 \$26663
+ gf180mcu_fd_sc_mcu9t5v0__aoi21_1
X$11491 \$28370 \$28372 \$28211 \$28381 \$26671 gf180mcu_fd_sc_mcu9t5v0__or2_1
X$11492 \$26672 \$26851 \$27015 \$26856 \$26849 gf180mcu_fd_sc_mcu9t5v0__nor2_1
X$11493 \$26674 \$28685 \$28535 \$28534 \$28689 \$27277
+ gf180mcu_fd_sc_mcu9t5v0__nor3_1
X$11494 \$26674 \$28487 \$28535 \$28534 \$28689 \$27576
+ gf180mcu_fd_sc_mcu9t5v0__nor3_1
X$11495 \$26674 \$28487 \$28533 \$28534 \$28381 \$27279
+ gf180mcu_fd_sc_mcu9t5v0__nor3_1
X$11496 \$26674 \$29232 \$27573 \$29123 \$29270 \$29236
+ gf180mcu_fd_sc_mcu9t5v0__and3_1
X$11497 \$26674 \$29124 \$29123 \$29270 \$29125 gf180mcu_fd_sc_mcu9t5v0__nor2_1
X$11498 \$26674 \$29123 \$28971 \$28686 gf180mcu_fd_sc_mcu9t5v0__clkinv_1
X$11499 \$26696 \$26872 \$26675 \$26856 \$26826 gf180mcu_fd_sc_mcu9t5v0__or2_1
X$11500 \$26798 \$26799 \$26677 \$26675 \$26856 \$26676
+ gf180mcu_fd_sc_mcu9t5v0__oai21_1
X$11501 \$26995 \$26830 \$26829 \$26675 \$26856 \$26831
+ gf180mcu_fd_sc_mcu9t5v0__oai21_1
X$11502 \$26864 \$26685 \$26812 \$26675 \$26856 \$26865
+ gf180mcu_fd_sc_mcu9t5v0__oai21_1
X$11503 \$26791 \$26675 \$26856 \$26850 gf180mcu_fd_sc_mcu9t5v0__clkinv_1
X$11504 \$26829 \$26675 \$26856 \$26696 gf180mcu_fd_sc_mcu9t5v0__clkinv_1
X$11505 \$26692 \$26869 \$26675 \$26856 \$26870 gf180mcu_fd_sc_mcu9t5v0__nand2_1
X$11506 \$26978 \$27782 \$26675 \$26856 \$26859 gf180mcu_fd_sc_mcu9t5v0__nand2_1
X$11507 \$26856 \$26675 gf180mcu_fd_sc_mcu9t5v0__filltie
X$11508 \$26856 \$26675 gf180mcu_fd_sc_mcu9t5v0__filltie
X$11509 \$26856 \$26675 gf180mcu_fd_sc_mcu9t5v0__filltie
X$11510 \$26856 \$26675 gf180mcu_fd_sc_mcu9t5v0__filltie
X$11511 \$26856 \$26675 gf180mcu_fd_sc_mcu9t5v0__filltie
X$11512 \$26856 \$26675 gf180mcu_fd_sc_mcu9t5v0__filltie
X$11513 \$26856 \$26675 gf180mcu_fd_sc_mcu9t5v0__endcap
X$11514 \$26856 \$26675 gf180mcu_fd_sc_mcu9t5v0__endcap
X$11515 \$27021 \$26975 \$26678 \$27015 \$26856 \$26804
+ gf180mcu_fd_sc_mcu9t5v0__nand3_1
X$11516 \$27652 \$27637 \$27776 \$26681 \$27035 gf180mcu_fd_sc_mcu9t5v0__xor2_1
X$11517 \$27652 \$26681 \$27637 \$27776 \$27332 gf180mcu_fd_sc_mcu9t5v0__nand2_1
X$11518 \$26681 \$27637 \$27776 \$27792 gf180mcu_fd_sc_mcu9t5v0__clkinv_1
X$11519 \$26682 \$26862 \$27015 \$26856 \$26985 gf180mcu_fd_sc_mcu9t5v0__nor2_1
X$11520 \$29646 \$29308 \$29109 \$26687 \$29305 \$28705 \$29634 \$29424 \$29540
+ gf180mcu_fd_sc_mcu9t5v0__aoi222_1
X$11521 \$26689 \$29109 \$29244 \$29123 \$29270 \$29243
+ gf180mcu_fd_sc_mcu9t5v0__aoi21_1
X$11522 \$26691 \$27015 \$26856 \$26823 gf180mcu_fd_sc_mcu9t5v0__clkinv_1
X$11523 \$26696 \$26872 \$27015 \$26856 \$26695 gf180mcu_fd_sc_mcu9t5v0__nand2_1
X$11524 \$26789 \$27309 \$27310 \$27315 \$27449 \$27441
+ gf180mcu_fd_sc_mcu9t5v0__aoi21_1
X$11525 \$26789 \$27309 \$27315 \$27449 \$27440 gf180mcu_fd_sc_mcu9t5v0__nand2_1
X$11526 \$27770 \$26793 \$28208 \$28211 \$28089 \$28209
+ gf180mcu_fd_sc_mcu9t5v0__nor3_1
X$11527 \$26855 \$27010 \$26793 \$27015 \$26856 \$26794
+ gf180mcu_fd_sc_mcu9t5v0__oai21_1
X$11528 \$26793 \$27151 \$27633 \$27637 \$27449 \$27311
+ gf180mcu_fd_sc_mcu9t5v0__nand3_1
X$11529 \$27780 \$28481 \$28534 \$28381 \$26793 gf180mcu_fd_sc_mcu9t5v0__nor2_1
X$11530 \$27576 \$26793 \$28211 \$28089 \$28210 gf180mcu_fd_sc_mcu9t5v0__nand2_1
X$11531 \$26793 \$27315 \$27449 \$27444 gf180mcu_fd_sc_mcu9t5v0__clkinv_1
X$11532 \$26796 \$27015 \$26856 \$29946 gf180mcu_fd_sc_mcu9t5v0__buf_8
X$11533 \$26972 \$27018 \$27015 \$26856 \$26797 gf180mcu_fd_sc_mcu9t5v0__nand2_1
X$11534 \$26972 \$27018 \$27015 \$26856 \$26798 gf180mcu_fd_sc_mcu9t5v0__nor2_1
X$11535 \$31373 \$31374 \$31376 \$31310 \$26800 gf180mcu_fd_sc_mcu9t5v0__xnor2_1
X$11536 \$26802 \$26973 \$27015 \$26856 \$26974 gf180mcu_fd_sc_mcu9t5v0__and2_1
X$11537 \$26977 \$26978 \$26858 \$27015 \$26856 \$26803
+ gf180mcu_fd_sc_mcu9t5v0__aoi21_1
X$11538 \$27155 \$26804 \$27015 \$26856 \$27026 gf180mcu_fd_sc_mcu9t5v0__or2_1
X$11539 \$27155 \$26804 \$27015 \$27153 \$27781 gf180mcu_fd_sc_mcu9t5v0__nor2_1
X$11540 \$26806 \$30470 \$30486 \$30469 \$30402 \$30485 \$29429
+ gf180mcu_fd_sc_mcu9t5v0__nor4_1
X$11541 \$26806 \$27323 \$27637 \$27776 \$27642 gf180mcu_fd_sc_mcu9t5v0__nand2_1
X$11542 \$26806 \$29634 \$29720 \$27155 gf180mcu_fd_sc_mcu9t5v0__clkinv_1
X$11543 \$28055 \$27927 \$27913 \$28089 \$26809 gf180mcu_fd_sc_mcu9t5v0__xnor2_1
X$11544 \$27286 \$27030 \$27315 \$27153 \$26810 gf180mcu_fd_sc_mcu9t5v0__nand2_1
X$11545 \$26811 \$27637 \$27449 \$27584 \$27645 gf180mcu_fd_sc_mcu9t5v0__xor2_1
X$11546 \$27583 \$27287 \$26811 \$27637 \$27776 \$27586
+ gf180mcu_fd_sc_mcu9t5v0__oai21_1
X$11547 \$26812 \$27585 \$27586 \$27637 \$27449 \$27648
+ gf180mcu_fd_sc_mcu9t5v0__and3_1
X$11548 \$27585 \$27586 \$26812 \$27637 \$27449 \$27646
+ gf180mcu_fd_sc_mcu9t5v0__aoi21_1
X$11549 \$27033 \$27288 \$26865 \$27015 \$27153 \$26814
+ gf180mcu_fd_sc_mcu9t5v0__and3_1
X$11550 \$27461 \$27315 \$27449 \$27337 \$26819 gf180mcu_fd_sc_mcu9t5v0__xor2_1
X$11551 \$28707 \$28830 \$28810 \$28689 \$26821 gf180mcu_fd_sc_mcu9t5v0__xnor2_1
X$11552 \$26823 \$27464 \$27044 \$27043 \$27015 \$27153 \$27168
+ gf180mcu_fd_sc_mcu9t5v0__aoi22_1
X$11553 \$26827 \$27598 \$27600 \$27637 \$27449 \$27170
+ gf180mcu_fd_sc_mcu9t5v0__mux2_1
X$11554 \$27470 \$27343 \$27342 \$27315 \$27449 \$26830
+ gf180mcu_fd_sc_mcu9t5v0__aoi21_1
X$11555 \$26839 \$26838 \$27305 \$27061 \$27015 \$27153 \$27062
+ gf180mcu_fd_sc_mcu9t5v0__oai22_1
X$11556 \$28518 \$28534 \$28381 \$26839 gf180mcu_fd_sc_mcu9t5v0__clkinv_1
X$11557 \$27188 \$27062 \$26840 \$27015 \$26856 \$26881
+ gf180mcu_fd_sc_mcu9t5v0__oai21_1
X$11558 \$27011 \$27151 \$27012 \$27015 \$27153 \$26855
+ gf180mcu_fd_sc_mcu9t5v0__aoi21_1
X$11559 \$26857 \$26976 \$27015 \$26856 \$26973 gf180mcu_fd_sc_mcu9t5v0__nor2_1
X$11560 \$27152 \$27314 \$27015 \$26856 \$26970 gf180mcu_fd_sc_mcu9t5v0__nor2_1
X$11561 \$26977 \$26978 \$27015 \$26856 \$27919 gf180mcu_fd_sc_mcu9t5v0__nand2_1
X$11562 \$26856 \$27015 gf180mcu_fd_sc_mcu9t5v0__filltie
X$11563 \$26856 \$27015 gf180mcu_fd_sc_mcu9t5v0__filltie
X$11564 \$26856 \$27015 gf180mcu_fd_sc_mcu9t5v0__filltie
X$11565 \$26856 \$27015 gf180mcu_fd_sc_mcu9t5v0__filltie
X$11566 \$26856 \$27015 gf180mcu_fd_sc_mcu9t5v0__filltie
X$11567 \$26856 \$27015 gf180mcu_fd_sc_mcu9t5v0__filltie
X$11568 \$26856 \$27015 gf180mcu_fd_sc_mcu9t5v0__endcap
X$11569 \$26856 \$27015 gf180mcu_fd_sc_mcu9t5v0__endcap
X$11570 \$28049 \$27919 \$26857 \$27913 \$28089 \$28047
+ gf180mcu_fd_sc_mcu9t5v0__aoi21_1
X$11571 \$27780 \$27919 \$26857 \$27913 \$27776 \$27920
+ gf180mcu_fd_sc_mcu9t5v0__aoi21_1
X$11572 \$28049 \$28687 \$30251 \$30339 \$26857 gf180mcu_fd_sc_mcu9t5v0__nor2_1
X$11573 \$26857 \$29693 \$30564 \$30485 \$30563 gf180mcu_fd_sc_mcu9t5v0__nor2_1
X$11574 \$30184 \$26857 \$30564 \$30625 \$30624 gf180mcu_fd_sc_mcu9t5v0__nand2_1
X$11575 \$30468 \$26857 \$30402 \$30485 \$30484 gf180mcu_fd_sc_mcu9t5v0__nand2_1
X$11576 \$27024 \$27025 \$26858 \$27015 \$27153 \$26976
+ gf180mcu_fd_sc_mcu9t5v0__aoi21_1
X$11577 \$28493 \$26858 \$28534 \$28381 \$28543 gf180mcu_fd_sc_mcu9t5v0__nor2_1
X$11578 \$27288 \$26865 \$27033 \$27315 \$27153 \$27034
+ gf180mcu_fd_sc_mcu9t5v0__aoi21_1
X$11579 \$27055 \$26876 \$27015 \$27153 \$27000 \$27347
+ gf180mcu_fd_sc_mcu9t5v0__xnor3_1
X$11580 \$27941 \$28514 \$27913 \$28089 \$26876 gf180mcu_fd_sc_mcu9t5v0__nand2_1
X$11581 \$26879 \$27015 \$27153 \$27187 gf180mcu_fd_sc_mcu9t5v0__clkinv_1
X$11582 \$30468 \$26969 \$30564 \$30485 \$27910 gf180mcu_fd_sc_mcu9t5v0__and2_1
X$11583 \$30468 \$26969 \$30402 \$30485 \$30677 gf180mcu_fd_sc_mcu9t5v0__nor2_1
X$11584 \$30184 \$31512 \$31400 \$26969 \$31376 \$31465 \$27019
+ gf180mcu_fd_sc_mcu9t5v0__oai211_1
X$11585 \$27020 \$27015 \$27153 \$26969 gf180mcu_fd_sc_mcu9t5v0__buf_8
X$11586 \$27448 \$27278 \$27577 \$27315 \$27449 \$26972
+ gf180mcu_fd_sc_mcu9t5v0__oai21_1
X$11587 \$28489 \$27320 \$27924 \$27921 \$26974 \$27913 \$28089 \$28495
+ gf180mcu_fd_sc_mcu9t5v0__oai221_1
X$11588 \$26974 \$27320 \$28338 \$28211 \$28381 \$28494
+ gf180mcu_fd_sc_mcu9t5v0__nand3_1
X$11589 \$27322 \$26977 \$27015 \$27153 \$26975 gf180mcu_fd_sc_mcu9t5v0__nor2_2
X$11590 \$26975 \$27321 \$27778 \$27315 \$27449 \$27320
+ gf180mcu_fd_sc_mcu9t5v0__nand3_1
X$11591 \$26975 \$27284 \$27315 \$27153 \$27283 gf180mcu_fd_sc_mcu9t5v0__nand2_1
X$11592 \$26977 \$27923 \$27782 \$27913 \$27776 \$27924
+ gf180mcu_fd_sc_mcu9t5v0__nand3_1
X$11593 \$26977 \$27321 \$28534 \$28381 \$28497 gf180mcu_fd_sc_mcu9t5v0__nor2_1
X$11594 \$26978 \$27027 \$27155 \$26979 \$27015 \$27153 \$27029
+ gf180mcu_fd_sc_mcu9t5v0__aoi211_4
X$11595 \$28382 \$28055 \$27324 \$26981 \$28211 \$28381 \$28345
+ gf180mcu_fd_sc_mcu9t5v0__nor4_1
X$11596 \$26981 \$28702 \$27324 \$27315 \$27153 \$27326
+ gf180mcu_fd_sc_mcu9t5v0__aoi21_1
X$11597 \$27324 \$26981 \$28702 \$27913 \$27776 \$27927
+ gf180mcu_fd_sc_mcu9t5v0__oai21_1
X$11598 \$28055 \$27324 \$26981 \$28702 \$27913 \$28089 \$28215
+ gf180mcu_fd_sc_mcu9t5v0__oai31_1
X$11599 \$27324 \$26981 \$28702 \$27315 \$27449 \$27455
+ gf180mcu_fd_sc_mcu9t5v0__nand3_1
X$11600 \$27286 \$27315 \$27153 \$27030 \$26984 gf180mcu_fd_sc_mcu9t5v0__xor2_1
X$11601 \$26984 \$26985 \$27315 \$27449 \$27644 gf180mcu_fd_sc_mcu9t5v0__xnor2_1
X$11602 \$26984 \$26985 \$27315 \$27153 \$27287 gf180mcu_fd_sc_mcu9t5v0__nor2_1
X$11603 \$27036 \$27290 \$27315 \$27153 \$26987 gf180mcu_fd_sc_mcu9t5v0__nand2_1
X$11604 \$28978 \$28810 \$28689 \$28827 \$26991 gf180mcu_fd_sc_mcu9t5v0__xor2_1
X$11605 \$26994 \$29308 \$29306 \$30557 \$29305 \$29726 \$29780 \$29847 \$29862
+ gf180mcu_fd_sc_mcu9t5v0__aoi222_1
X$11606 \$27052 \$27051 \$27015 \$27153 \$26999 gf180mcu_fd_sc_mcu9t5v0__xnor2_1
X$11607 \$27055 \$27347 \$27015 \$27153 \$27001 gf180mcu_fd_sc_mcu9t5v0__nand2_1
X$11608 \$27005 \$27913 \$27776 \$I54461 gf180mcu_fd_sc_mcu9t5v0__clkinv_1
X$11609 \$27008 \$28534 \$28381 \$28527 gf180mcu_fd_sc_mcu9t5v0__clkinv_1
X$11610 \$27012 \$27011 \$27151 \$27015 \$27153 \$27010
+ gf180mcu_fd_sc_mcu9t5v0__and3_1
X$11611 \$27314 \$27277 \$27315 \$27153 \$27011 gf180mcu_fd_sc_mcu9t5v0__nand2_1
X$11612 \$27011 \$27313 \$27315 \$27449 \$27446 gf180mcu_fd_sc_mcu9t5v0__nand2_1
X$11613 \$27575 \$27316 \$27574 \$27315 \$27449 \$27013
+ gf180mcu_fd_sc_mcu9t5v0__aoi21_1
X$11614 \$27152 \$27314 \$27315 \$27153 \$27014 gf180mcu_fd_sc_mcu9t5v0__nand2_1
X$11615 \$27039 \$27038 \$27163 \$27015 \$27153 \$27040
+ gf180mcu_fd_sc_mcu9t5v0__and3_1
X$11616 \$27289 \$27034 \$27035 \$27015 \$27153 \$27036
+ gf180mcu_fd_sc_mcu9t5v0__oai21_1
X$11617 \$27297 \$27298 \$27015 \$27153 \$27053 gf180mcu_fd_sc_mcu9t5v0__nor2_1
X$11618 \$27340 \$27015 \$27153 \$27171 gf180mcu_fd_sc_mcu9t5v0__clkinv_1
X$11619 \$27277 \$27015 \$27153 \$27017 gf180mcu_fd_sc_mcu9t5v0__clkinv_1
X$11620 \$27052 \$27051 \$27015 \$27153 \$27180 gf180mcu_fd_sc_mcu9t5v0__nand2_1
X$11621 \$27153 \$27015 gf180mcu_fd_sc_mcu9t5v0__filltie
X$11622 \$27153 \$27015 gf180mcu_fd_sc_mcu9t5v0__filltie
X$11623 \$27153 \$27015 gf180mcu_fd_sc_mcu9t5v0__filltie
X$11624 \$27153 \$27015 gf180mcu_fd_sc_mcu9t5v0__filltie
X$11625 \$27153 \$27015 gf180mcu_fd_sc_mcu9t5v0__filltie
X$11626 \$27153 \$27015 gf180mcu_fd_sc_mcu9t5v0__filltie
X$11627 \$27153 \$27015 gf180mcu_fd_sc_mcu9t5v0__endcap
X$11628 \$27153 \$27015 gf180mcu_fd_sc_mcu9t5v0__endcap
X$11629 \$27573 \$29123 \$29270 \$27016 \$29237 gf180mcu_fd_sc_mcu9t5v0__xor2_1
X$11630 \$27016 \$28378 \$29123 \$28971 \$29124 gf180mcu_fd_sc_mcu9t5v0__nor2_1
X$11631 \$28487 \$28535 \$29123 \$28971 \$27016 gf180mcu_fd_sc_mcu9t5v0__nand2_1
X$11632 \$27023 \$28492 \$28534 \$28381 \$27021 gf180mcu_fd_sc_mcu9t5v0__nand2_1
X$11633 \$27022 \$27318 \$27315 \$27449 \$27317 gf180mcu_fd_sc_mcu9t5v0__nor2_1
X$11634 \$28811 \$28810 \$28689 \$27023 gf180mcu_fd_sc_mcu9t5v0__clkinv_1
X$11635 \$27024 \$27283 \$27315 \$27153 \$27450 gf180mcu_fd_sc_mcu9t5v0__nand2_1
X$11636 \$27028 \$27315 \$27153 \$27323 gf180mcu_fd_sc_mcu9t5v0__clkinv_1
X$11637 \$28094 \$27029 \$28820 \$28810 \$28971 \$29296
+ gf180mcu_fd_sc_mcu9t5v0__and3_4
X$11638 \$28094 \$27029 \$28820 \$28810 \$28971 \$29094
+ gf180mcu_fd_sc_mcu9t5v0__nand3_2
X$11639 \$28056 \$27029 \$27913 \$28089 \$28095 gf180mcu_fd_sc_mcu9t5v0__nor2_1
X$11640 \$28094 \$27029 \$28534 \$28689 \$28551 gf180mcu_fd_sc_mcu9t5v0__nand2_1
X$11641 \$27459 \$27030 \$27315 \$27449 \$27583 gf180mcu_fd_sc_mcu9t5v0__nor2_1
X$11642 \$27588 \$27031 \$27637 \$27449 \$27033 gf180mcu_fd_sc_mcu9t5v0__xnor2_1
X$11643 \$27588 \$27031 \$27315 \$27449 \$27289 gf180mcu_fd_sc_mcu9t5v0__and2_1
X$11644 \$27031 \$27637 \$27449 \$27651 gf180mcu_fd_sc_mcu9t5v0__clkinv_1
X$11645 \$27033 \$27647 \$27646 \$27637 \$27776 \$27788
+ gf180mcu_fd_sc_mcu9t5v0__or3_1
X$11646 \$27647 \$27646 \$27033 \$27913 \$27776 \$27789
+ gf180mcu_fd_sc_mcu9t5v0__oai21_1
X$11647 \$27035 \$27289 \$27034 \$27315 \$27153 \$27290
+ gf180mcu_fd_sc_mcu9t5v0__or3_1
X$11648 \$27035 \$27913 \$27776 \$27932 \$27933 gf180mcu_fd_sc_mcu9t5v0__xor2_1
X$11649 \$27790 \$27789 \$27035 \$27913 \$27776 \$27791
+ gf180mcu_fd_sc_mcu9t5v0__aoi21_1
X$11650 \$27333 \$27332 \$27036 \$27315 \$27449 \$27334
+ gf180mcu_fd_sc_mcu9t5v0__and3_1
X$11651 \$27332 \$27036 \$27333 \$27315 \$27449 \$27331
+ gf180mcu_fd_sc_mcu9t5v0__aoi21_1
X$11652 \$27039 \$27637 \$27776 \$27656 \$27798 gf180mcu_fd_sc_mcu9t5v0__xor2_1
X$11653 \$27464 \$29276 \$29123 \$28971 \$27043 gf180mcu_fd_sc_mcu9t5v0__nor2_1
X$11654 \$27474 \$27296 \$27315 \$27449 \$27048 gf180mcu_fd_sc_mcu9t5v0__nor2_1
X$11655 \$27474 \$27296 \$27315 \$27153 \$27049 gf180mcu_fd_sc_mcu9t5v0__xnor2_1
X$11656 \$27055 \$27347 \$27315 \$27153 \$27056 gf180mcu_fd_sc_mcu9t5v0__nor2_1
X$11657 \$28079 \$27913 \$28089 \$27061 gf180mcu_fd_sc_mcu9t5v0__clkinv_1
X$11658 \$27061 \$27305 \$27350 \$27187 \$27315 \$27153 \$27188
+ gf180mcu_fd_sc_mcu9t5v0__aoi22_1
X$11659 \$27150 \$27913 \$28089 \$29266 gf180mcu_fd_sc_mcu9t5v0__buf_8
X$11660 \$27313 \$27568 \$27315 \$27449 \$27151 gf180mcu_fd_sc_mcu9t5v0__nand2_1
X$11661 \$27152 \$28528 \$28336 \$28534 \$28381 \$27770
+ gf180mcu_fd_sc_mcu9t5v0__and3_1
X$11662 \$28528 \$28336 \$27152 \$28534 \$28381 \$28208
+ gf180mcu_fd_sc_mcu9t5v0__aoi21_1
X$11663 \$28685 \$29232 \$29121 \$27152 \$29123 \$29270 \$29267
+ gf180mcu_fd_sc_mcu9t5v0__aoi211_1
X$11664 \$29267 \$29237 \$29236 \$27152 \$29123 \$29270 \$28486
+ gf180mcu_fd_sc_mcu9t5v0__aoi22_1
X$11665 \$27295 \$27179 \$27315 \$27153 \$27296 gf180mcu_fd_sc_mcu9t5v0__xnor2_1
X$11666 \$27280 \$27279 \$27315 \$27153 \$27278 gf180mcu_fd_sc_mcu9t5v0__nor2_1
X$11667 \$27153 \$27315 gf180mcu_fd_sc_mcu9t5v0__filltie
X$11668 \$27153 \$27315 gf180mcu_fd_sc_mcu9t5v0__filltie
X$11669 \$27153 \$27315 gf180mcu_fd_sc_mcu9t5v0__filltie
X$11670 \$27153 \$27315 gf180mcu_fd_sc_mcu9t5v0__filltie
X$11671 \$27153 \$27315 gf180mcu_fd_sc_mcu9t5v0__filltie
X$11672 \$27153 \$27315 gf180mcu_fd_sc_mcu9t5v0__filltie
X$11673 \$27153 \$27315 gf180mcu_fd_sc_mcu9t5v0__endcap
X$11674 \$27153 \$27315 gf180mcu_fd_sc_mcu9t5v0__endcap
X$11675 \$27155 \$30162 \$30160 \$30186 \$30251 \$30185 \$30252
+ gf180mcu_fd_sc_mcu9t5v0__nand4_1
X$11676 \$27155 \$27323 \$27315 \$27449 \$27452 gf180mcu_fd_sc_mcu9t5v0__nor2_1
X$11677 \$27460 \$27331 \$27335 \$27315 \$27449 \$27163
+ gf180mcu_fd_sc_mcu9t5v0__oai21_1
X$11678 \$27593 \$27637 \$27449 \$27164 gf180mcu_fd_sc_mcu9t5v0__clkinv_1
X$11679 \$27342 \$27470 \$27343 \$27315 \$27449 \$27172
+ gf180mcu_fd_sc_mcu9t5v0__and3_1
X$11680 \$27613 \$27637 \$27449 \$27811 \$27177 gf180mcu_fd_sc_mcu9t5v0__xor2_1
X$11681 \$27184 \$27614 \$27913 \$27776 \$27616 gf180mcu_fd_sc_mcu9t5v0__nor2_1
X$11682 \$27184 \$27614 \$27637 \$27449 \$27615 gf180mcu_fd_sc_mcu9t5v0__nand2_1
X$11683 \$27186 \$27945 \$27913 \$27776 \$27944 gf180mcu_fd_sc_mcu9t5v0__nor2_1
X$11684 \$27621 \$27302 \$27186 \$27945 \$27913 \$27776 \$27946
+ gf180mcu_fd_sc_mcu9t5v0__aoi22_1
X$11685 \$27909 \$27913 \$28089 \$27276 gf180mcu_fd_sc_mcu9t5v0__clkinv_1
X$11686 \$27314 \$27277 \$27637 \$27449 \$27313 gf180mcu_fd_sc_mcu9t5v0__or2_1
X$11687 \$27635 \$27913 \$27776 \$27279 \$27634 gf180mcu_fd_sc_mcu9t5v0__xor2_1
X$11688 \$27635 \$27279 \$27637 \$27449 \$27447 gf180mcu_fd_sc_mcu9t5v0__nand2_1
X$11689 \$27280 \$27279 \$27637 \$27449 \$27577 gf180mcu_fd_sc_mcu9t5v0__nand2_1
X$11690 \$29232 \$27774 \$27913 \$28089 \$27280 \$27912
+ gf180mcu_fd_sc_mcu9t5v0__xnor3_1
X$11691 \$27281 \$27920 \$27921 \$27913 \$27776 \$27777
+ gf180mcu_fd_sc_mcu9t5v0__oai21_1
X$11692 \$27638 \$27637 \$27776 \$27281 gf180mcu_fd_sc_mcu9t5v0__clkinv_1
X$11693 \$27282 \$27637 \$27449 \$27322 gf180mcu_fd_sc_mcu9t5v0__inv_2
X$11694 \$28811 \$28813 \$28934 \$28810 \$28971 \$27284
+ gf180mcu_fd_sc_mcu9t5v0__nand3_1
X$11695 \$27285 \$27321 \$28534 \$28381 \$28496 gf180mcu_fd_sc_mcu9t5v0__nor2_1
X$11696 \$27286 \$27315 \$27449 \$27459 gf180mcu_fd_sc_mcu9t5v0__clkinv_1
X$11697 \$27583 \$27287 \$27637 \$27449 \$27584 gf180mcu_fd_sc_mcu9t5v0__nor2_1
X$11698 \$27335 \$27460 \$27331 \$27315 \$27449 \$27291
+ gf180mcu_fd_sc_mcu9t5v0__or3_1
X$11699 \$30862 \$30966 \$30971 \$30900 \$27294 gf180mcu_fd_sc_mcu9t5v0__or2_2
X$11700 \$27670 \$27612 \$27637 \$27449 \$27297 gf180mcu_fd_sc_mcu9t5v0__nor2_1
X$11701 \$27670 \$27612 \$27613 \$27811 \$27812 \$27637 \$27776 \$27298
+ gf180mcu_fd_sc_mcu9t5v0__aoi221_1
X$11702 \$27621 \$27302 \$28077 \$28074 \$27913 \$28089 \$28075
+ gf180mcu_fd_sc_mcu9t5v0__oai22_1
X$11703 \$27310 \$29290 \$29424 \$29422 gf180mcu_fd_sc_mcu9t5v0__clkinv_4
X$11704 \$27310 \$29290 \$29424 \$29840 gf180mcu_fd_sc_mcu9t5v0__clkinv_4
X$11705 \$27314 \$27444 \$27637 \$27776 \$27312 gf180mcu_fd_sc_mcu9t5v0__nand2_1
X$11706 \$27330 \$27315 \$27449 \$27328 gf180mcu_fd_sc_mcu9t5v0__clkinv_1
X$11707 \$27336 \$27315 \$27449 \$27589 gf180mcu_fd_sc_mcu9t5v0__clkinv_1
X$11708 \$27340 \$27465 \$27600 \$27315 \$27449 \$27466
+ gf180mcu_fd_sc_mcu9t5v0__mux2_1
X$11709 \$27449 \$27315 gf180mcu_fd_sc_mcu9t5v0__filltie
X$11710 \$27449 \$27315 gf180mcu_fd_sc_mcu9t5v0__filltie
X$11711 \$27449 \$27315 gf180mcu_fd_sc_mcu9t5v0__filltie
X$11712 \$27449 \$27315 gf180mcu_fd_sc_mcu9t5v0__filltie
X$11713 \$27449 \$27315 gf180mcu_fd_sc_mcu9t5v0__filltie
X$11714 \$27449 \$27315 gf180mcu_fd_sc_mcu9t5v0__filltie
X$11715 \$27449 \$27315 gf180mcu_fd_sc_mcu9t5v0__endcap
X$11716 \$27449 \$27315 gf180mcu_fd_sc_mcu9t5v0__endcap
X$11717 \$27635 \$27573 \$27637 \$27776 \$27316 gf180mcu_fd_sc_mcu9t5v0__or2_1
X$11718 \$28811 \$28813 \$28810 \$28689 \$27321 gf180mcu_fd_sc_mcu9t5v0__nand2_1
X$11719 \$27333 \$27913 \$27776 \$27797 gf180mcu_fd_sc_mcu9t5v0__clkinv_1
X$11720 \$27335 \$27796 \$27913 \$27776 \$27934 gf180mcu_fd_sc_mcu9t5v0__xnor2_1
X$11721 \$28702 \$27592 \$27637 \$27449 \$27337 gf180mcu_fd_sc_mcu9t5v0__nand2_1
X$11722 \$27461 \$27592 \$28702 \$27637 \$27449 \$27338
+ gf180mcu_fd_sc_mcu9t5v0__oai21_1
X$11723 \$27807 \$27637 \$27776 \$27341 gf180mcu_fd_sc_mcu9t5v0__clkinv_1
X$11724 \$27469 \$27662 \$27342 \$27637 \$27449 \$27468
+ gf180mcu_fd_sc_mcu9t5v0__oai21_1
X$11725 \$27342 \$27469 \$27662 \$27603 \$27637 \$27449 \$27601
+ gf180mcu_fd_sc_mcu9t5v0__oai31_1
X$11726 \$28111 \$28112 \$28109 \$28211 \$28089 \$27343
+ gf180mcu_fd_sc_mcu9t5v0__oai21_1
X$11727 \$30076 \$30054 \$30027 \$30074 \$27344 gf180mcu_fd_sc_mcu9t5v0__xor2_1
X$11728 \$27444 \$27772 \$27637 \$27776 \$27571 gf180mcu_fd_sc_mcu9t5v0__nor2_1
X$11729 \$27635 \$27444 \$27637 \$27449 \$27636 gf180mcu_fd_sc_mcu9t5v0__nand2_1
X$11730 \$27447 \$27569 \$27446 \$27637 \$27449 \$27633
+ gf180mcu_fd_sc_mcu9t5v0__nand3_1
X$11731 \$27447 \$27569 \$27637 \$27449 \$27568 gf180mcu_fd_sc_mcu9t5v0__nand2_1
X$11732 \$27635 \$27573 \$27637 \$27449 \$27574 gf180mcu_fd_sc_mcu9t5v0__and2_1
X$11733 \$27604 \$27605 \$27606 \$27637 \$27449 \$27663
+ gf180mcu_fd_sc_mcu9t5v0__oai21_1
X$11734 \$27616 \$27815 \$27617 \$27615 \$27637 \$27449 \$27613
+ gf180mcu_fd_sc_mcu9t5v0__oai31_1
X$11735 \$27581 \$27580 \$27579 \$27637 \$27449 \$27641
+ gf180mcu_fd_sc_mcu9t5v0__nand3_1
X$11736 \$27632 \$27566 \$27637 \$27449 \$27631 gf180mcu_fd_sc_mcu9t5v0__nand2_1
X$11737 \$27593 \$27462 \$27637 \$27449 \$27594 gf180mcu_fd_sc_mcu9t5v0__nand2_1
X$11738 \$27463 \$27594 \$27637 \$27449 \$27596 gf180mcu_fd_sc_mcu9t5v0__nand2_1
X$11739 \$27569 \$27571 \$27637 \$27449 \$27572 gf180mcu_fd_sc_mcu9t5v0__nand2_1
X$11740 \$27449 \$27637 gf180mcu_fd_sc_mcu9t5v0__filltie
X$11741 \$27449 \$27637 gf180mcu_fd_sc_mcu9t5v0__filltie
X$11742 \$27449 \$27637 gf180mcu_fd_sc_mcu9t5v0__filltie
X$11743 \$27449 \$27637 gf180mcu_fd_sc_mcu9t5v0__filltie
X$11744 \$27449 \$27637 gf180mcu_fd_sc_mcu9t5v0__filltie
X$11745 \$27449 \$27637 gf180mcu_fd_sc_mcu9t5v0__filltie
X$11746 \$27449 \$27637 gf180mcu_fd_sc_mcu9t5v0__endcap
X$11747 \$27449 \$27637 gf180mcu_fd_sc_mcu9t5v0__endcap
X$11748 \$28489 \$27778 \$27450 \$28534 \$28381 \$28491
+ gf180mcu_fd_sc_mcu9t5v0__nand3_1
X$11749 \$28545 \$27452 \$28534 \$28689 \$28694 gf180mcu_fd_sc_mcu9t5v0__nand2_1
X$11750 \$28340 \$27454 \$29290 \$29270 \$29271 gf180mcu_fd_sc_mcu9t5v0__and2_1
X$11751 \$27454 \$27581 \$29780 \$29720 \$30314 gf180mcu_fd_sc_mcu9t5v0__nor2_1
X$11752 \$28340 \$27454 \$29780 \$29720 \$29781 gf180mcu_fd_sc_mcu9t5v0__nand2_1
X$11753 \$28382 \$28215 \$28211 \$28089 \$27456 gf180mcu_fd_sc_mcu9t5v0__xnor2_1
X$11754 \$28059 \$28101 \$27461 \$27592 \$27913 \$28089 \$28060
+ gf180mcu_fd_sc_mcu9t5v0__nor4_1
X$11755 \$28101 \$27461 \$27592 \$28702 \$28211 \$28089 \$28102
+ gf180mcu_fd_sc_mcu9t5v0__oai31_1
X$11756 \$30568 \$27464 \$30240 \$30402 \$30485 \$30478
+ gf180mcu_fd_sc_mcu9t5v0__aoi21_1
X$11757 \$30259 \$27464 \$30241 \$30251 \$30185 \$30243
+ gf180mcu_fd_sc_mcu9t5v0__aoi21_1
X$11758 \$30704 \$27464 \$29959 \$30696 \$30625 \$30703
+ gf180mcu_fd_sc_mcu9t5v0__aoi21_1
X$11759 \$27464 \$29699 \$30063 \$30054 \$30027 \$30062
+ gf180mcu_fd_sc_mcu9t5v0__oai21_1
X$11760 \$27464 \$31535 \$31465 \$27600 gf180mcu_fd_sc_mcu9t5v0__inv_1
X$11761 \$27464 \$29641 \$29780 \$29720 \$29794 gf180mcu_fd_sc_mcu9t5v0__nor2_1
X$11762 \$30320 \$27464 \$30172 \$30256 \$30251 \$30339 \$30414
+ gf180mcu_fd_sc_mcu9t5v0__aoi22_1
X$11763 \$29859 \$27464 \$29933 \$29794 \$29954 \$29847 \$29970
+ gf180mcu_fd_sc_mcu9t5v0__aoi22_1
X$11764 \$31385 \$27464 \$31376 \$31465 \$31467 gf180mcu_fd_sc_mcu9t5v0__nand2_1
X$11765 \$29704 \$27464 \$29634 \$29720 \$29702 gf180mcu_fd_sc_mcu9t5v0__nand2_1
X$11766 \$30173 \$27464 \$30054 \$30027 \$30063 gf180mcu_fd_sc_mcu9t5v0__nand2_1
X$11767 \$31539 \$31535 \$31584 \$27464 gf180mcu_fd_sc_mcu9t5v0__buf_8
X$11768 \$28581 \$28580 \$28534 \$28689 \$27474 gf180mcu_fd_sc_mcu9t5v0__nand2_1
X$11769 \$28520 \$28519 \$28327 \$28480 \$28534 \$28689 \$27564
+ gf180mcu_fd_sc_mcu9t5v0__nor4_1
X$11770 \$28332 \$28331 \$28330 \$28328 \$28211 \$28381 \$27565
+ gf180mcu_fd_sc_mcu9t5v0__nor4_1
X$11771 \$27632 \$27913 \$28089 \$27567 gf180mcu_fd_sc_mcu9t5v0__clkinv_1
X$11772 \$27912 \$27576 \$27634 \$27637 \$27776 \$27569
+ gf180mcu_fd_sc_mcu9t5v0__nand3_1
X$11773 \$28930 \$29232 \$27573 \$28810 \$28971 \$28336
+ gf180mcu_fd_sc_mcu9t5v0__and3_1
X$11774 \$28930 \$29232 \$27573 \$29123 \$28971 \$28970
+ gf180mcu_fd_sc_mcu9t5v0__aoi21_1
X$11775 \$27573 \$27780 \$29123 \$28971 \$29080 gf180mcu_fd_sc_mcu9t5v0__nand2_1
X$11776 \$27774 \$27914 \$27915 \$27913 \$27776 \$27575
+ gf180mcu_fd_sc_mcu9t5v0__oai21_1
X$11777 \$28930 \$27576 \$28534 \$28689 \$28484 gf180mcu_fd_sc_mcu9t5v0__xnor2_1
X$11778 \$27912 \$27576 \$27634 \$27913 \$27776 \$27772
+ gf180mcu_fd_sc_mcu9t5v0__aoi21_1
X$11779 \$27588 \$27651 \$27637 \$27776 \$27790 gf180mcu_fd_sc_mcu9t5v0__nand2_1
X$11780 \$27590 \$27796 \$27655 \$27637 \$27776 \$27656
+ gf180mcu_fd_sc_mcu9t5v0__oai21_1
X$11781 \$28564 \$28563 \$28534 \$28689 \$27592 gf180mcu_fd_sc_mcu9t5v0__nand2_1
X$11782 \$29319 \$29290 \$29270 \$29320 \$27599 gf180mcu_fd_sc_mcu9t5v0__xor2_1
X$11783 \$27600 \$30403 \$31520 \$31535 \$31584 \$31590
+ gf180mcu_fd_sc_mcu9t5v0__aoi21_1
X$11784 \$28946 \$29441 \$27600 \$29290 \$29424 \$29443
+ gf180mcu_fd_sc_mcu9t5v0__mux2_1
X$11785 \$30494 \$30425 \$27600 \$30402 \$30485 \$30496
+ gf180mcu_fd_sc_mcu9t5v0__mux2_1
X$11786 \$28107 \$28061 \$27600 \$27913 \$28089 \$28106
+ gf180mcu_fd_sc_mcu9t5v0__mux2_1
X$11787 \$29930 \$29790 \$27600 \$29954 \$29847 \$29968
+ gf180mcu_fd_sc_mcu9t5v0__mux2_1
X$11788 \$27807 \$28713 \$27600 \$28810 \$28689 \$28834
+ gf180mcu_fd_sc_mcu9t5v0__mux2_1
X$11789 \$29715 \$29713 \$27600 \$29780 \$29720 \$29800
+ gf180mcu_fd_sc_mcu9t5v0__mux2_1
X$11790 \$29309 \$27913 \$27776 \$27602 gf180mcu_fd_sc_mcu9t5v0__clkinv_1
X$11791 \$28109 \$28111 \$28112 \$28211 \$28089 \$27604
+ gf180mcu_fd_sc_mcu9t5v0__nor3_1
X$11792 \$27670 \$27810 \$27637 \$27776 \$27611 \$27612
+ gf180mcu_fd_sc_mcu9t5v0__xnor3_1
X$11793 \$27613 \$27811 \$27812 \$27913 \$27776 \$27810
+ gf180mcu_fd_sc_mcu9t5v0__aoi21_1
X$11794 \$28072 \$28117 \$28071 \$27913 \$28089 \$27617
+ gf180mcu_fd_sc_mcu9t5v0__aoi21_1
X$11795 \$27815 \$27617 \$27913 \$27776 \$27673 gf180mcu_fd_sc_mcu9t5v0__nor2_1
X$11796 \$27768 \$27626 \$27625 \$27766 \$27913 \$28089 \$28040
+ gf180mcu_fd_sc_mcu9t5v0__nand4_1
X$11797 \$27768 \$27626 \$27625 \$27766 \$27637 \$27776 \$27627
+ gf180mcu_fd_sc_mcu9t5v0__nor4_1
X$11798 \$28332 \$28331 \$28330 \$28328 \$28534 \$28689 \$27628
+ gf180mcu_fd_sc_mcu9t5v0__nand4_1
X$11799 \$27781 \$28687 \$27637 \$27776 \$27780 gf180mcu_fd_sc_mcu9t5v0__nor2_1
X$11800 \$27776 \$27637 gf180mcu_fd_sc_mcu9t5v0__filltie
X$11801 \$27776 \$27637 gf180mcu_fd_sc_mcu9t5v0__filltie
X$11802 \$27776 \$27637 gf180mcu_fd_sc_mcu9t5v0__filltie
X$11803 \$27776 \$27637 gf180mcu_fd_sc_mcu9t5v0__filltie
X$11804 \$27776 \$27637 gf180mcu_fd_sc_mcu9t5v0__filltie
X$11805 \$27776 \$27637 gf180mcu_fd_sc_mcu9t5v0__filltie
X$11806 \$27776 \$27637 gf180mcu_fd_sc_mcu9t5v0__endcap
X$11807 \$27776 \$27637 gf180mcu_fd_sc_mcu9t5v0__endcap
X$11808 \$27917 \$27639 \$27913 \$27776 \$27778 gf180mcu_fd_sc_mcu9t5v0__nor2_1
X$11809 \$28050 \$27640 \$27913 \$28089 \$27925 gf180mcu_fd_sc_mcu9t5v0__nand2_1
X$11810 \$28094 \$27642 \$27913 \$28089 \$28057 gf180mcu_fd_sc_mcu9t5v0__nand2_1
X$11811 \$28056 \$27642 \$27913 \$27776 \$27785 gf180mcu_fd_sc_mcu9t5v0__nand2_1
X$11812 \$27652 \$27792 \$27791 \$27913 \$27776 \$27795
+ gf180mcu_fd_sc_mcu9t5v0__aoi21_1
X$11813 \$27654 \$27793 \$27913 \$27776 \$27794 gf180mcu_fd_sc_mcu9t5v0__nand2_1
X$11814 \$28539 \$27658 \$29292 \$29290 \$29270 \$29291
+ gf180mcu_fd_sc_mcu9t5v0__oai21_1
X$11815 \$29690 \$29634 \$29424 \$27658 gf180mcu_fd_sc_mcu9t5v0__buf_8
X$11816 \$30332 \$30266 \$30251 \$30339 \$27659 gf180mcu_fd_sc_mcu9t5v0__xnor2_1
X$11817 \$29797 \$29799 \$29780 \$29847 \$27660 gf180mcu_fd_sc_mcu9t5v0__xnor2_1
X$11818 \$28108 \$28233 \$28109 \$28234 \$28211 \$28089 \$27662
+ gf180mcu_fd_sc_mcu9t5v0__aoi211_1
X$11819 \$28337 \$28930 \$28211 \$28381 \$27774 gf180mcu_fd_sc_mcu9t5v0__nand2_1
X$11820 \$27797 \$27795 \$27794 \$27913 \$27776 \$27796
+ gf180mcu_fd_sc_mcu9t5v0__oai21_1
X$11821 \$27812 \$27939 \$27913 \$27776 \$27811 gf180mcu_fd_sc_mcu9t5v0__nor2_1
X$11822 \$27917 \$27913 \$27776 \$27923 gf180mcu_fd_sc_mcu9t5v0__clkinv_1
X$11823 \$27908 \$28085 \$27913 \$27776 \$27907 gf180mcu_fd_sc_mcu9t5v0__nand2_1
X$11824 \$27790 \$27789 \$27913 \$27776 \$27932 gf180mcu_fd_sc_mcu9t5v0__nand2_1
X$11825 \$27776 \$27913 gf180mcu_fd_sc_mcu9t5v0__filltie
X$11826 \$27776 \$27913 gf180mcu_fd_sc_mcu9t5v0__filltie
X$11827 \$27776 \$27913 gf180mcu_fd_sc_mcu9t5v0__filltie
X$11828 \$27776 \$27913 gf180mcu_fd_sc_mcu9t5v0__filltie
X$11829 \$27776 \$27913 gf180mcu_fd_sc_mcu9t5v0__filltie
X$11830 \$27776 \$27913 gf180mcu_fd_sc_mcu9t5v0__filltie
X$11831 \$27776 \$27913 gf180mcu_fd_sc_mcu9t5v0__endcap
X$11832 \$27776 \$27913 gf180mcu_fd_sc_mcu9t5v0__endcap
X$11833 \$28496 \$28693 \$27778 \$28534 \$28381 \$28338
+ gf180mcu_fd_sc_mcu9t5v0__nand3_1
X$11834 \$28496 \$27778 \$28810 \$28689 \$28812 gf180mcu_fd_sc_mcu9t5v0__nand2_1
X$11835 \$27778 \$28810 \$28689 \$28537 gf180mcu_fd_sc_mcu9t5v0__clkinv_1
X$11836 \$29232 \$27780 \$29123 \$29270 \$29234 gf180mcu_fd_sc_mcu9t5v0__nand2_1
X$11837 \$27780 \$28810 \$28689 \$28528 gf180mcu_fd_sc_mcu9t5v0__clkinv_1
X$11838 \$27797 \$27795 \$27913 \$28089 \$28096 gf180mcu_fd_sc_mcu9t5v0__xnor2_1
X$11839 \$27936 \$27913 \$28089 \$27805 gf180mcu_fd_sc_mcu9t5v0__clkinv_1
X$11840 \$29296 \$27809 \$29134 \$29123 \$29270 \$29273
+ gf180mcu_fd_sc_mcu9t5v0__oai21_4
X$11841 \$29132 \$29123 \$29270 \$27809 gf180mcu_fd_sc_mcu9t5v0__buf_8
X$11842 \$28068 \$28067 \$27913 \$28089 \$27812 gf180mcu_fd_sc_mcu9t5v0__and2_1
X$11843 \$28366 \$28365 \$28211 \$28381 \$27815 gf180mcu_fd_sc_mcu9t5v0__nor2_1
X$11844 \$27900 \$28681 \$28680 \$28033 \$28534 \$28381 \$28370
+ gf180mcu_fd_sc_mcu9t5v0__nand4_1
X$11845 \$27900 \$28681 \$28680 \$28033 \$28211 \$28381 \$27901
+ gf180mcu_fd_sc_mcu9t5v0__nor4_1
X$11846 \$30184 \$27910 \$30564 \$30485 \$30561 gf180mcu_fd_sc_mcu9t5v0__xnor2_1
X$11847 \$27910 \$30562 \$30677 \$30484 \$30696 \$30625 \$30607
+ gf180mcu_fd_sc_mcu9t5v0__oai31_1
X$11848 \$30184 \$27910 \$29425 \$28540 \$30054 \$30185 \$30159
+ gf180mcu_fd_sc_mcu9t5v0__aoi22_1
X$11849 \$27912 \$28211 \$28089 \$28210 \$28088 gf180mcu_fd_sc_mcu9t5v0__xor2_1
X$11850 \$29232 \$27912 \$27913 \$28089 \$27914 gf180mcu_fd_sc_mcu9t5v0__nor2_1
X$11851 \$29232 \$27912 \$28211 \$28089 \$27915 gf180mcu_fd_sc_mcu9t5v0__nand2_1
X$11852 \$27941 \$27913 \$28089 \$28514 \$27940 gf180mcu_fd_sc_mcu9t5v0__xor2_1
X$11853 \$28062 \$27913 \$28089 gf180mcu_fd_sc_mcu9t5v0__inv_3
X$11854 \$28076 \$28075 \$27946 \$27913 \$28089 \$28072
+ gf180mcu_fd_sc_mcu9t5v0__oai21_1
X$11855 \$28068 \$28067 \$27913 \$28089 \$27939 gf180mcu_fd_sc_mcu9t5v0__nor2_1
X$11856 \$28237 \$27944 \$27913 \$28089 \$28117 gf180mcu_fd_sc_mcu9t5v0__nor2_1
X$11857 \$28230 \$27913 \$28089 \$28062 gf180mcu_fd_sc_mcu9t5v0__clkbuf_8
X$11858 \$28094 \$27913 \$28089 \$28056 gf180mcu_fd_sc_mcu9t5v0__clkinv_1
X$11859 \$28107 \$27913 \$28089 \$27937 gf180mcu_fd_sc_mcu9t5v0__clkinv_1
X$11860 \$27919 \$27918 \$27913 \$28089 \$28045 gf180mcu_fd_sc_mcu9t5v0__nand2_1
X$11861 \$28089 \$27913 gf180mcu_fd_sc_mcu9t5v0__filltie
X$11862 \$28089 \$27913 gf180mcu_fd_sc_mcu9t5v0__filltie
X$11863 \$28089 \$27913 gf180mcu_fd_sc_mcu9t5v0__filltie
X$11864 \$28089 \$27913 gf180mcu_fd_sc_mcu9t5v0__filltie
X$11865 \$28089 \$27913 gf180mcu_fd_sc_mcu9t5v0__filltie
X$11866 \$28089 \$27913 gf180mcu_fd_sc_mcu9t5v0__filltie
X$11867 \$28089 \$27913 gf180mcu_fd_sc_mcu9t5v0__endcap
X$11868 \$28089 \$27913 gf180mcu_fd_sc_mcu9t5v0__endcap
X$11869 \$28537 \$27919 \$28691 \$28534 \$28689 \$28690
+ gf180mcu_fd_sc_mcu9t5v0__aoi21_1
X$11870 \$27919 \$28691 \$28490 \$28491 \$28534 \$28381 \$28538
+ gf180mcu_fd_sc_mcu9t5v0__oai211_1
X$11871 \$27926 \$29123 \$29270 gf180mcu_fd_sc_mcu9t5v0__clkbuf_4
X$11872 \$27926 \$29129 \$28819 \$29123 \$29270 gf180mcu_fd_sc_mcu9t5v0__dffq_2
X$11873 \$27926 \$29430 \$28501 \$29290 \$29424 gf180mcu_fd_sc_mcu9t5v0__dffq_2
X$11874 \$27926 \$29128 \$29090 \$29290 \$29270 gf180mcu_fd_sc_mcu9t5v0__dffq_2
X$11875 \$27926 \$28699 \$28549 \$28810 \$28689 gf180mcu_fd_sc_mcu9t5v0__dffq_2
X$11876 \$27926 \$28092 \$28343 \$28211 \$28089 gf180mcu_fd_sc_mcu9t5v0__dffq_2
X$11877 \$27926 \$29272 \$28816 \$29290 \$29270 gf180mcu_fd_sc_mcu9t5v0__dffq_2
X$11878 \$27928 \$29300 \$29290 \$29270 \$29301 gf180mcu_fd_sc_mcu9t5v0__nand2_1
X$11879 \$27929 \$28504 \$28534 \$28381 \$28555 gf180mcu_fd_sc_mcu9t5v0__nand2_1
X$11880 \$27935 \$29123 \$28971 gf180mcu_fd_sc_mcu9t5v0__inv_3
X$11881 \$27936 \$29308 \$29123 \$29270 \$29246 gf180mcu_fd_sc_mcu9t5v0__nand2_1
X$11882 \$27942 \$28534 \$28381 gf180mcu_fd_sc_mcu9t5v0__clkbuf_4
X$11883 \$28044 \$28085 \$28211 \$28089 \$28086 gf180mcu_fd_sc_mcu9t5v0__nand2_1
X$11884 \$29691 \$29628 \$28049 \$28967 \$29634 \$29720 \$29690
+ gf180mcu_fd_sc_mcu9t5v0__nand4_1
X$11885 \$29924 \$28049 \$29848 \$28340 \$29780 \$29720 \$29721
+ gf180mcu_fd_sc_mcu9t5v0__nor4_1
X$11886 \$28049 \$30679 \$30696 \$30625 \$30695 gf180mcu_fd_sc_mcu9t5v0__and2_1
X$11887 \$28049 \$28539 \$28687 \$29290 \$29424 \$29425
+ gf180mcu_fd_sc_mcu9t5v0__aoi21_1
X$11888 \$28049 \$30679 \$30696 \$30763 \$30771 gf180mcu_fd_sc_mcu9t5v0__nand2_1
X$11889 \$28049 \$28539 \$28534 \$28689 \$28493 gf180mcu_fd_sc_mcu9t5v0__nand2_1
X$11890 \$28049 \$29693 \$30564 \$30625 \$30562 gf180mcu_fd_sc_mcu9t5v0__nand2_1
X$11891 \$28049 \$28489 \$28810 \$28689 \$28691 gf180mcu_fd_sc_mcu9t5v0__nand2_1
X$11892 \$28049 \$28967 \$29634 \$29424 \$29626 gf180mcu_fd_sc_mcu9t5v0__nand2_1
X$11893 \$28213 \$28211 \$28381 \$28049 gf180mcu_fd_sc_mcu9t5v0__buf_8
X$11894 \$30680 \$30698 \$30696 \$30625 \$28050 gf180mcu_fd_sc_mcu9t5v0__nand2_1
X$11895 \$28341 \$28340 \$28213 \$28534 \$28381 \$28051
+ gf180mcu_fd_sc_mcu9t5v0__nor3_4
X$11896 \$28501 \$28547 \$28502 \$28534 \$28381 \$28052
+ gf180mcu_fd_sc_mcu9t5v0__and3_2
X$11897 \$28697 \$28547 \$28502 \$28534 \$28689 \$28053
+ gf180mcu_fd_sc_mcu9t5v0__nor3_2
X$11898 \$28342 \$28343 \$28211 \$28381 \$28054 gf180mcu_fd_sc_mcu9t5v0__and2_2
X$11899 \$28980 \$28060 \$28700 \$28810 \$28971 \$28979
+ gf180mcu_fd_sc_mcu9t5v0__aoi21_1
X$11900 \$28700 \$28060 \$28810 \$28689 \$28830 gf180mcu_fd_sc_mcu9t5v0__nor2_1
X$11901 \$28062 \$28384 \$28357 \$28534 \$28381 gf180mcu_fd_sc_mcu9t5v0__dffq_2
X$11902 \$28116 \$28211 \$28089 \$28071 gf180mcu_fd_sc_mcu9t5v0__clkinv_1
X$11903 \$28077 \$28074 \$28211 \$28381 \$28394 gf180mcu_fd_sc_mcu9t5v0__nand2_1
X$11904 \$28394 \$28589 \$28516 \$28534 \$28381 \$28076
+ gf180mcu_fd_sc_mcu9t5v0__and3_1
X$11905 \$28080 \$28810 \$28971 gf180mcu_fd_sc_mcu9t5v0__clkinv_8
X$11906 \$28089 \$28211 gf180mcu_fd_sc_mcu9t5v0__filltie
X$11907 \$28089 \$28211 gf180mcu_fd_sc_mcu9t5v0__filltie
X$11908 \$28089 \$28211 gf180mcu_fd_sc_mcu9t5v0__filltie
X$11909 \$28089 \$28211 gf180mcu_fd_sc_mcu9t5v0__filltie
X$11910 \$28089 \$28211 gf180mcu_fd_sc_mcu9t5v0__filltie
X$11911 \$28089 \$28211 gf180mcu_fd_sc_mcu9t5v0__filltie
X$11912 \$28089 \$28211 gf180mcu_fd_sc_mcu9t5v0__endcap
X$11913 \$28089 \$28211 gf180mcu_fd_sc_mcu9t5v0__endcap
X$11914 \$28543 \$28091 \$28494 \$28541 \$28534 \$28381 \$28490
+ gf180mcu_fd_sc_mcu9t5v0__oai31_1
X$11915 \$28507 \$28534 \$28381 \$28104 gf180mcu_fd_sc_mcu9t5v0__clkinv_1
X$11916 \$28509 \$28534 \$28381 \$28105 gf180mcu_fd_sc_mcu9t5v0__clkinv_1
X$11917 \$28109 \$28211 \$28381 \$28358 gf180mcu_fd_sc_mcu9t5v0__clkinv_1
X$11918 \$32269 \$32169 \$32248 \$32171 \$28110 gf180mcu_fd_sc_mcu9t5v0__nor2_1
X$11919 \$28837 \$29447 \$28573 \$28810 \$28689 \$28112
+ gf180mcu_fd_sc_mcu9t5v0__aoi21_1
X$11920 \$28366 \$28365 \$28393 \$28367 \$28211 \$28381 \$28116
+ gf180mcu_fd_sc_mcu9t5v0__aoi22_1
X$11921 \$28230 \$28211 \$28381 gf180mcu_fd_sc_mcu9t5v0__clkinv_12
X$11922 \$28358 \$28386 \$28359 \$28232 \$28211 \$28381 \$28385
+ gf180mcu_fd_sc_mcu9t5v0__oai31_1
X$11923 \$28234 \$28233 \$28211 \$28381 \$28359 gf180mcu_fd_sc_mcu9t5v0__nor2_1
X$11924 \$28335 \$28334 \$28211 \$28381 \$28376 gf180mcu_fd_sc_mcu9t5v0__nor2_1
X$11925 \$28393 \$28367 \$28211 \$28381 \$28237 gf180mcu_fd_sc_mcu9t5v0__nor2_1
X$11926 \$28360 \$28211 \$28381 \$28234 gf180mcu_fd_sc_mcu9t5v0__clkinv_1
X$11927 \$28381 \$28211 gf180mcu_fd_sc_mcu9t5v0__filltie
X$11928 \$28381 \$28211 gf180mcu_fd_sc_mcu9t5v0__filltie
X$11929 \$28381 \$28211 gf180mcu_fd_sc_mcu9t5v0__filltie
X$11930 \$28381 \$28211 gf180mcu_fd_sc_mcu9t5v0__filltie
X$11931 \$28381 \$28211 gf180mcu_fd_sc_mcu9t5v0__filltie
X$11932 \$28381 \$28211 gf180mcu_fd_sc_mcu9t5v0__filltie
X$11933 \$28381 \$28211 gf180mcu_fd_sc_mcu9t5v0__endcap
X$11934 \$28381 \$28211 gf180mcu_fd_sc_mcu9t5v0__endcap
X$11935 \$28212 \$29780 \$29720 gf180mcu_fd_sc_mcu9t5v0__inv_3
X$11936 \$28213 \$28340 \$28534 \$28689 \$28545 gf180mcu_fd_sc_mcu9t5v0__nor2_1
X$11937 \$30705 \$30696 \$30763 \$30759 \$28221 gf180mcu_fd_sc_mcu9t5v0__xor2_1
X$11938 \$31108 \$28222 \$31100 \$31032 \$31107 gf180mcu_fd_sc_mcu9t5v0__nand2_1
X$11939 \$30039 \$29954 \$29847 \$29865 \$28229 gf180mcu_fd_sc_mcu9t5v0__xor2_1
X$11940 \$28573 \$28233 \$28810 \$28971 \$28945 gf180mcu_fd_sc_mcu9t5v0__xnor2_1
X$11941 \$28946 \$28836 \$28947 \$28810 \$28971 \$28233
+ gf180mcu_fd_sc_mcu9t5v0__aoi21_1
X$11942 \$28234 \$28386 \$28534 \$28381 \$28573 gf180mcu_fd_sc_mcu9t5v0__nor2_1
X$11943 \$28520 \$28519 \$28327 \$28480 \$28534 \$28381 \$28372
+ gf180mcu_fd_sc_mcu9t5v0__nand4_1
X$11944 \$28336 \$28969 \$28970 \$29080 \$29123 \$28971 \$29081
+ gf180mcu_fd_sc_mcu9t5v0__oai31_1
X$11945 \$30162 \$28545 \$28341 \$30160 \$30054 \$30185 \$29088
+ gf180mcu_fd_sc_mcu9t5v0__nand4_1
X$11946 \$30237 \$30343 \$30251 \$30185 \$28341 gf180mcu_fd_sc_mcu9t5v0__nor2_2
X$11947 \$28502 \$28546 \$28534 \$28381 \$28342 gf180mcu_fd_sc_mcu9t5v0__xnor2_1
X$11948 \$28549 \$28342 \$28534 \$28689 \$28698 gf180mcu_fd_sc_mcu9t5v0__nand2_1
X$11949 \$28700 \$28345 \$28810 \$28689 \$28822 gf180mcu_fd_sc_mcu9t5v0__nor2_1
X$11950 \$28937 \$28345 \$28810 \$28971 \$28938 gf180mcu_fd_sc_mcu9t5v0__nand2_1
X$11951 \$29435 \$28822 \$28810 \$28689 \$28347 gf180mcu_fd_sc_mcu9t5v0__xnor2_1
X$11952 \$28350 \$29780 \$29720 gf180mcu_fd_sc_mcu9t5v0__clkbuf_4
X$11953 \$28352 \$29537 \$29634 \$29424 \$29639 gf180mcu_fd_sc_mcu9t5v0__nand2_1
X$11954 \$28506 \$28559 \$28534 \$28381 \$28353 gf180mcu_fd_sc_mcu9t5v0__xnor2_1
X$11955 \$28706 \$28534 \$28689 \$28562 \$28355 gf180mcu_fd_sc_mcu9t5v0__xor2_1
X$11956 \$29082 \$28378 \$29123 \$28971 \$29083 gf180mcu_fd_sc_mcu9t5v0__nor2_1
X$11957 \$28486 \$28531 \$28484 \$28483 \$28534 \$28381 \$28485
+ gf180mcu_fd_sc_mcu9t5v0__nor4_1
X$11958 \$28381 \$28534 gf180mcu_fd_sc_mcu9t5v0__filltie
X$11959 \$28381 \$28534 gf180mcu_fd_sc_mcu9t5v0__filltie
X$11960 \$28381 \$28534 gf180mcu_fd_sc_mcu9t5v0__filltie
X$11961 \$28381 \$28534 gf180mcu_fd_sc_mcu9t5v0__filltie
X$11962 \$28381 \$28534 gf180mcu_fd_sc_mcu9t5v0__filltie
X$11963 \$28381 \$28534 gf180mcu_fd_sc_mcu9t5v0__filltie
X$11964 \$28381 \$28534 gf180mcu_fd_sc_mcu9t5v0__endcap
X$11965 \$28381 \$28534 gf180mcu_fd_sc_mcu9t5v0__endcap
X$11966 \$28687 \$28485 \$28534 \$28689 \$28481 gf180mcu_fd_sc_mcu9t5v0__nor2_1
X$11967 \$28532 \$28530 \$28534 \$28689 \$28483 gf180mcu_fd_sc_mcu9t5v0__nand2_1
X$11968 \$28487 \$29123 \$28971 \$28685 gf180mcu_fd_sc_mcu9t5v0__clkinv_1
X$11969 \$28489 \$28934 \$28812 \$28810 \$28971 \$28932
+ gf180mcu_fd_sc_mcu9t5v0__nor3_1
X$11970 \$28541 \$28542 \$28534 \$28689 \$28492 gf180mcu_fd_sc_mcu9t5v0__nor2_1
X$11971 \$28543 \$28495 \$28932 \$28542 \$28810 \$28971 \$28973
+ gf180mcu_fd_sc_mcu9t5v0__oai31_1
X$11972 \$28811 \$28495 \$28810 \$28689 \$29086 gf180mcu_fd_sc_mcu9t5v0__nand2_1
X$11973 \$28546 \$28502 \$28534 \$28689 \$28696 gf180mcu_fd_sc_mcu9t5v0__nor2_1
X$11974 \$28547 \$28502 \$28534 \$28689 \$28936 gf180mcu_fd_sc_mcu9t5v0__nor2_1
X$11975 \$28547 \$28502 \$28816 \$28810 \$28689 \$28817
+ gf180mcu_fd_sc_mcu9t5v0__nand3_1
X$11976 \$28936 \$28502 \$28694 \$28810 \$28971 \$28935
+ gf180mcu_fd_sc_mcu9t5v0__mux2_1
X$11977 \$28552 \$28551 \$28534 \$28689 \$28503 gf180mcu_fd_sc_mcu9t5v0__nand2_1
X$11978 \$28506 \$28534 \$28689 \$28561 gf180mcu_fd_sc_mcu9t5v0__clkinv_1
X$11979 \$28507 \$29109 \$29306 \$29934 \$29711 \$29954 \$29847 \$29861
+ gf180mcu_fd_sc_mcu9t5v0__aoi221_1
X$11980 \$28509 \$29308 \$29306 \$30176 \$29305 \$29643 \$29634 \$29720 \$29710
+ gf180mcu_fd_sc_mcu9t5v0__aoi222_1
X$11981 \$28566 \$28569 \$28510 \$28810 \$28971 gf180mcu_fd_sc_mcu9t5v0__dffq_2
X$11982 \$28511 \$28534 \$28689 gf180mcu_fd_sc_mcu9t5v0__inv_3
X$11983 \$28590 \$28515 \$28842 \$29112 \$28810 \$28689 \$28516
+ gf180mcu_fd_sc_mcu9t5v0__oai211_1
X$11984 \$28590 \$28515 \$28534 \$28689 \$28589 gf180mcu_fd_sc_mcu9t5v0__nand2_1
X$11985 \$28527 \$28534 \$28689 \$29842 gf180mcu_fd_sc_mcu9t5v0__buf_8
X$11986 \$28930 \$28528 \$28931 \$28810 \$28971 \$28929
+ gf180mcu_fd_sc_mcu9t5v0__aoi21_1
X$11987 \$28535 \$28534 \$28689 \$28533 gf180mcu_fd_sc_mcu9t5v0__clkinv_1
X$11988 \$28581 \$28534 \$28689 \$28580 \$28582 gf180mcu_fd_sc_mcu9t5v0__xor2_1
X$11989 \$28948 \$28534 \$28689 gf180mcu_fd_sc_mcu9t5v0__clkinv_12
X$11990 \$28706 \$28560 \$28702 \$28534 \$28689 \$28827
+ gf180mcu_fd_sc_mcu9t5v0__oai21_1
X$11991 \$28700 \$28703 \$28534 \$28689 \$28559 gf180mcu_fd_sc_mcu9t5v0__nor2_1
X$11992 \$28700 \$28563 \$28534 \$28689 \$28565 gf180mcu_fd_sc_mcu9t5v0__nor2_1
X$11993 \$28561 \$28703 \$28534 \$28689 \$28560 gf180mcu_fd_sc_mcu9t5v0__nand2_1
X$11994 \$28702 \$28560 \$28534 \$28689 \$28562 gf180mcu_fd_sc_mcu9t5v0__nand2_1
X$11995 \$28820 \$28551 \$28534 \$28689 \$28553 gf180mcu_fd_sc_mcu9t5v0__nand2_1
X$11996 \$28576 \$28574 \$28534 \$28689 \$28577 gf180mcu_fd_sc_mcu9t5v0__nand2_1
X$11997 \$28696 \$28546 \$28694 \$28534 \$28689 \$28815
+ gf180mcu_fd_sc_mcu9t5v0__mux2_1
X$11998 \$28689 \$28534 gf180mcu_fd_sc_mcu9t5v0__filltie
X$11999 \$28689 \$28534 gf180mcu_fd_sc_mcu9t5v0__filltie
X$12000 \$28689 \$28534 gf180mcu_fd_sc_mcu9t5v0__filltie
X$12001 \$28689 \$28534 gf180mcu_fd_sc_mcu9t5v0__filltie
X$12002 \$28689 \$28534 gf180mcu_fd_sc_mcu9t5v0__filltie
X$12003 \$28689 \$28534 gf180mcu_fd_sc_mcu9t5v0__filltie
X$12004 \$28689 \$28534 gf180mcu_fd_sc_mcu9t5v0__endcap
X$12005 \$28689 \$28534 gf180mcu_fd_sc_mcu9t5v0__endcap
X$12006 \$28686 \$28685 \$28535 \$29123 \$28971 \$29082
+ gf180mcu_fd_sc_mcu9t5v0__nor3_1
X$12007 \$28535 \$29083 \$29084 \$29123 \$28971 \$29126
+ gf180mcu_fd_sc_mcu9t5v0__aoi21_1
X$12008 \$28535 \$29083 \$29290 \$29270 \$29269 gf180mcu_fd_sc_mcu9t5v0__nand2_1
X$12009 \$28687 \$28539 \$29634 \$29424 \$29693 gf180mcu_fd_sc_mcu9t5v0__nor2_1
X$12010 \$28543 \$28932 \$28933 \$28810 \$28971 \$28972
+ gf180mcu_fd_sc_mcu9t5v0__or3_1
X$12011 \$29955 \$28545 \$30312 \$30251 \$30339 \$30313
+ gf180mcu_fd_sc_mcu9t5v0__and3_1
X$12012 \$30164 \$28545 \$30312 \$30251 \$30339 \$30253
+ gf180mcu_fd_sc_mcu9t5v0__nand3_1
X$12013 \$28546 \$28810 \$28971 \$28547 gf180mcu_fd_sc_mcu9t5v0__inv_1
X$12014 \$28820 \$28810 \$28689 \$28552 gf180mcu_fd_sc_mcu9t5v0__clkinv_1
X$12015 \$28554 \$30251 \$30185 gf180mcu_fd_sc_mcu9t5v0__inv_4
X$12016 \$29312 \$29308 \$29305 \$28556 \$29290 \$29270 \$29311
+ gf180mcu_fd_sc_mcu9t5v0__aoi22_1
X$12017 \$29309 \$29308 \$29306 \$29307 \$29305 \$28558 \$29290 \$29270 \$29310
+ gf180mcu_fd_sc_mcu9t5v0__aoi222_1
X$12018 \$28978 \$28706 \$28560 \$28810 \$28689 \$28563
+ gf180mcu_fd_sc_mcu9t5v0__nor3_1
X$12019 \$28829 \$28810 \$28689 \$28564 gf180mcu_fd_sc_mcu9t5v0__clkinv_1
X$12020 \$28566 \$29954 \$29847 gf180mcu_fd_sc_mcu9t5v0__clkinv_3
X$12021 \$28573 \$28837 \$29447 \$28810 \$28689 \$28839
+ gf180mcu_fd_sc_mcu9t5v0__and3_1
X$12022 \$29279 \$29716 \$29445 \$29325 \$29290 \$29424 \$28574
+ gf180mcu_fd_sc_mcu9t5v0__oai31_1
X$12023 \$31099 \$31040 \$30971 \$31032 \$28575 gf180mcu_fd_sc_mcu9t5v0__xnor2_1
X$12024 \$28685 \$29269 \$29124 \$28687 \$29123 \$29270 \$29238
+ gf180mcu_fd_sc_mcu9t5v0__aoi211_1
X$12025 \$28685 \$29232 \$28686 \$29123 \$28971 \$29121
+ gf180mcu_fd_sc_mcu9t5v0__oai21_1
X$12026 \$31249 \$31156 \$31248 \$28687 \$31232 \$31310 \$31311
+ gf180mcu_fd_sc_mcu9t5v0__oai22_1
X$12027 \$28687 \$29125 \$29123 \$29270 \$29268 gf180mcu_fd_sc_mcu9t5v0__nor2_1
X$12028 \$29293 \$29290 \$29270 \$28687 gf180mcu_fd_sc_mcu9t5v0__buf_8
X$12029 \$28940 \$28938 \$28702 \$28810 \$28689 \$28823
+ gf180mcu_fd_sc_mcu9t5v0__oai21_1
X$12030 \$28819 \$28810 \$28689 \$28697 gf180mcu_fd_sc_mcu9t5v0__clkinv_1
X$12031 \$28689 \$28810 gf180mcu_fd_sc_mcu9t5v0__filltie
X$12032 \$28689 \$28810 gf180mcu_fd_sc_mcu9t5v0__filltie
X$12033 \$28689 \$28810 gf180mcu_fd_sc_mcu9t5v0__filltie
X$12034 \$28689 \$28810 gf180mcu_fd_sc_mcu9t5v0__filltie
X$12035 \$28689 \$28810 gf180mcu_fd_sc_mcu9t5v0__filltie
X$12036 \$28689 \$28810 gf180mcu_fd_sc_mcu9t5v0__filltie
X$12037 \$28689 \$28810 gf180mcu_fd_sc_mcu9t5v0__endcap
X$12038 \$28689 \$28810 gf180mcu_fd_sc_mcu9t5v0__endcap
X$12039 \$30950 \$31031 \$30971 \$31032 \$28693 gf180mcu_fd_sc_mcu9t5v0__or2_1
X$12040 \$28693 \$29239 \$28973 \$29123 \$29270 \$29127
+ gf180mcu_fd_sc_mcu9t5v0__oai21_1
X$12041 \$29924 \$29849 \$29722 \$28694 \$29954 \$29847 \$29953
+ gf180mcu_fd_sc_mcu9t5v0__and4_1
X$12042 \$29722 \$28694 \$29954 \$30027 \$30028 gf180mcu_fd_sc_mcu9t5v0__or2_1
X$12043 \$29722 \$28694 \$30054 \$30027 \$30236 gf180mcu_fd_sc_mcu9t5v0__nand2_1
X$12044 \$30347 \$30553 \$30402 \$30339 \$28700 gf180mcu_fd_sc_mcu9t5v0__and2_1
X$12045 \$28700 \$29963 \$29954 \$30027 \$29932 gf180mcu_fd_sc_mcu9t5v0__nor2_1
X$12046 \$28700 \$30426 \$30402 \$30339 \$30428 gf180mcu_fd_sc_mcu9t5v0__nor2_1
X$12047 \$28700 \$29728 \$29780 \$29720 \$29799 gf180mcu_fd_sc_mcu9t5v0__nor2_1
X$12048 \$28700 \$29957 \$30054 \$30027 \$30060 gf180mcu_fd_sc_mcu9t5v0__nor2_1
X$12049 \$28700 \$29317 \$29290 \$29270 \$29314 gf180mcu_fd_sc_mcu9t5v0__nor2_1
X$12050 \$28940 \$28939 \$28810 \$28971 \$28701 gf180mcu_fd_sc_mcu9t5v0__xnor2_1
X$12051 \$29433 \$29637 \$28702 \$29780 \$29847 \$29787
+ gf180mcu_fd_sc_mcu9t5v0__oai21_1
X$12052 \$30039 \$29864 \$28702 \$29954 \$30027 \$29937
+ gf180mcu_fd_sc_mcu9t5v0__oai21_1
X$12053 \$29926 \$30061 \$28702 \$29954 \$30027 \$29962
+ gf180mcu_fd_sc_mcu9t5v0__oai21_1
X$12054 \$30691 \$30034 \$28702 \$30696 \$30625 \$30559
+ gf180mcu_fd_sc_mcu9t5v0__oai21_1
X$12055 \$29786 \$29433 \$29637 \$28702 \$29954 \$29847 \$29855
+ gf180mcu_fd_sc_mcu9t5v0__oai31_1
X$12056 \$28702 \$29864 \$29780 \$29847 \$29865 gf180mcu_fd_sc_mcu9t5v0__nand2_1
X$12057 \$28702 \$30061 \$30054 \$30185 \$30170 gf180mcu_fd_sc_mcu9t5v0__nand2_1
X$12058 \$28702 \$28938 \$28810 \$28971 \$28939 gf180mcu_fd_sc_mcu9t5v0__nand2_1
X$12059 \$28702 \$30034 \$30564 \$30485 \$30570 gf180mcu_fd_sc_mcu9t5v0__nand2_1
X$12060 \$28702 \$29541 \$29634 \$29424 \$29320 gf180mcu_fd_sc_mcu9t5v0__nand2_1
X$12061 \$29637 \$28702 \$29634 \$29720 \$29698 gf180mcu_fd_sc_mcu9t5v0__nand2_1
X$12062 \$30475 \$30402 \$30485 \$28702 gf180mcu_fd_sc_mcu9t5v0__buf_8
X$12063 \$28941 \$28940 \$28938 \$28810 \$28971 \$28703
+ gf180mcu_fd_sc_mcu9t5v0__nor3_1
X$12064 \$28707 \$29123 \$28971 \$28980 gf180mcu_fd_sc_mcu9t5v0__clkinv_1
X$12065 \$29438 \$28979 \$29304 \$29290 \$29270 \$28708
+ gf180mcu_fd_sc_mcu9t5v0__oai21_1
X$12066 \$29100 \$29123 \$28971 \$28710 gf180mcu_fd_sc_mcu9t5v0__clkinv_1
X$12067 \$28981 \$28810 \$28971 \$28711 gf180mcu_fd_sc_mcu9t5v0__clkinv_1
X$12068 \$28833 \$28810 \$28971 \$28714 gf180mcu_fd_sc_mcu9t5v0__clkinv_1
X$12069 \$28808 \$29123 \$28971 \$29119 gf180mcu_fd_sc_mcu9t5v0__buf_8
X$12070 \$28809 \$29123 \$28971 \$29120 gf180mcu_fd_sc_mcu9t5v0__buf_8
X$12071 \$28952 \$28810 \$28971 \$29106 gf180mcu_fd_sc_mcu9t5v0__buf_8
X$12072 \$28976 \$28954 \$28810 \$28971 \$28953 gf180mcu_fd_sc_mcu9t5v0__nor2_1
X$12073 \$29435 \$28810 \$28971 \$28937 gf180mcu_fd_sc_mcu9t5v0__clkinv_1
X$12074 \$29090 \$28936 \$28810 \$28971 \$28818 gf180mcu_fd_sc_mcu9t5v0__nand2_1
X$12075 \$28971 \$28810 gf180mcu_fd_sc_mcu9t5v0__filltie
X$12076 \$28971 \$28810 gf180mcu_fd_sc_mcu9t5v0__filltie
X$12077 \$28971 \$28810 gf180mcu_fd_sc_mcu9t5v0__filltie
X$12078 \$28971 \$28810 gf180mcu_fd_sc_mcu9t5v0__filltie
X$12079 \$28971 \$28810 gf180mcu_fd_sc_mcu9t5v0__filltie
X$12080 \$28971 \$28810 gf180mcu_fd_sc_mcu9t5v0__filltie
X$12081 \$28971 \$28810 gf180mcu_fd_sc_mcu9t5v0__endcap
X$12082 \$28971 \$28810 gf180mcu_fd_sc_mcu9t5v0__endcap
X$12083 \$28813 \$29425 \$30696 \$30625 \$30541 gf180mcu_fd_sc_mcu9t5v0__nand2_1
X$12084 \$28941 \$29123 \$28971 \$28823 \$28942 gf180mcu_fd_sc_mcu9t5v0__xor2_1
X$12085 \$28833 \$29308 \$29440 \$29290 \$29424 \$31412
+ gf180mcu_fd_sc_mcu9t5v0__aoi21_1
X$12086 \$28930 \$29232 \$29123 \$29270 \$29233 gf180mcu_fd_sc_mcu9t5v0__xnor2_1
X$12087 \$30042 \$30247 \$29279 \$30251 \$30185 \$28947
+ gf180mcu_fd_sc_mcu9t5v0__aoi21_1
X$12088 \$28976 \$29105 \$29123 \$28971 \$28951 gf180mcu_fd_sc_mcu9t5v0__nor2_1
X$12089 \$29137 \$28952 \$29136 \$29248 \$29123 \$29270 \$29250
+ gf180mcu_fd_sc_mcu9t5v0__nand4_1
X$12090 \$29252 \$29251 \$29123 \$29270 \$28954 gf180mcu_fd_sc_mcu9t5v0__xnor2_1
X$12091 \$28965 \$29290 \$29270 \$29841 gf180mcu_fd_sc_mcu9t5v0__buf_8
X$12092 \$28966 \$29290 \$29270 \$29288 gf180mcu_fd_sc_mcu9t5v0__buf_8
X$12093 \$28969 \$29233 \$29234 \$29123 \$29270 \$29231
+ gf180mcu_fd_sc_mcu9t5v0__oai21_1
X$12094 \$29106 \$29108 \$29123 \$28971 \$29105 gf180mcu_fd_sc_mcu9t5v0__xnor2_1
X$12095 \$29094 \$29095 \$29096 \$29123 \$28971 \$29093
+ gf180mcu_fd_sc_mcu9t5v0__aoi21_4
X$12096 \$29137 \$29138 \$29108 \$29123 \$28971 \$29139
+ gf180mcu_fd_sc_mcu9t5v0__nor3_1
X$12097 \$29108 \$28976 \$29123 \$28971 \$28983 gf180mcu_fd_sc_mcu9t5v0__nor2_1
X$12098 \$29096 \$29123 \$28971 \$28976 gf180mcu_fd_sc_mcu9t5v0__buf_8
X$12099 \$29092 \$29123 \$28971 \$29130 gf180mcu_fd_sc_mcu9t5v0__clkinv_1
X$12100 \$30901 \$29082 \$29123 \$28971 \$28975 gf180mcu_fd_sc_mcu9t5v0__nand2_1
X$12101 \$28983 \$29255 \$29123 \$28971 \$29110 gf180mcu_fd_sc_mcu9t5v0__nand2_1
X$12102 \$28971 \$29123 gf180mcu_fd_sc_mcu9t5v0__filltie
X$12103 \$28971 \$29123 gf180mcu_fd_sc_mcu9t5v0__filltie
X$12104 \$28971 \$29123 gf180mcu_fd_sc_mcu9t5v0__filltie
X$12105 \$28971 \$29123 gf180mcu_fd_sc_mcu9t5v0__filltie
X$12106 \$28971 \$29123 gf180mcu_fd_sc_mcu9t5v0__filltie
X$12107 \$28971 \$29123 gf180mcu_fd_sc_mcu9t5v0__filltie
X$12108 \$28971 \$29123 gf180mcu_fd_sc_mcu9t5v0__endcap
X$12109 \$28971 \$29123 gf180mcu_fd_sc_mcu9t5v0__endcap
X$12110 \$29629 \$29630 \$29634 \$29424 \$28974 gf180mcu_fd_sc_mcu9t5v0__nand2_1
X$12111 \$28981 \$29109 \$29123 \$29270 \$29245 gf180mcu_fd_sc_mcu9t5v0__nand2_1
X$12112 \$29078 \$29425 \$29290 \$29424 \$29292 gf180mcu_fd_sc_mcu9t5v0__nand2_1
X$12113 \$29924 \$29848 \$29849 \$29954 \$29847 \$29089
+ gf180mcu_fd_sc_mcu9t5v0__or3_1
X$12114 \$30550 \$29093 \$30488 \$30474 \$30402 \$30485 \$30472
+ gf180mcu_fd_sc_mcu9t5v0__oai31_4
X$12115 \$30550 \$29093 \$30488 \$30411 \$30402 \$30339 \$30318
+ gf180mcu_fd_sc_mcu9t5v0__oai31_4
X$12116 \$29093 \$30054 \$30027 \$30059 gf180mcu_fd_sc_mcu9t5v0__buf_8
X$12117 \$29132 \$29123 \$29270 \$29095 gf180mcu_fd_sc_mcu9t5v0__clkinv_1
X$12118 \$29134 \$29123 \$29270 \$29096 gf180mcu_fd_sc_mcu9t5v0__clkinv_1
X$12119 \$29100 \$29109 \$29645 \$29634 \$29424 \$29644
+ gf180mcu_fd_sc_mcu9t5v0__aoi21_1
X$12120 \$30071 \$29954 \$29847 \$29937 \$29101 gf180mcu_fd_sc_mcu9t5v0__xor2_1
X$12121 \$29312 \$29290 \$29270 \$29103 gf180mcu_fd_sc_mcu9t5v0__clkinv_1
X$12122 \$29252 \$29106 \$29108 \$29134 \$29123 \$29270 \$29254
+ gf180mcu_fd_sc_mcu9t5v0__nand4_1
X$12123 \$29252 \$29106 \$29123 \$29270 \$29109 gf180mcu_fd_sc_mcu9t5v0__nor2_1
X$12124 \$29137 \$29106 \$29123 \$29270 \$29255 gf180mcu_fd_sc_mcu9t5v0__nor2_1
X$12125 \$29106 \$29108 \$29123 \$29270 \$29251 gf180mcu_fd_sc_mcu9t5v0__nand2_1
X$12126 \$29137 \$29106 \$29290 \$29270 \$29329 gf180mcu_fd_sc_mcu9t5v0__nand2_1
X$12127 \$29106 \$29123 \$29270 \$29138 gf180mcu_fd_sc_mcu9t5v0__clkinv_1
X$12128 \$29108 \$29134 \$29255 \$29290 \$29270 \$29256
+ gf180mcu_fd_sc_mcu9t5v0__nand3_1
X$12129 \$29108 \$29329 \$29290 \$29424 \$29449 gf180mcu_fd_sc_mcu9t5v0__nand2_1
X$12130 \$29136 \$29123 \$29270 \$29108 gf180mcu_fd_sc_mcu9t5v0__buf_8
X$12131 \$30038 \$29109 \$29972 \$29954 \$30027 \$30036
+ gf180mcu_fd_sc_mcu9t5v0__aoi21_1
X$12132 \$29321 \$29249 \$29328 \$29123 \$29270 \$29281
+ gf180mcu_fd_sc_mcu9t5v0__oai21_1
X$12133 \$29139 \$29123 \$29270 \$29306 gf180mcu_fd_sc_mcu9t5v0__buf_8
X$12134 \$29137 \$29123 \$29270 \$29252 gf180mcu_fd_sc_mcu9t5v0__clkinv_1
X$12135 \$29246 \$29245 \$29123 \$29270 \$31182 gf180mcu_fd_sc_mcu9t5v0__nand2_1
X$12136 \$29270 \$29123 gf180mcu_fd_sc_mcu9t5v0__filltie
X$12137 \$29270 \$29123 gf180mcu_fd_sc_mcu9t5v0__filltie
X$12138 \$29270 \$29123 gf180mcu_fd_sc_mcu9t5v0__filltie
X$12139 \$29270 \$29123 gf180mcu_fd_sc_mcu9t5v0__filltie
X$12140 \$29270 \$29123 gf180mcu_fd_sc_mcu9t5v0__filltie
X$12141 \$29270 \$29123 gf180mcu_fd_sc_mcu9t5v0__filltie
X$12142 \$29270 \$29123 gf180mcu_fd_sc_mcu9t5v0__endcap
X$12143 \$29270 \$29123 gf180mcu_fd_sc_mcu9t5v0__endcap
X$12144 \$29250 \$29290 \$29270 \$29132 gf180mcu_fd_sc_mcu9t5v0__buf_8
X$12145 \$29134 \$29306 \$29290 \$29270 \$29282 gf180mcu_fd_sc_mcu9t5v0__nand2_1
X$12146 \$29248 \$29290 \$29424 \$29134 gf180mcu_fd_sc_mcu9t5v0__buf_8
X$12147 \$29235 \$30696 \$30763 gf180mcu_fd_sc_mcu9t5v0__inv_8
X$12148 \$31155 \$29239 \$30971 \$31032 \$31012 gf180mcu_fd_sc_mcu9t5v0__nor2_1
X$12149 \$29242 \$29539 \$29634 \$29424 \$29642 gf180mcu_fd_sc_mcu9t5v0__nand2_1
X$12150 \$31530 \$31020 \$29243 \$31239 \$30857 \$31535 \$31465 \$31529
+ gf180mcu_fd_sc_mcu9t5v0__oai221_1
X$12151 \$29310 \$29290 \$29270 \$29244 gf180mcu_fd_sc_mcu9t5v0__clkinv_1
X$12152 \$31962 \$32033 \$31967 \$32034 \$29247 gf180mcu_fd_sc_mcu9t5v0__xnor2_1
X$12153 \$29446 \$29444 \$29290 \$29424 \$29249 gf180mcu_fd_sc_mcu9t5v0__and2_1
X$12154 \$29329 \$29251 \$29290 \$29270 \$29308 gf180mcu_fd_sc_mcu9t5v0__nand2_1
X$12155 \$29255 \$29290 \$29270 \$29305 gf180mcu_fd_sc_mcu9t5v0__buf_8
X$12156 \$29324 \$29281 \$29290 \$29270 \$29327 gf180mcu_fd_sc_mcu9t5v0__and2_1
X$12157 \$29446 \$29444 \$29290 \$29270 \$29328 gf180mcu_fd_sc_mcu9t5v0__or2_1
X$12158 \$29315 \$29314 \$29316 \$29290 \$29270 \$29276
+ gf180mcu_fd_sc_mcu9t5v0__aoi21_1
X$12159 \$29324 \$29281 \$29290 \$29270 \$29280 gf180mcu_fd_sc_mcu9t5v0__nor2_1
X$12160 \$29273 \$29290 \$29270 \$30850 gf180mcu_fd_sc_mcu9t5v0__buf_8
X$12161 \$29270 \$29290 gf180mcu_fd_sc_mcu9t5v0__filltie
X$12162 \$29270 \$29290 gf180mcu_fd_sc_mcu9t5v0__filltie
X$12163 \$29270 \$29290 gf180mcu_fd_sc_mcu9t5v0__filltie
X$12164 \$29270 \$29290 gf180mcu_fd_sc_mcu9t5v0__filltie
X$12165 \$29270 \$29290 gf180mcu_fd_sc_mcu9t5v0__filltie
X$12166 \$29270 \$29290 gf180mcu_fd_sc_mcu9t5v0__filltie
X$12167 \$29270 \$29290 gf180mcu_fd_sc_mcu9t5v0__endcap
X$12168 \$29270 \$29290 gf180mcu_fd_sc_mcu9t5v0__endcap
X$12169 \$29279 \$30042 \$30247 \$30251 \$30339 \$30269
+ gf180mcu_fd_sc_mcu9t5v0__and3_1
X$12170 \$29716 \$29445 \$29279 \$29634 \$29424 \$29447
+ gf180mcu_fd_sc_mcu9t5v0__oai21_1
X$12171 \$29965 \$29424 \$29290 \$29448 gf180mcu_fd_sc_mcu9t5v0__clkbuf_16
X$12172 \$29439 \$29290 \$29424 \$29440 gf180mcu_fd_sc_mcu9t5v0__clkinv_1
X$12173 \$29424 \$29290 gf180mcu_fd_sc_mcu9t5v0__filltie
X$12174 \$29424 \$29290 gf180mcu_fd_sc_mcu9t5v0__filltie
X$12175 \$29424 \$29290 gf180mcu_fd_sc_mcu9t5v0__filltie
X$12176 \$29424 \$29290 gf180mcu_fd_sc_mcu9t5v0__filltie
X$12177 \$29424 \$29290 gf180mcu_fd_sc_mcu9t5v0__filltie
X$12178 \$29424 \$29290 gf180mcu_fd_sc_mcu9t5v0__filltie
X$12179 \$29424 \$29290 gf180mcu_fd_sc_mcu9t5v0__filltie
X$12180 \$29424 \$29290 gf180mcu_fd_sc_mcu9t5v0__filltie
X$12181 \$29424 \$29290 gf180mcu_fd_sc_mcu9t5v0__filltie
X$12182 \$29424 \$29290 gf180mcu_fd_sc_mcu9t5v0__filltie
X$12183 \$29424 \$29290 gf180mcu_fd_sc_mcu9t5v0__filltie
X$12184 \$29424 \$29290 gf180mcu_fd_sc_mcu9t5v0__filltie
X$12185 \$29424 \$29290 gf180mcu_fd_sc_mcu9t5v0__endcap
X$12186 \$29424 \$29290 gf180mcu_fd_sc_mcu9t5v0__endcap
X$12187 \$31240 \$29306 \$29305 \$31167 \$31182 \$31232 \$31175 \$31242
+ gf180mcu_fd_sc_mcu9t5v0__aoi221_1
X$12188 \$31109 \$29306 \$29305 \$31168 \$31182 \$31232 \$31175 \$31183
+ gf180mcu_fd_sc_mcu9t5v0__aoi221_1
X$12189 \$30710 \$29306 \$30689 \$30696 \$30625 \$30690
+ gf180mcu_fd_sc_mcu9t5v0__aoi21_1
X$12190 \$30265 \$29308 \$30068 \$30054 \$30027 \$30861
+ gf180mcu_fd_sc_mcu9t5v0__aoi21_1
X$12191 \$29311 \$29634 \$29720 \$29711 gf180mcu_fd_sc_mcu9t5v0__clkinv_1
X$12192 \$29319 \$29541 \$29634 \$29424 \$29317 gf180mcu_fd_sc_mcu9t5v0__nor2_1
X$12193 \$31882 \$29321 \$31810 \$31733 \$31026 gf180mcu_fd_sc_mcu9t5v0__nor2_1
X$12194 \$30070 \$31956 \$31967 \$31886 \$29321 gf180mcu_fd_sc_mcu9t5v0__nand2_1
X$12195 \$30045 \$30268 \$29954 \$29847 \$29324 gf180mcu_fd_sc_mcu9t5v0__and2_1
X$12196 \$29717 \$29327 \$29938 \$29780 \$29847 \$29801
+ gf180mcu_fd_sc_mcu9t5v0__aoi21_1
X$12197 \$30180 \$30070 \$30054 \$30027 \$29331 gf180mcu_fd_sc_mcu9t5v0__and2_1
X$12198 \$30075 \$30073 \$29331 \$29954 \$30027 \$29446
+ gf180mcu_fd_sc_mcu9t5v0__nand3_1
X$12199 \$29633 \$29429 \$29428 \$29536 \$29634 \$29424 \$29427
+ gf180mcu_fd_sc_mcu9t5v0__nand4_1
X$12200 \$29626 \$29627 \$29634 \$29424 \$29426 gf180mcu_fd_sc_mcu9t5v0__nor2_1
X$12201 \$29629 \$29628 \$29634 \$29424 \$29627 gf180mcu_fd_sc_mcu9t5v0__nand2_1
X$12202 \$29424 \$29634 gf180mcu_fd_sc_mcu9t5v0__filltie
X$12203 \$29424 \$29634 gf180mcu_fd_sc_mcu9t5v0__filltie
X$12204 \$29424 \$29634 gf180mcu_fd_sc_mcu9t5v0__endcap
X$12205 \$29424 \$29634 gf180mcu_fd_sc_mcu9t5v0__endcap
X$12206 \$29425 \$29626 \$29780 \$29720 \$29778 gf180mcu_fd_sc_mcu9t5v0__and2_1
X$12207 \$31012 \$29425 \$31013 \$30971 \$30900 \$30970
+ gf180mcu_fd_sc_mcu9t5v0__mux2_1
X$12208 \$30164 \$30058 \$30163 \$30054 \$30185 \$29428
+ gf180mcu_fd_sc_mcu9t5v0__nor3_1
X$12209 \$29433 \$29780 \$29720 \$29698 \$29700 gf180mcu_fd_sc_mcu9t5v0__xor2_1
X$12210 \$29925 \$29786 \$29433 \$29637 \$29954 \$29847 \$29957
+ gf180mcu_fd_sc_mcu9t5v0__nor4_1
X$12211 \$29436 \$29634 \$29720 \$29692 gf180mcu_fd_sc_mcu9t5v0__clkinv_1
X$12212 \$29920 \$29954 \$29847 \$29436 gf180mcu_fd_sc_mcu9t5v0__buf_8
X$12213 \$30354 \$30428 \$30402 \$30339 \$29442 gf180mcu_fd_sc_mcu9t5v0__xnor2_1
X$12214 \$30337 \$30335 \$30251 \$30339 \$29444 gf180mcu_fd_sc_mcu9t5v0__nand2_1
X$12215 \$29866 \$29730 \$29780 \$29720 \$29445 gf180mcu_fd_sc_mcu9t5v0__nor2_1
X$12216 \$32161 \$32101 \$29449 \$31967 \$32034 \$32026
+ gf180mcu_fd_sc_mcu9t5v0__mux2_1
X$12217 \$31747 \$31621 \$29449 \$31607 \$31733 \$31688
+ gf180mcu_fd_sc_mcu9t5v0__mux2_1
X$12218 \$31263 \$31322 \$29449 \$31232 \$31310 \$31262
+ gf180mcu_fd_sc_mcu9t5v0__mux2_1
X$12219 \$31618 \$31616 \$29449 \$31607 \$31584 \$31619
+ gf180mcu_fd_sc_mcu9t5v0__mux2_1
X$12220 \$32999 \$32774 \$29449 \$32853 \$32765 \$32858
+ gf180mcu_fd_sc_mcu9t5v0__mux2_1
X$12221 \$32090 \$31878 \$29449 \$32100 \$32034 \$32036
+ gf180mcu_fd_sc_mcu9t5v0__mux2_1
X$12222 \$32985 \$32638 \$29449 \$32721 \$32629 \$32531
+ gf180mcu_fd_sc_mcu9t5v0__mux2_1
X$12223 \$32532 \$32347 \$29449 \$32543 \$32467 \$32639
+ gf180mcu_fd_sc_mcu9t5v0__mux2_1
X$12224 \$29540 \$30696 \$30625 \$30689 gf180mcu_fd_sc_mcu9t5v0__clkinv_1
X$12225 \$29798 \$29728 \$29780 \$29720 \$29541 gf180mcu_fd_sc_mcu9t5v0__nand2_1
X$12226 \$29628 \$29626 \$29780 \$29720 \$29630 gf180mcu_fd_sc_mcu9t5v0__nor2_1
X$12227 \$29628 \$29778 \$29954 \$29847 \$29952 gf180mcu_fd_sc_mcu9t5v0__nand2_1
X$12228 \$29691 \$29634 \$29720 \$29629 gf180mcu_fd_sc_mcu9t5v0__clkinv_1
X$12229 \$29693 \$29630 \$29780 \$29847 \$29846 gf180mcu_fd_sc_mcu9t5v0__nand2_1
X$12230 \$29691 \$29630 \$29954 \$29847 \$29920 gf180mcu_fd_sc_mcu9t5v0__nand2_1
X$12231 \$29924 \$29848 \$29849 \$29780 \$29847 \$29633
+ gf180mcu_fd_sc_mcu9t5v0__nor3_1
X$12232 \$29710 \$29634 \$29720 \$29645 gf180mcu_fd_sc_mcu9t5v0__clkinv_1
X$12233 \$29720 \$29634 gf180mcu_fd_sc_mcu9t5v0__filltie
X$12234 \$29720 \$29634 gf180mcu_fd_sc_mcu9t5v0__filltie
X$12235 \$29720 \$29634 gf180mcu_fd_sc_mcu9t5v0__endcap
X$12236 \$29720 \$29634 gf180mcu_fd_sc_mcu9t5v0__endcap
X$12237 \$32422 \$31020 \$29644 \$31239 \$30327 \$31376 \$31310 \$31390
+ gf180mcu_fd_sc_mcu9t5v0__oai221_1
X$12238 \$29690 \$30678 \$30696 \$30625 \$30694 gf180mcu_fd_sc_mcu9t5v0__nand2_1
X$12239 \$29691 \$29778 \$29954 \$29847 \$29919 gf180mcu_fd_sc_mcu9t5v0__nand2_1
X$12240 \$29784 \$29780 \$29720 \$29696 gf180mcu_fd_sc_mcu9t5v0__clkinv_1
X$12241 \$29704 \$30064 \$30189 \$30251 \$30185 \$30242
+ gf180mcu_fd_sc_mcu9t5v0__oai21_1
X$12242 \$29704 \$29707 \$30174 \$30054 \$30027 \$30066
+ gf180mcu_fd_sc_mcu9t5v0__nand3_1
X$12243 \$29704 \$30064 \$30054 \$30027 \$30065 gf180mcu_fd_sc_mcu9t5v0__nor2_1
X$12244 \$29704 \$29707 \$29780 \$29847 \$29858 gf180mcu_fd_sc_mcu9t5v0__nand2_1
X$12245 \$30322 \$30564 \$30485 \$29706 \$30617 gf180mcu_fd_sc_mcu9t5v0__xor2_1
X$12246 \$30259 \$29706 \$30323 \$30324 \$30251 \$30339 \$30351
+ gf180mcu_fd_sc_mcu9t5v0__aoi211_1
X$12247 \$30259 \$29706 \$30402 \$30339 \$30417 gf180mcu_fd_sc_mcu9t5v0__nor2_1
X$12248 \$30259 \$29706 \$30402 \$30339 \$30418 gf180mcu_fd_sc_mcu9t5v0__nand2_1
X$12249 \$30322 \$29706 \$30402 \$30339 \$30330 gf180mcu_fd_sc_mcu9t5v0__nand2_1
X$12250 \$29707 \$30054 \$30027 \$30064 gf180mcu_fd_sc_mcu9t5v0__clkinv_1
X$12251 \$30631 \$29708 \$30564 \$30625 \$30614 gf180mcu_fd_sc_mcu9t5v0__xnor2_1
X$12252 \$30631 \$29708 \$30564 \$30625 \$30632 gf180mcu_fd_sc_mcu9t5v0__and2_1
X$12253 \$30568 \$29708 \$30615 \$30564 \$30485 \$30479
+ gf180mcu_fd_sc_mcu9t5v0__oai21_1
X$12254 \$30568 \$29708 \$30696 \$30625 \$30688 gf180mcu_fd_sc_mcu9t5v0__nor2_1
X$12255 \$29712 \$29796 \$29780 \$29847 \$29727 gf180mcu_fd_sc_mcu9t5v0__nor2_1
X$12256 \$30634 \$30564 \$30485 \$30559 \$29714 gf180mcu_fd_sc_mcu9t5v0__xor2_1
X$12257 \$29715 \$29977 \$29954 \$30027 \$30042 gf180mcu_fd_sc_mcu9t5v0__nand2_1
X$12258 \$29938 \$29979 \$29954 \$29847 \$29717 gf180mcu_fd_sc_mcu9t5v0__nor2_1
X$12259 \$29866 \$29730 \$29780 \$29720 \$29731 gf180mcu_fd_sc_mcu9t5v0__and2_1
X$12260 \$29784 \$29722 \$29783 \$29780 \$29720 \$29782
+ gf180mcu_fd_sc_mcu9t5v0__aoi21_1
X$12261 \$29720 \$29780 gf180mcu_fd_sc_mcu9t5v0__filltie
X$12262 \$29720 \$29780 gf180mcu_fd_sc_mcu9t5v0__filltie
X$12263 \$29720 \$29780 gf180mcu_fd_sc_mcu9t5v0__endcap
X$12264 \$29720 \$29780 gf180mcu_fd_sc_mcu9t5v0__endcap
X$12265 \$29785 \$29722 \$29784 \$29780 \$29847 \$29783
+ gf180mcu_fd_sc_mcu9t5v0__aoi21_1
X$12266 \$29784 \$29722 \$30056 \$29954 \$30027 \$30029
+ gf180mcu_fd_sc_mcu9t5v0__aoi21_1
X$12267 \$30056 \$29722 \$30029 \$30054 \$30027 \$30165
+ gf180mcu_fd_sc_mcu9t5v0__aoi21_1
X$12268 \$29722 \$31253 \$31232 \$31310 \$31177 gf180mcu_fd_sc_mcu9t5v0__nor2_1
X$12269 \$29722 \$31971 \$31967 \$32034 \$32018 gf180mcu_fd_sc_mcu9t5v0__nor2_1
X$12270 \$29722 \$30166 \$30054 \$30185 \$30057 gf180mcu_fd_sc_mcu9t5v0__nor2_1
X$12271 \$29722 \$30609 \$30564 \$30625 \$30626 gf180mcu_fd_sc_mcu9t5v0__nor2_1
X$12272 \$29722 \$31377 \$31376 \$31310 \$31254 gf180mcu_fd_sc_mcu9t5v0__nor2_1
X$12273 \$29722 \$31588 \$31607 \$31584 \$31608 gf180mcu_fd_sc_mcu9t5v0__nor2_1
X$12274 \$29722 \$31741 \$31607 \$31584 \$31609 gf180mcu_fd_sc_mcu9t5v0__nor2_1
X$12275 \$29722 \$31875 \$31967 \$31886 \$31948 gf180mcu_fd_sc_mcu9t5v0__nor2_1
X$12276 \$29722 \$30956 \$30971 \$30900 \$30957 gf180mcu_fd_sc_mcu9t5v0__nor2_1
X$12277 \$30566 \$30696 \$30625 \$29722 gf180mcu_fd_sc_mcu9t5v0__buf_8
X$12278 \$29927 \$29954 \$29847 \$29962 \$29724 gf180mcu_fd_sc_mcu9t5v0__xor2_1
X$12279 \$30071 \$30039 \$29864 \$29954 \$29847 \$29728
+ gf180mcu_fd_sc_mcu9t5v0__nor3_1
X$12280 \$29919 \$29779 \$29954 \$29847 \$30053 gf180mcu_fd_sc_mcu9t5v0__nand2_1
X$12281 \$29786 \$29787 \$29780 \$29847 \$29788 gf180mcu_fd_sc_mcu9t5v0__xnor2_1
X$12282 \$29797 \$29780 \$29847 \$29798 gf180mcu_fd_sc_mcu9t5v0__clkinv_1
X$12283 \$30056 \$29780 \$29847 \$29785 gf180mcu_fd_sc_mcu9t5v0__clkinv_1
X$12284 \$29847 \$29780 gf180mcu_fd_sc_mcu9t5v0__filltie
X$12285 \$29847 \$29780 gf180mcu_fd_sc_mcu9t5v0__filltie
X$12286 \$29847 \$29780 gf180mcu_fd_sc_mcu9t5v0__endcap
X$12287 \$29847 \$29780 gf180mcu_fd_sc_mcu9t5v0__endcap
X$12288 \$30163 \$30253 \$29781 \$30820 \$30771 \$30819 \$30763 \$30821
+ gf180mcu_fd_sc_mcu9t5v0__oai221_1
X$12289 \$31424 \$31117 \$29801 \$31397 \$31376 \$31465 \$31425 \$31398
+ gf180mcu_fd_sc_mcu9t5v0__oai32_4
X$12290 \$31117 \$29801 \$31376 \$31310 \$31399 gf180mcu_fd_sc_mcu9t5v0__nor2_1
X$12291 \$29952 \$29846 \$29954 \$29847 \$29845 gf180mcu_fd_sc_mcu9t5v0__nand2_1
X$12292 \$29848 \$29922 \$29954 \$29847 \$29921 gf180mcu_fd_sc_mcu9t5v0__xnor2_1
X$12293 \$29931 \$29932 \$29969 \$29954 \$29847 \$29933
+ gf180mcu_fd_sc_mcu9t5v0__oai21_1
X$12294 \$29923 \$29953 \$29954 \$29847 \$29922 gf180mcu_fd_sc_mcu9t5v0__nor2_1
X$12295 \$29862 \$29954 \$29847 \$29972 gf180mcu_fd_sc_mcu9t5v0__clkinv_1
X$12296 \$29974 \$29935 \$29954 \$29847 \$29973 gf180mcu_fd_sc_mcu9t5v0__nand2_1
X$12297 \$29847 \$29954 gf180mcu_fd_sc_mcu9t5v0__filltie
X$12298 \$29847 \$29954 gf180mcu_fd_sc_mcu9t5v0__filltie
X$12299 \$29847 \$29954 gf180mcu_fd_sc_mcu9t5v0__endcap
X$12300 \$29847 \$29954 gf180mcu_fd_sc_mcu9t5v0__endcap
X$12301 \$29924 \$30028 \$30251 \$30185 \$30340 \$29849
+ gf180mcu_fd_sc_mcu9t5v0__xnor3_1
X$12302 \$29849 \$30164 \$30058 \$30163 \$30054 \$30185 \$30186
+ gf180mcu_fd_sc_mcu9t5v0__nor4_1
X$12303 \$29924 \$29849 \$30028 \$29954 \$30027 \$29923
+ gf180mcu_fd_sc_mcu9t5v0__nor3_1
X$12304 \$29849 \$30340 \$30235 \$30402 \$30339 \$30310
+ gf180mcu_fd_sc_mcu9t5v0__mux2_1
X$12305 \$29851 \$30404 \$30695 \$30696 \$30625 \$30699
+ gf180mcu_fd_sc_mcu9t5v0__aoi21_2
X$12306 \$30543 \$29851 \$30254 \$30405 \$30402 \$30339 \$30406
+ gf180mcu_fd_sc_mcu9t5v0__oai22_1
X$12307 \$30316 \$29851 \$30239 \$30405 \$30402 \$30339 \$30346
+ gf180mcu_fd_sc_mcu9t5v0__oai22_1
X$12308 \$29851 \$30404 \$30564 \$30625 \$30627 gf180mcu_fd_sc_mcu9t5v0__nand2_1
X$12309 \$29925 \$29855 \$29954 \$30027 \$29958 gf180mcu_fd_sc_mcu9t5v0__xnor2_1
X$12310 \$30037 \$30054 \$30027 \$29859 gf180mcu_fd_sc_mcu9t5v0__clkinv_1
X$12311 \$30258 \$29860 \$29954 \$30027 \$29971 gf180mcu_fd_sc_mcu9t5v0__nand2_1
X$12312 \$31414 \$31020 \$29861 \$31239 \$30833 \$31232 \$31310 \$31315
+ gf180mcu_fd_sc_mcu9t5v0__oai221_1
X$12313 \$30427 \$30426 \$30402 \$30339 \$29864 gf180mcu_fd_sc_mcu9t5v0__nand2_1
X$12314 \$29866 \$30497 \$30482 \$30402 \$30485 \$30483
+ gf180mcu_fd_sc_mcu9t5v0__nor3_1
X$12315 \$30497 \$30482 \$29866 \$30564 \$30485 \$30247
+ gf180mcu_fd_sc_mcu9t5v0__oai21_1
X$12316 \$29924 \$30251 \$30185 \$30235 \$30309 gf180mcu_fd_sc_mcu9t5v0__xor2_1
X$12317 \$29926 \$30170 \$30054 \$30185 \$30171 gf180mcu_fd_sc_mcu9t5v0__xnor2_1
X$12318 \$29927 \$29926 \$30061 \$29954 \$30027 \$29963
+ gf180mcu_fd_sc_mcu9t5v0__nor3_1
X$12319 \$29930 \$29964 \$30251 \$30185 \$30260 gf180mcu_fd_sc_mcu9t5v0__xnor2_1
X$12320 \$29930 \$29964 \$30251 \$30339 \$30328 gf180mcu_fd_sc_mcu9t5v0__and2_1
X$12321 \$29930 \$30326 \$30351 \$30251 \$30339 \$30262
+ gf180mcu_fd_sc_mcu9t5v0__aoi21_1
X$12322 \$29931 \$29954 \$30027 \$30033 gf180mcu_fd_sc_mcu9t5v0__clkinv_1
X$12323 \$30043 \$30045 \$30044 \$29954 \$30027 \$29938
+ gf180mcu_fd_sc_mcu9t5v0__aoi21_1
X$12324 \$29965 \$30027 \$29954 \$29943 gf180mcu_fd_sc_mcu9t5v0__clkbuf_16
X$12325 \$30031 \$30027 \$29954 \$29965 gf180mcu_fd_sc_mcu9t5v0__clkbuf_16
X$12326 \$30044 \$30043 \$30045 \$29954 \$30027 \$29979
+ gf180mcu_fd_sc_mcu9t5v0__and3_1
X$12327 \$30035 \$29954 \$30027 \$30068 gf180mcu_fd_sc_mcu9t5v0__clkinv_1
X$12328 \$29961 \$29954 \$30027 \$30030 gf180mcu_fd_sc_mcu9t5v0__clkinv_1
X$12329 \$30033 \$29963 \$29954 \$30027 \$30034 gf180mcu_fd_sc_mcu9t5v0__nand2_1
X$12330 \$30027 \$29954 gf180mcu_fd_sc_mcu9t5v0__filltie
X$12331 \$30027 \$29954 gf180mcu_fd_sc_mcu9t5v0__filltie
X$12332 \$30027 \$29954 gf180mcu_fd_sc_mcu9t5v0__endcap
X$12333 \$30027 \$29954 gf180mcu_fd_sc_mcu9t5v0__endcap
X$12334 \$29955 \$30054 \$30027 \$30164 gf180mcu_fd_sc_mcu9t5v0__buf_8
X$12335 \$30030 \$29957 \$30054 \$30027 \$30061 gf180mcu_fd_sc_mcu9t5v0__nand2_1
X$12336 \$29964 \$30402 \$30339 \$30326 gf180mcu_fd_sc_mcu9t5v0__clkinv_1
X$12337 \$30173 \$30054 \$30185 \$29967 \$30174 gf180mcu_fd_sc_mcu9t5v0__xor2_1
X$12338 \$30173 \$29967 \$30054 \$30185 \$30189 gf180mcu_fd_sc_mcu9t5v0__xnor2_1
X$12339 \$30173 \$29967 \$30402 \$30339 \$30416 gf180mcu_fd_sc_mcu9t5v0__nand2_1
X$12340 \$29967 \$30402 \$30339 \$30350 gf180mcu_fd_sc_mcu9t5v0__clkinv_1
X$12341 \$30070 \$30073 \$30054 \$30027 \$30074 gf180mcu_fd_sc_mcu9t5v0__nand2_1
X$12342 \$30027 \$30054 gf180mcu_fd_sc_mcu9t5v0__filltie
X$12343 \$30027 \$30054 gf180mcu_fd_sc_mcu9t5v0__filltie
X$12344 \$30027 \$30054 gf180mcu_fd_sc_mcu9t5v0__endcap
X$12345 \$30027 \$30054 gf180mcu_fd_sc_mcu9t5v0__endcap
X$12346 \$30343 \$30028 \$30236 \$30402 \$30339 \$30400
+ gf180mcu_fd_sc_mcu9t5v0__nand3_1
X$12347 \$30028 \$30236 \$30251 \$30185 \$30235 gf180mcu_fd_sc_mcu9t5v0__nand2_1
X$12348 \$30028 \$30236 \$30401 \$30402 \$30339 \$30341
+ gf180mcu_fd_sc_mcu9t5v0__mux2_1
X$12349 \$30030 \$30060 \$30054 \$30185 \$30188 gf180mcu_fd_sc_mcu9t5v0__xnor2_1
X$12350 \$30965 \$30900 \$30971 \$30031 gf180mcu_fd_sc_mcu9t5v0__clkbuf_16
X$12351 \$30634 \$30691 \$30034 \$30564 \$30625 \$30426
+ gf180mcu_fd_sc_mcu9t5v0__nor3_1
X$12352 \$31022 \$31020 \$30036 \$31239 \$30633 \$30971 \$31032 \$31021
+ gf180mcu_fd_sc_mcu9t5v0__oai221_1
X$12353 \$30337 \$30336 \$30251 \$30339 \$30043 gf180mcu_fd_sc_mcu9t5v0__or2_1
X$12354 \$31116 \$31093 \$31100 \$31032 \$30044 gf180mcu_fd_sc_mcu9t5v0__xnor2_1
X$12355 \$31026 \$30431 \$30430 \$30402 \$30339 \$30045
+ gf180mcu_fd_sc_mcu9t5v0__or3_1
X$12356 \$30159 \$30054 \$30185 \$30183 gf180mcu_fd_sc_mcu9t5v0__clkinv_1
X$12357 \$30180 \$30075 \$30054 \$30185 \$30076 gf180mcu_fd_sc_mcu9t5v0__nand2_1
X$12358 \$30174 \$30065 \$30054 \$30185 \$30190 gf180mcu_fd_sc_mcu9t5v0__nand2_1
X$12359 \$30185 \$30054 gf180mcu_fd_sc_mcu9t5v0__filltie
X$12360 \$30185 \$30054 gf180mcu_fd_sc_mcu9t5v0__filltie
X$12361 \$30185 \$30054 gf180mcu_fd_sc_mcu9t5v0__endcap
X$12362 \$30185 \$30054 gf180mcu_fd_sc_mcu9t5v0__endcap
X$12363 \$30470 \$30486 \$30469 \$30252 \$30402 \$30485 \$30055
+ gf180mcu_fd_sc_mcu9t5v0__nor4_1
X$12364 \$30238 \$30058 \$30251 \$30185 \$30239 gf180mcu_fd_sc_mcu9t5v0__or2_1
X$12365 \$30059 \$30960 \$31232 \$31310 \$31879 gf180mcu_fd_sc_mcu9t5v0__nor2_1
X$12366 \$30059 \$30488 \$31100 \$31032 \$31019 gf180mcu_fd_sc_mcu9t5v0__nor2_1
X$12367 \$30059 \$31182 \$32248 \$32307 \$32321 gf180mcu_fd_sc_mcu9t5v0__nand2_1
X$12368 \$30555 \$30416 \$30066 \$30819 \$30763 \$30832
+ gf180mcu_fd_sc_mcu9t5v0__and3_1
X$12369 \$30416 \$30066 \$30555 \$30696 \$30625 \$30707
+ gf180mcu_fd_sc_mcu9t5v0__aoi21_1
X$12370 \$31267 \$30070 \$31391 \$31264 \$31535 \$31465 \$31532
+ gf180mcu_fd_sc_mcu9t5v0__and4_1
X$12371 \$30070 \$31391 \$31754 \$31607 \$31584 \$31420
+ gf180mcu_fd_sc_mcu9t5v0__nand3_1
X$12372 \$30075 \$31391 \$31264 \$30070 \$31535 \$31465 \$31531
+ gf180mcu_fd_sc_mcu9t5v0__aoi22_1
X$12373 \$30075 \$31935 \$31751 \$30070 \$31967 \$31886 \$31833
+ gf180mcu_fd_sc_mcu9t5v0__aoi22_1
X$12374 \$30075 \$31956 \$31935 \$30070 \$31967 \$31886 \$30430
+ gf180mcu_fd_sc_mcu9t5v0__aoi22_1
X$12375 \$30070 \$31751 \$31967 \$32034 \$31973 gf180mcu_fd_sc_mcu9t5v0__nand2_1
X$12376 \$30070 \$31391 \$31535 \$31584 \$31596 gf180mcu_fd_sc_mcu9t5v0__nand2_1
X$12377 \$30070 \$31935 \$31967 \$31886 \$31887 gf180mcu_fd_sc_mcu9t5v0__nand2_1
X$12378 \$31025 \$30971 \$31032 \$30070 gf180mcu_fd_sc_mcu9t5v0__buf_8
X$12379 \$30483 \$30481 \$30402 \$30485 \$30072 gf180mcu_fd_sc_mcu9t5v0__nor2_1
X$12380 \$30075 \$30073 \$30251 \$30339 \$30355 gf180mcu_fd_sc_mcu9t5v0__nand2_1
X$12381 \$31416 \$30073 \$31376 \$31465 \$31172 gf180mcu_fd_sc_mcu9t5v0__nand2_1
X$12382 \$31417 \$30073 \$31376 \$31310 \$31272 gf180mcu_fd_sc_mcu9t5v0__nand2_1
X$12383 \$32163 \$32100 \$32034 \$30073 gf180mcu_fd_sc_mcu9t5v0__buf_8
X$12384 \$30075 \$31935 \$31967 \$32034 \$31882 gf180mcu_fd_sc_mcu9t5v0__nand2_1
X$12385 \$31111 \$31100 \$31032 \$30075 gf180mcu_fd_sc_mcu9t5v0__buf_8
X$12386 \$31321 \$31320 \$31376 \$31310 \$30160 gf180mcu_fd_sc_mcu9t5v0__nor2_1
X$12387 \$30964 \$31015 \$30162 \$30971 \$30900 \$30848
+ gf180mcu_fd_sc_mcu9t5v0__oai21_2
X$12388 \$31524 \$31535 \$31465 \$30162 gf180mcu_fd_sc_mcu9t5v0__clkinv_1
X$12389 \$30850 \$30960 \$30753 \$30163 \$30819 \$30900 \$30825
+ gf180mcu_fd_sc_mcu9t5v0__aoi211_2
X$12390 \$30684 \$30685 \$30683 \$30164 \$30696 \$30625 \$30611
+ gf180mcu_fd_sc_mcu9t5v0__oai31_4
X$12391 \$30167 \$30403 \$30316 \$30251 \$30339 \$30315
+ gf180mcu_fd_sc_mcu9t5v0__aoi21_1
X$12392 \$30409 \$30318 \$30346 \$30251 \$30339 \$30168
+ gf180mcu_fd_sc_mcu9t5v0__nand3_1
X$12393 \$30173 \$30350 \$30402 \$30339 \$30415 gf180mcu_fd_sc_mcu9t5v0__nand2_1
X$12394 \$31024 \$31020 \$30690 \$31239 \$30175 \$30971 \$31032 \$31023
+ gf180mcu_fd_sc_mcu9t5v0__oai221_1
X$12395 \$30175 \$30776 \$30696 \$30625 \$30761 gf180mcu_fd_sc_mcu9t5v0__nand2_1
X$12396 \$30180 \$31416 \$31376 \$31465 \$31271 gf180mcu_fd_sc_mcu9t5v0__nand2_1
X$12397 \$30180 \$31417 \$31376 \$31310 \$30429 gf180mcu_fd_sc_mcu9t5v0__nand2_1
X$12398 \$31746 \$31810 \$31733 \$30180 gf180mcu_fd_sc_mcu9t5v0__buf_8
X$12399 \$31029 \$31027 \$30971 \$31032 \$30181 \$30967
+ gf180mcu_fd_sc_mcu9t5v0__xnor3_1
X$12400 \$30181 \$31100 \$31032 \$31117 gf180mcu_fd_sc_mcu9t5v0__clkinv_1
X$12401 \$30184 \$31464 \$31376 \$31465 \$31400 gf180mcu_fd_sc_mcu9t5v0__nand2_1
X$12402 \$30184 \$31874 \$31810 \$31886 \$31802 gf180mcu_fd_sc_mcu9t5v0__nand2_1
X$12403 \$30184 \$31375 \$31376 \$31310 \$31374 gf180mcu_fd_sc_mcu9t5v0__nand2_1
X$12404 \$30184 \$31803 \$31810 \$31733 \$31677 gf180mcu_fd_sc_mcu9t5v0__nand2_1
X$12405 \$30184 \$31805 \$31810 \$31733 \$31679 gf180mcu_fd_sc_mcu9t5v0__nand2_1
X$12406 \$30184 \$31604 \$31607 \$31584 \$31603 gf180mcu_fd_sc_mcu9t5v0__nand2_1
X$12407 \$30184 \$31607 \$31733 \$31732 gf180mcu_fd_sc_mcu9t5v0__clkinv_1
X$12408 \$30237 \$30251 \$30185 \$30235 \$30311 gf180mcu_fd_sc_mcu9t5v0__xor2_1
X$12409 \$30323 \$30244 \$30251 \$30185 \$30261 gf180mcu_fd_sc_mcu9t5v0__and2_1
X$12410 \$30265 \$30251 \$30185 \$30249 gf180mcu_fd_sc_mcu9t5v0__clkinv_1
X$12411 \$30242 \$30190 \$30251 \$30185 \$30257 gf180mcu_fd_sc_mcu9t5v0__nand2_1
X$12412 \$30327 \$30246 \$30251 \$30185 \$30263 gf180mcu_fd_sc_mcu9t5v0__nand2_1
X$12413 \$30185 \$30251 gf180mcu_fd_sc_mcu9t5v0__filltie
X$12414 \$30185 \$30251 gf180mcu_fd_sc_mcu9t5v0__filltie
X$12415 \$30185 \$30251 gf180mcu_fd_sc_mcu9t5v0__endcap
X$12416 \$30185 \$30251 gf180mcu_fd_sc_mcu9t5v0__endcap
X$12417 \$31382 \$31611 \$30187 \$31742 \$31607 \$31584 \$31610
+ gf180mcu_fd_sc_mcu9t5v0__oai31_1
X$12418 \$30191 \$30333 \$30251 \$30339 \$30332 gf180mcu_fd_sc_mcu9t5v0__nand2_1
X$12419 \$30191 \$30251 \$30339 \$30334 gf180mcu_fd_sc_mcu9t5v0__clkinv_1
X$12420 \$30237 \$30402 \$30339 \$30343 \$30401 gf180mcu_fd_sc_mcu9t5v0__xor2_1
X$12421 \$30237 \$30343 \$30402 \$30339 \$30312 gf180mcu_fd_sc_mcu9t5v0__nand2_1
X$12422 \$30318 \$30409 \$30239 \$30402 \$30485 \$30487
+ gf180mcu_fd_sc_mcu9t5v0__aoi21_2
X$12423 \$30415 \$30242 \$30554 \$30564 \$30485 \$30567
+ gf180mcu_fd_sc_mcu9t5v0__aoi21_1
X$12424 \$30415 \$30242 \$30402 \$30485 \$30492 gf180mcu_fd_sc_mcu9t5v0__nand2_1
X$12425 \$30417 \$30479 \$30418 \$30402 \$30485 \$30244
+ gf180mcu_fd_sc_mcu9t5v0__oai21_1
X$12426 \$30260 \$30330 \$30419 \$30251 \$30339 \$30353
+ gf180mcu_fd_sc_mcu9t5v0__and3_1
X$12427 \$30330 \$30419 \$30260 \$30251 \$30339 \$30329
+ gf180mcu_fd_sc_mcu9t5v0__aoi21_1
X$12428 \$30314 \$30315 \$30251 \$30339 \$30345 gf180mcu_fd_sc_mcu9t5v0__nor2_1
X$12429 \$30328 \$30329 \$30251 \$30339 \$30266 gf180mcu_fd_sc_mcu9t5v0__nor2_1
X$12430 \$30322 \$30251 \$30339 \$30259 gf180mcu_fd_sc_mcu9t5v0__clkinv_1
X$12431 \$30260 \$30251 \$30339 \$30323 gf180mcu_fd_sc_mcu9t5v0__clkinv_1
X$12432 \$30339 \$30251 gf180mcu_fd_sc_mcu9t5v0__filltie
X$12433 \$30339 \$30251 gf180mcu_fd_sc_mcu9t5v0__filltie
X$12434 \$30339 \$30251 gf180mcu_fd_sc_mcu9t5v0__endcap
X$12435 \$30339 \$30251 gf180mcu_fd_sc_mcu9t5v0__endcap
X$12436 \$30253 \$30696 \$30763 \$30405 gf180mcu_fd_sc_mcu9t5v0__buf_8
X$12437 \$30472 \$30409 \$30254 \$30564 \$30485 \$30549
+ gf180mcu_fd_sc_mcu9t5v0__aoi21_1
X$12438 \$30404 \$30255 \$30628 \$30553 \$30564 \$30625 \$30629
+ gf180mcu_fd_sc_mcu9t5v0__aoi22_1
X$12439 \$31092 \$31020 \$30861 \$31239 \$30258 \$31100 \$31032 \$31110
+ gf180mcu_fd_sc_mcu9t5v0__oai221_1
X$12440 \$30332 \$30402 \$30485 \$30262 \$30421 gf180mcu_fd_sc_mcu9t5v0__xor2_1
X$12441 \$30333 \$30262 \$30334 \$30402 \$30339 \$30423
+ gf180mcu_fd_sc_mcu9t5v0__aoi21_1
X$12442 \$30333 \$30262 \$30480 \$30334 \$30402 \$30485 \$30482
+ gf180mcu_fd_sc_mcu9t5v0__aoi211_1
X$12443 \$30558 \$30267 \$30422 \$30564 \$30485 \$30495
+ gf180mcu_fd_sc_mcu9t5v0__and3_1
X$12444 \$30267 \$30422 \$30558 \$30564 \$30485 \$30493
+ gf180mcu_fd_sc_mcu9t5v0__aoi21_1
X$12445 \$31026 \$30430 \$30431 \$30402 \$30485 \$30268
+ gf180mcu_fd_sc_mcu9t5v0__oai21_1
X$12446 \$31947 \$30314 \$31967 \$31886 \$31946 gf180mcu_fd_sc_mcu9t5v0__nor2_1
X$12447 \$30314 \$31823 \$31810 \$31886 \$31824 gf180mcu_fd_sc_mcu9t5v0__nor2_1
X$12448 \$30314 \$31683 \$31607 \$31733 \$31739 gf180mcu_fd_sc_mcu9t5v0__nor2_1
X$12449 \$30314 \$31590 \$31535 \$31584 \$31589 gf180mcu_fd_sc_mcu9t5v0__nor2_1
X$12450 \$30314 \$31517 \$31535 \$31465 \$31537 gf180mcu_fd_sc_mcu9t5v0__nor2_1
X$12451 \$30314 \$30822 \$30819 \$30763 \$30751 gf180mcu_fd_sc_mcu9t5v0__nor2_1
X$12452 \$30314 \$30542 \$30564 \$30485 \$30471 gf180mcu_fd_sc_mcu9t5v0__nor2_1
X$12453 \$30314 \$30958 \$30971 \$30900 \$30959 gf180mcu_fd_sc_mcu9t5v0__nor2_1
X$12454 \$30320 \$30477 \$30613 \$30564 \$30625 \$30612
+ gf180mcu_fd_sc_mcu9t5v0__oai21_1
X$12455 \$30349 \$30402 \$30339 \$30320 gf180mcu_fd_sc_mcu9t5v0__clkinv_1
X$12456 \$30614 \$30612 \$30417 \$30688 \$30564 \$30625 \$30324
+ gf180mcu_fd_sc_mcu9t5v0__aoi211_1
X$12457 \$30328 \$30329 \$30332 \$30402 \$30339 \$30422
+ gf180mcu_fd_sc_mcu9t5v0__oai21_1
X$12458 \$30429 \$30355 \$30402 \$30339 \$30335 gf180mcu_fd_sc_mcu9t5v0__nand2_1
X$12459 \$31271 \$31272 \$31232 \$31310 \$30336 gf180mcu_fd_sc_mcu9t5v0__xnor2_1
X$12460 \$30337 \$30336 \$30402 \$30339 \$30431 gf180mcu_fd_sc_mcu9t5v0__xnor2_1
X$12461 \$30429 \$30355 \$30402 \$30339 \$30337 gf180mcu_fd_sc_mcu9t5v0__or2_1
X$12462 \$30400 \$30341 \$30402 \$30339 \$30342 gf180mcu_fd_sc_mcu9t5v0__nand2_1
X$12463 \$30339 \$30402 gf180mcu_fd_sc_mcu9t5v0__filltie
X$12464 \$30339 \$30402 gf180mcu_fd_sc_mcu9t5v0__filltie
X$12465 \$30339 \$30402 gf180mcu_fd_sc_mcu9t5v0__endcap
X$12466 \$30339 \$30402 gf180mcu_fd_sc_mcu9t5v0__endcap
X$12467 \$30901 \$30347 \$32255 \$32023 \$31967 \$32034 \$31825
+ gf180mcu_fd_sc_mcu9t5v0__and4_1
X$12468 \$32020 \$32019 \$31967 \$32034 \$30347 gf180mcu_fd_sc_mcu9t5v0__or2_1
X$12469 \$30347 \$30553 \$30564 \$30485 \$30475 gf180mcu_fd_sc_mcu9t5v0__nand2_1
X$12470 \$30349 \$30477 \$30819 \$30763 \$30705 gf180mcu_fd_sc_mcu9t5v0__xnor2_1
X$12471 \$30349 \$30477 \$30819 \$30763 \$30773 gf180mcu_fd_sc_mcu9t5v0__nand2_1
X$12472 \$30354 \$30402 \$30485 \$30427 gf180mcu_fd_sc_mcu9t5v0__clkinv_1
X$12473 \$30558 \$30402 \$30485 \$30480 gf180mcu_fd_sc_mcu9t5v0__clkinv_1
X$12474 \$30487 \$30402 \$30485 \$30410 gf180mcu_fd_sc_mcu9t5v0__clkinv_1
X$12475 \$30485 \$30402 gf180mcu_fd_sc_mcu9t5v0__filltie
X$12476 \$30485 \$30402 gf180mcu_fd_sc_mcu9t5v0__filltie
X$12477 \$30485 \$30402 gf180mcu_fd_sc_mcu9t5v0__endcap
X$12478 \$30485 \$30402 gf180mcu_fd_sc_mcu9t5v0__endcap
X$12479 \$31970 \$30403 \$31405 \$31967 \$31886 \$31947
+ gf180mcu_fd_sc_mcu9t5v0__aoi21_1
X$12480 \$31612 \$30403 \$31519 \$31810 \$31733 \$31823
+ gf180mcu_fd_sc_mcu9t5v0__aoi21_1
X$12481 \$30565 \$30403 \$30543 \$30564 \$30485 \$30542
+ gf180mcu_fd_sc_mcu9t5v0__aoi21_1
X$12482 \$30972 \$30403 \$30902 \$30971 \$30900 \$30958
+ gf180mcu_fd_sc_mcu9t5v0__aoi21_1
X$12483 \$30697 \$30403 \$30820 \$30696 \$30625 \$30822
+ gf180mcu_fd_sc_mcu9t5v0__aoi21_1
X$12484 \$30825 \$30405 \$30819 \$30763 \$30849 gf180mcu_fd_sc_mcu9t5v0__nor2_2
X$12485 \$30545 \$30406 \$30564 \$30485 \$30544 gf180mcu_fd_sc_mcu9t5v0__nand2_1
X$12486 \$30407 \$30752 \$30772 \$30696 \$30763 \$30680
+ gf180mcu_fd_sc_mcu9t5v0__nor3_1
X$12487 \$30409 \$30472 \$30564 \$30485 \$30545 gf180mcu_fd_sc_mcu9t5v0__and2_1
X$12488 \$30753 \$30826 \$30754 \$30696 \$30763 \$30409
+ gf180mcu_fd_sc_mcu9t5v0__aoi21_1
X$12489 \$31016 \$30849 \$30410 \$30971 \$30900 \$30547
+ gf180mcu_fd_sc_mcu9t5v0__nand3_1
X$12490 \$30551 \$30474 \$30411 \$30412 \$30564 \$30485 \$30552
+ gf180mcu_fd_sc_mcu9t5v0__and4_1
X$12491 \$30550 \$30686 \$30564 \$30485 \$30412 gf180mcu_fd_sc_mcu9t5v0__nor2_1
X$12492 \$30632 \$30616 \$30617 \$30564 \$30625 \$30419
+ gf180mcu_fd_sc_mcu9t5v0__oai21_1
X$12493 \$30558 \$30423 \$30564 \$30625 \$30621 gf180mcu_fd_sc_mcu9t5v0__nor2_1
X$12494 \$30691 \$30564 \$30625 \$30570 \$30424 gf180mcu_fd_sc_mcu9t5v0__xor2_1
X$12495 \$30469 \$31100 \$31032 \$31084 gf180mcu_fd_sc_mcu9t5v0__clkinv_1
X$12496 \$30470 \$30971 \$30900 \$30844 gf180mcu_fd_sc_mcu9t5v0__clkinv_1
X$12497 \$30617 \$30479 \$30618 \$30564 \$30625 \$30619
+ gf180mcu_fd_sc_mcu9t5v0__oai21_1
X$12498 \$30555 \$30492 \$30564 \$30485 \$30556 gf180mcu_fd_sc_mcu9t5v0__xnor2_1
X$12499 \$30549 \$30682 \$30548 \$30547 \$30564 \$30485 \$30566
+ gf180mcu_fd_sc_mcu9t5v0__nor4_1
X$12500 \$30562 \$30540 \$30541 \$30564 \$30485 \$30608
+ gf180mcu_fd_sc_mcu9t5v0__oai21_1
X$12501 \$30555 \$30564 \$30485 \$30554 gf180mcu_fd_sc_mcu9t5v0__clkinv_1
X$12502 \$30544 \$30564 \$30485 \$30565 gf180mcu_fd_sc_mcu9t5v0__clkinv_1
X$12503 \$30485 \$30564 gf180mcu_fd_sc_mcu9t5v0__filltie
X$12504 \$30485 \$30564 gf180mcu_fd_sc_mcu9t5v0__filltie
X$12505 \$30485 \$30564 gf180mcu_fd_sc_mcu9t5v0__endcap
X$12506 \$30485 \$30564 gf180mcu_fd_sc_mcu9t5v0__endcap
X$12507 \$30486 \$31100 \$31032 \$31083 gf180mcu_fd_sc_mcu9t5v0__clkinv_1
X$12508 \$30549 \$30487 \$30564 \$30625 \$30683 gf180mcu_fd_sc_mcu9t5v0__or2_2
X$12509 \$31036 \$30971 \$31032 \$30488 gf180mcu_fd_sc_mcu9t5v0__inv_1
X$12510 \$30494 \$30564 \$30625 \$30622 gf180mcu_fd_sc_mcu9t5v0__clkinv_1
X$12511 \$30540 \$30694 \$30696 \$30763 \$30764 gf180mcu_fd_sc_mcu9t5v0__and2_1
X$12512 \$31085 \$30824 \$31101 \$31100 \$31032 \$30540
+ gf180mcu_fd_sc_mcu9t5v0__nand3_1
X$12513 \$30546 \$30681 \$30696 \$30625 \$30698 gf180mcu_fd_sc_mcu9t5v0__nor2_1
X$12514 \$31017 \$30848 \$30847 \$30971 \$31032 \$30548
+ gf180mcu_fd_sc_mcu9t5v0__nand3_1
X$12515 \$30550 \$30686 \$30551 \$30696 \$30625 \$30755
+ gf180mcu_fd_sc_mcu9t5v0__oai21_1
X$12516 \$30550 \$30696 \$30625 \$30765 gf180mcu_fd_sc_mcu9t5v0__clkinv_1
X$12517 \$30852 \$30550 \$30767 \$30819 \$30900 \$30853
+ gf180mcu_fd_sc_mcu9t5v0__mux2_1
X$12518 \$30551 \$30699 \$30755 \$30696 \$30763 \$30754
+ gf180mcu_fd_sc_mcu9t5v0__oai21_1
X$12519 \$30551 \$30699 \$30819 \$30763 \$30829 gf180mcu_fd_sc_mcu9t5v0__nor2_1
X$12520 \$30551 \$31258 \$31100 \$31175 \$30823 gf180mcu_fd_sc_mcu9t5v0__nand2_1
X$12521 \$30551 \$30696 \$30763 \$30753 gf180mcu_fd_sc_mcu9t5v0__clkinv_1
X$12522 \$30830 \$30552 \$30819 \$30763 \$31165 gf180mcu_fd_sc_mcu9t5v0__nor2_1
X$12523 \$31813 \$31812 \$31825 \$31810 \$31886 \$30553
+ gf180mcu_fd_sc_mcu9t5v0__nand3_1
X$12524 \$30687 \$30756 \$30696 \$30763 \$30555 gf180mcu_fd_sc_mcu9t5v0__xnor2_1
X$12525 \$30562 \$30561 \$30624 \$30696 \$30625 \$30843
+ gf180mcu_fd_sc_mcu9t5v0__oai21_1
X$12526 \$31516 \$31013 \$30563 \$32721 \$32765 \$32720
+ gf180mcu_fd_sc_mcu9t5v0__and3_1
X$12527 \$31013 \$30563 \$31516 \$32721 \$32629 \$32700
+ gf180mcu_fd_sc_mcu9t5v0__aoi21_1
X$12528 \$31155 \$30563 \$31232 \$31175 \$32404 gf180mcu_fd_sc_mcu9t5v0__nand2_1
X$12529 \$30631 \$30564 \$30625 \$30568 gf180mcu_fd_sc_mcu9t5v0__clkinv_1
X$12530 \$30633 \$30569 \$30564 \$30625 \$30620 gf180mcu_fd_sc_mcu9t5v0__nand2_1
X$12531 \$30614 \$30612 \$30564 \$30625 \$30615 gf180mcu_fd_sc_mcu9t5v0__nand2_1
X$12532 \$30625 \$30564 gf180mcu_fd_sc_mcu9t5v0__filltie
X$12533 \$30625 \$30564 gf180mcu_fd_sc_mcu9t5v0__filltie
X$12534 \$30625 \$30564 gf180mcu_fd_sc_mcu9t5v0__endcap
X$12535 \$30625 \$30564 gf180mcu_fd_sc_mcu9t5v0__endcap
X$12536 \$30705 \$30757 \$30567 \$30696 \$30763 \$30758
+ gf180mcu_fd_sc_mcu9t5v0__or3_1
X$12537 \$30757 \$30567 \$30705 \$30696 \$30625 \$30613
+ gf180mcu_fd_sc_mcu9t5v0__oai21_1
X$12538 \$30614 \$30612 \$30819 \$30763 \$30855 gf180mcu_fd_sc_mcu9t5v0__xnor2_1
X$12539 \$30613 \$30758 \$30696 \$30763 \$30768 gf180mcu_fd_sc_mcu9t5v0__nand2_1
X$12540 \$30614 \$30773 \$30774 \$30819 \$30900 \$30834
+ gf180mcu_fd_sc_mcu9t5v0__and3_1
X$12541 \$30773 \$30774 \$30614 \$30819 \$30763 \$30616
+ gf180mcu_fd_sc_mcu9t5v0__aoi21_1
X$12542 \$30632 \$30616 \$30696 \$30625 \$30708 gf180mcu_fd_sc_mcu9t5v0__nor2_1
X$12543 \$30617 \$30708 \$30696 \$30625 \$30709 gf180mcu_fd_sc_mcu9t5v0__xnor2_1
X$12544 \$30700 \$30696 \$30625 \$30686 gf180mcu_fd_sc_mcu9t5v0__inv_1
X$12545 \$30687 \$30696 \$30625 \$30704 gf180mcu_fd_sc_mcu9t5v0__clkinv_1
X$12546 \$30625 \$30696 gf180mcu_fd_sc_mcu9t5v0__filltie
X$12547 \$30625 \$30696 gf180mcu_fd_sc_mcu9t5v0__filltie
X$12548 \$30625 \$30696 gf180mcu_fd_sc_mcu9t5v0__endcap
X$12549 \$30625 \$30696 gf180mcu_fd_sc_mcu9t5v0__endcap
X$12550 \$31261 \$30629 \$31612 \$31232 \$31310 \$31312
+ gf180mcu_fd_sc_mcu9t5v0__mux2_1
X$12551 \$31520 \$31521 \$31380 \$31518 \$30975 \$31519 \$31535 \$31465 \$30681
+ gf180mcu_fd_sc_mcu9t5v0__oai222_1
X$12552 \$30963 \$30845 \$30971 \$31032 \$30682 gf180mcu_fd_sc_mcu9t5v0__nand2_1
X$12553 \$30848 \$30849 \$30847 \$30819 \$30900 \$30845 \$30684
+ gf180mcu_fd_sc_mcu9t5v0__nand4_2
X$12554 \$31016 \$30963 \$31017 \$30971 \$30900 \$30685
+ gf180mcu_fd_sc_mcu9t5v0__nand3_2
X$12555 \$30687 \$30756 \$30707 \$30696 \$30763 \$30759
+ gf180mcu_fd_sc_mcu9t5v0__aoi21_1
X$12556 \$30765 \$30696 \$30763 \$30701 gf180mcu_fd_sc_mcu9t5v0__buf_8
X$12557 \$30704 \$30756 \$30696 \$30763 \$30757 gf180mcu_fd_sc_mcu9t5v0__nor2_1
X$12558 \$30699 \$30700 \$30767 \$30696 \$30763 \$30766
+ gf180mcu_fd_sc_mcu9t5v0__mux2_1
X$12559 \$30763 \$30696 gf180mcu_fd_sc_mcu9t5v0__filltie
X$12560 \$30763 \$30696 gf180mcu_fd_sc_mcu9t5v0__filltie
X$12561 \$30763 \$30696 gf180mcu_fd_sc_mcu9t5v0__endcap
X$12562 \$30763 \$30696 gf180mcu_fd_sc_mcu9t5v0__endcap
X$12563 \$30767 \$30819 \$30763 \$30697 gf180mcu_fd_sc_mcu9t5v0__clkinv_1
X$12564 \$30765 \$30753 \$30700 \$30819 \$30763 \$30830
+ gf180mcu_fd_sc_mcu9t5v0__nor3_2
X$12565 \$30705 \$30759 \$30819 \$30763 \$30774 gf180mcu_fd_sc_mcu9t5v0__or2_1
X$12566 \$31405 \$31256 \$31255 \$31233 \$31232 \$31310 \$30752
+ gf180mcu_fd_sc_mcu9t5v0__oai22_1
X$12567 \$30753 \$30826 \$30819 \$30763 \$30828 gf180mcu_fd_sc_mcu9t5v0__nand2_1
X$12568 \$30829 \$30755 \$30830 \$30828 \$30819 \$30763 \$30827
+ gf180mcu_fd_sc_mcu9t5v0__oai31_2
X$12569 \$30833 \$30837 \$30819 \$30763 \$30760 gf180mcu_fd_sc_mcu9t5v0__nand2_1
X$12570 \$30841 \$30863 \$30907 \$30819 \$30763 \$30840
+ gf180mcu_fd_sc_mcu9t5v0__and3_2
X$12571 \$30821 \$30819 \$30763 \$30826 gf180mcu_fd_sc_mcu9t5v0__clkinv_1
X$12572 \$30821 \$30823 \$30819 \$30763 \$30767 gf180mcu_fd_sc_mcu9t5v0__nand2_1
X$12573 \$30763 \$30819 gf180mcu_fd_sc_mcu9t5v0__filltie
X$12574 \$30763 \$30819 gf180mcu_fd_sc_mcu9t5v0__filltie
X$12575 \$30763 \$30819 gf180mcu_fd_sc_mcu9t5v0__endcap
X$12576 \$30763 \$30819 gf180mcu_fd_sc_mcu9t5v0__endcap
X$12577 \$30846 \$31015 \$30844 \$30819 \$30900 \$30845
+ gf180mcu_fd_sc_mcu9t5v0__oai21_2
X$12578 \$30827 \$30819 \$30900 \$31015 gf180mcu_fd_sc_mcu9t5v0__buf_8
X$12579 \$30857 \$30860 \$30819 \$30900 \$30836 gf180mcu_fd_sc_mcu9t5v0__nand2_1
X$12580 \$30900 \$30819 gf180mcu_fd_sc_mcu9t5v0__filltie
X$12581 \$30900 \$30819 gf180mcu_fd_sc_mcu9t5v0__filltie
X$12582 \$30900 \$30819 gf180mcu_fd_sc_mcu9t5v0__endcap
X$12583 \$30900 \$30819 gf180mcu_fd_sc_mcu9t5v0__endcap
X$12584 \$30826 \$30823 \$30971 \$31032 \$31034 gf180mcu_fd_sc_mcu9t5v0__nand2_1
X$12585 \$31015 \$30846 \$30971 \$31032 \$30824 gf180mcu_fd_sc_mcu9t5v0__nor2_1
X$12586 \$30824 \$30973 \$30971 \$31032 \$31014 gf180mcu_fd_sc_mcu9t5v0__nand2_1
X$12587 \$30838 \$30971 \$31032 gf180mcu_fd_sc_mcu9t5v0__clkinv_8
X$12588 \$33544 \$33533 \$33528 \$33527 \$30841 gf180mcu_fd_sc_mcu9t5v0__or2_1
X$12589 \$30863 \$30841 \$30907 \$30971 \$30900 \$30862
+ gf180mcu_fd_sc_mcu9t5v0__aoi21_2
X$12590 \$30960 \$30850 \$30974 \$30971 \$30900 \$30846
+ gf180mcu_fd_sc_mcu9t5v0__aoi21_4
X$12591 \$31086 \$31015 \$31084 \$31100 \$31032 \$30847
+ gf180mcu_fd_sc_mcu9t5v0__oai21_2
X$12592 \$30960 \$30850 \$31103 \$31100 \$31175 \$31158
+ gf180mcu_fd_sc_mcu9t5v0__aoi21_4
X$12593 \$30960 \$30850 \$31257 \$31232 \$31175 \$31086
+ gf180mcu_fd_sc_mcu9t5v0__aoi21_4
X$12594 \$30850 \$30960 \$31018 \$30971 \$31032 \$30964
+ gf180mcu_fd_sc_mcu9t5v0__aoi21_4
X$12595 \$30850 \$30960 \$31163 \$31100 \$31175 \$31162
+ gf180mcu_fd_sc_mcu9t5v0__aoi21_4
X$12596 \$30850 \$30960 \$31178 \$31232 \$31175 \$31238
+ gf180mcu_fd_sc_mcu9t5v0__aoi21_2
X$12597 \$30850 \$31232 \$31175 \$31239 gf180mcu_fd_sc_mcu9t5v0__buf_8
X$12598 \$31540 \$30851 \$31592 \$31535 \$31584 \$31541
+ gf180mcu_fd_sc_mcu9t5v0__oai21_1
X$12599 \$30852 \$31685 \$31607 \$31733 \$31614 gf180mcu_fd_sc_mcu9t5v0__nand2_1
X$12600 \$30858 \$31100 \$31032 gf180mcu_fd_sc_mcu9t5v0__clkbuf_4
X$12601 \$31098 \$31097 \$31099 \$31100 \$31032 \$30863
+ gf180mcu_fd_sc_mcu9t5v0__oai21_2
X$12602 \$31029 \$30967 \$30971 \$30900 \$30906 gf180mcu_fd_sc_mcu9t5v0__or2_1
X$12603 \$31025 \$30971 \$30900 \$31024 gf180mcu_fd_sc_mcu9t5v0__inv_1
X$12604 \$30951 \$30971 \$30900 \$30952 gf180mcu_fd_sc_mcu9t5v0__clkinv_1
X$12605 \$30900 \$30971 gf180mcu_fd_sc_mcu9t5v0__filltie
X$12606 \$30900 \$30971 gf180mcu_fd_sc_mcu9t5v0__filltie
X$12607 \$30900 \$30971 gf180mcu_fd_sc_mcu9t5v0__endcap
X$12608 \$30900 \$30971 gf180mcu_fd_sc_mcu9t5v0__endcap
X$12609 \$32552 \$32151 \$30901 \$32339 \$32307 \$32345
+ gf180mcu_fd_sc_mcu9t5v0__oai21_1
X$12610 \$30901 \$32151 \$32339 \$32307 \$32346 gf180mcu_fd_sc_mcu9t5v0__nand2_1
X$12611 \$30901 \$31607 \$31733 \$30955 gf180mcu_fd_sc_mcu9t5v0__clkinv_1
X$12612 \$31744 \$30901 \$32253 \$32100 \$32171 \$32155
+ gf180mcu_fd_sc_mcu9t5v0__mux2_1
X$12613 \$30901 \$31744 \$32023 \$31967 \$32034 \$31972
+ gf180mcu_fd_sc_mcu9t5v0__mux2_1
X$12614 \$30901 \$31744 \$32255 \$32248 \$32171 \$32177
+ gf180mcu_fd_sc_mcu9t5v0__mux2_1
X$12615 \$31411 \$31020 \$31412 \$31239 \$30904 \$31376 \$31465 \$31413
+ gf180mcu_fd_sc_mcu9t5v0__oai221_1
X$12616 \$30904 \$31266 \$31232 \$31310 \$31244 gf180mcu_fd_sc_mcu9t5v0__nand2_1
X$12617 \$31027 \$31039 \$30906 \$31100 \$31032 \$31329
+ gf180mcu_fd_sc_mcu9t5v0__oai21_1
X$12618 \$33728 \$33722 \$33716 \$33727 \$30907 gf180mcu_fd_sc_mcu9t5v0__xor2_1
X$12619 \$32086 \$32227 \$32248 \$32171 \$30950 gf180mcu_fd_sc_mcu9t5v0__nand2_1
X$12620 \$30950 \$32224 \$32248 \$32171 \$32226 gf180mcu_fd_sc_mcu9t5v0__nand2_1
X$12621 \$31154 \$31031 \$31100 \$31175 \$30951 gf180mcu_fd_sc_mcu9t5v0__or2_1
X$12622 \$32519 \$30953 \$32912 \$32853 \$32934 \$32911
+ gf180mcu_fd_sc_mcu9t5v0__oai21_1
X$12623 \$32251 \$30953 \$32913 \$32992 \$32934 \$32980
+ gf180mcu_fd_sc_mcu9t5v0__oai21_1
X$12624 \$31945 \$30953 \$31968 \$31967 \$31886 \$31969
+ gf180mcu_fd_sc_mcu9t5v0__oai21_1
X$12625 \$30955 \$31813 \$31810 \$31733 \$31744 gf180mcu_fd_sc_mcu9t5v0__or2_1
X$12626 \$31239 \$30960 \$31232 \$31310 \$31258 gf180mcu_fd_sc_mcu9t5v0__nand2_1
X$12627 \$31036 \$31100 \$31175 \$30960 gf180mcu_fd_sc_mcu9t5v0__buf_8
X$12628 \$31158 \$31015 \$31083 \$31100 \$31032 \$30963
+ gf180mcu_fd_sc_mcu9t5v0__oai21_2
X$12629 \$31015 \$30964 \$30971 \$31032 \$30975 gf180mcu_fd_sc_mcu9t5v0__nor2_1
X$12630 \$32017 \$32034 \$31967 \$30965 gf180mcu_fd_sc_mcu9t5v0__clkbuf_16
X$12631 \$33730 \$33727 \$33724 \$33722 \$33716 \$30966
+ gf180mcu_fd_sc_mcu9t5v0__oai21_1
X$12632 \$31246 \$31316 \$31232 \$31175 \$30967 gf180mcu_fd_sc_mcu9t5v0__xnor2_1
X$12633 \$31029 \$30967 \$30971 \$31032 \$31039 gf180mcu_fd_sc_mcu9t5v0__and2_1
X$12634 \$31026 \$31113 \$31028 \$30971 \$31032 \$31027
+ gf180mcu_fd_sc_mcu9t5v0__aoi21_1
X$12635 \$31035 \$30971 \$31032 \$31018 gf180mcu_fd_sc_mcu9t5v0__clkinv_1
X$12636 \$31032 \$30971 gf180mcu_fd_sc_mcu9t5v0__filltie
X$12637 \$31032 \$30971 gf180mcu_fd_sc_mcu9t5v0__filltie
X$12638 \$31032 \$30971 gf180mcu_fd_sc_mcu9t5v0__endcap
X$12639 \$31032 \$30971 gf180mcu_fd_sc_mcu9t5v0__endcap
X$12640 \$31088 \$31100 \$31032 \$30974 gf180mcu_fd_sc_mcu9t5v0__clkinv_1
X$12641 \$30975 \$31523 \$31535 \$31465 \$31540 gf180mcu_fd_sc_mcu9t5v0__nand2_1
X$12642 \$31013 \$31376 \$31465 \$31404 \$31373 gf180mcu_fd_sc_mcu9t5v0__xor2_1
X$12643 \$31013 \$32339 \$32467 \$31375 \$32409 gf180mcu_fd_sc_mcu9t5v0__xor2_1
X$12644 \$31013 \$31807 \$32248 \$32307 \$32230 gf180mcu_fd_sc_mcu9t5v0__and2_1
X$12645 \$31013 \$32142 \$32543 \$32467 \$32546 gf180mcu_fd_sc_mcu9t5v0__and2_1
X$12646 \$31013 \$32698 \$32633 \$32704 \$32721 \$32765 \$32768
+ gf180mcu_fd_sc_mcu9t5v0__aoi22_1
X$12647 \$31013 \$32142 \$32339 \$32467 \$32411 gf180mcu_fd_sc_mcu9t5v0__nand2_1
X$12648 \$31013 \$31404 \$31535 \$31584 \$31536 gf180mcu_fd_sc_mcu9t5v0__nand2_1
X$12649 \$31516 \$31013 \$32519 \$32721 \$32629 \$32703
+ gf180mcu_fd_sc_mcu9t5v0__mux2_1
X$12650 \$31238 \$31015 \$31237 \$31232 \$31175 \$31016
+ gf180mcu_fd_sc_mcu9t5v0__oai21_2
X$12651 \$31015 \$31158 \$31086 \$31159 \$31100 \$31175 \$31101
+ gf180mcu_fd_sc_mcu9t5v0__nor4_1
X$12652 \$31015 \$31162 \$31104 \$31100 \$31032 \$31017
+ gf180mcu_fd_sc_mcu9t5v0__oai21_2
X$12653 \$31015 \$31158 \$31232 \$31310 \$31255 gf180mcu_fd_sc_mcu9t5v0__nor2_1
X$12654 \$31015 \$31238 \$31232 \$31310 \$31256 gf180mcu_fd_sc_mcu9t5v0__nor2_1
X$12655 \$31015 \$31086 \$31232 \$31310 \$31380 gf180mcu_fd_sc_mcu9t5v0__nor2_1
X$12656 \$31015 \$31162 \$31100 \$31175 \$31521 gf180mcu_fd_sc_mcu9t5v0__nor2_1
X$12657 \$31528 \$31020 \$31242 \$31239 \$31325 \$31535 \$31465 \$31543
+ gf180mcu_fd_sc_mcu9t5v0__oai221_1
X$12658 \$31239 \$31183 \$31020 \$31410 \$31243 \$31376 \$31465 \$31409
+ gf180mcu_fd_sc_mcu9t5v0__oai221_1
X$12659 \$32418 \$31020 \$32321 \$32339 \$32307 \$32348
+ gf180mcu_fd_sc_mcu9t5v0__oai21_1
X$12660 \$31879 \$32339 \$32307 \$31020 gf180mcu_fd_sc_mcu9t5v0__clkinv_1
X$12661 \$31324 \$31388 \$31020 \$31376 \$31310 \$31389
+ gf180mcu_fd_sc_mcu9t5v0__mux2_1
X$12662 \$32265 \$32339 \$32307 \$31022 gf180mcu_fd_sc_mcu9t5v0__clkinv_1
X$12663 \$31324 \$31022 \$32339 \$32307 \$32713 gf180mcu_fd_sc_mcu9t5v0__nand2_1
X$12664 \$31324 \$31267 \$31024 \$31264 \$31232 \$31310 \$31171
+ gf180mcu_fd_sc_mcu9t5v0__nand4_1
X$12665 \$31324 \$31024 \$31264 \$31267 \$31232 \$31310 \$31245
+ gf180mcu_fd_sc_mcu9t5v0__aoi22_1
X$12666 \$31408 \$31024 \$31376 \$31310 \$31269 gf180mcu_fd_sc_mcu9t5v0__nand2_1
X$12667 \$31096 \$31113 \$31100 \$31175 \$31116 \$31026
+ gf180mcu_fd_sc_mcu9t5v0__xnor3_1
X$12668 \$31026 \$31113 \$31100 \$31032 \$31095 gf180mcu_fd_sc_mcu9t5v0__xnor2_1
X$12669 \$31096 \$31095 \$31100 \$31032 \$31028 gf180mcu_fd_sc_mcu9t5v0__nor2_1
X$12670 \$31116 \$31093 \$31100 \$31032 \$31029 gf180mcu_fd_sc_mcu9t5v0__nand2_1
X$12671 \$32148 \$32147 \$32308 \$32100 \$32171 \$31031
+ gf180mcu_fd_sc_mcu9t5v0__nand3_1
X$12672 \$31035 \$31164 \$31088 \$31087 \$31100 \$31032 \$31105
+ gf180mcu_fd_sc_mcu9t5v0__nand4_1
X$12673 \$31112 \$31172 \$31100 \$31032 \$31094 gf180mcu_fd_sc_mcu9t5v0__or2_1
X$12674 \$31098 \$31097 \$31100 \$31032 \$31040 gf180mcu_fd_sc_mcu9t5v0__nor2_1
X$12675 \$31094 \$31114 \$31100 \$31032 \$31115 gf180mcu_fd_sc_mcu9t5v0__nor2_1
X$12676 \$31091 \$31100 \$31032 \$31103 gf180mcu_fd_sc_mcu9t5v0__clkinv_1
X$12677 \$31032 \$31100 gf180mcu_fd_sc_mcu9t5v0__filltie
X$12678 \$31032 \$31100 gf180mcu_fd_sc_mcu9t5v0__filltie
X$12679 \$31032 \$31100 gf180mcu_fd_sc_mcu9t5v0__endcap
X$12680 \$31032 \$31100 gf180mcu_fd_sc_mcu9t5v0__endcap
X$12681 \$31035 \$31258 \$31376 \$31465 \$31384 gf180mcu_fd_sc_mcu9t5v0__nand2_1
X$12682 \$31163 \$31165 \$31105 \$31100 \$31175 \$31036 \$31103
+ gf180mcu_fd_sc_mcu9t5v0__nor4_2
X$12683 \$31746 \$31038 \$32100 \$32034 \$32094 gf180mcu_fd_sc_mcu9t5v0__nand2_1
X$12684 \$31038 \$32339 \$32307 \$32265 gf180mcu_fd_sc_mcu9t5v0__buf_8
X$12685 \$31164 \$31258 \$31232 \$31310 \$31085 gf180mcu_fd_sc_mcu9t5v0__nand2_1
X$12686 \$31085 \$31382 \$31376 \$31310 \$31383 gf180mcu_fd_sc_mcu9t5v0__nand2_1
X$12687 \$31087 \$31232 \$31310 \$31257 gf180mcu_fd_sc_mcu9t5v0__clkinv_1
X$12688 \$31111 \$31100 \$31175 \$31092 gf180mcu_fd_sc_mcu9t5v0__inv_1
X$12689 \$31324 \$31092 \$31100 \$31175 \$32326 gf180mcu_fd_sc_mcu9t5v0__nand2_1
X$12690 \$31882 \$31883 \$31967 \$31886 \$31093 \$31973
+ gf180mcu_fd_sc_mcu9t5v0__xnor3_1
X$12691 \$31094 \$31173 \$31232 \$31175 \$31246 \$31174
+ gf180mcu_fd_sc_mcu9t5v0__xnor3_1
X$12692 \$31271 \$31272 \$31232 \$31310 \$31096 gf180mcu_fd_sc_mcu9t5v0__or2_1
X$12693 \$32589 \$32540 \$32541 \$32543 \$32467 \$31097
+ gf180mcu_fd_sc_mcu9t5v0__aoi21_2
X$12694 \$33441 \$33437 \$33317 \$33423 \$31098 gf180mcu_fd_sc_mcu9t5v0__nor2_1
X$12695 \$33544 \$33528 \$33624 \$33533 \$31099 gf180mcu_fd_sc_mcu9t5v0__xor2_1
X$12696 \$31112 \$31100 \$31175 \$31172 \$31113 gf180mcu_fd_sc_mcu9t5v0__xor2_1
X$12697 \$31174 \$31173 \$31100 \$31175 \$31114 gf180mcu_fd_sc_mcu9t5v0__xnor2_1
X$12698 \$31392 \$31245 \$31171 \$31100 \$31175 \$31184
+ gf180mcu_fd_sc_mcu9t5v0__oai21_1
X$12699 \$31175 \$31100 gf180mcu_fd_sc_mcu9t5v0__filltie
X$12700 \$31175 \$31100 gf180mcu_fd_sc_mcu9t5v0__filltie
X$12701 \$31175 \$31100 gf180mcu_fd_sc_mcu9t5v0__endcap
X$12702 \$31175 \$31100 gf180mcu_fd_sc_mcu9t5v0__endcap
X$12703 \$31321 \$31376 \$31310 \$31104 gf180mcu_fd_sc_mcu9t5v0__clkinv_1
X$12704 \$31111 \$31232 \$31175 \$31267 gf180mcu_fd_sc_mcu9t5v0__buf_8
X$12705 \$31746 \$32095 \$32100 \$32034 \$31112 gf180mcu_fd_sc_mcu9t5v0__nand2_1
X$12706 \$31174 \$31173 \$31115 \$31232 \$31310 \$31395
+ gf180mcu_fd_sc_mcu9t5v0__aoi21_1
X$12707 \$31154 \$31156 \$31232 \$31175 \$31229 gf180mcu_fd_sc_mcu9t5v0__and2_1
X$12708 \$32225 \$32333 \$32226 \$32248 \$32171 \$31154
+ gf180mcu_fd_sc_mcu9t5v0__aoi21_1
X$12709 \$31156 \$32720 \$32700 \$32721 \$32765 \$32767
+ gf180mcu_fd_sc_mcu9t5v0__nor3_1
X$12710 \$31156 \$32766 \$32721 \$32765 \$32719 gf180mcu_fd_sc_mcu9t5v0__nor2_1
X$12711 \$31386 \$31232 \$31310 \$31163 gf180mcu_fd_sc_mcu9t5v0__clkinv_1
X$12712 \$31164 \$31232 \$31175 \$31178 gf180mcu_fd_sc_mcu9t5v0__clkinv_1
X$12713 \$31243 \$31170 \$31232 \$31175 \$31169 gf180mcu_fd_sc_mcu9t5v0__nand2_1
X$12714 \$32094 \$32100 \$32034 \$32029 \$31173 gf180mcu_fd_sc_mcu9t5v0__xor2_1
X$12715 \$31753 \$31887 \$31883 \$31833 \$31810 \$31886 \$31174
+ gf180mcu_fd_sc_mcu9t5v0__oai22_2
X$12716 \$31175 \$31232 gf180mcu_fd_sc_mcu9t5v0__filltie
X$12717 \$31175 \$31232 gf180mcu_fd_sc_mcu9t5v0__filltie
X$12718 \$31175 \$31232 gf180mcu_fd_sc_mcu9t5v0__endcap
X$12719 \$31175 \$31232 gf180mcu_fd_sc_mcu9t5v0__endcap
X$12720 \$31319 \$31230 \$31252 \$31251 \$31232 \$31310 \$31176
+ gf180mcu_fd_sc_mcu9t5v0__oai31_1
X$12721 \$31184 \$32328 \$32543 \$32467 \$32536 gf180mcu_fd_sc_mcu9t5v0__xnor2_1
X$12722 \$31184 \$32328 \$32339 \$32467 \$32465 gf180mcu_fd_sc_mcu9t5v0__nand2_1
X$12723 \$31229 \$31247 \$31232 \$31310 \$31248 gf180mcu_fd_sc_mcu9t5v0__nand2_1
X$12724 \$31230 \$32332 \$32403 \$32339 \$32467 \$32402
+ gf180mcu_fd_sc_mcu9t5v0__oai21_1
X$12725 \$31230 \$32246 \$32247 \$32248 \$32171 \$32145
+ gf180mcu_fd_sc_mcu9t5v0__oai21_1
X$12726 \$32780 \$31230 \$32781 \$32853 \$32765 \$32779
+ gf180mcu_fd_sc_mcu9t5v0__oai21_1
X$12727 \$31231 \$32248 \$32171 gf180mcu_fd_sc_mcu9t5v0__clkbuf_4
X$12728 \$31269 \$31392 \$31232 \$31310 \$31317 \$31268
+ gf180mcu_fd_sc_mcu9t5v0__xnor3_1
X$12729 \$31250 \$31375 \$31232 \$31310 \$31252 gf180mcu_fd_sc_mcu9t5v0__nor2_1
X$12730 \$31246 \$31316 \$31232 \$31310 \$31328 gf180mcu_fd_sc_mcu9t5v0__nand2_1
X$12731 \$31267 \$31264 \$31232 \$31310 \$31268 gf180mcu_fd_sc_mcu9t5v0__nand2_1
X$12732 \$31250 \$32404 \$31232 \$31310 \$31251 gf180mcu_fd_sc_mcu9t5v0__nand2_1
X$12733 \$31255 \$31234 \$31232 \$31310 \$31235 gf180mcu_fd_sc_mcu9t5v0__nand2_1
X$12734 \$31310 \$31232 gf180mcu_fd_sc_mcu9t5v0__filltie
X$12735 \$31310 \$31232 gf180mcu_fd_sc_mcu9t5v0__filltie
X$12736 \$31310 \$31232 gf180mcu_fd_sc_mcu9t5v0__endcap
X$12737 \$31310 \$31232 gf180mcu_fd_sc_mcu9t5v0__endcap
X$12738 \$31320 \$31376 \$31310 \$31237 gf180mcu_fd_sc_mcu9t5v0__clkinv_1
X$12739 \$31325 \$31241 \$31376 \$31310 \$31265 gf180mcu_fd_sc_mcu9t5v0__nand2_1
X$12740 \$31249 \$31319 \$31376 \$31310 \$31247 \$31514
+ gf180mcu_fd_sc_mcu9t5v0__xnor3_1
X$12741 \$31249 \$31586 \$31607 \$31584 \$31735 \$31606
+ gf180mcu_fd_sc_mcu9t5v0__xnor3_1
X$12742 \$31515 \$31535 \$31584 \$31249 gf180mcu_fd_sc_mcu9t5v0__clkinv_1
X$12743 \$31250 \$31536 \$31535 \$31465 \$31512 \$31516
+ gf180mcu_fd_sc_mcu9t5v0__xnor3_1
X$12744 \$31250 \$31375 \$31535 \$31465 \$31319 gf180mcu_fd_sc_mcu9t5v0__and2_1
X$12745 \$31250 \$31516 \$31376 \$31465 \$31403 gf180mcu_fd_sc_mcu9t5v0__nor2_1
X$12746 \$31250 \$31516 \$31535 \$31465 \$31587 gf180mcu_fd_sc_mcu9t5v0__nand2_1
X$12747 \$31256 \$31406 \$31376 \$31465 \$31382 gf180mcu_fd_sc_mcu9t5v0__nand2_1
X$12748 \$31386 \$31258 \$31376 \$31310 \$31385 gf180mcu_fd_sc_mcu9t5v0__nand2_1
X$12749 \$31264 \$32100 \$32171 \$31954 gf180mcu_fd_sc_mcu9t5v0__buf_8
X$12750 \$31267 \$31751 \$31607 \$31733 \$31753 gf180mcu_fd_sc_mcu9t5v0__nand2_1
X$12751 \$31328 \$31534 \$31376 \$31310 \$31397 \$31395
+ gf180mcu_fd_sc_mcu9t5v0__xnor3_1
X$12752 \$31532 \$31317 \$31376 \$31310 \$31327 gf180mcu_fd_sc_mcu9t5v0__and2_1
X$12753 \$31532 \$31317 \$31376 \$31310 \$31393 gf180mcu_fd_sc_mcu9t5v0__or2_1
X$12754 \$31418 \$31393 \$31327 \$31376 \$31310 \$31394
+ gf180mcu_fd_sc_mcu9t5v0__aoi21_1
X$12755 \$31328 \$31376 \$31310 \$31396 gf180mcu_fd_sc_mcu9t5v0__clkinv_1
X$12756 \$31329 \$31376 \$31310 \$31398 gf180mcu_fd_sc_mcu9t5v0__clkinv_1
X$12757 \$31380 \$31379 \$31376 \$31310 \$31378 gf180mcu_fd_sc_mcu9t5v0__nand2_1
X$12758 \$31415 \$31391 \$31376 \$31310 \$31392 gf180mcu_fd_sc_mcu9t5v0__nand2_1
X$12759 \$31310 \$31376 gf180mcu_fd_sc_mcu9t5v0__filltie
X$12760 \$31310 \$31376 gf180mcu_fd_sc_mcu9t5v0__filltie
X$12761 \$31310 \$31376 gf180mcu_fd_sc_mcu9t5v0__endcap
X$12762 \$31310 \$31376 gf180mcu_fd_sc_mcu9t5v0__endcap
X$12763 \$31525 \$31314 \$31535 \$31465 \$31388 gf180mcu_fd_sc_mcu9t5v0__nand2_1
X$12764 \$31596 \$31754 \$31607 \$31584 \$31316 gf180mcu_fd_sc_mcu9t5v0__xnor2_1
X$12765 \$31532 \$31418 \$31376 \$31465 \$31317 \$31598
+ gf180mcu_fd_sc_mcu9t5v0__xor3_2
X$12766 \$31319 \$31682 \$31738 \$31607 \$31733 \$31681
+ gf180mcu_fd_sc_mcu9t5v0__aoi21_1
X$12767 \$31324 \$32268 \$32248 \$32171 \$32030 \$32166
+ gf180mcu_fd_sc_mcu9t5v0__xnor3_1
X$12768 \$31324 \$32329 \$32354 \$32339 \$32467 \$32537
+ gf180mcu_fd_sc_mcu9t5v0__aoi21_1
X$12769 \$31324 \$32418 \$32419 \$32339 \$32467 \$32420
+ gf180mcu_fd_sc_mcu9t5v0__aoi21_1
X$12770 \$31324 \$31410 \$32248 \$32307 \$32320 gf180mcu_fd_sc_mcu9t5v0__nand2_1
X$12771 \$31324 \$31530 \$32248 \$32307 \$32322 gf180mcu_fd_sc_mcu9t5v0__nand2_1
X$12772 \$31324 \$31411 \$32543 \$32467 \$32578 gf180mcu_fd_sc_mcu9t5v0__nand2_1
X$12773 \$31324 \$31414 \$32543 \$32467 \$32558 gf180mcu_fd_sc_mcu9t5v0__nand2_1
X$12774 \$31324 \$31528 \$32248 \$32171 \$32259 gf180mcu_fd_sc_mcu9t5v0__nand2_1
X$12775 \$31324 \$32422 \$32543 \$32467 \$32712 gf180mcu_fd_sc_mcu9t5v0__nand2_1
X$12776 \$31408 \$31535 \$31465 \$31324 gf180mcu_fd_sc_mcu9t5v0__buf_8
X$12777 \$31397 \$31535 \$31465 \$31424 \$31329 gf180mcu_fd_sc_mcu9t5v0__xor2_2
X$12778 \$31375 \$31373 \$31513 \$31535 \$31465 \$31466
+ gf180mcu_fd_sc_mcu9t5v0__nand3_1
X$12779 \$31375 \$31373 \$31376 \$31465 \$31401 gf180mcu_fd_sc_mcu9t5v0__nand2_1
X$12780 \$32086 \$32309 \$32339 \$32307 \$31375 gf180mcu_fd_sc_mcu9t5v0__nor2_1
X$12781 \$31395 \$31421 \$31423 \$31376 \$31465 \$31422
+ gf180mcu_fd_sc_mcu9t5v0__oai21_1
X$12782 \$31415 \$31376 \$31465 \$31414 gf180mcu_fd_sc_mcu9t5v0__inv_2
X$12783 \$31415 \$31376 \$31465 \$31417 gf180mcu_fd_sc_mcu9t5v0__buf_8
X$12784 \$31420 \$31419 \$31376 \$31465 \$31469 gf180mcu_fd_sc_mcu9t5v0__nand2_1
X$12785 \$31402 \$31466 \$31376 \$31465 \$31605 gf180mcu_fd_sc_mcu9t5v0__nand2_1
X$12786 \$31465 \$31376 gf180mcu_fd_sc_mcu9t5v0__filltie
X$12787 \$31465 \$31376 gf180mcu_fd_sc_mcu9t5v0__filltie
X$12788 \$31465 \$31376 gf180mcu_fd_sc_mcu9t5v0__endcap
X$12789 \$31465 \$31376 gf180mcu_fd_sc_mcu9t5v0__endcap
X$12790 \$31381 \$31535 \$31584 gf180mcu_fd_sc_mcu9t5v0__inv_4
X$12791 \$31382 \$32100 \$32034 \$31970 gf180mcu_fd_sc_mcu9t5v0__inv_1
X$12792 \$31382 \$32021 \$32035 \$32022 \$31967 \$32034 \$31950
+ gf180mcu_fd_sc_mcu9t5v0__oai31_1
X$12793 \$31382 \$32021 \$32088 \$32087 \$32100 \$32034 \$31949
+ gf180mcu_fd_sc_mcu9t5v0__oai31_1
X$12794 \$31933 \$31382 \$31967 \$32034 \$32022 gf180mcu_fd_sc_mcu9t5v0__nand2_1
X$12795 \$32089 \$31382 \$32100 \$32034 \$32087 gf180mcu_fd_sc_mcu9t5v0__nand2_1
X$12796 \$31743 \$31382 \$31810 \$31733 \$31742 gf180mcu_fd_sc_mcu9t5v0__nand2_1
X$12797 \$31384 \$31540 \$31535 \$31584 \$31591 gf180mcu_fd_sc_mcu9t5v0__nand2_1
X$12798 \$31526 \$31525 \$31535 \$31465 \$31387 gf180mcu_fd_sc_mcu9t5v0__nand2_1
X$12799 \$32179 \$31391 \$32921 \$32853 \$32934 \$32794
+ gf180mcu_fd_sc_mcu9t5v0__nand3_1
X$12800 \$32421 \$31391 \$31954 \$32721 \$32765 \$32725
+ gf180mcu_fd_sc_mcu9t5v0__nand3_1
X$12801 \$32265 \$31391 \$32535 \$32543 \$32467 \$32557
+ gf180mcu_fd_sc_mcu9t5v0__nand3_1
X$12802 \$32092 \$31391 \$32864 \$32992 \$32934 \$32925
+ gf180mcu_fd_sc_mcu9t5v0__nand3_1
X$12803 \$32265 \$31391 \$32543 \$32629 \$32643 gf180mcu_fd_sc_mcu9t5v0__nand2_1
X$12804 \$32095 \$31391 \$32248 \$32307 \$32324 gf180mcu_fd_sc_mcu9t5v0__nand2_1
X$12805 \$32092 \$31391 \$32853 \$32934 \$32923 gf180mcu_fd_sc_mcu9t5v0__nand2_1
X$12806 \$31416 \$31391 \$32248 \$32171 \$32266 gf180mcu_fd_sc_mcu9t5v0__nand2_1
X$12807 \$32421 \$31391 \$32992 \$32934 \$32533 gf180mcu_fd_sc_mcu9t5v0__nand2_1
X$12808 \$32179 \$31391 \$32992 \$32934 \$32936 gf180mcu_fd_sc_mcu9t5v0__nand2_1
X$12809 \$31594 \$31391 \$32992 \$32934 \$33002 gf180mcu_fd_sc_mcu9t5v0__nand2_1
X$12810 \$31394 \$32423 \$32339 \$32307 \$32538 \$32031
+ gf180mcu_fd_sc_mcu9t5v0__xor3_1
X$12811 \$31394 \$32423 \$32339 \$32467 \$32424 gf180mcu_fd_sc_mcu9t5v0__nor2_1
X$12812 \$31394 \$32423 \$32339 \$32467 \$32466 gf180mcu_fd_sc_mcu9t5v0__nand2_1
X$12813 \$31396 \$31534 \$31535 \$31465 \$31421 gf180mcu_fd_sc_mcu9t5v0__nor2_1
X$12814 \$31396 \$31534 \$31535 \$31465 \$31423 gf180mcu_fd_sc_mcu9t5v0__nand2_1
X$12815 \$31401 \$31535 \$31465 \$31513 \$31464 gf180mcu_fd_sc_mcu9t5v0__xor2_1
X$12816 \$31514 \$31512 \$31535 \$31465 \$31402 gf180mcu_fd_sc_mcu9t5v0__nand2_1
X$12817 \$31536 \$31403 \$31587 \$31535 \$31584 \$31586
+ gf180mcu_fd_sc_mcu9t5v0__oai21_1
X$12818 \$31404 \$32016 \$31810 \$31886 \$31811 gf180mcu_fd_sc_mcu9t5v0__and2_1
X$12819 \$32179 \$32248 \$32171 \$31410 gf180mcu_fd_sc_mcu9t5v0__clkinv_1
X$12820 \$31416 \$31967 \$31886 \$31411 gf180mcu_fd_sc_mcu9t5v0__inv_1
X$12821 \$31415 \$31751 \$31607 \$31733 \$31690 gf180mcu_fd_sc_mcu9t5v0__nand2_1
X$12822 \$31415 \$31954 \$31810 \$31886 \$32263 gf180mcu_fd_sc_mcu9t5v0__nand2_1
X$12823 \$31415 \$31935 \$31810 \$31886 \$31818 gf180mcu_fd_sc_mcu9t5v0__nand2_1
X$12824 \$32095 \$31416 \$31935 \$31816 \$32248 \$32307 \$32325
+ gf180mcu_fd_sc_mcu9t5v0__and4_1
X$12825 \$32095 \$31935 \$31816 \$31416 \$32248 \$32307 \$32261
+ gf180mcu_fd_sc_mcu9t5v0__aoi22_1
X$12826 \$31416 \$31954 \$32248 \$32307 \$32579 gf180mcu_fd_sc_mcu9t5v0__nand2_1
X$12827 \$31416 \$31956 \$31967 \$31886 \$31830 gf180mcu_fd_sc_mcu9t5v0__nand2_1
X$12828 \$31595 \$31535 \$31584 \$31416 gf180mcu_fd_sc_mcu9t5v0__buf_8
X$12829 \$31417 \$31956 \$31810 \$31886 \$31883 gf180mcu_fd_sc_mcu9t5v0__nand2_1
X$12830 \$32350 \$32264 \$32339 \$32307 \$31418 gf180mcu_fd_sc_mcu9t5v0__xnor2_1
X$12831 \$31420 \$31545 \$31535 \$31584 \$31419 \$31534
+ gf180mcu_fd_sc_mcu9t5v0__xor3_2
X$12832 \$31544 \$31533 \$31607 \$31733 \$31419 gf180mcu_fd_sc_mcu9t5v0__xnor2_1
X$12833 \$31420 \$31419 \$31607 \$31584 \$31622 gf180mcu_fd_sc_mcu9t5v0__nor2_1
X$12834 \$31422 \$31631 \$31607 \$31584 \$31546 gf180mcu_fd_sc_mcu9t5v0__xnor2_1
X$12835 \$31422 \$31632 \$31607 \$31733 \$31835 gf180mcu_fd_sc_mcu9t5v0__nand2_1
X$12836 \$31425 \$31535 \$31584 \$31546 \$31547 gf180mcu_fd_sc_mcu9t5v0__xor2_1
X$12837 \$31425 \$31546 \$31607 \$31584 \$31630 gf180mcu_fd_sc_mcu9t5v0__nand2_1
X$12838 \$31514 \$31535 \$31465 \$31512 \$31513 gf180mcu_fd_sc_mcu9t5v0__xor2_1
X$12839 \$31532 \$31531 \$31535 \$31465 \$31533 gf180mcu_fd_sc_mcu9t5v0__nor2_1
X$12840 \$31542 \$31540 \$31535 \$31465 \$31592 gf180mcu_fd_sc_mcu9t5v0__nand2_1
X$12841 \$31465 \$31535 gf180mcu_fd_sc_mcu9t5v0__filltie
X$12842 \$31465 \$31535 gf180mcu_fd_sc_mcu9t5v0__filltie
X$12843 \$31465 \$31535 gf180mcu_fd_sc_mcu9t5v0__endcap
X$12844 \$31465 \$31535 gf180mcu_fd_sc_mcu9t5v0__endcap
X$12845 \$31545 \$31469 \$31622 \$31607 \$31584 \$31623
+ gf180mcu_fd_sc_mcu9t5v0__aoi21_1
X$12846 \$31515 \$31514 \$31810 \$31733 \$31738 gf180mcu_fd_sc_mcu9t5v0__and2_1
X$12847 \$32086 \$32085 \$32084 \$32100 \$32034 \$31514
+ gf180mcu_fd_sc_mcu9t5v0__nor3_1
X$12848 \$31515 \$31514 \$31810 \$31886 \$31682 gf180mcu_fd_sc_mcu9t5v0__or2_1
X$12849 \$31515 \$31606 \$31810 \$31733 \$31737 gf180mcu_fd_sc_mcu9t5v0__and2_1
X$12850 \$31515 \$31606 \$31607 \$31733 \$31808 gf180mcu_fd_sc_mcu9t5v0__or2_1
X$12851 \$31516 \$32630 \$32701 \$32631 \$32721 \$32629 \$32702
+ gf180mcu_fd_sc_mcu9t5v0__oai211_1
X$12852 \$32697 \$32568 \$32630 \$31516 \$32543 \$32629 \$32631
+ gf180mcu_fd_sc_mcu9t5v0__aoi22_1
X$12853 \$31606 \$31516 \$32519 \$32721 \$32765 \$32704
+ gf180mcu_fd_sc_mcu9t5v0__mux2_1
X$12854 \$31521 \$31538 \$31535 \$31584 \$31539 gf180mcu_fd_sc_mcu9t5v0__nand2_1
X$12855 \$31594 \$31607 \$31584 \$31528 gf180mcu_fd_sc_mcu9t5v0__clkinv_1
X$12856 \$32095 \$32248 \$32171 \$31530 gf180mcu_fd_sc_mcu9t5v0__inv_1
X$12857 \$31544 \$31533 \$31598 \$31535 \$31584 \$31599
+ gf180mcu_fd_sc_mcu9t5v0__and3_1
X$12858 \$31544 \$31533 \$31535 \$31584 \$31597 gf180mcu_fd_sc_mcu9t5v0__nand2_1
X$12859 \$31600 \$31625 \$31599 \$31535 \$31584 \$32032
+ gf180mcu_fd_sc_mcu9t5v0__aoi21_1
X$12860 \$31584 \$31535 gf180mcu_fd_sc_mcu9t5v0__filltie
X$12861 \$31584 \$31535 gf180mcu_fd_sc_mcu9t5v0__filltie
X$12862 \$31584 \$31535 gf180mcu_fd_sc_mcu9t5v0__endcap
X$12863 \$31584 \$31535 gf180mcu_fd_sc_mcu9t5v0__endcap
X$12864 \$32178 \$31540 \$32248 \$32307 \$32257 gf180mcu_fd_sc_mcu9t5v0__nand2_1
X$12865 \$32158 \$31540 \$32100 \$32171 \$32157 gf180mcu_fd_sc_mcu9t5v0__nand2_1
X$12866 \$32772 \$31540 \$32543 \$32629 \$32528 gf180mcu_fd_sc_mcu9t5v0__nand2_1
X$12867 \$31876 \$31540 \$31967 \$31886 \$31952 gf180mcu_fd_sc_mcu9t5v0__nand2_1
X$12868 \$32576 \$31540 \$32543 \$32467 \$32529 gf180mcu_fd_sc_mcu9t5v0__nand2_1
X$12869 \$31540 \$31607 \$31584 \$31612 gf180mcu_fd_sc_mcu9t5v0__clkinv_1
X$12870 \$31691 \$31690 \$31810 \$31733 \$31829 \$31544
+ gf180mcu_fd_sc_mcu9t5v0__xor3_2
X$12871 \$31755 \$31888 \$31810 \$31733 \$31832 \$31545
+ gf180mcu_fd_sc_mcu9t5v0__xor3_1
X$12872 \$31597 \$31598 \$31607 \$31584 \$31627 \$31600
+ gf180mcu_fd_sc_mcu9t5v0__xnor3_1
X$12873 \$31605 \$31680 \$31607 \$31584 \$31604 gf180mcu_fd_sc_mcu9t5v0__xnor2_1
X$12874 \$31597 \$31598 \$31607 \$31584 \$31625 gf180mcu_fd_sc_mcu9t5v0__xnor2_1
X$12875 \$31692 \$31627 \$31629 \$31607 \$31584 \$31628
+ gf180mcu_fd_sc_mcu9t5v0__aoi21_1
X$12876 \$31631 \$31607 \$31584 \$31632 gf180mcu_fd_sc_mcu9t5v0__clkinv_1
X$12877 \$31584 \$31607 gf180mcu_fd_sc_mcu9t5v0__filltie
X$12878 \$31584 \$31607 gf180mcu_fd_sc_mcu9t5v0__filltie
X$12879 \$31686 \$31614 \$31612 \$31607 \$31584 \$31615
+ gf180mcu_fd_sc_mcu9t5v0__mux2_1
X$12880 \$31584 \$31607 gf180mcu_fd_sc_mcu9t5v0__endcap
X$12881 \$31584 \$31607 gf180mcu_fd_sc_mcu9t5v0__endcap
X$12882 \$31586 \$31808 \$31737 \$31810 \$31733 \$31809
+ gf180mcu_fd_sc_mcu9t5v0__aoi21_1
X$12883 \$31594 \$31956 \$32988 \$32992 \$32934 \$33006
+ gf180mcu_fd_sc_mcu9t5v0__nand3_1
X$12884 \$31594 \$31935 \$32853 \$32934 \$32926 gf180mcu_fd_sc_mcu9t5v0__nand2_1
X$12885 \$31594 \$31816 \$32992 \$33062 \$33067 gf180mcu_fd_sc_mcu9t5v0__nand2_1
X$12886 \$31594 \$31954 \$32853 \$32934 \$32793 gf180mcu_fd_sc_mcu9t5v0__nand2_1
X$12887 \$31594 \$32353 \$32853 \$32765 \$32799 gf180mcu_fd_sc_mcu9t5v0__nand2_1
X$12888 \$31594 \$31956 \$33071 \$33062 \$33061 gf180mcu_fd_sc_mcu9t5v0__nand2_1
X$12889 \$31746 \$31594 \$32248 \$32307 \$32268 gf180mcu_fd_sc_mcu9t5v0__nand2_1
X$12890 \$31595 \$31689 \$31810 \$31886 \$31691 gf180mcu_fd_sc_mcu9t5v0__nand2_1
X$12891 \$32165 \$32030 \$32100 \$32034 \$31881 \$31600
+ gf180mcu_fd_sc_mcu9t5v0__xor3_1
X$12892 \$31605 \$31680 \$31607 \$31733 \$31734 gf180mcu_fd_sc_mcu9t5v0__nand2_1
X$12893 \$31606 \$32720 \$32992 \$33062 \$33045 gf180mcu_fd_sc_mcu9t5v0__and2_1
X$12894 \$31606 \$32518 \$32568 \$32697 \$32409 \$32543 \$32467 \$32544
+ gf180mcu_fd_sc_mcu9t5v0__oai221_1
X$12895 \$31606 \$32720 \$32404 \$32992 \$33062 \$33046
+ gf180mcu_fd_sc_mcu9t5v0__oai21_1
X$12896 \$31606 \$32251 \$32248 \$32171 \$32148 gf180mcu_fd_sc_mcu9t5v0__nand2_1
X$12897 \$31966 \$31606 \$32519 \$32339 \$32467 \$32410
+ gf180mcu_fd_sc_mcu9t5v0__mux2_1
X$12898 \$31627 \$31607 \$31733 \$31623 \$31693 gf180mcu_fd_sc_mcu9t5v0__xor2_1
X$12899 \$31756 \$31693 \$31607 \$31733 \$31631 gf180mcu_fd_sc_mcu9t5v0__xnor2_1
X$12900 \$31818 \$31753 \$31607 \$31733 \$31831 gf180mcu_fd_sc_mcu9t5v0__and2_1
X$12901 \$31689 \$31607 \$31733 \$31935 gf180mcu_fd_sc_mcu9t5v0__buf_8
X$12902 \$31691 \$31690 \$31607 \$31733 \$31750 gf180mcu_fd_sc_mcu9t5v0__nor2_1
X$12903 \$31623 \$31607 \$31733 \$31692 gf180mcu_fd_sc_mcu9t5v0__clkinv_1
X$12904 \$31691 \$31690 \$31607 \$31733 \$31749 gf180mcu_fd_sc_mcu9t5v0__nand2_1
X$12905 \$31733 \$31607 gf180mcu_fd_sc_mcu9t5v0__filltie
X$12906 \$31733 \$31607 gf180mcu_fd_sc_mcu9t5v0__filltie
X$12907 \$31733 \$31607 gf180mcu_fd_sc_mcu9t5v0__endcap
X$12908 \$31733 \$31607 gf180mcu_fd_sc_mcu9t5v0__endcap
X$12909 \$32020 \$32019 \$32021 \$31967 \$32034 \$31611
+ gf180mcu_fd_sc_mcu9t5v0__aoi21_1
X$12910 \$31613 \$32155 \$32157 \$32100 \$32171 \$32156
+ gf180mcu_fd_sc_mcu9t5v0__oai21_1
X$12911 \$31613 \$32177 \$32257 \$32248 \$32307 \$32256
+ gf180mcu_fd_sc_mcu9t5v0__oai21_1
X$12912 \$31613 \$32416 \$32529 \$32543 \$32467 \$32555
+ gf180mcu_fd_sc_mcu9t5v0__oai21_1
X$12913 \$31613 \$32527 \$32528 \$32543 \$32467 \$32554
+ gf180mcu_fd_sc_mcu9t5v0__oai21_1
X$12914 \$31613 \$31972 \$31952 \$31967 \$31886 \$31951
+ gf180mcu_fd_sc_mcu9t5v0__oai21_1
X$12915 \$31617 \$32152 \$31970 \$32100 \$32171 \$32159
+ gf180mcu_fd_sc_mcu9t5v0__mux2_1
X$12916 \$31628 \$31959 \$31967 \$31886 \$31819 gf180mcu_fd_sc_mcu9t5v0__xnor2_1
X$12917 \$31628 \$31959 \$31967 \$31886 \$31961 gf180mcu_fd_sc_mcu9t5v0__nor2_1
X$12918 \$31756 \$31693 \$31810 \$31733 \$31629 gf180mcu_fd_sc_mcu9t5v0__nor2_1
X$12919 \$31630 \$31835 \$31819 \$31810 \$31886 \$31885
+ gf180mcu_fd_sc_mcu9t5v0__aoi21_1
X$12920 \$31835 \$31630 \$31810 \$31733 \$31820 gf180mcu_fd_sc_mcu9t5v0__nand2_1
X$12921 \$32079 \$32082 \$32100 \$32034 \$31803 \$31676
+ gf180mcu_fd_sc_mcu9t5v0__xnor3_1
X$12922 \$32627 \$32564 \$32721 \$32629 \$31676 \$32697
+ gf180mcu_fd_sc_mcu9t5v0__xnor3_1
X$12923 \$31676 \$32223 \$32100 \$32171 \$32170 gf180mcu_fd_sc_mcu9t5v0__nor2_1
X$12924 \$31676 \$32223 \$32248 \$32171 \$32222 gf180mcu_fd_sc_mcu9t5v0__nand2_1
X$12925 \$31941 \$31967 \$31886 \$31678 \$31822 gf180mcu_fd_sc_mcu9t5v0__xor2_1
X$12926 \$31932 \$31809 \$31967 \$31886 \$31678 \$31966
+ gf180mcu_fd_sc_mcu9t5v0__xnor3_1
X$12927 \$31941 \$31678 \$31967 \$31886 \$31965 gf180mcu_fd_sc_mcu9t5v0__nand2_1
X$12928 \$31807 \$31810 \$31733 \$31735 \$31680 gf180mcu_fd_sc_mcu9t5v0__xor2_1
X$12929 \$31932 \$31681 \$32248 \$32307 \$31807 \$32246
+ gf180mcu_fd_sc_mcu9t5v0__xor3_1
X$12930 \$32338 \$31681 \$32339 \$32307 \$32335 gf180mcu_fd_sc_mcu9t5v0__or2_1
X$12931 \$31812 \$31744 \$31810 \$31733 \$31684 gf180mcu_fd_sc_mcu9t5v0__nand2_1
X$12932 \$31690 \$31882 \$31831 \$31830 \$31810 \$31886 \$31832
+ gf180mcu_fd_sc_mcu9t5v0__oai22_1
X$12933 \$32589 \$32562 \$32721 \$32629 \$31694 gf180mcu_fd_sc_mcu9t5v0__nand2_1
X$12934 \$31732 \$31964 \$31810 \$31886 \$31804 gf180mcu_fd_sc_mcu9t5v0__nand2_1
X$12935 \$31818 \$31753 \$31810 \$31733 \$31754 \$31830
+ gf180mcu_fd_sc_mcu9t5v0__xnor3_1
X$12936 \$31745 \$31810 \$31733 \$31814 gf180mcu_fd_sc_mcu9t5v0__clkinv_1
X$12937 \$31748 \$31810 \$31733 \$31828 gf180mcu_fd_sc_mcu9t5v0__clkinv_1
X$12938 \$31806 \$31734 \$31810 \$31733 \$31821 gf180mcu_fd_sc_mcu9t5v0__nand2_1
X$12939 \$31807 \$31735 \$31810 \$31733 \$31806 gf180mcu_fd_sc_mcu9t5v0__nand2_1
X$12940 \$31733 \$31810 gf180mcu_fd_sc_mcu9t5v0__filltie
X$12941 \$31733 \$31810 gf180mcu_fd_sc_mcu9t5v0__filltie
X$12942 \$31733 \$31810 gf180mcu_fd_sc_mcu9t5v0__endcap
X$12943 \$31733 \$31810 gf180mcu_fd_sc_mcu9t5v0__endcap
X$12944 \$32421 \$31746 \$32179 \$32353 \$33071 \$33062 \$33085
+ gf180mcu_fd_sc_mcu9t5v0__nand4_1
X$12945 \$31746 \$32353 \$33179 \$33071 \$33184 \$33195
+ gf180mcu_fd_sc_mcu9t5v0__aoi21_1
X$12946 \$31746 \$32353 \$32421 \$33071 \$33184 \$33179
+ gf180mcu_fd_sc_mcu9t5v0__oai21_1
X$12947 \$31746 \$32092 \$32265 \$32163 \$32248 \$32171 \$32164
+ gf180mcu_fd_sc_mcu9t5v0__aoi22_1
X$12948 \$32421 \$31746 \$32179 \$32353 \$33071 \$33062 \$33086
+ gf180mcu_fd_sc_mcu9t5v0__aoi22_1
X$12949 \$31746 \$32179 \$32853 \$32765 \$32800 gf180mcu_fd_sc_mcu9t5v0__nand2_1
X$12950 \$31829 \$31749 \$31750 \$31810 \$31886 \$31881
+ gf180mcu_fd_sc_mcu9t5v0__aoi21_1
X$12951 \$31751 \$31967 \$31886 \$31816 gf180mcu_fd_sc_mcu9t5v0__buf_8
X$12952 \$31755 \$31834 \$31884 \$31810 \$31886 \$31756
+ gf180mcu_fd_sc_mcu9t5v0__aoi21_1
X$12953 \$32094 \$32029 \$31967 \$32034 \$31755 gf180mcu_fd_sc_mcu9t5v0__nor2_1
X$12954 \$32244 \$32339 \$32307 \$32331 \$31801 gf180mcu_fd_sc_mcu9t5v0__xor2_1
X$12955 \$32142 \$31801 \$32100 \$32171 \$31874 \$32143
+ gf180mcu_fd_sc_mcu9t5v0__xnor3_1
X$12956 \$31822 \$31821 \$31810 \$31886 \$31805 gf180mcu_fd_sc_mcu9t5v0__xnor2_1
X$12957 \$32086 \$32310 \$32519 \$32248 \$32307 \$31807
+ gf180mcu_fd_sc_mcu9t5v0__nor3_1
X$12958 \$31932 \$31807 \$32339 \$32307 \$32338 gf180mcu_fd_sc_mcu9t5v0__nor2_1
X$12959 \$31932 \$31807 \$32339 \$32307 \$32336 gf180mcu_fd_sc_mcu9t5v0__nand2_1
X$12960 \$32014 \$31809 \$32015 \$31967 \$32034 \$32013
+ gf180mcu_fd_sc_mcu9t5v0__aoi21_1
X$12961 \$31832 \$31888 \$31810 \$31886 \$31884 gf180mcu_fd_sc_mcu9t5v0__and2_1
X$12962 \$31832 \$31888 \$31810 \$31886 \$31834 gf180mcu_fd_sc_mcu9t5v0__or2_1
X$12963 \$31880 \$31810 \$31886 \$31817 gf180mcu_fd_sc_mcu9t5v0__clkinv_1
X$12964 \$31822 \$31821 \$31810 \$31886 \$31940 gf180mcu_fd_sc_mcu9t5v0__nand2_1
X$12965 \$31886 \$31810 gf180mcu_fd_sc_mcu9t5v0__filltie
X$12966 \$31886 \$31810 gf180mcu_fd_sc_mcu9t5v0__filltie
X$12967 \$31886 \$31810 gf180mcu_fd_sc_mcu9t5v0__endcap
X$12968 \$31886 \$31810 gf180mcu_fd_sc_mcu9t5v0__endcap
X$12969 \$33077 \$33171 \$32019 \$33071 \$33184 \$31812
+ gf180mcu_fd_sc_mcu9t5v0__mux2_1
X$12970 \$32552 \$32151 \$32526 \$32253 \$32248 \$32307 \$31813
+ gf180mcu_fd_sc_mcu9t5v0__nor4_1
X$12971 \$32421 \$31935 \$31816 \$32853 \$32765 \$32861
+ gf180mcu_fd_sc_mcu9t5v0__and3_1
X$12972 \$32179 \$31816 \$32992 \$33062 \$33060 gf180mcu_fd_sc_mcu9t5v0__nand2_1
X$12973 \$32421 \$31816 \$32992 \$33062 \$33052 gf180mcu_fd_sc_mcu9t5v0__nand2_1
X$12974 \$32095 \$31816 \$32248 \$32171 \$32262 gf180mcu_fd_sc_mcu9t5v0__nand2_1
X$12975 \$32265 \$31816 \$32992 \$32934 \$33005 gf180mcu_fd_sc_mcu9t5v0__nand2_1
X$12976 \$32092 \$31816 \$32992 \$32934 \$33003 gf180mcu_fd_sc_mcu9t5v0__nand2_1
X$12977 \$31826 \$33059 \$31970 \$32992 \$33062 \$33064
+ gf180mcu_fd_sc_mcu9t5v0__mux2_1
X$12978 \$31827 \$32721 \$32765 gf180mcu_fd_sc_mcu9t5v0__inv_3
X$12979 \$32102 \$32027 \$31967 \$31886 \$31829 gf180mcu_fd_sc_mcu9t5v0__and2_1
X$12980 \$32330 \$32243 \$32248 \$32171 \$31836 gf180mcu_fd_sc_mcu9t5v0__xnor2_1
X$12981 \$31881 \$31967 \$32034 \$32030 \$32104 gf180mcu_fd_sc_mcu9t5v0__xor2_1
X$12982 \$31881 \$32030 \$32167 \$32100 \$32171 \$31936
+ gf180mcu_fd_sc_mcu9t5v0__oai21_1
X$12983 \$31961 \$31885 \$31962 \$31967 \$31886 \$31960
+ gf180mcu_fd_sc_mcu9t5v0__oai21_1
X$12984 \$31961 \$31885 \$31967 \$32034 \$32033 gf180mcu_fd_sc_mcu9t5v0__nor2_1
X$12985 \$31939 \$31931 \$31967 \$31886 \$31964 \$31938
+ gf180mcu_fd_sc_mcu9t5v0__xor3_1
X$12986 \$31936 \$31958 \$31967 \$31886 \$31974 gf180mcu_fd_sc_mcu9t5v0__and2_1
X$12987 \$31965 \$31940 \$31967 \$31886 \$31931 gf180mcu_fd_sc_mcu9t5v0__nand2_1
X$12988 \$31886 \$31967 gf180mcu_fd_sc_mcu9t5v0__filltie
X$12989 \$31886 \$31967 gf180mcu_fd_sc_mcu9t5v0__filltie
X$12990 \$31886 \$31967 gf180mcu_fd_sc_mcu9t5v0__endcap
X$12991 \$31886 \$31967 gf180mcu_fd_sc_mcu9t5v0__endcap
X$12992 \$32165 \$32164 \$32100 \$32171 \$31888 gf180mcu_fd_sc_mcu9t5v0__nor2_1
X$12993 \$31931 \$32011 \$32012 \$31967 \$32034 \$32079
+ gf180mcu_fd_sc_mcu9t5v0__aoi21_1
X$12994 \$31932 \$31966 \$31967 \$32034 \$32015 gf180mcu_fd_sc_mcu9t5v0__nor2_1
X$12995 \$31932 \$31966 \$31967 \$32034 \$32014 gf180mcu_fd_sc_mcu9t5v0__nand2_1
X$12996 \$31932 \$32404 \$32248 \$32171 \$32247 gf180mcu_fd_sc_mcu9t5v0__nand2_1
X$12997 \$31934 \$32100 \$32034 \$32025 gf180mcu_fd_sc_mcu9t5v0__clkinv_1
X$12998 \$32265 \$31935 \$32721 \$32765 \$32648 gf180mcu_fd_sc_mcu9t5v0__nand2_1
X$12999 \$32092 \$31935 \$32853 \$32934 \$32927 gf180mcu_fd_sc_mcu9t5v0__nand2_1
X$13000 \$32179 \$31935 \$32853 \$32934 \$32922 gf180mcu_fd_sc_mcu9t5v0__nand2_1
X$13001 \$32421 \$31935 \$32853 \$32765 \$32862 gf180mcu_fd_sc_mcu9t5v0__nand2_1
X$13002 \$31936 \$31958 \$31967 \$32034 \$31959 gf180mcu_fd_sc_mcu9t5v0__xnor2_1
X$13003 \$32627 \$32542 \$32721 \$32765 \$32780 \$31939
+ gf180mcu_fd_sc_mcu9t5v0__xnor3_1
X$13004 \$31939 \$31964 \$31967 \$32034 \$32012 gf180mcu_fd_sc_mcu9t5v0__nor2_1
X$13005 \$32086 \$32698 \$32721 \$32629 \$31939 gf180mcu_fd_sc_mcu9t5v0__nand2_1
X$13006 \$31939 \$31964 \$31967 \$32034 \$32011 gf180mcu_fd_sc_mcu9t5v0__nand2_1
X$13007 \$32228 \$31941 \$32543 \$32467 \$32408 gf180mcu_fd_sc_mcu9t5v0__xnor2_1
X$13008 \$32228 \$31941 \$32517 \$32543 \$32467 \$32542
+ gf180mcu_fd_sc_mcu9t5v0__aoi21_1
X$13009 \$32086 \$32567 \$32543 \$32467 \$31941 gf180mcu_fd_sc_mcu9t5v0__nor2_1
X$13010 \$32404 \$31943 \$32407 \$32406 \$32339 \$32467 \$32405
+ gf180mcu_fd_sc_mcu9t5v0__oai31_1
X$13011 \$31945 \$32229 \$32248 \$32171 \$32312 gf180mcu_fd_sc_mcu9t5v0__or2_1
X$13012 \$31945 \$32410 \$32251 \$32339 \$32307 \$32252
+ gf180mcu_fd_sc_mcu9t5v0__aoi21_1
X$13013 \$31945 \$32634 \$32545 \$32721 \$32629 \$32706
+ gf180mcu_fd_sc_mcu9t5v0__aoi21_1
X$13014 \$31945 \$32410 \$32569 \$32543 \$32467 \$32545
+ gf180mcu_fd_sc_mcu9t5v0__oai21_1
X$13015 \$32632 \$31945 \$32704 \$32721 \$32629 \$32311
+ gf180mcu_fd_sc_mcu9t5v0__nand3_1
X$13016 \$32309 \$32567 \$32543 \$32629 \$31945 gf180mcu_fd_sc_mcu9t5v0__nand2_1
X$13017 \$31945 \$32634 \$32721 \$32629 \$32705 gf180mcu_fd_sc_mcu9t5v0__nand2_1
X$13018 \$32095 \$31954 \$32248 \$32307 \$32323 gf180mcu_fd_sc_mcu9t5v0__nand2_1
X$13019 \$32265 \$31954 \$32853 \$32765 \$32863 gf180mcu_fd_sc_mcu9t5v0__nand2_1
X$13020 \$32179 \$31954 \$32992 \$32934 \$33172 gf180mcu_fd_sc_mcu9t5v0__nand2_1
X$13021 \$32421 \$31954 \$32543 \$32467 \$32577 gf180mcu_fd_sc_mcu9t5v0__nand2_1
X$13022 \$32092 \$31954 \$32992 \$32934 \$33080 gf180mcu_fd_sc_mcu9t5v0__nand2_1
X$13023 \$32092 \$31956 \$32721 \$32629 \$32581 gf180mcu_fd_sc_mcu9t5v0__and2_1
X$13024 \$32179 \$31956 \$33054 \$32992 \$33062 \$33082
+ gf180mcu_fd_sc_mcu9t5v0__and3_1
X$13025 \$32179 \$31956 \$33054 \$32992 \$32934 \$33004
+ gf180mcu_fd_sc_mcu9t5v0__aoi21_1
X$13026 \$32265 \$31956 \$32248 \$32307 \$32350 gf180mcu_fd_sc_mcu9t5v0__nand2_1
X$13027 \$32421 \$31956 \$32992 \$33062 \$33066 gf180mcu_fd_sc_mcu9t5v0__nand2_1
X$13028 \$32027 \$31967 \$32034 \$31956 gf180mcu_fd_sc_mcu9t5v0__buf_8
X$13029 \$32032 \$32031 \$31967 \$32034 \$31958 gf180mcu_fd_sc_mcu9t5v0__xnor2_1
X$13030 \$32168 \$32105 \$31960 \$32100 \$32171 \$32169
+ gf180mcu_fd_sc_mcu9t5v0__and3_1
X$13031 \$31960 \$32105 \$32168 \$32100 \$32171 \$32269
+ gf180mcu_fd_sc_mcu9t5v0__aoi21_1
X$13032 \$32241 \$32248 \$32171 \$32098 \$31962 gf180mcu_fd_sc_mcu9t5v0__xor2_1
X$13033 \$32228 \$32013 \$32100 \$32171 \$31964 \$32172
+ gf180mcu_fd_sc_mcu9t5v0__xnor3_1
X$13034 \$32086 \$31966 \$32100 \$32171 \$32147 gf180mcu_fd_sc_mcu9t5v0__xnor2_1
X$13035 \$31966 \$33045 \$32992 \$33062 \$33044 gf180mcu_fd_sc_mcu9t5v0__and2_1
X$13036 \$31966 \$33045 \$32404 \$33071 \$33062 \$33069
+ gf180mcu_fd_sc_mcu9t5v0__oai21_1
X$13037 \$32172 \$32227 \$32144 \$31966 \$32248 \$32171 \$32249
+ gf180mcu_fd_sc_mcu9t5v0__aoi22_1
X$13038 \$32085 \$32016 \$31967 \$32034 \$31968 gf180mcu_fd_sc_mcu9t5v0__nand2_1
X$13039 \$32034 \$31967 gf180mcu_fd_sc_mcu9t5v0__filltie
X$13040 \$32034 \$31967 gf180mcu_fd_sc_mcu9t5v0__filltie
X$13041 \$32034 \$31967 gf180mcu_fd_sc_mcu9t5v0__endcap
X$13042 \$32034 \$31967 gf180mcu_fd_sc_mcu9t5v0__endcap
X$13043 \$32935 \$33051 \$31970 \$32992 \$33062 \$33065
+ gf180mcu_fd_sc_mcu9t5v0__mux2_1
X$13044 \$32792 \$32791 \$31970 \$32853 \$32765 \$32857
+ gf180mcu_fd_sc_mcu9t5v0__mux2_1
X$13045 \$32530 \$32553 \$31970 \$32543 \$32467 \$32556
+ gf180mcu_fd_sc_mcu9t5v0__mux2_1
X$13046 \$32097 \$32031 \$31974 \$32100 \$32034 \$32098
+ gf180mcu_fd_sc_mcu9t5v0__aoi21_1
X$13047 \$32173 \$32013 \$32083 \$32100 \$32034 \$32564
+ gf180mcu_fd_sc_mcu9t5v0__aoi21_1
X$13048 \$32519 \$32016 \$32853 \$32934 \$32912 gf180mcu_fd_sc_mcu9t5v0__nand2_1
X$13049 \$32086 \$32016 \$32853 \$32934 \$32913 gf180mcu_fd_sc_mcu9t5v0__nand2_1
X$13050 \$33047 \$33062 \$32992 \$32017 gf180mcu_fd_sc_mcu9t5v0__clkbuf_16
X$13051 \$32708 \$32573 \$32019 \$32543 \$32629 \$32574
+ gf180mcu_fd_sc_mcu9t5v0__aoi21_1
X$13052 \$32233 \$32237 \$32236 \$32019 \$32248 \$32171 \$32176
+ gf180mcu_fd_sc_mcu9t5v0__aoi211_1
X$13053 \$32313 \$32996 \$33075 \$32019 \$33071 \$33062 \$33076
+ gf180mcu_fd_sc_mcu9t5v0__aoi211_1
X$13054 \$32019 \$33050 \$32021 \$33076 \$32992 \$33062 \$33051
+ gf180mcu_fd_sc_mcu9t5v0__aoi211_1
X$13055 \$32019 \$32523 \$32021 \$32574 \$32543 \$32629 \$32553
+ gf180mcu_fd_sc_mcu9t5v0__aoi211_1
X$13056 \$32019 \$32790 \$32021 \$32771 \$32853 \$32765 \$32791
+ gf180mcu_fd_sc_mcu9t5v0__aoi211_1
X$13057 \$32019 \$32150 \$32021 \$32176 \$32248 \$32171 \$32152
+ gf180mcu_fd_sc_mcu9t5v0__aoi211_1
X$13058 \$32019 \$33077 \$32021 \$33078 \$33071 \$33062 \$33059
+ gf180mcu_fd_sc_mcu9t5v0__aoi211_1
X$13059 \$32019 \$33050 \$33063 \$32992 \$33062 \$32552
+ gf180mcu_fd_sc_mcu9t5v0__oai21_1
X$13060 \$32019 \$32150 \$32175 \$32100 \$32171 \$32151
+ gf180mcu_fd_sc_mcu9t5v0__oai21_1
X$13061 \$32019 \$32254 \$32239 \$32248 \$32171 \$32035
+ gf180mcu_fd_sc_mcu9t5v0__oai21_1
X$13062 \$32019 \$32238 \$32154 \$32248 \$32171 \$32253
+ gf180mcu_fd_sc_mcu9t5v0__oai21_1
X$13063 \$32019 \$32523 \$32525 \$32543 \$32467 \$32526
+ gf180mcu_fd_sc_mcu9t5v0__oai21_1
X$13064 \$32236 \$32235 \$32019 \$32248 \$32171 \$32175
+ gf180mcu_fd_sc_mcu9t5v0__oai21_1
X$13065 \$32019 \$32723 \$32721 \$32765 \$32771 gf180mcu_fd_sc_mcu9t5v0__nor2_1
X$13066 \$32019 \$33171 \$33071 \$33184 \$33078 gf180mcu_fd_sc_mcu9t5v0__nor2_1
X$13067 \$32313 \$33073 \$32915 \$32019 \$33071 \$33062 \$33063
+ gf180mcu_fd_sc_mcu9t5v0__oai211_1
X$13068 \$32019 \$32153 \$32100 \$32171 \$32154 gf180mcu_fd_sc_mcu9t5v0__nand2_1
X$13069 \$32019 \$32318 \$32248 \$32307 \$32239 gf180mcu_fd_sc_mcu9t5v0__nand2_1
X$13070 \$32019 \$32524 \$32543 \$32467 \$32525 gf180mcu_fd_sc_mcu9t5v0__nand2_1
X$13071 \$32232 \$32248 \$32171 \$32019 gf180mcu_fd_sc_mcu9t5v0__buf_8
X$13072 \$32318 \$32254 \$32019 \$32248 \$32171 \$32023
+ gf180mcu_fd_sc_mcu9t5v0__mux2_1
X$13073 \$32153 \$32238 \$32019 \$32248 \$32171 \$32088
+ gf180mcu_fd_sc_mcu9t5v0__mux2_1
X$13074 \$32790 \$32723 \$32019 \$32853 \$32765 \$32255
+ gf180mcu_fd_sc_mcu9t5v0__mux2_1
X$13075 \$32233 \$32317 \$32248 \$32307 \$32020 gf180mcu_fd_sc_mcu9t5v0__nand2_1
X$13076 \$32095 \$32163 \$32100 \$32171 \$32029 gf180mcu_fd_sc_mcu9t5v0__nand2_1
X$13077 \$32032 \$32100 \$32034 \$32097 gf180mcu_fd_sc_mcu9t5v0__clkinv_1
X$13078 \$32034 \$32100 gf180mcu_fd_sc_mcu9t5v0__filltie
X$13079 \$32034 \$32100 gf180mcu_fd_sc_mcu9t5v0__filltie
X$13080 \$32034 \$32100 gf180mcu_fd_sc_mcu9t5v0__endcap
X$13081 \$32034 \$32100 gf180mcu_fd_sc_mcu9t5v0__endcap
X$13082 \$32079 \$32170 \$32222 \$32248 \$32171 \$32143
+ gf180mcu_fd_sc_mcu9t5v0__oai21_1
X$13083 \$32244 \$32082 \$32248 \$32171 \$32225 gf180mcu_fd_sc_mcu9t5v0__xnor2_1
X$13084 \$32086 \$32144 \$32248 \$32307 \$32082 gf180mcu_fd_sc_mcu9t5v0__nand2_1
X$13085 \$32228 \$32172 \$32248 \$32171 \$32083 gf180mcu_fd_sc_mcu9t5v0__and2_1
X$13086 \$32086 \$32085 \$32084 \$32248 \$32171 \$32250
+ gf180mcu_fd_sc_mcu9t5v0__aoi21_1
X$13087 \$32519 \$32248 \$32307 \$32084 gf180mcu_fd_sc_mcu9t5v0__clkinv_1
X$13088 \$32085 \$32084 \$32100 \$32171 \$32144 gf180mcu_fd_sc_mcu9t5v0__nor2_1
X$13089 \$32697 \$32084 \$32250 \$32172 \$32248 \$32307 \$32229
+ gf180mcu_fd_sc_mcu9t5v0__aoi22_1
X$13090 \$32310 \$32084 \$32248 \$32307 \$32309 gf180mcu_fd_sc_mcu9t5v0__nand2_1
X$13091 \$32085 \$32519 \$32086 \$32543 \$32467 \$32518
+ gf180mcu_fd_sc_mcu9t5v0__aoi21_1
X$13092 \$32086 \$32085 \$32721 \$32765 \$32630 gf180mcu_fd_sc_mcu9t5v0__nor2_1
X$13093 \$32085 \$32519 \$32543 \$32629 \$32698 gf180mcu_fd_sc_mcu9t5v0__nor2_1
X$13094 \$32085 \$32519 \$32543 \$32629 \$32567 gf180mcu_fd_sc_mcu9t5v0__nand2_1
X$13095 \$32086 \$32085 \$32543 \$32629 \$32568 gf180mcu_fd_sc_mcu9t5v0__nand2_1
X$13096 \$32085 \$32339 \$32307 \$32310 gf180mcu_fd_sc_mcu9t5v0__clkinv_1
X$13097 \$32086 \$32567 \$32543 \$32629 \$32569 gf180mcu_fd_sc_mcu9t5v0__xnor2_1
X$13098 \$32086 \$32144 \$32100 \$32171 \$32223 gf180mcu_fd_sc_mcu9t5v0__and2_1
X$13099 \$32086 \$32227 \$32248 \$32171 \$32142 gf180mcu_fd_sc_mcu9t5v0__and2_1
X$13100 \$32086 \$32698 \$32627 \$32721 \$32629 \$32628
+ gf180mcu_fd_sc_mcu9t5v0__aoi21_1
X$13101 \$32627 \$32086 \$32698 \$32721 \$32629 \$32566
+ gf180mcu_fd_sc_mcu9t5v0__nand3_1
X$13102 \$32086 \$32309 \$32543 \$32629 \$32632 gf180mcu_fd_sc_mcu9t5v0__nand2_1
X$13103 \$32981 \$32992 \$32934 \$32086 gf180mcu_fd_sc_mcu9t5v0__buf_8
X$13104 \$32092 \$32163 \$32248 \$32307 \$32166 gf180mcu_fd_sc_mcu9t5v0__nand2_2
X$13105 \$32092 \$32339 \$32467 \$32422 gf180mcu_fd_sc_mcu9t5v0__clkinv_1
X$13106 \$32534 \$32543 \$32467 \$32093 gf180mcu_fd_sc_mcu9t5v0__clkinv_1
X$13107 \$32166 \$32094 \$32100 \$32171 \$32165 gf180mcu_fd_sc_mcu9t5v0__nor2_1
X$13108 \$32102 \$32248 \$32171 \$32095 gf180mcu_fd_sc_mcu9t5v0__buf_8
X$13109 \$32098 \$32241 \$32100 \$32171 \$32105 gf180mcu_fd_sc_mcu9t5v0__or2_1
X$13110 \$32149 \$32100 \$32171 \$32233 gf180mcu_fd_sc_mcu9t5v0__buf_8
X$13111 \$32165 \$32104 \$32100 \$32171 \$32167 gf180mcu_fd_sc_mcu9t5v0__nand2_1
X$13112 \$32171 \$32100 gf180mcu_fd_sc_mcu9t5v0__filltie
X$13113 \$32171 \$32100 gf180mcu_fd_sc_mcu9t5v0__filltie
X$13114 \$32171 \$32100 gf180mcu_fd_sc_mcu9t5v0__endcap
X$13115 \$32171 \$32100 gf180mcu_fd_sc_mcu9t5v0__endcap
X$13116 \$32230 \$32231 \$32248 \$32171 \$32149 gf180mcu_fd_sc_mcu9t5v0__nor2_1
X$13117 \$33170 \$33206 \$33205 \$32313 \$33261 \$33184 \$32150
+ gf180mcu_fd_sc_mcu9t5v0__aoi22_1
X$13118 \$32785 \$32787 \$32853 \$32765 \$32153 gf180mcu_fd_sc_mcu9t5v0__or2_1
X$13119 \$32163 \$32339 \$32307 \$32353 gf180mcu_fd_sc_mcu9t5v0__buf_8
X$13120 \$32268 \$32166 \$32339 \$32307 \$32354 gf180mcu_fd_sc_mcu9t5v0__nor2_1
X$13121 \$32268 \$32166 \$32248 \$32307 \$32329 gf180mcu_fd_sc_mcu9t5v0__nand2_1
X$13122 \$32588 \$32539 \$32543 \$32629 \$32168 gf180mcu_fd_sc_mcu9t5v0__xnor2_1
X$13123 \$32233 \$32234 \$32248 \$32171 \$32235 gf180mcu_fd_sc_mcu9t5v0__and2_1
X$13124 \$32228 \$32172 \$32248 \$32171 \$32173 gf180mcu_fd_sc_mcu9t5v0__or2_1
X$13125 \$32242 \$32269 \$32248 \$32171 \$32243 gf180mcu_fd_sc_mcu9t5v0__nor2_1
X$13126 \$32244 \$32223 \$32248 \$32171 \$32224 gf180mcu_fd_sc_mcu9t5v0__nand2_1
X$13127 \$32171 \$32248 gf180mcu_fd_sc_mcu9t5v0__filltie
X$13128 \$32171 \$32248 gf180mcu_fd_sc_mcu9t5v0__filltie
X$13129 \$32171 \$32248 gf180mcu_fd_sc_mcu9t5v0__endcap
X$13130 \$32171 \$32248 gf180mcu_fd_sc_mcu9t5v0__endcap
X$13131 \$32172 \$32721 \$32629 \$32632 \$32701 gf180mcu_fd_sc_mcu9t5v0__xor2_1
X$13132 \$32172 \$33044 \$33056 \$33071 \$33184 \$33068
+ gf180mcu_fd_sc_mcu9t5v0__aoi21_1
X$13133 \$32172 \$33044 \$32404 \$32992 \$33062 \$33056
+ gf180mcu_fd_sc_mcu9t5v0__oai21_1
X$13134 \$32172 \$33044 \$32992 \$32934 \$32910 gf180mcu_fd_sc_mcu9t5v0__nand2_1
X$13135 \$32225 \$32333 \$32339 \$32307 \$32332 gf180mcu_fd_sc_mcu9t5v0__nor2_1
X$13136 \$32310 \$32519 \$32248 \$32307 \$32227 gf180mcu_fd_sc_mcu9t5v0__nor2_1
X$13137 \$32228 \$32404 \$32339 \$32467 \$32406 gf180mcu_fd_sc_mcu9t5v0__nand2_1
X$13138 \$32230 \$32231 \$32248 \$32307 \$32313 gf180mcu_fd_sc_mcu9t5v0__or2_1
X$13139 \$32311 \$32249 \$32251 \$32248 \$32307 \$32231
+ gf180mcu_fd_sc_mcu9t5v0__aoi21_1
X$13140 \$32251 \$32314 \$32312 \$32252 \$32248 \$32307 \$32232
+ gf180mcu_fd_sc_mcu9t5v0__aoi22_1
X$13141 \$32549 \$32636 \$32710 \$32233 \$32543 \$32629 \$32236
+ gf180mcu_fd_sc_mcu9t5v0__aoi211_1
X$13142 \$32415 \$32414 \$33185 \$32788 \$32233 \$32853 \$32765 \$32856
+ gf180mcu_fd_sc_mcu9t5v0__oai221_1
X$13143 \$32233 \$32412 \$32784 \$32856 \$32853 \$32765 \$32789
+ gf180mcu_fd_sc_mcu9t5v0__oai31_1
X$13144 \$32233 \$32707 \$32520 \$33209 \$33261 \$33184 \$33211
+ gf180mcu_fd_sc_mcu9t5v0__oai31_1
X$13145 \$32233 \$32522 \$32548 \$32543 \$32467 \$32550
+ gf180mcu_fd_sc_mcu9t5v0__nand3_1
X$13146 \$32233 \$33207 \$33208 \$33261 \$33184 \$33209
+ gf180mcu_fd_sc_mcu9t5v0__nand3_1
X$13147 \$32233 \$32707 \$32571 \$32721 \$32629 \$32708
+ gf180mcu_fd_sc_mcu9t5v0__nand3_1
X$13148 \$32415 \$32414 \$32917 \$32233 \$32339 \$32467 \$32318
+ gf180mcu_fd_sc_mcu9t5v0__oai211_1
X$13149 \$32916 \$33262 \$32995 \$32233 \$32992 \$33062 \$32316
+ gf180mcu_fd_sc_mcu9t5v0__oai211_1
X$13150 \$32570 \$32342 \$32344 \$32917 \$32233 \$32853 \$32934 \$33048
+ gf180mcu_fd_sc_mcu9t5v0__aoi221_1
X$13151 \$32984 \$32770 \$33049 \$32918 \$32233 \$32992 \$32934 \$32787
+ gf180mcu_fd_sc_mcu9t5v0__aoi221_1
X$13152 \$32413 \$32343 \$32340 \$32342 \$32339 \$32307 \$32234
+ gf180mcu_fd_sc_mcu9t5v0__oai22_1
X$13153 \$32413 \$32343 \$32344 \$32339 \$32307 \$32237
+ gf180mcu_fd_sc_mcu9t5v0__oai21_1
X$13154 \$32315 \$32316 \$32248 \$32307 \$32238 gf180mcu_fd_sc_mcu9t5v0__nand2_1
X$13155 \$32584 \$32561 \$32543 \$32467 \$32241 gf180mcu_fd_sc_mcu9t5v0__xnor2_1
X$13156 \$32242 \$32269 \$32330 \$32248 \$32307 \$32270
+ gf180mcu_fd_sc_mcu9t5v0__oai21_1
X$13157 \$32588 \$32539 \$32543 \$32467 \$32242 gf180mcu_fd_sc_mcu9t5v0__nor2_1
X$13158 \$32244 \$32404 \$32339 \$32467 \$32403 gf180mcu_fd_sc_mcu9t5v0__nand2_1
X$13159 \$32266 \$32263 \$32248 \$32307 \$32328 \$32326
+ gf180mcu_fd_sc_mcu9t5v0__xnor3_1
X$13160 \$32326 \$32263 \$32248 \$32307 \$32327 gf180mcu_fd_sc_mcu9t5v0__and2_1
X$13161 \$32325 \$32261 \$32248 \$32307 \$32264 gf180mcu_fd_sc_mcu9t5v0__nor2_1
X$13162 \$32307 \$32248 gf180mcu_fd_sc_mcu9t5v0__filltie
X$13163 \$32307 \$32248 gf180mcu_fd_sc_mcu9t5v0__filltie
X$13164 \$32307 \$32248 gf180mcu_fd_sc_mcu9t5v0__endcap
X$13165 \$32307 \$32248 gf180mcu_fd_sc_mcu9t5v0__endcap
X$13166 \$32981 \$32853 \$32934 \$32567 \$32251 gf180mcu_fd_sc_mcu9t5v0__xor2_1
X$13167 \$32251 \$32768 \$32853 \$32934 \$32782 gf180mcu_fd_sc_mcu9t5v0__or2_1
X$13168 \$32251 \$32768 \$32853 \$32934 \$32854 gf180mcu_fd_sc_mcu9t5v0__nor2_1
X$13169 \$32251 \$32314 \$32853 \$32934 \$32855 gf180mcu_fd_sc_mcu9t5v0__nor2_1
X$13170 \$32313 \$32710 \$32254 \$32788 \$32721 \$32765 \$32723
+ gf180mcu_fd_sc_mcu9t5v0__oai22_1
X$13171 \$32313 \$32707 \$32721 \$32629 \$32254 gf180mcu_fd_sc_mcu9t5v0__nand2_1
X$13172 \$32533 \$33172 \$33071 \$33184 \$33188 \$32259
+ gf180mcu_fd_sc_mcu9t5v0__xnor3_1
X$13173 \$32259 \$33172 \$33071 \$33062 \$33187 gf180mcu_fd_sc_mcu9t5v0__and2_1
X$13174 \$32259 \$33172 \$33071 \$33184 \$33212 gf180mcu_fd_sc_mcu9t5v0__or2_1
X$13175 \$32350 \$32325 \$32261 \$32339 \$32307 \$32351
+ gf180mcu_fd_sc_mcu9t5v0__nor3_1
X$13176 \$32581 \$32648 \$32721 \$32629 \$32718 \$32262
+ gf180mcu_fd_sc_mcu9t5v0__xnor3_1
X$13177 \$32262 \$32648 \$32721 \$32765 \$32650 gf180mcu_fd_sc_mcu9t5v0__nor2_1
X$13178 \$32262 \$32648 \$32543 \$32629 \$32580 gf180mcu_fd_sc_mcu9t5v0__nand2_1
X$13179 \$32326 \$32263 \$32339 \$32307 \$32352 gf180mcu_fd_sc_mcu9t5v0__or2_1
X$13180 \$32266 \$32327 \$32352 \$32339 \$32307 \$32797
+ gf180mcu_fd_sc_mcu9t5v0__oai21_1
X$13181 \$32270 \$32355 \$32425 \$32339 \$32467 \$32426
+ gf180mcu_fd_sc_mcu9t5v0__aoi21_2
X$13182 \$32355 \$32270 \$32425 \$32339 \$32307 \$32356
+ gf180mcu_fd_sc_mcu9t5v0__and3_1
X$13183 \$32313 \$32340 \$32341 \$32339 \$32307 \$32315
+ gf180mcu_fd_sc_mcu9t5v0__nand3_1
X$13184 \$32336 \$32335 \$32339 \$32307 \$32334 gf180mcu_fd_sc_mcu9t5v0__nand2_1
X$13185 \$32307 \$32339 gf180mcu_fd_sc_mcu9t5v0__filltie
X$13186 \$32307 \$32339 gf180mcu_fd_sc_mcu9t5v0__filltie
X$13187 \$32307 \$32339 gf180mcu_fd_sc_mcu9t5v0__endcap
X$13188 \$32307 \$32339 gf180mcu_fd_sc_mcu9t5v0__endcap
X$13189 \$32702 \$32544 \$32543 \$32629 \$32308 gf180mcu_fd_sc_mcu9t5v0__nor2_1
X$13190 \$32309 \$32567 \$32543 \$32629 \$32633 gf180mcu_fd_sc_mcu9t5v0__and2_1
X$13191 \$32786 \$32520 \$32313 \$33261 \$33184 \$33206
+ gf180mcu_fd_sc_mcu9t5v0__aoi21_1
X$13192 \$32786 \$32709 \$32547 \$32707 \$32313 \$32853 \$32934 \$32915
+ gf180mcu_fd_sc_mcu9t5v0__oai221_1
X$13193 \$32314 \$32545 \$32412 \$32521 \$32313 \$32543 \$32467 \$32551
+ gf180mcu_fd_sc_mcu9t5v0__oai221_1
X$13194 \$32982 \$32413 \$32709 \$32412 \$32313 \$32543 \$32467 \$32468
+ gf180mcu_fd_sc_mcu9t5v0__oai221_1
X$13195 \$32547 \$32784 \$32313 \$32786 \$32853 \$32765 \$32785
+ gf180mcu_fd_sc_mcu9t5v0__aoi211_1
X$13196 \$32313 \$32575 \$32551 \$32543 \$32467 \$32524
+ gf180mcu_fd_sc_mcu9t5v0__oai21_1
X$13197 \$32313 \$33266 \$33261 \$33184 \$33075 gf180mcu_fd_sc_mcu9t5v0__nor2_1
X$13198 \$32313 \$33210 \$33261 \$33184 \$33267 gf180mcu_fd_sc_mcu9t5v0__nor2_1
X$13199 \$32314 \$32545 \$32572 \$32313 \$32543 \$32629 \$32573
+ gf180mcu_fd_sc_mcu9t5v0__oai211_1
X$13200 \$33263 \$33312 \$33311 \$32786 \$32313 \$33261 \$33310 \$33057
+ gf180mcu_fd_sc_mcu9t5v0__aoi221_1
X$13201 \$32313 \$33264 \$33317 \$33310 \$33313 gf180mcu_fd_sc_mcu9t5v0__nand2_1
X$13202 \$32314 \$32545 \$32770 \$32721 \$32629 \$32710
+ gf180mcu_fd_sc_mcu9t5v0__nor3_1
X$13203 \$32314 \$32770 \$32788 \$33261 \$33184 \$33210
+ gf180mcu_fd_sc_mcu9t5v0__oai21_1
X$13204 \$32314 \$32993 \$33201 \$33261 \$33184 \$33203
+ gf180mcu_fd_sc_mcu9t5v0__oai21_1
X$13205 \$32633 \$32703 \$32721 \$32629 \$32314 gf180mcu_fd_sc_mcu9t5v0__nand2_1
X$13206 \$32314 \$32982 \$33261 \$33310 \$33263 gf180mcu_fd_sc_mcu9t5v0__nand2_1
X$13207 \$32415 \$32414 \$32339 \$32467 \$32317 gf180mcu_fd_sc_mcu9t5v0__nor2_1
X$13208 \$32533 \$32320 \$32853 \$32765 \$32859 \$32577
+ gf180mcu_fd_sc_mcu9t5v0__xnor3_1
X$13209 \$32577 \$32320 \$32543 \$32629 \$32641 gf180mcu_fd_sc_mcu9t5v0__and2_1
X$13210 \$32577 \$32320 \$32543 \$32629 \$32642 gf180mcu_fd_sc_mcu9t5v0__or2_1
X$13211 \$32322 \$32853 \$32934 \$32863 \$32864 gf180mcu_fd_sc_mcu9t5v0__xor2_1
X$13212 \$32322 \$32863 \$32925 \$32853 \$32934 \$32866
+ gf180mcu_fd_sc_mcu9t5v0__oai21_1
X$13213 \$32578 \$32543 \$32629 \$32323 \$32535 gf180mcu_fd_sc_mcu9t5v0__xor2_1
X$13214 \$32578 \$32323 \$32557 \$32543 \$32629 \$32644
+ gf180mcu_fd_sc_mcu9t5v0__oai21_1
X$13215 \$32324 \$32579 \$32721 \$32629 \$32715 \$32558
+ gf180mcu_fd_sc_mcu9t5v0__xnor3_1
X$13216 \$32324 \$32645 \$32646 \$32721 \$32765 \$32727
+ gf180mcu_fd_sc_mcu9t5v0__oai21_1
X$13217 \$32325 \$32351 \$32339 \$32467 \$32647 gf180mcu_fd_sc_mcu9t5v0__nor2_1
X$13218 \$32808 \$32932 \$32853 \$32934 \$32330 gf180mcu_fd_sc_mcu9t5v0__xnor2_1
X$13219 \$32564 \$32563 \$32565 \$32543 \$32629 \$32331
+ gf180mcu_fd_sc_mcu9t5v0__oai21_1
X$13220 \$32566 \$32542 \$32628 \$32543 \$32629 \$32333
+ gf180mcu_fd_sc_mcu9t5v0__aoi21_1
X$13221 \$32408 \$32339 \$32467 \$32334 \$32407 gf180mcu_fd_sc_mcu9t5v0__xor2_1
X$13222 \$32336 \$32335 \$32408 \$32339 \$32467 \$32517
+ gf180mcu_fd_sc_mcu9t5v0__aoi21_1
X$13223 \$32552 \$32339 \$32467 \$32346 \$32416 gf180mcu_fd_sc_mcu9t5v0__xor2_1
X$13224 \$32570 \$32410 \$32339 \$32467 \$32340 gf180mcu_fd_sc_mcu9t5v0__or2_1
X$13225 \$32426 \$32356 \$32339 \$32467 \$32357 gf180mcu_fd_sc_mcu9t5v0__nor2_1
X$13226 \$32421 \$32339 \$32467 \$32418 gf180mcu_fd_sc_mcu9t5v0__clkinv_1
X$13227 \$32415 \$32412 \$32339 \$32467 \$32413 gf180mcu_fd_sc_mcu9t5v0__nand2_1
X$13228 \$32467 \$32339 gf180mcu_fd_sc_mcu9t5v0__filltie
X$13229 \$32467 \$32339 gf180mcu_fd_sc_mcu9t5v0__filltie
X$13230 \$32467 \$32339 gf180mcu_fd_sc_mcu9t5v0__endcap
X$13231 \$32467 \$32339 gf180mcu_fd_sc_mcu9t5v0__endcap
X$13232 \$32411 \$32412 \$32520 \$32543 \$32467 \$32341
+ gf180mcu_fd_sc_mcu9t5v0__nand3_1
X$13233 \$32546 \$32782 \$32853 \$32765 \$32342 gf180mcu_fd_sc_mcu9t5v0__nor2_1
X$13234 \$32411 \$32982 \$32543 \$32467 \$32343 gf180mcu_fd_sc_mcu9t5v0__nor2_1
X$13235 \$32570 \$32343 \$32547 \$32982 \$32543 \$32467 \$32521
+ gf180mcu_fd_sc_mcu9t5v0__aoi22_1
X$13236 \$32786 \$32993 \$33263 \$33071 \$33184 \$32344
+ gf180mcu_fd_sc_mcu9t5v0__nand3_1
X$13237 \$32526 \$32543 \$32467 \$32345 \$32527 gf180mcu_fd_sc_mcu9t5v0__xor2_1
X$13238 \$32808 \$32933 \$32853 \$32934 \$32355 gf180mcu_fd_sc_mcu9t5v0__nand2_1
X$13239 \$32627 \$32404 \$32992 \$32934 \$32781 gf180mcu_fd_sc_mcu9t5v0__nand2_1
X$13240 \$32855 \$32982 \$32411 \$32853 \$32765 \$32709
+ gf180mcu_fd_sc_mcu9t5v0__aoi21_1
X$13241 \$32411 \$32412 \$32784 \$33049 \$32992 \$33062 \$32996
+ gf180mcu_fd_sc_mcu9t5v0__aoi22_1
X$13242 \$32411 \$32570 \$32543 \$32629 \$32415 gf180mcu_fd_sc_mcu9t5v0__nand2_1
X$13243 \$32411 \$32982 \$32992 \$32934 \$32993 gf180mcu_fd_sc_mcu9t5v0__nand2_1
X$13244 \$32412 \$32918 \$33261 \$33310 \$33312 gf180mcu_fd_sc_mcu9t5v0__and2_1
X$13245 \$32546 \$32520 \$32412 \$32543 \$32629 \$32571
+ gf180mcu_fd_sc_mcu9t5v0__oai21_1
X$13246 \$32415 \$32412 \$32414 \$32711 \$32543 \$32629 \$32575
+ gf180mcu_fd_sc_mcu9t5v0__oai211_1
X$13247 \$32412 \$32993 \$32784 \$33071 \$33184 \$33170
+ gf180mcu_fd_sc_mcu9t5v0__nand3_1
X$13248 \$32412 \$32993 \$32918 \$32853 \$32934 \$32711
+ gf180mcu_fd_sc_mcu9t5v0__nand3_1
X$13249 \$32412 \$32916 \$32853 \$32934 \$32636 gf180mcu_fd_sc_mcu9t5v0__nor2_1
X$13250 \$32982 \$32783 \$33263 \$32412 \$33261 \$33184 \$33207
+ gf180mcu_fd_sc_mcu9t5v0__oai211_1
X$13251 \$32993 \$33185 \$33186 \$32412 \$33071 \$33184 \$33073
+ gf180mcu_fd_sc_mcu9t5v0__aoi22_1
X$13252 \$32984 \$32770 \$33074 \$32412 \$33071 \$33062 \$32995
+ gf180mcu_fd_sc_mcu9t5v0__aoi22_1
X$13253 \$32412 \$32521 \$32543 \$32467 \$32522 gf180mcu_fd_sc_mcu9t5v0__nand2_1
X$13254 \$32412 \$33203 \$33261 \$33184 \$33204 gf180mcu_fd_sc_mcu9t5v0__nand2_1
X$13255 \$32706 \$33261 \$33184 \$32412 gf180mcu_fd_sc_mcu9t5v0__buf_8
X$13256 \$32782 \$32786 \$32853 \$32765 \$32414 gf180mcu_fd_sc_mcu9t5v0__nand2_1
X$13257 \$32415 \$32782 \$32783 \$32853 \$32934 \$32918
+ gf180mcu_fd_sc_mcu9t5v0__nand3_1
X$13258 \$32415 \$32783 \$32853 \$32765 \$32547 gf180mcu_fd_sc_mcu9t5v0__nand2_1
X$13259 \$32470 \$32543 \$32467 \$32417 gf180mcu_fd_sc_mcu9t5v0__clkinv_1
X$13260 \$32533 \$32577 \$32543 \$32467 \$32419 gf180mcu_fd_sc_mcu9t5v0__nand2_1
X$13261 \$32725 \$32775 \$32420 \$32721 \$32765 \$32726
+ gf180mcu_fd_sc_mcu9t5v0__aoi21_1
X$13262 \$32718 \$32536 \$32543 \$32467 \$32423 gf180mcu_fd_sc_mcu9t5v0__xnor2_1
X$13263 \$32538 \$32466 \$32424 \$32543 \$32467 \$32560
+ gf180mcu_fd_sc_mcu9t5v0__aoi21_1
X$13264 \$33183 \$33071 \$33184 \$33197 \$32425 gf180mcu_fd_sc_mcu9t5v0__xor2_1
X$13265 \$32472 \$32426 \$32590 \$32543 \$32467 \$32562
+ gf180mcu_fd_sc_mcu9t5v0__or3_1
X$13266 \$32472 \$32426 \$32590 \$32543 \$32629 \$32589
+ gf180mcu_fd_sc_mcu9t5v0__oai21_2
X$13267 \$32718 \$32536 \$32465 \$32543 \$32629 \$32798
+ gf180mcu_fd_sc_mcu9t5v0__oai21_1
X$13268 \$32537 \$32543 \$32467 \$32559 \$32538 gf180mcu_fd_sc_mcu9t5v0__xor2_1
X$13269 \$32982 \$32547 \$32543 \$32467 \$32549 gf180mcu_fd_sc_mcu9t5v0__nand2_1
X$13270 \$32550 \$32468 \$32543 \$32467 \$32523 gf180mcu_fd_sc_mcu9t5v0__nand2_1
X$13271 \$32467 \$32543 gf180mcu_fd_sc_mcu9t5v0__filltie
X$13272 \$32467 \$32543 gf180mcu_fd_sc_mcu9t5v0__filltie
X$13273 \$32467 \$32543 gf180mcu_fd_sc_mcu9t5v0__endcap
X$13274 \$32467 \$32543 gf180mcu_fd_sc_mcu9t5v0__endcap
X$13275 \$33200 \$33197 \$33071 \$33184 \$32472 gf180mcu_fd_sc_mcu9t5v0__nor2_1
X$13276 \$32786 \$32520 \$32916 \$32992 \$33062 \$32788
+ gf180mcu_fd_sc_mcu9t5v0__nor3_1
X$13277 \$32855 \$32982 \$32853 \$32934 \$32520 gf180mcu_fd_sc_mcu9t5v0__nor2_1
X$13278 \$32533 \$32641 \$32642 \$32721 \$32629 \$32775
+ gf180mcu_fd_sc_mcu9t5v0__oai21_1
X$13279 \$32533 \$33187 \$33212 \$33261 \$33184 \$33213
+ gf180mcu_fd_sc_mcu9t5v0__oai21_1
X$13280 \$32643 \$32535 \$32721 \$32629 \$32714 gf180mcu_fd_sc_mcu9t5v0__xnor2_1
X$13281 \$32537 \$32559 \$32721 \$32629 \$32583 gf180mcu_fd_sc_mcu9t5v0__nor2_1
X$13282 \$32806 \$32853 \$32765 \$32539 gf180mcu_fd_sc_mcu9t5v0__clkinv_1
X$13283 \$33385 \$33329 \$33317 \$33310 \$32540 gf180mcu_fd_sc_mcu9t5v0__nand2_1
X$13284 \$32540 \$32589 \$32543 \$32629 \$32728 gf180mcu_fd_sc_mcu9t5v0__nand2_1
X$13285 \$32541 \$32721 \$32765 \$32728 \$32778 gf180mcu_fd_sc_mcu9t5v0__xor2_1
X$13286 \$33440 \$33424 \$33423 \$33437 \$32541 gf180mcu_fd_sc_mcu9t5v0__xor2_1
X$13287 \$32647 \$32582 \$32543 \$32629 \$32559 gf180mcu_fd_sc_mcu9t5v0__xnor2_1
X$13288 \$32560 \$32653 \$32543 \$32629 \$32561 gf180mcu_fd_sc_mcu9t5v0__xnor2_1
X$13289 \$32558 \$32579 \$32543 \$32629 \$32645 gf180mcu_fd_sc_mcu9t5v0__and2_1
X$13290 \$32558 \$32579 \$32543 \$32629 \$32646 gf180mcu_fd_sc_mcu9t5v0__or2_1
X$13291 \$32581 \$32580 \$32650 \$32543 \$32629 \$32649
+ gf180mcu_fd_sc_mcu9t5v0__aoi21_1
X$13292 \$32651 \$32583 \$32543 \$32629 \$32584 gf180mcu_fd_sc_mcu9t5v0__nor2_1
X$13293 \$32647 \$32582 \$32543 \$32629 \$32651 gf180mcu_fd_sc_mcu9t5v0__nor2_1
X$13294 \$32560 \$32653 \$32543 \$32629 \$32585 gf180mcu_fd_sc_mcu9t5v0__nor2_1
X$13295 \$32585 \$32587 \$32543 \$32629 \$32588 gf180mcu_fd_sc_mcu9t5v0__nor2_1
X$13296 \$32547 \$32636 \$32543 \$32629 \$32548 gf180mcu_fd_sc_mcu9t5v0__nand2_1
X$13297 \$32632 \$32703 \$32543 \$32629 \$32634 gf180mcu_fd_sc_mcu9t5v0__nand2_1
X$13298 \$32569 \$32635 \$32543 \$32629 \$32570 gf180mcu_fd_sc_mcu9t5v0__nand2_1
X$13299 \$32629 \$32543 gf180mcu_fd_sc_mcu9t5v0__filltie
X$13300 \$32629 \$32543 gf180mcu_fd_sc_mcu9t5v0__filltie
X$13301 \$32629 \$32543 gf180mcu_fd_sc_mcu9t5v0__endcap
X$13302 \$32629 \$32543 gf180mcu_fd_sc_mcu9t5v0__endcap
X$13303 \$32545 \$32721 \$32629 \$32722 gf180mcu_fd_sc_mcu9t5v0__clkinv_1
X$13304 \$32546 \$32982 \$32992 \$32934 \$32916 gf180mcu_fd_sc_mcu9t5v0__nor2_1
X$13305 \$32546 \$32855 \$32853 \$32934 \$32783 gf180mcu_fd_sc_mcu9t5v0__nand2_1
X$13306 \$32546 \$32982 \$32992 \$32934 \$32770 gf180mcu_fd_sc_mcu9t5v0__nand2_1
X$13307 \$32546 \$32570 \$32992 \$32934 \$33201 gf180mcu_fd_sc_mcu9t5v0__nand2_1
X$13308 \$32584 \$32561 \$32721 \$32629 \$32587 gf180mcu_fd_sc_mcu9t5v0__nor2_1
X$13309 \$32627 \$32697 \$32721 \$32765 \$32563 gf180mcu_fd_sc_mcu9t5v0__nor2_1
X$13310 \$32627 \$32697 \$32721 \$32765 \$32565 gf180mcu_fd_sc_mcu9t5v0__nand2_1
X$13311 \$32570 \$32782 \$32853 \$32765 \$32784 gf180mcu_fd_sc_mcu9t5v0__nand2_1
X$13312 \$32855 \$32770 \$32636 \$32721 \$32765 \$32572
+ gf180mcu_fd_sc_mcu9t5v0__oai21_1
X$13313 \$32777 \$32721 \$32765 \$32582 gf180mcu_fd_sc_mcu9t5v0__clkinv_1
X$13314 \$33385 \$33386 \$33317 \$33423 \$32590 gf180mcu_fd_sc_mcu9t5v0__xnor2_1
X$13315 \$32633 \$32703 \$32721 \$32629 \$32635 gf180mcu_fd_sc_mcu9t5v0__and2_1
X$13316 \$32629 \$32721 gf180mcu_fd_sc_mcu9t5v0__filltie
X$13317 \$32629 \$32721 gf180mcu_fd_sc_mcu9t5v0__filltie
X$13318 \$32629 \$32721 gf180mcu_fd_sc_mcu9t5v0__endcap
X$13319 \$32629 \$32721 gf180mcu_fd_sc_mcu9t5v0__endcap
X$13320 \$32635 \$32982 \$32706 \$33071 \$33184 \$33185
+ gf180mcu_fd_sc_mcu9t5v0__aoi21_1
X$13321 \$32635 \$32982 \$33071 \$33184 \$33202 gf180mcu_fd_sc_mcu9t5v0__nand2_1
X$13322 \$32640 \$32853 \$32934 \$32986 gf180mcu_fd_sc_mcu9t5v0__clkinv_1
X$13323 \$32644 \$32865 \$33261 \$33184 \$33215 gf180mcu_fd_sc_mcu9t5v0__xnor2_1
X$13324 \$32644 \$32865 \$33071 \$33062 \$33081 gf180mcu_fd_sc_mcu9t5v0__nand2_1
X$13325 \$32649 \$32853 \$32934 \$32803 \$32869 gf180mcu_fd_sc_mcu9t5v0__xor2_1
X$13326 \$32649 \$32992 \$32934 \$32868 gf180mcu_fd_sc_mcu9t5v0__clkinv_1
X$13327 \$32798 \$32870 \$32853 \$32765 \$32653 \$32928
+ gf180mcu_fd_sc_mcu9t5v0__xnor3_1
X$13328 \$32697 \$32853 \$32934 \$32910 \$32766 gf180mcu_fd_sc_mcu9t5v0__xor2_1
X$13329 \$32705 \$32722 \$32721 \$32765 \$32769 gf180mcu_fd_sc_mcu9t5v0__nand2_1
X$13330 \$32786 \$33202 \$33261 \$33184 \$32707 gf180mcu_fd_sc_mcu9t5v0__nand2_1
X$13331 \$32712 \$32853 \$32934 \$32793 \$32921 gf180mcu_fd_sc_mcu9t5v0__xor2_1
X$13332 \$32712 \$32793 \$32794 \$32853 \$32765 \$32860
+ gf180mcu_fd_sc_mcu9t5v0__oai21_1
X$13333 \$33002 \$33080 \$33071 \$33184 \$33191 \$32713
+ gf180mcu_fd_sc_mcu9t5v0__xnor3_1
X$13334 \$32713 \$33080 \$33261 \$33184 \$33173 gf180mcu_fd_sc_mcu9t5v0__and2_1
X$13335 \$32713 \$33080 \$33071 \$33062 \$33175 gf180mcu_fd_sc_mcu9t5v0__or2_1
X$13336 \$32727 \$32714 \$32853 \$32765 \$32796 gf180mcu_fd_sc_mcu9t5v0__xnor2_1
X$13337 \$32727 \$32714 \$32853 \$32765 \$33178 gf180mcu_fd_sc_mcu9t5v0__nand2_1
X$13338 \$32797 \$32715 \$32853 \$32765 \$32989 gf180mcu_fd_sc_mcu9t5v0__xnor2_1
X$13339 \$32797 \$32715 \$32853 \$32765 \$32867 gf180mcu_fd_sc_mcu9t5v0__nand2_1
X$13340 \$32765 \$32721 gf180mcu_fd_sc_mcu9t5v0__filltie
X$13341 \$32765 \$32721 gf180mcu_fd_sc_mcu9t5v0__filltie
X$13342 \$32765 \$32721 gf180mcu_fd_sc_mcu9t5v0__endcap
X$13343 \$32765 \$32721 gf180mcu_fd_sc_mcu9t5v0__endcap
X$13344 \$33372 \$32726 \$33424 \$33527 \$33526 gf180mcu_fd_sc_mcu9t5v0__xnor2_1
X$13345 \$33427 \$32726 \$33424 \$33527 \$33635 gf180mcu_fd_sc_mcu9t5v0__nor2_1
X$13346 \$32799 \$32853 \$32765 \$32800 \$32777 gf180mcu_fd_sc_mcu9t5v0__xor2_1
X$13347 \$32923 \$32864 \$32853 \$32765 \$32865 gf180mcu_fd_sc_mcu9t5v0__xnor2_1
X$13348 \$32799 \$32800 \$32853 \$32765 \$32802 gf180mcu_fd_sc_mcu9t5v0__or2_1
X$13349 \$32868 \$32803 \$32805 \$32853 \$32765 \$32804
+ gf180mcu_fd_sc_mcu9t5v0__aoi21_1
X$13350 \$32804 \$32807 \$32809 \$32853 \$32765 \$32808
+ gf180mcu_fd_sc_mcu9t5v0__oai21_1
X$13351 \$32789 \$32853 \$32765 \$32790 gf180mcu_fd_sc_mcu9t5v0__clkinv_1
X$13352 \$32765 \$32853 gf180mcu_fd_sc_mcu9t5v0__filltie
X$13353 \$32765 \$32853 gf180mcu_fd_sc_mcu9t5v0__filltie
X$13354 \$32765 \$32853 gf180mcu_fd_sc_mcu9t5v0__endcap
X$13355 \$32765 \$32853 gf180mcu_fd_sc_mcu9t5v0__endcap
X$13356 \$32769 \$32853 \$32934 \$32786 gf180mcu_fd_sc_mcu9t5v0__buf_8
X$13357 \$32786 \$32770 \$33312 \$33261 \$33310 \$33266
+ gf180mcu_fd_sc_mcu9t5v0__aoi21_1
X$13358 \$32786 \$33263 \$32770 \$33261 \$33184 \$33262
+ gf180mcu_fd_sc_mcu9t5v0__nand3_1
X$13359 \$32982 \$32783 \$33263 \$32786 \$33261 \$33310 \$33264
+ gf180mcu_fd_sc_mcu9t5v0__oai211_1
X$13360 \$32784 \$32984 \$32992 \$32934 \$32917 gf180mcu_fd_sc_mcu9t5v0__nand2_1
X$13361 \$33202 \$32784 \$33071 \$33184 \$33074 gf180mcu_fd_sc_mcu9t5v0__nand2_1
X$13362 \$32786 \$32916 \$32992 \$32934 \$32984 gf180mcu_fd_sc_mcu9t5v0__nor2_1
X$13363 \$33083 \$33071 \$33184 \$32796 \$33194 gf180mcu_fd_sc_mcu9t5v0__xor2_1
X$13364 \$33083 \$32796 \$33178 \$33071 \$33184 \$33269
+ gf180mcu_fd_sc_mcu9t5v0__oai21_1
X$13365 \$32798 \$32928 \$32853 \$32934 \$32871 gf180mcu_fd_sc_mcu9t5v0__nor2_1
X$13366 \$32798 \$32928 \$32853 \$32934 \$32930 gf180mcu_fd_sc_mcu9t5v0__nand2_1
X$13367 \$32802 \$32853 \$32934 \$32869 \$32870 gf180mcu_fd_sc_mcu9t5v0__xor2_1
X$13368 \$32802 \$32869 \$32992 \$32934 \$32805 gf180mcu_fd_sc_mcu9t5v0__nor2_1
X$13369 \$33180 \$33086 \$33071 \$33062 \$32803 gf180mcu_fd_sc_mcu9t5v0__nor2_1
X$13370 \$32872 \$32804 \$32853 \$32934 \$32806 \$32991
+ gf180mcu_fd_sc_mcu9t5v0__xnor3_1
X$13371 \$32872 \$32991 \$32992 \$32934 \$32807 gf180mcu_fd_sc_mcu9t5v0__nor2_1
X$13372 \$32872 \$32991 \$32992 \$32934 \$32809 gf180mcu_fd_sc_mcu9t5v0__nand2_1
X$13373 \$32931 \$32871 \$32930 \$32853 \$32934 \$32872
+ gf180mcu_fd_sc_mcu9t5v0__oai21_1
X$13374 \$32934 \$32853 gf180mcu_fd_sc_mcu9t5v0__filltie
X$13375 \$32934 \$32853 gf180mcu_fd_sc_mcu9t5v0__filltie
X$13376 \$32934 \$32853 gf180mcu_fd_sc_mcu9t5v0__endcap
X$13377 \$32934 \$32853 gf180mcu_fd_sc_mcu9t5v0__endcap
X$13378 \$32854 \$32992 \$32934 \$32982 gf180mcu_fd_sc_mcu9t5v0__buf_8
X$13379 \$33213 \$32859 \$33317 \$33310 \$33318 gf180mcu_fd_sc_mcu9t5v0__xnor2_1
X$13380 \$33213 \$32859 \$33317 \$33310 \$33426 gf180mcu_fd_sc_mcu9t5v0__nand2_1
X$13381 \$32860 \$33188 \$33317 \$33310 \$33319 gf180mcu_fd_sc_mcu9t5v0__xnor2_1
X$13382 \$32860 \$33188 \$33261 \$33310 \$33314 gf180mcu_fd_sc_mcu9t5v0__nand2_1
X$13383 \$33377 \$33321 \$32861 \$33317 \$33423 \$33376
+ gf180mcu_fd_sc_mcu9t5v0__aoi21_1
X$13384 \$33052 \$32862 \$32861 \$33317 \$33310 \$33321
+ gf180mcu_fd_sc_mcu9t5v0__aoi21_1
X$13385 \$33060 \$33317 \$33423 \$32862 \$33378 gf180mcu_fd_sc_mcu9t5v0__xor2_1
X$13386 \$33060 \$32862 \$33432 \$33424 \$33423 \$33431
+ gf180mcu_fd_sc_mcu9t5v0__oai21_1
X$13387 \$32866 \$33191 \$33317 \$33423 \$33380 gf180mcu_fd_sc_mcu9t5v0__xnor2_1
X$13388 \$32866 \$33191 \$33317 \$33423 \$33379 gf180mcu_fd_sc_mcu9t5v0__nand2_1
X$13389 \$32990 \$32989 \$32867 \$32992 \$32934 \$33007
+ gf180mcu_fd_sc_mcu9t5v0__oai21_1
X$13390 \$32870 \$32992 \$32934 \$32931 gf180mcu_fd_sc_mcu9t5v0__clkinv_1
X$13391 \$33185 \$32918 \$33261 \$33184 \$33208 gf180mcu_fd_sc_mcu9t5v0__nand2_1
X$13392 \$32993 \$32918 \$33261 \$33184 \$33311 gf180mcu_fd_sc_mcu9t5v0__nand2_1
X$13393 \$32936 \$32921 \$32992 \$32934 \$33001 gf180mcu_fd_sc_mcu9t5v0__xnor2_1
X$13394 \$33067 \$32922 \$33071 \$33184 \$33066 \$33177
+ gf180mcu_fd_sc_mcu9t5v0__xor3_1
X$13395 \$33067 \$32922 \$33071 \$33062 \$33176 gf180mcu_fd_sc_mcu9t5v0__and2_1
X$13396 \$33003 \$32992 \$33062 \$32926 \$33054 gf180mcu_fd_sc_mcu9t5v0__xor2_1
X$13397 \$32926 \$33060 \$33176 \$33066 \$33261 \$33310 \$33315
+ gf180mcu_fd_sc_mcu9t5v0__oai22_1
X$13398 \$33003 \$32926 \$33071 \$33184 \$33193 gf180mcu_fd_sc_mcu9t5v0__nor2_1
X$13399 \$33005 \$32992 \$33062 \$32927 \$32988 gf180mcu_fd_sc_mcu9t5v0__xor2_1
X$13400 \$33005 \$32927 \$32992 \$32934 \$32937 gf180mcu_fd_sc_mcu9t5v0__or2_1
X$13401 \$32989 \$32992 \$32934 \$32990 \$32928 gf180mcu_fd_sc_mcu9t5v0__xor2_1
X$13402 \$33088 \$33218 \$33261 \$33184 \$32932 gf180mcu_fd_sc_mcu9t5v0__xnor2_1
X$13403 \$32932 \$32992 \$32934 \$32933 gf180mcu_fd_sc_mcu9t5v0__clkinv_1
X$13404 \$32934 \$32992 gf180mcu_fd_sc_mcu9t5v0__filltie
X$13405 \$32934 \$32992 gf180mcu_fd_sc_mcu9t5v0__filltie
X$13406 \$32934 \$32992 gf180mcu_fd_sc_mcu9t5v0__endcap
X$13407 \$32934 \$32992 gf180mcu_fd_sc_mcu9t5v0__endcap
X$13408 \$32937 \$33006 \$33071 \$33062 \$33084 gf180mcu_fd_sc_mcu9t5v0__and2_1
X$13409 \$33061 \$32992 \$33062 \$32988 \$32990 gf180mcu_fd_sc_mcu9t5v0__xor2_1
X$13410 \$33182 \$33090 \$33071 \$33184 \$32991 gf180mcu_fd_sc_mcu9t5v0__xnor2_1
X$13411 \$33048 \$33057 \$32992 \$33062 \$33050 gf180mcu_fd_sc_mcu9t5v0__or2_1
X$13412 \$33045 \$33046 \$32992 \$33062 \$33072 gf180mcu_fd_sc_mcu9t5v0__nor2_1
X$13413 \$33262 \$32992 \$33062 \$33049 gf180mcu_fd_sc_mcu9t5v0__clkinv_1
X$13414 \$33062 \$32992 gf180mcu_fd_sc_mcu9t5v0__filltie
X$13415 \$33062 \$32992 gf180mcu_fd_sc_mcu9t5v0__filltie
X$13416 \$33062 \$32992 gf180mcu_fd_sc_mcu9t5v0__endcap
X$13417 \$33062 \$32992 gf180mcu_fd_sc_mcu9t5v0__endcap
X$13418 \$33174 \$33001 \$33317 \$33310 \$33374 gf180mcu_fd_sc_mcu9t5v0__xnor2_1
X$13419 \$33174 \$33001 \$33317 \$33310 \$33320 gf180mcu_fd_sc_mcu9t5v0__nand2_1
X$13420 \$33002 \$33173 \$33175 \$33071 \$33184 \$33174
+ gf180mcu_fd_sc_mcu9t5v0__oai21_1
X$13421 \$33082 \$33004 \$33071 \$33062 \$33083 gf180mcu_fd_sc_mcu9t5v0__or2_1
X$13422 \$33007 \$33194 \$33071 \$33062 \$33090 gf180mcu_fd_sc_mcu9t5v0__xnor2_1
X$13423 \$33007 \$33194 \$33071 \$33184 \$33198 gf180mcu_fd_sc_mcu9t5v0__nand2_1
X$13424 \$33044 \$33069 \$33071 \$33062 \$33070 gf180mcu_fd_sc_mcu9t5v0__nor2_1
X$13425 \$33774 \$33773 \$33722 \$33047 gf180mcu_fd_sc_mcu9t5v0__clkbuf_16
X$13426 \$33180 \$33087 \$33089 \$33071 \$33062 \$33088
+ gf180mcu_fd_sc_mcu9t5v0__aoi21_1
X$13427 \$33195 \$33071 \$33062 \$33196 gf180mcu_fd_sc_mcu9t5v0__clkinv_1
X$13428 \$33062 \$33071 gf180mcu_fd_sc_mcu9t5v0__filltie
X$13429 \$33062 \$33071 gf180mcu_fd_sc_mcu9t5v0__filltie
X$13430 \$33062 \$33071 gf180mcu_fd_sc_mcu9t5v0__endcap
X$13431 \$33062 \$33071 gf180mcu_fd_sc_mcu9t5v0__endcap
X$13432 \$33066 \$33321 \$33317 \$33423 \$33427 gf180mcu_fd_sc_mcu9t5v0__xnor2_1
X$13433 \$33066 \$33317 \$33423 \$33377 gf180mcu_fd_sc_mcu9t5v0__clkinv_1
X$13434 \$33180 \$33195 \$33071 \$33184 \$33182 \$33084
+ gf180mcu_fd_sc_mcu9t5v0__xnor3_1
X$13435 \$33177 \$33215 \$33081 \$33071 \$33184 \$33192
+ gf180mcu_fd_sc_mcu9t5v0__oai21_1
X$13436 \$33085 \$33071 \$33184 \$33180 gf180mcu_fd_sc_mcu9t5v0__clkinv_1
X$13437 \$33183 \$33071 \$33184 \$33200 gf180mcu_fd_sc_mcu9t5v0__clkinv_1
X$13438 \$33182 \$33071 \$33184 \$33199 gf180mcu_fd_sc_mcu9t5v0__clkinv_1
X$13439 \$33084 \$33196 \$33071 \$33184 \$33087 gf180mcu_fd_sc_mcu9t5v0__nand2_1
X$13440 \$33184 \$33071 gf180mcu_fd_sc_mcu9t5v0__filltie
X$13441 \$33184 \$33071 gf180mcu_fd_sc_mcu9t5v0__filltie
X$13442 \$33184 \$33071 gf180mcu_fd_sc_mcu9t5v0__endcap
X$13443 \$33184 \$33071 gf180mcu_fd_sc_mcu9t5v0__endcap
X$13444 \$33211 \$33261 \$33184 \$33077 gf180mcu_fd_sc_mcu9t5v0__clkinv_1
X$13445 \$33193 \$33082 \$33261 \$33184 \$33216 gf180mcu_fd_sc_mcu9t5v0__nor2_1
X$13446 \$33084 \$33196 \$33261 \$33184 \$33089 gf180mcu_fd_sc_mcu9t5v0__nor2_1
X$13447 \$33088 \$33218 \$33217 \$33261 \$33184 \$33183
+ gf180mcu_fd_sc_mcu9t5v0__oai21_1
X$13448 \$33199 \$33090 \$33198 \$33261 \$33184 \$33273
+ gf180mcu_fd_sc_mcu9t5v0__oai21_1
X$13449 \$33267 \$33265 \$33261 \$33310 \$33171 gf180mcu_fd_sc_mcu9t5v0__nor2_1
X$13450 \$33177 \$33261 \$33184 \$33215 \$33268 gf180mcu_fd_sc_mcu9t5v0__xor2_1
X$13451 \$33179 \$33216 \$33317 \$33310 \$33324 gf180mcu_fd_sc_mcu9t5v0__or2_1
X$13452 \$33179 \$33376 \$33528 \$33527 \$33532 gf180mcu_fd_sc_mcu9t5v0__or2_1
X$13453 \$33179 \$33376 \$33528 \$33624 \$33535 gf180mcu_fd_sc_mcu9t5v0__nand2_1
X$13454 \$33179 \$33216 \$33317 \$33310 \$33323 gf180mcu_fd_sc_mcu9t5v0__nand2_1
X$13455 \$33179 \$33528 \$33624 \$33536 gf180mcu_fd_sc_mcu9t5v0__clkinv_1
X$13456 \$33273 \$33272 \$33261 \$33184 \$33217 gf180mcu_fd_sc_mcu9t5v0__nand2_1
X$13457 \$33204 \$33262 \$33261 \$33184 \$33205 gf180mcu_fd_sc_mcu9t5v0__nand2_1
X$13458 \$33184 \$33261 gf180mcu_fd_sc_mcu9t5v0__filltie
X$13459 \$33184 \$33261 gf180mcu_fd_sc_mcu9t5v0__filltie
X$13460 \$33184 \$33261 gf180mcu_fd_sc_mcu9t5v0__endcap
X$13461 \$33184 \$33261 gf180mcu_fd_sc_mcu9t5v0__endcap
X$13462 \$33202 \$33201 \$33261 \$33310 \$33186 gf180mcu_fd_sc_mcu9t5v0__nand2_1
X$13463 \$33192 \$33317 \$33423 \$33381 \$33383 gf180mcu_fd_sc_mcu9t5v0__xor2_1
X$13464 \$33192 \$33317 \$33310 \$33322 gf180mcu_fd_sc_mcu9t5v0__clkinv_1
X$13465 \$33324 \$33328 \$33317 \$33310 \$33197 gf180mcu_fd_sc_mcu9t5v0__xnor2_1
X$13466 \$33202 \$33312 \$33313 \$33261 \$33310 \$33265
+ gf180mcu_fd_sc_mcu9t5v0__aoi21_1
X$13467 \$33273 \$33272 \$33261 \$33310 \$33218 gf180mcu_fd_sc_mcu9t5v0__xnor2_1
X$13468 \$33271 \$33261 \$33310 \$33270 \$33272 gf180mcu_fd_sc_mcu9t5v0__xor2_1
X$13469 \$33269 \$33268 \$33261 \$33310 \$33270 gf180mcu_fd_sc_mcu9t5v0__xnor2_1
X$13470 \$33269 \$33268 \$33261 \$33310 \$33316 gf180mcu_fd_sc_mcu9t5v0__nand2_1
X$13471 \$33310 \$33261 gf180mcu_fd_sc_mcu9t5v0__filltie
X$13472 \$33310 \$33261 gf180mcu_fd_sc_mcu9t5v0__filltie
X$13473 \$33310 \$33261 gf180mcu_fd_sc_mcu9t5v0__endcap
X$13474 \$33310 \$33261 gf180mcu_fd_sc_mcu9t5v0__endcap
X$13475 \$33271 \$33270 \$33316 \$33317 \$33310 \$33325
+ gf180mcu_fd_sc_mcu9t5v0__oai21_1
X$13476 \$33323 \$33324 \$33317 \$33310 \$33271 gf180mcu_fd_sc_mcu9t5v0__nand2_1
X$13477 \$33325 \$33326 \$33317 \$33310 \$33327 gf180mcu_fd_sc_mcu9t5v0__nand2_1
X$13478 \$33310 \$33317 gf180mcu_fd_sc_mcu9t5v0__filltie
X$13479 \$33310 \$33317 gf180mcu_fd_sc_mcu9t5v0__filltie
X$13480 \$33310 \$33317 gf180mcu_fd_sc_mcu9t5v0__endcap
X$13481 \$33310 \$33317 gf180mcu_fd_sc_mcu9t5v0__endcap
X$13482 \$33372 \$33319 \$33314 \$33317 \$33423 \$33373
+ gf180mcu_fd_sc_mcu9t5v0__oai21_1
X$13483 \$33536 \$33315 \$33424 \$33527 \$33435 gf180mcu_fd_sc_mcu9t5v0__xnor2_1
X$13484 \$33536 \$33315 \$33424 \$33527 \$33436 gf180mcu_fd_sc_mcu9t5v0__nand2_1
X$13485 \$33325 \$33317 \$33423 \$33438 \$33328 gf180mcu_fd_sc_mcu9t5v0__xor2_1
X$13486 \$33380 \$33433 \$33317 \$33423 \$33381 gf180mcu_fd_sc_mcu9t5v0__xnor2_1
X$13487 \$33322 \$33381 \$33317 \$33423 \$33384 gf180mcu_fd_sc_mcu9t5v0__or2_1
X$13488 \$33324 \$33328 \$33327 \$33317 \$33423 \$33385
+ gf180mcu_fd_sc_mcu9t5v0__oai21_1
X$13489 \$33372 \$33374 \$33320 \$33317 \$33423 \$33375
+ gf180mcu_fd_sc_mcu9t5v0__oai21_1
X$13490 \$33438 \$33317 \$33423 \$33326 gf180mcu_fd_sc_mcu9t5v0__clkinv_1
X$13491 \$33386 \$33317 \$33423 \$33329 gf180mcu_fd_sc_mcu9t5v0__clkinv_1
X$13492 \$33423 \$33317 gf180mcu_fd_sc_mcu9t5v0__filltie
X$13493 \$33423 \$33317 gf180mcu_fd_sc_mcu9t5v0__filltie
X$13494 \$33423 \$33317 gf180mcu_fd_sc_mcu9t5v0__endcap
X$13495 \$33423 \$33317 gf180mcu_fd_sc_mcu9t5v0__endcap
X$13496 \$33427 \$33318 \$33424 \$33423 \$33428 gf180mcu_fd_sc_mcu9t5v0__xnor2_1
X$13497 \$33372 \$33318 \$33426 \$33424 \$33423 \$33425
+ gf180mcu_fd_sc_mcu9t5v0__oai21_1
X$13498 \$33427 \$33319 \$33424 \$33423 \$33429 gf180mcu_fd_sc_mcu9t5v0__xnor2_1
X$13499 \$33427 \$33424 \$33423 \$33372 gf180mcu_fd_sc_mcu9t5v0__clkinv_1
X$13500 \$33373 \$33428 \$33528 \$33527 \$33529 gf180mcu_fd_sc_mcu9t5v0__xnor2_1
X$13501 \$33373 \$33428 \$33528 \$33527 \$33627 gf180mcu_fd_sc_mcu9t5v0__nand2_1
X$13502 \$33427 \$33374 \$33424 \$33423 \$33430 gf180mcu_fd_sc_mcu9t5v0__xnor2_1
X$13503 \$33375 \$33429 \$33528 \$33527 \$33631 gf180mcu_fd_sc_mcu9t5v0__xnor2_1
X$13504 \$33375 \$33429 \$33531 \$33528 \$33527 \$33530
+ gf180mcu_fd_sc_mcu9t5v0__aoi21_1
X$13505 \$33536 \$33376 \$33528 \$33624 \$33630 gf180mcu_fd_sc_mcu9t5v0__xnor2_1
X$13506 \$33377 \$33378 \$33424 \$33423 \$33433 gf180mcu_fd_sc_mcu9t5v0__xnor2_1
X$13507 \$33377 \$33378 \$33424 \$33527 \$33432 gf180mcu_fd_sc_mcu9t5v0__nand2_1
X$13508 \$33380 \$33433 \$33379 \$33424 \$33423 \$33434
+ gf180mcu_fd_sc_mcu9t5v0__oai21_1
X$13509 \$33383 \$33435 \$33424 \$33423 \$33438 gf180mcu_fd_sc_mcu9t5v0__xnor2_1
X$13510 \$33383 \$33435 \$33384 \$33424 \$33423 \$33487
+ gf180mcu_fd_sc_mcu9t5v0__oai21_1
X$13511 \$33436 \$33439 \$33424 \$33423 \$33386 gf180mcu_fd_sc_mcu9t5v0__xnor2_1
X$13512 \$33436 \$33439 \$33489 \$33424 \$33423 \$33440
+ gf180mcu_fd_sc_mcu9t5v0__oai21_1
X$13513 \$33440 \$33424 \$33423 \$33441 gf180mcu_fd_sc_mcu9t5v0__clkinv_1
X$13514 \$33423 \$33424 gf180mcu_fd_sc_mcu9t5v0__filltie
X$13515 \$33423 \$33424 gf180mcu_fd_sc_mcu9t5v0__filltie
X$13516 \$33423 \$33424 gf180mcu_fd_sc_mcu9t5v0__endcap
X$13517 \$33423 \$33424 gf180mcu_fd_sc_mcu9t5v0__endcap
X$13518 \$33434 \$33430 \$33424 \$33527 \$33485 gf180mcu_fd_sc_mcu9t5v0__xnor2_1
X$13519 \$33487 \$33488 \$33424 \$33527 \$33439 gf180mcu_fd_sc_mcu9t5v0__xnor2_1
X$13520 \$33537 \$33485 \$33424 \$33527 \$33486 gf180mcu_fd_sc_mcu9t5v0__nor2_1
X$13521 \$33487 \$33488 \$33424 \$33527 \$33489 gf180mcu_fd_sc_mcu9t5v0__nand2_1
X$13522 \$33527 \$33424 gf180mcu_fd_sc_mcu9t5v0__filltie
X$13523 \$33527 \$33424 gf180mcu_fd_sc_mcu9t5v0__filltie
X$13524 \$33527 \$33424 gf180mcu_fd_sc_mcu9t5v0__endcap
X$13525 \$33527 \$33424 gf180mcu_fd_sc_mcu9t5v0__endcap
X$13526 \$33425 \$33526 \$33528 \$33624 \$33625 gf180mcu_fd_sc_mcu9t5v0__or2_1
X$13527 \$33425 \$33526 \$33528 \$33624 \$33626 gf180mcu_fd_sc_mcu9t5v0__nand2_1
X$13528 \$33434 \$33430 \$33486 \$33528 \$33624 \$33539
+ gf180mcu_fd_sc_mcu9t5v0__aoi21_1
X$13529 \$33536 \$33431 \$33528 \$33527 \$33537 gf180mcu_fd_sc_mcu9t5v0__xnor2_1
X$13530 \$33536 \$33431 \$33528 \$33527 \$33542 gf180mcu_fd_sc_mcu9t5v0__nand2_1
X$13531 \$33542 \$33541 \$33528 \$33527 \$33437 gf180mcu_fd_sc_mcu9t5v0__xnor2_1
X$13532 \$33537 \$33485 \$33528 \$33527 \$33538 gf180mcu_fd_sc_mcu9t5v0__xnor2_1
X$13533 \$33538 \$33528 \$33527 \$33488 gf180mcu_fd_sc_mcu9t5v0__clkinv_1
X$13534 \$33539 \$33534 \$33528 \$33527 \$33540 gf180mcu_fd_sc_mcu9t5v0__nor2_1
X$13535 \$33535 \$33532 \$33528 \$33527 \$33629 gf180mcu_fd_sc_mcu9t5v0__nand2_1
X$13536 \$33527 \$33528 gf180mcu_fd_sc_mcu9t5v0__filltie
X$13537 \$33527 \$33528 gf180mcu_fd_sc_mcu9t5v0__filltie
X$13538 \$33527 \$33528 gf180mcu_fd_sc_mcu9t5v0__endcap
X$13539 \$33527 \$33528 gf180mcu_fd_sc_mcu9t5v0__endcap
X$13540 \$33629 \$33631 \$33528 \$33624 \$33534 gf180mcu_fd_sc_mcu9t5v0__xnor2_1
X$13541 \$33539 \$33534 \$33528 \$33624 \$33541 gf180mcu_fd_sc_mcu9t5v0__xnor2_1
X$13542 \$33629 \$33529 \$33627 \$33528 \$33624 \$33628
+ gf180mcu_fd_sc_mcu9t5v0__oai21_1
X$13543 \$33629 \$33631 \$33528 \$33624 \$33531 gf180mcu_fd_sc_mcu9t5v0__nor2_1
X$13544 \$33540 \$33543 \$33528 \$33624 \$33544 gf180mcu_fd_sc_mcu9t5v0__nor2_1
X$13545 \$33542 \$33541 \$33528 \$33624 \$33543 gf180mcu_fd_sc_mcu9t5v0__nor2_1
X$13546 \$33624 \$33528 gf180mcu_fd_sc_mcu9t5v0__filltie
X$13547 \$33624 \$33528 gf180mcu_fd_sc_mcu9t5v0__filltie
X$13548 \$33624 \$33528 gf180mcu_fd_sc_mcu9t5v0__endcap
X$13549 \$33624 \$33528 gf180mcu_fd_sc_mcu9t5v0__endcap
X$13550 \$33630 \$33529 \$33633 \$33624 \$33636 gf180mcu_fd_sc_mcu9t5v0__xnor2_1
X$13551 \$33532 \$33636 \$33633 \$33624 \$33533 \$33530
+ gf180mcu_fd_sc_mcu9t5v0__xnor3_1
X$13552 \$33530 \$33633 \$33716 \$33721 gf180mcu_fd_sc_mcu9t5v0__clkinv_1
X$13553 \$33532 \$33726 \$33722 \$33773 \$33727 gf180mcu_fd_sc_mcu9t5v0__xnor2_1
X$13554 \$33532 \$33720 \$33729 \$33722 \$33716 \$33728
+ gf180mcu_fd_sc_mcu9t5v0__oai21_1
X$13555 \$33719 \$33725 \$33532 \$33722 \$33716 \$33723
+ gf180mcu_fd_sc_mcu9t5v0__mux2_1
X$13556 \$33624 \$33633 gf180mcu_fd_sc_mcu9t5v0__filltie
X$13557 \$33624 \$33633 gf180mcu_fd_sc_mcu9t5v0__filltie
X$13558 \$33626 \$33625 \$33630 \$33633 \$33624 \$33634
+ gf180mcu_fd_sc_mcu9t5v0__mux2_1
X$13559 \$33624 \$33633 gf180mcu_fd_sc_mcu9t5v0__endcap
X$13560 \$33624 \$33633 gf180mcu_fd_sc_mcu9t5v0__endcap
X$13561 \$33626 \$33625 \$33633 \$33716 \$33717 gf180mcu_fd_sc_mcu9t5v0__nand2_1
X$13562 \$33628 \$33718 \$33633 \$33716 \$33719 gf180mcu_fd_sc_mcu9t5v0__or2_1
X$13563 \$33628 \$33718 \$33722 \$33716 \$33725 gf180mcu_fd_sc_mcu9t5v0__nand2_1
X$13564 \$33630 \$33717 \$33633 \$33716 \$33718 gf180mcu_fd_sc_mcu9t5v0__xnor2_1
X$13565 \$33721 \$33636 \$33633 \$33716 \$33720 gf180mcu_fd_sc_mcu9t5v0__nor2_1
X$13566 \$33716 \$33633 gf180mcu_fd_sc_mcu9t5v0__filltie
X$13567 \$33716 \$33633 gf180mcu_fd_sc_mcu9t5v0__filltie
X$13568 \$33716 \$33633 gf180mcu_fd_sc_mcu9t5v0__endcap
X$13569 \$33716 \$33633 gf180mcu_fd_sc_mcu9t5v0__endcap
X$13570 \$33635 \$33723 \$33722 \$33716 \$33724 \$33634
+ gf180mcu_fd_sc_mcu9t5v0__xnor3_1
X$13571 \$33721 \$33636 \$33722 \$33773 \$33729 gf180mcu_fd_sc_mcu9t5v0__nand2_1
X$13572 \$33725 \$33719 \$33722 \$33716 \$33726 gf180mcu_fd_sc_mcu9t5v0__nand2_1
X$13573 \$33716 \$33722 gf180mcu_fd_sc_mcu9t5v0__filltie
X$13574 \$33716 \$33722 gf180mcu_fd_sc_mcu9t5v0__filltie
X$13575 \$33716 \$33722 gf180mcu_fd_sc_mcu9t5v0__endcap
X$13576 \$33716 \$33722 gf180mcu_fd_sc_mcu9t5v0__endcap
X$13577 \$33728 \$33722 \$33773 \$33730 gf180mcu_fd_sc_mcu9t5v0__clkinv_1
X$13578 \$33773 \$33722 gf180mcu_fd_sc_mcu9t5v0__filltie
X$13579 \$33773 \$33722 gf180mcu_fd_sc_mcu9t5v0__filltie
X$13580 \$33773 \$33722 gf180mcu_fd_sc_mcu9t5v0__endcap
X$13581 \$33773 \$33722 gf180mcu_fd_sc_mcu9t5v0__endcap
X$13582 \$33773 \$33853 gf180mcu_fd_sc_mcu9t5v0__filltie
X$13583 \$33773 \$33853 gf180mcu_fd_sc_mcu9t5v0__filltie
X$13584 \$33773 \$33853 gf180mcu_fd_sc_mcu9t5v0__endcap
X$13585 \$33773 \$33853 gf180mcu_fd_sc_mcu9t5v0__endcap
X$13586 \$34298 \$I29195 \$34215 \$33774 gf180mcu_fd_sc_mcu9t5v0__clkbuf_1
X$13587 \$33891 \$33853 gf180mcu_fd_sc_mcu9t5v0__filltie
X$13588 \$33891 \$33853 gf180mcu_fd_sc_mcu9t5v0__filltie
X$13589 \$33891 \$33853 gf180mcu_fd_sc_mcu9t5v0__endcap
X$13590 \$33891 \$33853 gf180mcu_fd_sc_mcu9t5v0__endcap
X$13591 \$33891 \$33892 gf180mcu_fd_sc_mcu9t5v0__filltie
X$13592 \$33891 \$33892 gf180mcu_fd_sc_mcu9t5v0__filltie
X$13593 \$33891 \$33892 gf180mcu_fd_sc_mcu9t5v0__endcap
X$13594 \$33891 \$33892 gf180mcu_fd_sc_mcu9t5v0__endcap
X$13595 \$33936 \$33892 gf180mcu_fd_sc_mcu9t5v0__filltie
X$13596 \$33936 \$33892 gf180mcu_fd_sc_mcu9t5v0__filltie
X$13597 \$33936 \$33892 gf180mcu_fd_sc_mcu9t5v0__endcap
X$13598 \$33936 \$33892 gf180mcu_fd_sc_mcu9t5v0__endcap
X$13599 \$33936 \$34015 gf180mcu_fd_sc_mcu9t5v0__filltie
X$13600 \$33936 \$34015 gf180mcu_fd_sc_mcu9t5v0__filltie
X$13601 \$33936 \$34015 gf180mcu_fd_sc_mcu9t5v0__endcap
X$13602 \$33936 \$34015 gf180mcu_fd_sc_mcu9t5v0__endcap
X$13603 \$34016 \$34015 gf180mcu_fd_sc_mcu9t5v0__filltie
X$13604 \$34016 \$34015 gf180mcu_fd_sc_mcu9t5v0__filltie
X$13605 \$34016 \$34015 gf180mcu_fd_sc_mcu9t5v0__endcap
X$13606 \$34016 \$34015 gf180mcu_fd_sc_mcu9t5v0__endcap
X$13607 \$34016 \$34095 gf180mcu_fd_sc_mcu9t5v0__filltie
X$13608 \$34016 \$34095 gf180mcu_fd_sc_mcu9t5v0__filltie
X$13609 \$34016 \$34095 gf180mcu_fd_sc_mcu9t5v0__endcap
X$13610 \$34016 \$34095 gf180mcu_fd_sc_mcu9t5v0__endcap
X$13611 \$34096 \$34095 gf180mcu_fd_sc_mcu9t5v0__filltie
X$13612 \$34096 \$34095 gf180mcu_fd_sc_mcu9t5v0__filltie
X$13613 \$34096 \$34095 gf180mcu_fd_sc_mcu9t5v0__endcap
X$13614 \$34096 \$34095 gf180mcu_fd_sc_mcu9t5v0__endcap
X$13615 \$34096 \$34134 gf180mcu_fd_sc_mcu9t5v0__filltie
X$13616 \$34096 \$34134 gf180mcu_fd_sc_mcu9t5v0__filltie
X$13617 \$34096 \$34134 gf180mcu_fd_sc_mcu9t5v0__endcap
X$13618 \$34096 \$34134 gf180mcu_fd_sc_mcu9t5v0__endcap
X$13619 \$34213 \$34134 gf180mcu_fd_sc_mcu9t5v0__filltie
X$13620 \$34213 \$34134 gf180mcu_fd_sc_mcu9t5v0__filltie
X$13621 \$34213 \$34134 gf180mcu_fd_sc_mcu9t5v0__endcap
X$13622 \$34213 \$34134 gf180mcu_fd_sc_mcu9t5v0__endcap
X$13623 \$34213 \$34217 gf180mcu_fd_sc_mcu9t5v0__filltie
X$13624 \$34213 \$34217 gf180mcu_fd_sc_mcu9t5v0__filltie
X$13625 \$34213 \$34217 gf180mcu_fd_sc_mcu9t5v0__endcap
X$13626 \$34213 \$34217 gf180mcu_fd_sc_mcu9t5v0__endcap
X$13627 \$34299 \$I28861 \$34215 \$34300 gf180mcu_fd_sc_mcu9t5v0__buf_1
X$13628 \$34215 \$34217 gf180mcu_fd_sc_mcu9t5v0__filltie
X$13629 \$34215 \$34217 gf180mcu_fd_sc_mcu9t5v0__filltie
X$13630 \$34215 \$34302 gf180mcu_fd_sc_mcu9t5v0__filltie
X$13631 \$34215 \$34302 gf180mcu_fd_sc_mcu9t5v0__filltie
X$13632 \$34215 \$34302 gf180mcu_fd_sc_mcu9t5v0__filltie
X$13633 \$34215 \$34302 gf180mcu_fd_sc_mcu9t5v0__filltie
X$13634 \$34215 \$34302 gf180mcu_fd_sc_mcu9t5v0__filltie
X$13635 \$34215 \$34302 gf180mcu_fd_sc_mcu9t5v0__filltie
X$13636 \$34215 \$34296 gf180mcu_fd_sc_mcu9t5v0__filltie
X$13637 \$34215 \$34296 gf180mcu_fd_sc_mcu9t5v0__filltie
X$13638 \$34215 \$I1471 gf180mcu_fd_sc_mcu9t5v0__filltie
X$13639 \$34215 \$34296 gf180mcu_fd_sc_mcu9t5v0__filltie
X$13640 \$34215 \$34296 gf180mcu_fd_sc_mcu9t5v0__filltie
X$13641 \$34215 \$I1222 gf180mcu_fd_sc_mcu9t5v0__filltie
X$13642 \$34215 \$34217 gf180mcu_fd_sc_mcu9t5v0__endcap
X$13643 \$34215 \$34217 gf180mcu_fd_sc_mcu9t5v0__endcap
X$13644 \$34215 \$34296 gf180mcu_fd_sc_mcu9t5v0__endcap
X$13645 \$34297 \$34296 gf180mcu_fd_sc_mcu9t5v0__endcap
X$13646 \$34301 \$34302 gf180mcu_fd_sc_mcu9t5v0__filltie
X$13647 \$34301 \$34302 gf180mcu_fd_sc_mcu9t5v0__filltie
X$13648 \$34301 \$34302 gf180mcu_fd_sc_mcu9t5v0__endcap
X$13649 \$I18268 \$I18288 \$I18278 \$I18298 \$I18308 \$I18318 \$I18328 \$I18338
+ \$I18348 \$I18358 \$I18368 \$I18378 \$I18388 \$I18398 \$I18408 \$I18418
+ \$I18428 \$I18448 \$I18438 \$I18458 \$I18468 \$I18478 \$I18488 \$I18498
+ \$I18508 \$I18518 \$I18528 \$I18538 \$I18548 \$I18558 \$I18568 \$I18578
+ \$I18598 \$I18588 \$I18618 \$I18608 \$I18668 \$I18628 \$I18638 \$I18678
+ \$I18688 \$I18648 \$I18658 \$I18698 \$I18708 \$I18728 \$I18718 \$I18738
+ \$I18748 \$I18768 \$I18758 \$I18778 \$I18788 \$I18798 \$I18808 \$I18818
+ \$I18828 \$I18848 \$I18838 \$I18858 \$I18868 \$I18888 \$I18878 \$I18898
+ \$I18908 \$I18928 \$I18918 \$I18938 \$I18948 \$I18968 \$I18958 \$I18978
+ \$I18988 \$I18998 \$I19008 \$I19018 \$I19028 \$I19048 \$I19038 \$I19058
+ \$I19068 \$I19078 \$I19088 \$I19098 \$I19148 \$I19108 \$I19128 \$I19158
+ \$I19168 \$I19118 \$I19138 \$I19188 \$I19178 \$I19228 \$I19198 \$I19208
+ \$I19218 \$I19248 \$I19238 \$I19258 \$I19268 \$I19278 \$I19288 \$I19298
+ gf180mcu_fd_io__dvdd
X$13650 \$I591 \$I1182 gf180mcu_fd_sc_mcu9t5v0__endcap
X$13651 \$I588 \$I1182 gf180mcu_fd_sc_mcu9t5v0__endcap
X$13652 \$I590 \$I1181 gf180mcu_fd_sc_mcu9t5v0__endcap
X$13653 \$I591 \$I1181 gf180mcu_fd_sc_mcu9t5v0__endcap
X$13654 \$I589 \$I1180 gf180mcu_fd_sc_mcu9t5v0__endcap
X$13655 \$I571 \$I1180 gf180mcu_fd_sc_mcu9t5v0__endcap
X$13656 \$I588 \$I1179 gf180mcu_fd_sc_mcu9t5v0__endcap
X$13657 \$I570 \$I1179 gf180mcu_fd_sc_mcu9t5v0__endcap
X$13658 \$I587 \$I1178 gf180mcu_fd_sc_mcu9t5v0__endcap
X$13659 \$I586 \$I1177 gf180mcu_fd_sc_mcu9t5v0__endcap
X$13660 \$I576 \$I1177 gf180mcu_fd_sc_mcu9t5v0__endcap
X$13661 \$I585 \$I1176 gf180mcu_fd_sc_mcu9t5v0__endcap
X$13662 \$I567 \$I1176 gf180mcu_fd_sc_mcu9t5v0__endcap
X$13663 \$I584 \$I1175 gf180mcu_fd_sc_mcu9t5v0__endcap
X$13664 \$I585 \$I1175 gf180mcu_fd_sc_mcu9t5v0__endcap
X$13665 \$I583 \$I1174 gf180mcu_fd_sc_mcu9t5v0__endcap
X$13666 \$I584 \$I1174 gf180mcu_fd_sc_mcu9t5v0__endcap
X$13667 \$I582 \$I1173 gf180mcu_fd_sc_mcu9t5v0__endcap
X$13668 \$I583 \$I1173 gf180mcu_fd_sc_mcu9t5v0__endcap
X$13669 \$I581 \$I1172 gf180mcu_fd_sc_mcu9t5v0__endcap
X$13670 \$I535 \$I1172 gf180mcu_fd_sc_mcu9t5v0__endcap
X$13671 \$I580 \$I1171 gf180mcu_fd_sc_mcu9t5v0__endcap
X$13672 \$I586 \$I1171 gf180mcu_fd_sc_mcu9t5v0__endcap
X$13673 \$I579 \$I1170 gf180mcu_fd_sc_mcu9t5v0__endcap
X$13674 \$I578 \$I1170 gf180mcu_fd_sc_mcu9t5v0__endcap
X$13675 \$I578 \$I1169 gf180mcu_fd_sc_mcu9t5v0__endcap
X$13676 \$I581 \$I1169 gf180mcu_fd_sc_mcu9t5v0__endcap
X$13677 \$I577 \$I1168 gf180mcu_fd_sc_mcu9t5v0__endcap
X$13678 \$I579 \$I1168 gf180mcu_fd_sc_mcu9t5v0__endcap
X$13679 \$I576 \$I1167 gf180mcu_fd_sc_mcu9t5v0__endcap
X$13680 \$I577 \$I1167 gf180mcu_fd_sc_mcu9t5v0__endcap
X$13681 \$I575 \$I1166 gf180mcu_fd_sc_mcu9t5v0__endcap
X$13682 \$I549 \$I1166 gf180mcu_fd_sc_mcu9t5v0__endcap
X$13683 \$I574 \$I1165 gf180mcu_fd_sc_mcu9t5v0__endcap
X$13684 \$I555 \$I1165 gf180mcu_fd_sc_mcu9t5v0__endcap
X$13685 \$I573 \$I1164 gf180mcu_fd_sc_mcu9t5v0__endcap
X$13686 \$I568 \$I1164 gf180mcu_fd_sc_mcu9t5v0__endcap
X$13687 \$I572 \$I1163 gf180mcu_fd_sc_mcu9t5v0__endcap
X$13688 \$I557 \$I1163 gf180mcu_fd_sc_mcu9t5v0__endcap
X$13689 \$I571 \$I1162 gf180mcu_fd_sc_mcu9t5v0__endcap
X$13690 \$I559 \$I1162 gf180mcu_fd_sc_mcu9t5v0__endcap
X$13691 \$I570 \$I1161 gf180mcu_fd_sc_mcu9t5v0__endcap
X$13692 \$I572 \$I1161 gf180mcu_fd_sc_mcu9t5v0__endcap
X$13693 \$I569 \$I1160 gf180mcu_fd_sc_mcu9t5v0__endcap
X$13694 \$I563 \$I1160 gf180mcu_fd_sc_mcu9t5v0__endcap
X$13695 \$I568 \$I1159 gf180mcu_fd_sc_mcu9t5v0__endcap
X$13696 \$I569 \$I1159 gf180mcu_fd_sc_mcu9t5v0__endcap
X$13697 \$I567 \$I1158 gf180mcu_fd_sc_mcu9t5v0__endcap
X$13698 \$I480 \$I1158 gf180mcu_fd_sc_mcu9t5v0__endcap
X$13699 \$I565 \$I1156 gf180mcu_fd_sc_mcu9t5v0__endcap
X$13700 \$I590 \$I1156 gf180mcu_fd_sc_mcu9t5v0__endcap
X$13701 \$I563 \$I1154 gf180mcu_fd_sc_mcu9t5v0__endcap
X$13702 \$I554 \$I1154 gf180mcu_fd_sc_mcu9t5v0__endcap
X$13703 \$I562 \$I1153 gf180mcu_fd_sc_mcu9t5v0__endcap
X$13704 \$I532 \$I1153 gf180mcu_fd_sc_mcu9t5v0__endcap
X$13705 \$I559 \$I1150 gf180mcu_fd_sc_mcu9t5v0__endcap
X$13706 \$I573 \$I1150 gf180mcu_fd_sc_mcu9t5v0__endcap
X$13707 \$I557 \$I1148 gf180mcu_fd_sc_mcu9t5v0__endcap
X$13708 \$I589 \$I1148 gf180mcu_fd_sc_mcu9t5v0__endcap
X$13709 \$I555 \$I1146 gf180mcu_fd_sc_mcu9t5v0__endcap
X$13710 \$I565 \$I1146 gf180mcu_fd_sc_mcu9t5v0__endcap
X$13711 \$I554 \$I1145 gf180mcu_fd_sc_mcu9t5v0__endcap
X$13712 \$I548 \$I1145 gf180mcu_fd_sc_mcu9t5v0__endcap
X$13713 \$I553 \$I1144 gf180mcu_fd_sc_mcu9t5v0__endcap
X$13714 \$I550 \$I1144 gf180mcu_fd_sc_mcu9t5v0__endcap
X$13715 \$I552 \$I1143 gf180mcu_fd_sc_mcu9t5v0__endcap
X$13716 \$I551 \$I1143 gf180mcu_fd_sc_mcu9t5v0__endcap
X$13717 \$I551 \$I1142 gf180mcu_fd_sc_mcu9t5v0__endcap
X$13718 \$I547 \$I1142 gf180mcu_fd_sc_mcu9t5v0__endcap
X$13719 \$I550 \$I1141 gf180mcu_fd_sc_mcu9t5v0__endcap
X$13720 \$I562 \$I1141 gf180mcu_fd_sc_mcu9t5v0__endcap
X$13721 \$I549 \$I1140 gf180mcu_fd_sc_mcu9t5v0__endcap
X$13722 \$I553 \$I1140 gf180mcu_fd_sc_mcu9t5v0__endcap
X$13723 \$I548 \$I1139 gf180mcu_fd_sc_mcu9t5v0__endcap
X$13724 \$I575 \$I1139 gf180mcu_fd_sc_mcu9t5v0__endcap
X$13725 \$I547 \$I1138 gf180mcu_fd_sc_mcu9t5v0__endcap
X$13726 \$I537 \$I1138 gf180mcu_fd_sc_mcu9t5v0__endcap
X$13727 \$I545 \$I1136 gf180mcu_fd_sc_mcu9t5v0__endcap
X$13728 \$I552 \$I1136 gf180mcu_fd_sc_mcu9t5v0__endcap
X$13729 \$I538 \$I1134 gf180mcu_fd_sc_mcu9t5v0__endcap
X$13730 \$I539 \$I1130 gf180mcu_fd_sc_mcu9t5v0__endcap
X$13731 \$I545 \$I1130 gf180mcu_fd_sc_mcu9t5v0__endcap
X$13732 \$I538 \$I1129 gf180mcu_fd_sc_mcu9t5v0__endcap
X$13733 \$I574 \$I1129 gf180mcu_fd_sc_mcu9t5v0__endcap
X$13734 \$I537 \$I1128 gf180mcu_fd_sc_mcu9t5v0__endcap
X$13735 \$I533 \$I1128 gf180mcu_fd_sc_mcu9t5v0__endcap
X$13736 \$I536 \$I1127 gf180mcu_fd_sc_mcu9t5v0__endcap
X$13737 \$I582 \$I1127 gf180mcu_fd_sc_mcu9t5v0__endcap
X$13738 \$I535 \$I1126 gf180mcu_fd_sc_mcu9t5v0__endcap
X$13739 \$I536 \$I1126 gf180mcu_fd_sc_mcu9t5v0__endcap
X$13740 \$I533 \$I1124 gf180mcu_fd_sc_mcu9t5v0__endcap
X$13741 \$I525 \$I1124 gf180mcu_fd_sc_mcu9t5v0__endcap
X$13742 \$I532 \$I1123 gf180mcu_fd_sc_mcu9t5v0__endcap
X$13743 \$I539 \$I1123 gf180mcu_fd_sc_mcu9t5v0__endcap
X$13744 \$I531 \$I1122 gf180mcu_fd_sc_mcu9t5v0__endcap
X$13745 \$I528 \$I1122 gf180mcu_fd_sc_mcu9t5v0__endcap
X$13746 \$I530 \$I1121 gf180mcu_fd_sc_mcu9t5v0__endcap
X$13747 \$I518 \$I1121 gf180mcu_fd_sc_mcu9t5v0__endcap
X$13748 \$I529 \$I1120 gf180mcu_fd_sc_mcu9t5v0__endcap
X$13749 \$I531 \$I1120 gf180mcu_fd_sc_mcu9t5v0__endcap
X$13750 \$I528 \$I1119 gf180mcu_fd_sc_mcu9t5v0__endcap
X$13751 \$I524 \$I1119 gf180mcu_fd_sc_mcu9t5v0__endcap
X$13752 \$I527 \$I1118 gf180mcu_fd_sc_mcu9t5v0__endcap
X$13753 \$I517 \$I1118 gf180mcu_fd_sc_mcu9t5v0__endcap
X$13754 \$I526 \$I1117 gf180mcu_fd_sc_mcu9t5v0__endcap
X$13755 \$I523 \$I1117 gf180mcu_fd_sc_mcu9t5v0__endcap
X$13756 \$I525 \$I1116 gf180mcu_fd_sc_mcu9t5v0__endcap
X$13757 \$I522 \$I1116 gf180mcu_fd_sc_mcu9t5v0__endcap
X$13758 \$I524 \$I1115 gf180mcu_fd_sc_mcu9t5v0__endcap
X$13759 \$I530 \$I1115 gf180mcu_fd_sc_mcu9t5v0__endcap
X$13760 \$I523 \$I1114 gf180mcu_fd_sc_mcu9t5v0__endcap
X$13761 \$I529 \$I1114 gf180mcu_fd_sc_mcu9t5v0__endcap
X$13762 \$I522 \$I1113 gf180mcu_fd_sc_mcu9t5v0__endcap
X$13763 \$I521 \$I1113 gf180mcu_fd_sc_mcu9t5v0__endcap
X$13764 \$I521 \$I1112 gf180mcu_fd_sc_mcu9t5v0__endcap
X$13765 \$I527 \$I1112 gf180mcu_fd_sc_mcu9t5v0__endcap
X$13766 \$I518 \$I1109 gf180mcu_fd_sc_mcu9t5v0__endcap
X$13767 \$I580 \$I1109 gf180mcu_fd_sc_mcu9t5v0__endcap
X$13768 \$I517 \$I1108 gf180mcu_fd_sc_mcu9t5v0__endcap
X$13769 \$I526 \$I1108 gf180mcu_fd_sc_mcu9t5v0__endcap
X$13770 \$I489 \$I1080 gf180mcu_fd_sc_mcu9t5v0__endcap
X$13771 \$I479 \$I1080 gf180mcu_fd_sc_mcu9t5v0__endcap
X$13772 \$I486 \$I1077 gf180mcu_fd_sc_mcu9t5v0__endcap
X$13773 \$I489 \$I1077 gf180mcu_fd_sc_mcu9t5v0__endcap
X$13774 \$I483 \$I1074 gf180mcu_fd_sc_mcu9t5v0__endcap
X$13775 \$I474 \$I1074 gf180mcu_fd_sc_mcu9t5v0__endcap
X$13776 \$I480 \$I1071 gf180mcu_fd_sc_mcu9t5v0__endcap
X$13777 \$I486 \$I1071 gf180mcu_fd_sc_mcu9t5v0__endcap
X$13778 \$I479 \$I1070 gf180mcu_fd_sc_mcu9t5v0__endcap
X$13779 \$I483 \$I1070 gf180mcu_fd_sc_mcu9t5v0__endcap
X$13780 \$I474 \$I1065 gf180mcu_fd_sc_mcu9t5v0__endcap
X$13781 \$I472 \$I1065 gf180mcu_fd_sc_mcu9t5v0__endcap
X$13782 \$I472 \$I1063 gf180mcu_fd_sc_mcu9t5v0__endcap
X$13783 \$I488 \$I1063 gf180mcu_fd_sc_mcu9t5v0__endcap
.ENDS butterfold_padframe_top

.SUBCKT gf180mcu_fd_sc_mcu9t5v0__and2_4 A1 A2 VDD VSS Z
.ENDS gf180mcu_fd_sc_mcu9t5v0__and2_4

.SUBCKT gf180mcu_fd_sc_mcu9t5v0__clkbuf_2 I VDD VSS
.ENDS gf180mcu_fd_sc_mcu9t5v0__clkbuf_2

.SUBCKT gf180mcu_fd_sc_mcu9t5v0__buf_4 I VDD VSS Z
.ENDS gf180mcu_fd_sc_mcu9t5v0__buf_4

.SUBCKT gf180mcu_fd_sc_mcu9t5v0__nand4_4 A1 A2 A3 A4 VDD VSS ZN
.ENDS gf180mcu_fd_sc_mcu9t5v0__nand4_4

.SUBCKT gf180mcu_fd_sc_mcu9t5v0__clkbuf_20 I VDD VSS Z
.ENDS gf180mcu_fd_sc_mcu9t5v0__clkbuf_20

.SUBCKT gf180mcu_fd_sc_mcu9t5v0__aoi22_2 A1 A2 B1 B2 VDD VSS ZN
.ENDS gf180mcu_fd_sc_mcu9t5v0__aoi22_2

.SUBCKT gf180mcu_fd_sc_mcu9t5v0__oai221_4 A1 A2 B1 B2 C VDD VSS ZN
.ENDS gf180mcu_fd_sc_mcu9t5v0__oai221_4

.SUBCKT gf180mcu_fd_sc_mcu9t5v0__and4_2 A1 A2 A3 A4 VDD VSS Z
.ENDS gf180mcu_fd_sc_mcu9t5v0__and4_2

.SUBCKT gf180mcu_fd_sc_mcu9t5v0__oai211_4 A1 A2 B C VSS ZN VDD
.ENDS gf180mcu_fd_sc_mcu9t5v0__oai211_4

.SUBCKT gf180mcu_fd_sc_mcu9t5v0__nand3_4 A1 A2 A3 VDD VSS ZN
.ENDS gf180mcu_fd_sc_mcu9t5v0__nand3_4

.SUBCKT gf180mcu_fd_sc_mcu9t5v0__or4_4 A1 A2 A3 VDD VSS Z A4
.ENDS gf180mcu_fd_sc_mcu9t5v0__or4_4

.SUBCKT gf180mcu_fd_sc_mcu9t5v0__or3_4 A1 A2 A3 VDD VSS Z
.ENDS gf180mcu_fd_sc_mcu9t5v0__or3_4

.SUBCKT gf180mcu_fd_sc_mcu9t5v0__oai211_2 A1 A2 B C VDD VSS ZN
.ENDS gf180mcu_fd_sc_mcu9t5v0__oai211_2

.SUBCKT gf180mcu_fd_sc_mcu9t5v0__and4_4 A1 A2 A3 A4 VDD VSS Z
.ENDS gf180mcu_fd_sc_mcu9t5v0__and4_4

.SUBCKT gf180mcu_fd_sc_mcu9t5v0__aoi221_4 A2 B2 C VSS A1 ZN B1 VDD
.ENDS gf180mcu_fd_sc_mcu9t5v0__aoi221_4

.SUBCKT gf180mcu_fd_sc_mcu9t5v0__buf_12 I VDD VSS Z
.ENDS gf180mcu_fd_sc_mcu9t5v0__buf_12

.SUBCKT gf180mcu_fd_sc_mcu9t5v0__nor4_4 A1 A2 A4 VDD VSS ZN A3
.ENDS gf180mcu_fd_sc_mcu9t5v0__nor4_4

.SUBCKT gf180mcu_fd_sc_mcu9t5v0__aoi22_4 A1 B1 B2 VDD VSS ZN A2
.ENDS gf180mcu_fd_sc_mcu9t5v0__aoi22_4

.SUBCKT gf180mcu_fd_sc_mcu9t5v0__mux2_2 I0 I1 S VDD VSS Z
.ENDS gf180mcu_fd_sc_mcu9t5v0__mux2_2

.SUBCKT gf180mcu_fd_sc_mcu9t5v0__or3_2 A1 A2 A3 VDD VSS Z
.ENDS gf180mcu_fd_sc_mcu9t5v0__or3_2

.SUBCKT gf180mcu_fd_sc_mcu9t5v0__nand2_4 A1 A2 VDD VSS ZN
.ENDS gf180mcu_fd_sc_mcu9t5v0__nand2_4

.SUBCKT gf180mcu_fd_sc_mcu9t5v0__clkinv_2 I VDD VSS ZN
.ENDS gf180mcu_fd_sc_mcu9t5v0__clkinv_2

.SUBCKT gf180mcu_fd_sc_mcu9t5v0__clkinv_4 I VDD VSS ZN
.ENDS gf180mcu_fd_sc_mcu9t5v0__clkinv_4

.SUBCKT gf180mcu_fd_sc_mcu9t5v0__and3_4 A1 A2 A3 VDD VSS Z
.ENDS gf180mcu_fd_sc_mcu9t5v0__and3_4

.SUBCKT gf180mcu_fd_sc_mcu9t5v0__aoi211_4 A1 A2 B C VDD VSS ZN
.ENDS gf180mcu_fd_sc_mcu9t5v0__aoi211_4

.SUBCKT gf180mcu_fd_sc_mcu9t5v0__nor3_4 A1 A2 A3 VDD VSS ZN
.ENDS gf180mcu_fd_sc_mcu9t5v0__nor3_4

.SUBCKT gf180mcu_fd_sc_mcu9t5v0__inv_8 I VDD VSS
.ENDS gf180mcu_fd_sc_mcu9t5v0__inv_8

.SUBCKT gf180mcu_fd_sc_mcu9t5v0__nand4_2 A1 A2 A3 VDD VSS A4 ZN
.ENDS gf180mcu_fd_sc_mcu9t5v0__nand4_2

.SUBCKT gf180mcu_fd_sc_mcu9t5v0__nor2_2 A1 A2 VDD VSS ZN
.ENDS gf180mcu_fd_sc_mcu9t5v0__nor2_2

.SUBCKT gf180mcu_fd_sc_mcu9t5v0__nand3_2 A1 A2 A3 VDD VSS ZN
.ENDS gf180mcu_fd_sc_mcu9t5v0__nand3_2

.SUBCKT gf180mcu_fd_sc_mcu9t5v0__oai222_1 A1 A2 B1 B2 C1 C2 VDD VSS ZN
.ENDS gf180mcu_fd_sc_mcu9t5v0__oai222_1

.SUBCKT gf180mcu_fd_sc_mcu9t5v0__aoi21_4 A1 A2 B VDD VSS ZN
.ENDS gf180mcu_fd_sc_mcu9t5v0__aoi21_4

.SUBCKT gf180mcu_fd_sc_mcu9t5v0__nor4_2 A1 A3 A4 VDD VSS ZN A2
.ENDS gf180mcu_fd_sc_mcu9t5v0__nor4_2

.SUBCKT gf180mcu_fd_sc_mcu9t5v0__oai31_4 A1 A2 A3 B VDD VSS ZN
.ENDS gf180mcu_fd_sc_mcu9t5v0__oai31_4

.SUBCKT gf180mcu_fd_sc_mcu9t5v0__nor3_2 A1 A2 A3 VDD VSS ZN
.ENDS gf180mcu_fd_sc_mcu9t5v0__nor3_2

.SUBCKT gf180mcu_fd_sc_mcu9t5v0__and2_2 A1 A2 VDD VSS Z
.ENDS gf180mcu_fd_sc_mcu9t5v0__and2_2

.SUBCKT gf180mcu_fd_sc_mcu9t5v0__oai21_4 A1 A2 B VDD VSS ZN
.ENDS gf180mcu_fd_sc_mcu9t5v0__oai21_4

.SUBCKT gf180mcu_fd_sc_mcu9t5v0__aoi221_2 A1 A2 B1 B2 C VDD VSS ZN
.ENDS gf180mcu_fd_sc_mcu9t5v0__aoi221_2

.SUBCKT gf180mcu_fd_sc_mcu9t5v0__dlyc_1 I VDD VSS Z
.ENDS gf180mcu_fd_sc_mcu9t5v0__dlyc_1

.SUBCKT gf180mcu_fd_sc_mcu9t5v0__dffsnq_2 CLK D Q SETN VSS VDD
.ENDS gf180mcu_fd_sc_mcu9t5v0__dffsnq_2

.SUBCKT gf180mcu_fd_io__in_c \$1 PAD DVSS \$4 DVSS$1 DVSS$2 DVSS$3 DVSS$4 \$9
+ DVSS$5 DVSS$6 \$12 DVSS$7 DVSS$8 DVDD DVDD$1 \$17 DVDD$2 DVSS$9 DVSS$10 \$21
+ DVSS$11 DVDD$3 \$24 DVDD$4 DVDD$5 DVDD$6 DVDD$7 \$29 DVDD$8 DVDD$9 \$32
+ DVDD$10 DVDD$11 DVDD$12 DVDD$13 DVDD$14 \$38 DVSS$12 DVSS$13 \$41 DVSS$14
+ DVDD$15 DVDD$16 \$45 DVDD$17 DVDD$18 DVDD$19 \$49 DVDD$20 DVSS$15 DVSS$16
+ \$53 DVSS$17 VSS VSS$1 \$57 VSS$2 VDD VDD$1 \$61 VDD$2 DVDD$21 \$64 DVDD$22
+ DVDD$23 DVDD$24 DVDD$25 \$69 DVDD$26 DVDD$27 DVDD$28 \$73 DVDD$29 DVSS$18
+ DVSS$19 \$77 DVSS$20 DVDD$30 \$80 DVDD$31 DVDD$32 DVSS$21 \$84 DVSS$22
+ DVSS$23 VDD$3 VDD$4 \$89 VDD$5 VSS$3 \$92 VSS$4 VSS$5 DVSS$24 \$96 DVSS$25
+ DVSS$26 DVDD$33 DVDD$34 \$101 DVDD$35 PD DVSS$27 \$105 DVSS$28 DVSS$29 PU Y
.ENDS gf180mcu_fd_io__in_c

.SUBCKT gf180mcu_fd_io__dvdd DVSS DVSS$1 \$5 DVSS$2 DVSS$3 DVSS$4 \$9 DVSS$5
+ DVSS$6 \$12 DVSS$7 DVSS$8 DVDD$1 DVDD$2 \$17 DVDD$3 DVSS$9 \$20 DVSS$10
+ DVSS$11 DVDD$4 \$24 DVDD$5 DVDD$6 DVDD$7 DVDD$8 \$29 DVDD$9 DVDD$10 \$32
+ DVDD$11 DVDD$12 DVDD$13 DVDD$14 \$37 DVDD$15 DVDD$16 DVSS$12 DVSS$13 DVDD$17
+ \$43 \$44 DVSS$14 DVDD$18 DVDD$19 \$48 DVDD$20 DVDD$21 DVSS$15 \$52 DVSS$16
+ DVSS$17 VSS VSS$1 \$57 VSS$2 DVDD$22 \$60 DVDD$23 DVDD$24 DVDD$25 DVDD$26
+ \$65 DVDD$27 DVDD$28 \$68 DVDD$29 DVDD$30 DVDD$31 \$72 DVDD$32 DVDD$33
+ DVSS$18 DVSS$19 \$77 DVSS$20 DVDD$34 DVDD$35 \$81 DVDD$36 DVSS$21 \$84
+ DVSS$22 DVSS$23 VSS$3 DVDD$37 \$89 \$90 VSS$4 DVDD$38 DVDD$39 DVSS$24 VSS$5
+ DVDD$40 \$97 DVSS$25 DVSS$26 \$100 DVDD$41 DVDD$42 DVSS$27 \$104 DVSS$28
+ DVSS$29
.ENDS gf180mcu_fd_io__dvdd

.SUBCKT gf180mcu_fd_sc_mcu9t5v0__or4_1 A1 A2 A3 A4 VDD VSS Z
.ENDS gf180mcu_fd_sc_mcu9t5v0__or4_1

.SUBCKT gf180mcu_fd_sc_mcu9t5v0__tiel VDD VSS ZN
.ENDS gf180mcu_fd_sc_mcu9t5v0__tiel

.SUBCKT gf180mcu_fd_sc_mcu9t5v0__tieh VDD VSS Z
.ENDS gf180mcu_fd_sc_mcu9t5v0__tieh

.SUBCKT gf180mcu_fd_io__bi_t \$1 PAD DVSS DVSS$1 \$5 DVSS$2 DVSS$3 \$8 DVSS$4
+ DVSS$5 DVSS$6 DVSS$7 \$13 DVSS$8 DVDD DVDD$1 \$17 DVDD$2 DVSS$9 DVSS$10 \$21
+ DVSS$11 DVDD$3 \$24 DVDD$4 DVDD$5 DVDD$6 \$28 DVDD$7 DVDD$8 DVDD$9 DVDD$10
+ \$33 DVDD$11 DVDD$12 DVDD$13 DVDD$14 \$38 DVSS$12 \$40 DVSS$13 DVSS$14
+ DVDD$15 DVDD$16 \$45 DVDD$17 DVDD$18 \$48 DVDD$19 DVDD$20 DVSS$15 \$52
+ DVSS$16 DVSS$17 VSS \$56 VSS$1 VSS$2 VDD \$60 VDD$1 VDD$2 DVDD$21 \$64
+ DVDD$22 DVDD$23 PDRV0 DVDD$24 DVDD$25 \$70 DVDD$26 DVSS$18 DVDD$27 DVDD$28
+ \$75 DVSS$19 \$77 DVDD$29 DVDD$30 DVSS$20 DVSS$21 DVDD$31 \$83 DVDD$32
+ DVSS$22 \$86 DVSS$23 VSS$3 VDD$3 VSS$4 \$91 VDD$4 \$93 VDD$5 DVSS$24 VSS$5
+ \$97 DVSS$25 DVSS$26 PD DVDD$33 DVDD$34 \$103 DVDD$35 DVSS$27 DVSS$28 \$107
+ DVSS$29 CS PU PDRV1 IE SL A OE
.ENDS gf180mcu_fd_io__bi_t

.SUBCKT gf180mcu_fd_sc_mcu9t5v0__oai32_1 A1 A2 A3 B1 B2 VDD VSS ZN
.ENDS gf180mcu_fd_sc_mcu9t5v0__oai32_1

.SUBCKT gf180mcu_fd_sc_mcu9t5v0__aoi211_2 A1 A2 B C VDD VSS ZN
.ENDS gf180mcu_fd_sc_mcu9t5v0__aoi211_2

.SUBCKT gf180mcu_fd_sc_mcu9t5v0__inv_4 I VDD VSS
.ENDS gf180mcu_fd_sc_mcu9t5v0__inv_4

.SUBCKT gf180mcu_fd_sc_mcu9t5v0__clkinv_3 I VDD VSS
.ENDS gf180mcu_fd_sc_mcu9t5v0__clkinv_3

.SUBCKT gf180mcu_fd_sc_mcu9t5v0__nor4_1 A1 A2 A3 A4 VDD VSS ZN
.ENDS gf180mcu_fd_sc_mcu9t5v0__nor4_1

.SUBCKT gf180mcu_fd_sc_mcu9t5v0__clkbuf_4 I VDD VSS
.ENDS gf180mcu_fd_sc_mcu9t5v0__clkbuf_4

.SUBCKT gf180mcu_fd_sc_mcu9t5v0__dffrnq_4 CLK D RN VSS Q VDD
.ENDS gf180mcu_fd_sc_mcu9t5v0__dffrnq_4

.SUBCKT gf180mcu_fd_sc_mcu9t5v0__oai22_2 A1 A2 B1 B2 VDD VSS ZN
.ENDS gf180mcu_fd_sc_mcu9t5v0__oai22_2

.SUBCKT gf180mcu_fd_sc_mcu9t5v0__inv_2 I VDD VSS ZN
.ENDS gf180mcu_fd_sc_mcu9t5v0__inv_2

.SUBCKT gf180mcu_fd_sc_mcu9t5v0__oai32_4 A1 A2 A3 B1 VDD VSS ZN B2
.ENDS gf180mcu_fd_sc_mcu9t5v0__oai32_4

.SUBCKT gf180mcu_fd_sc_mcu9t5v0__xor2_2 A1 VDD VSS Z A2
.ENDS gf180mcu_fd_sc_mcu9t5v0__xor2_2

.SUBCKT gf180mcu_fd_sc_mcu9t5v0__xor3_2 A1 A3 VDD VSS A2 Z
.ENDS gf180mcu_fd_sc_mcu9t5v0__xor3_2

.SUBCKT gf180mcu_fd_sc_mcu9t5v0__clkinv_8 I VDD VSS
.ENDS gf180mcu_fd_sc_mcu9t5v0__clkinv_8

.SUBCKT gf180mcu_fd_sc_mcu9t5v0__clkinv_12 I VDD VSS
.ENDS gf180mcu_fd_sc_mcu9t5v0__clkinv_12

.SUBCKT gf180mcu_fd_sc_mcu9t5v0__and3_2 A1 A2 A3 VDD VSS Z
.ENDS gf180mcu_fd_sc_mcu9t5v0__and3_2

.SUBCKT gf180mcu_fd_sc_mcu9t5v0__or2_2 A1 A2 VDD VSS Z
.ENDS gf180mcu_fd_sc_mcu9t5v0__or2_2

.SUBCKT gf180mcu_fd_sc_mcu9t5v0__nor2_4 A1 A2 VDD VSS ZN
.ENDS gf180mcu_fd_sc_mcu9t5v0__nor2_4

.SUBCKT gf180mcu_fd_sc_mcu9t5v0__or3_1 A1 A2 A3 VDD VSS Z
.ENDS gf180mcu_fd_sc_mcu9t5v0__or3_1

.SUBCKT gf180mcu_fd_sc_mcu9t5v0__and4_1 A1 A2 A3 A4 VDD VSS Z
.ENDS gf180mcu_fd_sc_mcu9t5v0__and4_1

.SUBCKT gf180mcu_fd_sc_mcu9t5v0__nand2_2 A1 A2 VDD VSS ZN
.ENDS gf180mcu_fd_sc_mcu9t5v0__nand2_2

.SUBCKT gf180mcu_fd_sc_mcu9t5v0__inv_1 I VDD VSS ZN
.ENDS gf180mcu_fd_sc_mcu9t5v0__inv_1

.SUBCKT gf180mcu_fd_sc_mcu9t5v0__oai22_1 A1 A2 B1 B2 VDD VSS ZN
.ENDS gf180mcu_fd_sc_mcu9t5v0__oai22_1

.SUBCKT gf180mcu_fd_sc_mcu9t5v0__nand4_1 A1 A2 A3 A4 VDD VSS ZN
.ENDS gf180mcu_fd_sc_mcu9t5v0__nand4_1

.SUBCKT gf180mcu_fd_sc_mcu9t5v0__nand3_1 A1 A2 A3 VDD VSS ZN
.ENDS gf180mcu_fd_sc_mcu9t5v0__nand3_1

.SUBCKT gf180mcu_fd_sc_mcu9t5v0__aoi222_1 A1 A2 B1 B2 C1 C2 VDD VSS ZN
.ENDS gf180mcu_fd_sc_mcu9t5v0__aoi222_1

.SUBCKT gf180mcu_fd_sc_mcu9t5v0__inv_3 I VDD VSS
.ENDS gf180mcu_fd_sc_mcu9t5v0__inv_3

.SUBCKT gf180mcu_fd_sc_mcu9t5v0__clkbuf_8 I VDD VSS Z
.ENDS gf180mcu_fd_sc_mcu9t5v0__clkbuf_8

.SUBCKT gf180mcu_fd_sc_mcu9t5v0__aoi21_2 A1 A2 B VDD VSS ZN
.ENDS gf180mcu_fd_sc_mcu9t5v0__aoi21_2

.SUBCKT gf180mcu_fd_sc_mcu9t5v0__oai21_2 A1 A2 B VDD VSS ZN
.ENDS gf180mcu_fd_sc_mcu9t5v0__oai21_2

.SUBCKT gf180mcu_fd_sc_mcu9t5v0__or2_1 A1 A2 VDD VSS Z
.ENDS gf180mcu_fd_sc_mcu9t5v0__or2_1

.SUBCKT gf180mcu_fd_ip_sram__sram256x8m8wm1 VDD D[0] WEN[0] Q[0] Q[1] D[1]
+ WEN[1] WEN[2] D[2] Q[2] Q[3] WEN[3] D[3] CLK A[7] A[2] A[1] VSS$5 A[0] GWEN
+ CEN A[6] A[5] A[4] A[3] D[4] WEN[4] Q[4] VSS$13 Q[5] D[5] WEN[5] WEN[6] D[6]
+ Q[6] VSS$16 Q[7] WEN[7] D[7] VSS$17 VSS$18 VSS$19 VSS$20 VSS$21 VSS$22 VSS$23
+ VSS$24 VSS$25 VSS$35 VSS$37 VSS$39 VSS$41 VSS$43 VSS$45 VSS$47 VSS$49 VSS$51
+ VSS$53 VSS$55 VSS$57 VSS$59 VSS$61 VSS$63 VDD$47 VSS$70 VSS$76 VSS$87 VSS$93
.ENDS gf180mcu_fd_ip_sram__sram256x8m8wm1

.SUBCKT gf180mcu_fd_sc_mcu9t5v0__xor3_1 A1 A3 VDD VSS A2 Z
.ENDS gf180mcu_fd_sc_mcu9t5v0__xor3_1

.SUBCKT gf180mcu_fd_sc_mcu9t5v0__and3_1 A1 A2 A3 VDD VSS Z
.ENDS gf180mcu_fd_sc_mcu9t5v0__and3_1

.SUBCKT gf180mcu_fd_sc_mcu9t5v0__buf_1 I VDD VSS Z
.ENDS gf180mcu_fd_sc_mcu9t5v0__buf_1

.SUBCKT gf180mcu_fd_sc_mcu9t5v0__buf_20 I VDD VSS Z
.ENDS gf180mcu_fd_sc_mcu9t5v0__buf_20

.SUBCKT gf180mcu_fd_sc_mcu9t5v0__dffrnq_2 CLK D Q RN VDD VSS
.ENDS gf180mcu_fd_sc_mcu9t5v0__dffrnq_2

.SUBCKT gf180mcu_fd_sc_mcu9t5v0__dffq_2 CLK D Q VDD VSS
.ENDS gf180mcu_fd_sc_mcu9t5v0__dffq_2

.SUBCKT gf180mcu_fd_sc_mcu9t5v0__or2_4 A1 A2 VDD VSS Z
.ENDS gf180mcu_fd_sc_mcu9t5v0__or2_4

.SUBCKT gf180mcu_fd_sc_mcu9t5v0__aoi221_1 A1 A2 B1 B2 C VDD VSS ZN
.ENDS gf180mcu_fd_sc_mcu9t5v0__aoi221_1

.SUBCKT gf180mcu_fd_sc_mcu9t5v0__xnor3_1 A1 A3 VDD VSS ZN A2
.ENDS gf180mcu_fd_sc_mcu9t5v0__xnor3_1

.SUBCKT gf180mcu_fd_sc_mcu9t5v0__xnor2_1 A1 A2 VDD VSS ZN
.ENDS gf180mcu_fd_sc_mcu9t5v0__xnor2_1

.SUBCKT gf180mcu_fd_sc_mcu9t5v0__and2_1 A1 A2 VDD VSS Z
.ENDS gf180mcu_fd_sc_mcu9t5v0__and2_1

.SUBCKT gf180mcu_fd_sc_mcu9t5v0__oai31_1 A1 A2 A3 B VDD VSS ZN
.ENDS gf180mcu_fd_sc_mcu9t5v0__oai31_1

.SUBCKT gf180mcu_fd_sc_mcu9t5v0__oai21_1 A1 A2 B VDD VSS ZN
.ENDS gf180mcu_fd_sc_mcu9t5v0__oai21_1

.SUBCKT gf180mcu_fd_sc_mcu9t5v0__xor2_1 A1 VDD VSS A2 Z
.ENDS gf180mcu_fd_sc_mcu9t5v0__xor2_1

.SUBCKT gf180mcu_fd_sc_mcu9t5v0__aoi21_1 A1 A2 B VDD VSS ZN
.ENDS gf180mcu_fd_sc_mcu9t5v0__aoi21_1

.SUBCKT gf180mcu_fd_sc_mcu9t5v0__aoi211_1 A1 A2 B C VDD VSS ZN
.ENDS gf180mcu_fd_sc_mcu9t5v0__aoi211_1

.SUBCKT gf180mcu_fd_sc_mcu9t5v0__mux4_1 I0 I1 I2 I3 S0 S1 VDD VSS Z
.ENDS gf180mcu_fd_sc_mcu9t5v0__mux4_1

.SUBCKT gf180mcu_fd_sc_mcu9t5v0__oai221_1 A1 A2 B1 B2 C VDD VSS ZN
.ENDS gf180mcu_fd_sc_mcu9t5v0__oai221_1

.SUBCKT gf180mcu_fd_sc_mcu9t5v0__oai211_1 A1 A2 B C VDD VSS ZN
.ENDS gf180mcu_fd_sc_mcu9t5v0__oai211_1

.SUBCKT gf180mcu_fd_sc_mcu9t5v0__mux2_1 I0 I1 S VDD VSS Z
.ENDS gf180mcu_fd_sc_mcu9t5v0__mux2_1

.SUBCKT gf180mcu_fd_sc_mcu9t5v0__aoi22_1 A1 A2 B1 B2 VDD VSS ZN
.ENDS gf180mcu_fd_sc_mcu9t5v0__aoi22_1

.SUBCKT gf180mcu_fd_sc_mcu9t5v0__oai31_2 A1 A2 A3 B VDD VSS ZN
.ENDS gf180mcu_fd_sc_mcu9t5v0__oai31_2

.SUBCKT gf180mcu_fd_sc_mcu9t5v0__nor2_1 A1 A2 VDD VSS ZN
.ENDS gf180mcu_fd_sc_mcu9t5v0__nor2_1

.SUBCKT gf180mcu_fd_sc_mcu9t5v0__nand2_1 A1 A2 VDD VSS ZN
.ENDS gf180mcu_fd_sc_mcu9t5v0__nand2_1

.SUBCKT gf180mcu_fd_sc_mcu9t5v0__clkinv_1 I VDD VSS ZN
.ENDS gf180mcu_fd_sc_mcu9t5v0__clkinv_1

.SUBCKT gf180mcu_fd_sc_mcu9t5v0__clkbuf_1 I VDD VSS Z
.ENDS gf180mcu_fd_sc_mcu9t5v0__clkbuf_1

.SUBCKT gf180mcu_fd_sc_mcu9t5v0__nor3_1 A1 A2 A3 VDD VSS ZN
.ENDS gf180mcu_fd_sc_mcu9t5v0__nor3_1

.SUBCKT gf180mcu_fd_sc_mcu9t5v0__buf_8 I VDD VSS Z
.ENDS gf180mcu_fd_sc_mcu9t5v0__buf_8

.SUBCKT gf180mcu_fd_sc_mcu9t5v0__clkbuf_16 I VSS VDD Z
.ENDS gf180mcu_fd_sc_mcu9t5v0__clkbuf_16

.SUBCKT gf180mcu_fd_sc_mcu9t5v0__filltie VSS VDD
.ENDS gf180mcu_fd_sc_mcu9t5v0__filltie

.SUBCKT gf180mcu_fd_sc_mcu9t5v0__endcap VSS VDD
.ENDS gf180mcu_fd_sc_mcu9t5v0__endcap
