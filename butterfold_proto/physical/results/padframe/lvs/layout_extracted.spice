* ButterFold GDS hierarchical metal-connectivity netlist

* cell butterfold_padframe_top
.SUBCKT butterfold_padframe_top
* net 2980 pad_din_valid_i
* net 3008 pad_dout[0]
* net 4896 pad_din[0]
* net 4919 pad_dout[1]
* net 6660 pad_din[1]
* net 6683 pad_dout[2]
* net 8574 pad_din[2]
* net 8601 pad_dout[3]
* net 10445 pad_din[3]
* net 10480 pad_dout[4]
* net 12376 pad_din[4]
* net 12418 pad_dout[5]
* net 14403 pad_din[5]
* net 14437 pad_dout[6]
* net 16637 pad_din[6]
* net 16692 pad_dout[7]
* net 18832 pad_din[7]
* net 18862 pad_dout_valid_o
* net 20974 pad_din_ready_o
* net 33486 pad_clk
* net 33487 pad_rst_n
* cell instance $1 m0 *1 370.16,1108.8
X$1 17837 17709 gf180mcu_fd_sc_mcu9t5v0__endcap
* cell instance $2 r180 *1 1864.8,1108.8
X$2 33914 33829 gf180mcu_fd_sc_mcu9t5v0__endcap
* cell instance $3 m0 *1 609.84,1108.8
X$3 17837 17709 gf180mcu_fd_sc_mcu9t5v0__filltie
* cell instance $4 m0 *1 849.52,1108.8
X$4 17837 17709 gf180mcu_fd_sc_mcu9t5v0__filltie
* cell instance $5 m0 *1 1089.2,1108.8
X$5 17837 17709 gf180mcu_fd_sc_mcu9t5v0__filltie
* cell instance $6 m0 *1 1328.88,1108.8
X$6 17837 17709 gf180mcu_fd_sc_mcu9t5v0__filltie
* cell instance $7 m0 *1 1568.56,1108.8
X$7 17837 17709 gf180mcu_fd_sc_mcu9t5v0__filltie
* cell instance $8 m0 *1 1808.24,1108.8
X$8 17837 17709 gf180mcu_fd_sc_mcu9t5v0__filltie
* cell instance $9 r0 *1 1097.6,1108.8
X$9 17959 17837 17985 12129 gf180mcu_fd_sc_mcu9t5v0__clkbuf_16
* cell instance $10 m0 *1 1099.28,1118.88
X$10 32805 18104 17985 17959 gf180mcu_fd_sc_mcu9t5v0__clkbuf_16
* cell instance $11 r0 *1 1078,1572.48
X$11 30100 30039 30106 29214 gf180mcu_fd_sc_mcu9t5v0__clkbuf_16
* cell instance $12 r0 *1 1095.92,937.44
X$12 13458 13054 12900 9453 gf180mcu_fd_sc_mcu9t5v0__buf_8
* cell instance $13 m0 *1 602,1108.8
X$13 17700 11323 13314 17709 17837 17829 gf180mcu_fd_sc_mcu9t5v0__nor3_1
* cell instance $14 m0 *1 598.64,1108.8
X$14 17700 17709 17837 12888 gf180mcu_fd_sc_mcu9t5v0__clkbuf_1
* cell instance $15 m0 *1 468.72,1108.8
X$15 17825 17709 17837 17225 gf180mcu_fd_sc_mcu9t5v0__clkinv_1
* cell instance $16 m0 *1 613.2,1108.8
X$16 17079 17705 17709 17837 17831 gf180mcu_fd_sc_mcu9t5v0__nand2_1
* cell instance $17 m0 *1 884.24,1108.8
X$17 12622 17572 17709 17837 17526 gf180mcu_fd_sc_mcu9t5v0__nand2_1
* cell instance $18 m0 *1 888.16,1108.8
X$18 17711 17712 17709 17837 17574 gf180mcu_fd_sc_mcu9t5v0__nor2_1
* cell instance $19 m0 *1 606.48,1108.8
X$19 17703 12784 17709 17837 17830 gf180mcu_fd_sc_mcu9t5v0__nor2_1
* cell instance $20 m0 *1 617.68,1108.8
X$20 17117 17392 16498 17827 17709 17837 17832 gf180mcu_fd_sc_mcu9t5v0__oai31_2
* cell instance $21 r0 *1 1101.52,1048.32
X$21 16019 16153 14865 16158 16194 16008 16156 gf180mcu_fd_sc_mcu9t5v0__aoi22_1
* cell instance $22 m0 *1 998.48,1108.8
X$22 18394 17578 17709 17837 17715 gf180mcu_fd_sc_mcu9t5v0__nor2_1
* cell instance $23 m0 *1 988.96,1108.8
X$23 17579 17580 17709 17837 17581 gf180mcu_fd_sc_mcu9t5v0__nor2_1
* cell instance $24 m0 *1 1044.96,1108.8
X$24 17578 17990 17709 17837 17718 gf180mcu_fd_sc_mcu9t5v0__nor2_1
* cell instance $25 m0 *1 1177.68,1108.8
X$25 17722 13433 17718 17590 17709 17837 17537 gf180mcu_fd_sc_mcu9t5v0__aoi22_1
* cell instance $26 m0 *1 1017.52,1108.8
X$26 17843 17709 17837 17716 gf180mcu_fd_sc_mcu9t5v0__clkinv_1
* cell instance $27 m0 *1 1103.2,967.68
X$27 13591 13727 9112 13208 13586 13719 13459 gf180mcu_fd_sc_mcu9t5v0__aoi22_1
* cell instance $28 r0 *1 1104.32,957.6
X$28 13459 13590 13586 13428 13454 gf180mcu_fd_sc_mcu9t5v0__nand2_1
* cell instance $29 m0 *1 1048.88,1108.8
X$29 13895 17586 17709 17837 17583 gf180mcu_fd_sc_mcu9t5v0__nor2_1
* cell instance $30 m0 *1 1260.56,1108.8
X$30 13172 17709 17837 16459 gf180mcu_fd_sc_mcu9t5v0__clkinv_1
* cell instance $31 m0 *1 1098.16,1139.04
X$31 18604 18603 13024 18553 18731 14711 gf180mcu_fd_sc_mcu9t5v0__mux2_1
* cell instance $32 m0 *1 1102.64,1068.48
X$32 13895 16525 13461 16453 16506 16653 16526 gf180mcu_fd_sc_mcu9t5v0__oai211_1
* cell instance $33 r0 *1 1102.64,1068.48
X$33 16671 16670 16797 16798 16526 16784 16653 16796
+ gf180mcu_fd_sc_mcu9t5v0__oai221_1
* cell instance $34 m0 *1 850.64,1108.8
X$34 17839 17709 17837 15694 gf180mcu_fd_sc_mcu9t5v0__clkinv_1
* cell instance $35 r0 *1 1101.52,1159.2
X$35 19414 19455 18277 19448 19282 19175 gf180mcu_fd_sc_mcu9t5v0__mux2_1
* cell instance $36 m0 *1 1097.6,564.48
X$36 3346 3237 2145 2569 2987 3106 3334 3444 3458
+ gf180mcu_fd_sc_mcu9t5v0__mux4_1
* cell instance $37 m0 *1 1090.32,735.84
X$37 7337 7797 7564 7334 2987 3459 7671 7814 7796
+ gf180mcu_fd_sc_mcu9t5v0__mux4_1
* cell instance $38 m0 *1 1101.52,1169.28
X$38 19612 18614 18612 4950 19448 19605 19574 gf180mcu_fd_sc_mcu9t5v0__aoi22_1
* cell instance $39 m0 *1 1670.48,1108.8
X$39 17852 17735 17853 17611 17709 17837 17277 gf180mcu_fd_sc_mcu9t5v0__aoi211_1
* cell instance $40 m0 *1 1676.08,1108.8
X$40 17852 17735 17853 17709 17837 17426 gf180mcu_fd_sc_mcu9t5v0__aoi21_1
* cell instance $41 r0 *1 1099.28,1501.92
X$41 28996 29146 29062 29152 28997 gf180mcu_fd_sc_mcu9t5v0__xor2_1
* cell instance $42 r0 *1 1104.32,1491.84
X$42 18444 28997 28994 28989 28937 28998 gf180mcu_fd_sc_mcu9t5v0__oai21_1
* cell instance $43 m0 *1 1090.32,745.92
X$43 7337 7797 7564 7334 3120 3239 7919 7948 7965
+ gf180mcu_fd_sc_mcu9t5v0__mux4_1
* cell instance $44 r0 *1 1102.08,695.52
X$44 5778 7087 6968 5775 3239 3121 6909 6805 6783
+ gf180mcu_fd_sc_mcu9t5v0__mux4_1
* cell instance $45 r0 *1 1097.6,685.44
X$45 6275 6295 6922 5777 3239 3121 6664 6425 6675
+ gf180mcu_fd_sc_mcu9t5v0__mux4_1
* cell instance $46 m0 *1 1103.2,1542.24
X$46 29631 22854 29559 29636 29630 gf180mcu_fd_sc_mcu9t5v0__nand2_1
* cell instance $47 m0 *1 1102.64,1370.88
X$47 25552 22175 14872 25430 25581 25587 gf180mcu_fd_sc_mcu9t5v0__mux2_1
* cell instance $48 r0 *1 1102.64,715.68
X$48 7337 4254 4252 7087 7316 7195 7336 gf180mcu_fd_sc_mcu9t5v0__aoi22_1
* cell instance $49 m0 *1 1594.32,1108.8
X$49 14872 18278 17734 17733 17709 17837 17606 gf180mcu_fd_sc_mcu9t5v0__oai31_1
* cell instance $50 m0 *1 1697.92,1108.8
X$50 17738 17612 17709 17837 16344 gf180mcu_fd_sc_mcu9t5v0__and2_1
* cell instance $51 m0 *1 1691.76,1108.8
X$51 16215 17736 17738 17709 17837 17737 gf180mcu_fd_sc_mcu9t5v0__aoi21_1
* cell instance $52 m0 *1 1491.84,1108.8
X$52 16983 17849 14205 17709 17837 17729 gf180mcu_fd_sc_mcu9t5v0__mux2_1
* cell instance $53 m0 *1 1499.12,1108.8
X$53 17268 17729 17709 17837 17603 gf180mcu_fd_sc_mcu9t5v0__nand2_1
* cell instance $54 m0 *1 1501.92,1108.8
X$54 17603 17727 17548 17709 17837 17730 gf180mcu_fd_sc_mcu9t5v0__aoi21_1
* cell instance $55 m0 *1 1434.72,1108.8
X$55 17725 17971 17709 17837 15037 gf180mcu_fd_sc_mcu9t5v0__xnor2_1
* cell instance $56 m0 *1 1421.84,1108.8
X$56 17968 17724 17709 17837 17419 17969 gf180mcu_fd_sc_mcu9t5v0__xnor3_1
* cell instance $57 m0 *1 1104.88,1340.64
X$57 24585 23697 21004 24528 24712 24538 gf180mcu_fd_sc_mcu9t5v0__mux2_1
* cell instance $58 r0 *1 1101.52,1330.56
X$58 24127 24538 24528 24414 24094 gf180mcu_fd_sc_mcu9t5v0__and2_1
* cell instance $59 r0 *1 1104.88,1290.24
X$59 22896 23205 23319 23200 23206 gf180mcu_fd_sc_mcu9t5v0__nand2_1
* cell instance $60 r0 *1 1102.64,1239.84
X$60 21727 21847 21848 21728 21884 21719 21595 gf180mcu_fd_sc_mcu9t5v0__oai211_1
* cell instance $61 m0 *1 1313.76,1108.8
X$61 14310 17417 13492 17709 17837 17848 gf180mcu_fd_sc_mcu9t5v0__mux2_1
* cell instance $62 m0 *1 1094.8,1260
X$62 22174 21847 22124 22295 22133 21849 gf180mcu_fd_sc_mcu9t5v0__xnor3_1
* cell instance $63 m0 *1 1093.12,1290.24
X$63 22896 23166 23038 23200 22844 23205 gf180mcu_fd_sc_mcu9t5v0__xnor3_1
* cell instance $64 m0 *1 1099.84,1320.48
X$64 24094 23968 23957 24118 23967 gf180mcu_fd_sc_mcu9t5v0__xnor2_1
* cell instance $65 m0 *1 1480.08,1108.8
X$65 17849 17709 17837 17850 gf180mcu_fd_sc_mcu9t5v0__clkinv_1
* cell instance $66 m0 *1 1477.28,1108.8
X$66 17421 17850 17709 17837 17728 gf180mcu_fd_sc_mcu9t5v0__nand2_1
* cell instance $67 m0 *1 1284.64,1108.8
X$67 17298 17723 17709 17837 16325 17256 gf180mcu_fd_sc_mcu9t5v0__xnor3_1
* cell instance $68 m0 *1 1535.52,1108.8
X$68 17731 17732 17977 17709 17837 17851 gf180mcu_fd_sc_mcu9t5v0__mux2_1
* cell instance $69 r0 *1 1099.84,1209.6
X$69 20697 20948 17977 20936 20822 20947 gf180mcu_fd_sc_mcu9t5v0__mux2_1
* cell instance $70 m0 *1 1100.4,1350.72
X$70 25165 24127 14872 24828 25000 25008 gf180mcu_fd_sc_mcu9t5v0__mux2_1
* cell instance $71 m0 *1 1711.36,1108.8
X$71 17613 17553 16821 17709 17837 17854 gf180mcu_fd_sc_mcu9t5v0__mux2_1
* cell instance $72 r0 *1 1098.72,1018.08
X$72 15150 15281 13214 15271 15138 15280 gf180mcu_fd_sc_mcu9t5v0__mux2_1
* cell instance $73 r0 *1 1101.52,1078.56
X$73 16971 16972 13214 17123 16956 17250 gf180mcu_fd_sc_mcu9t5v0__mux2_1
* cell instance $74 m0 *1 1114.96,1108.8
X$74 13474 13475 15744 17709 17837 17719 gf180mcu_fd_sc_mcu9t5v0__aoi21_1
* cell instance $75 m0 *1 1110.48,1108.8
X$75 14820 17719 17720 17709 17837 17845 gf180mcu_fd_sc_mcu9t5v0__oai21_1
* cell instance $76 m0 *1 1149.68,1108.8
X$76 13474 14180 13475 17709 17837 17846 gf180mcu_fd_sc_mcu9t5v0__mux2_1
* cell instance $77 m0 *1 1026.48,1108.8
X$77 17956 17717 13214 17709 17837 17844 gf180mcu_fd_sc_mcu9t5v0__mux2_1
* cell instance $78 m0 *1 594.16,1108.8
X$78 17566 17702 17709 17837 18377 gf180mcu_fd_sc_mcu9t5v0__nor2_1
* cell instance $79 m0 *1 661.92,1108.8
X$79 14854 17080 14702 17706 17709 17837 17833 gf180mcu_fd_sc_mcu9t5v0__aoi22_1
* cell instance $80 m0 *1 659.68,1108.8
X$80 17833 17709 17837 17834 gf180mcu_fd_sc_mcu9t5v0__clkinv_1
* cell instance $81 m0 *1 1102.08,685.44
X$81 5775 2786 4949 5777 2992 6392 6425 6435 gf180mcu_fd_sc_mcu9t5v0__aoi221_1
* cell instance $82 r0 *1 1103.76,635.04
X$82 2257 5390 5297 5926 gf180mcu_fd_sc_mcu9t5v0__clkinv_1
* cell instance $83 r0 *1 1098.16,584.64
X$83 3001 4043 4156 4150 3907 4157 gf180mcu_fd_sc_mcu9t5v0__mux2_1
* cell instance $84 r0 *1 1104.32,594.72
X$84 3237 4380 4156 4389 4266 4044 gf180mcu_fd_sc_mcu9t5v0__mux2_1
* cell instance $85 m0 *1 1103.76,635.04
X$85 5283 5282 5183 5297 4562 gf180mcu_fd_sc_mcu9t5v0__nand2_1
* cell instance $86 r0 *1 1102.08,604.8
X$86 4379 4562 4493 4667 4512 4670 gf180mcu_fd_sc_mcu9t5v0__mux2_1
* cell instance $87 m0 *1 1101.52,897.12
X$87 11982 11575 11720 11860 12027 gf180mcu_fd_sc_mcu9t5v0__or2_4
* cell instance $88 r0 *1 1103.2,645.12
X$88 5777 5558 3920 5665 5411 5557 gf180mcu_fd_sc_mcu9t5v0__mux2_1
* cell instance $89 r0 *1 1103.2,786.24
X$89 9102 9321 2363 9201 8961 9210 gf180mcu_fd_sc_mcu9t5v0__mux2_1
* cell instance $90 r0 *1 1102.08,806.4
X$90 9820 10460 6030 9691 9575 9554 gf180mcu_fd_sc_mcu9t5v0__mux2_1
* cell instance $91 m0 *1 1100.96,806.4
X$91 9819 9554 5299 9432 9575 9583 gf180mcu_fd_sc_mcu9t5v0__mux2_1
* cell instance $92 m0 *1 898.8,1108.8
X$92 17841 17572 17709 17837 17842 gf180mcu_fd_sc_mcu9t5v0__nand2_1
* cell instance $93 m0 *1 893.76,1108.8
X$93 17841 17953 17840 17709 17837 17713 gf180mcu_fd_sc_mcu9t5v0__oai21_1
* cell instance $94 m0 *1 754.32,1108.8
X$94 12898 15400 17516 17709 17837 17836 gf180mcu_fd_sc_mcu9t5v0__nor3_1
* cell instance $95 m0 *1 844.48,1108.8
X$95 15694 17986 13427 17709 17837 17838 gf180mcu_fd_sc_mcu9t5v0__oai21_1
* cell instance $96 m0 *1 460.32,1108.8
X$96 17225 16130 17709 17837 17939 gf180mcu_fd_sc_mcu9t5v0__nand2_1
* cell instance $97 m0 *1 1092.56,766.08
X$97 6268 8335 7797 8445 8582 gf180mcu_fd_sc_mcu9t5v0__dffq_2
* cell instance $98 m0 *1 1098.72,655.2
X$98 4382 5557 5777 5665 5794 gf180mcu_fd_sc_mcu9t5v0__dffq_2
* cell instance $99 r0 *1 1104.88,776.16
X$99 6272 8975 8976 8843 8818 gf180mcu_fd_sc_mcu9t5v0__dffq_2
* cell instance $100 m0 *1 1097.6,796.32
X$100 6268 9210 9321 9201 9315 gf180mcu_fd_sc_mcu9t5v0__dffq_2
* cell instance $101 m0 *1 1095.92,614.88
X$101 2258 4670 4379 4667 4794 gf180mcu_fd_sc_mcu9t5v0__dffq_2
* cell instance $102 m0 *1 1097.04,816.48
X$102 9816 9583 9819 9691 9810 gf180mcu_fd_sc_mcu9t5v0__dffq_2
* cell instance $103 r0 *1 1104.88,544.32
X$103 2258 3002 3113 3215 3093 gf180mcu_fd_sc_mcu9t5v0__dffq_2
* cell instance $104 m0 *1 1090.88,594.72
X$104 2258 4157 3001 4150 4266 gf180mcu_fd_sc_mcu9t5v0__dffq_2
* cell instance $105 r0 *1 1097.6,836.64
X$105 9816 10322 10349 10338 10308 gf180mcu_fd_sc_mcu9t5v0__dffq_2
* cell instance $106 m0 *1 1103.76,574.56
X$106 2258 3573 3346 3558 3781 gf180mcu_fd_sc_mcu9t5v0__dffq_2
* cell instance $107 r0 *1 1102.64,504
X$107 2258 2372 2371 2243 2138 gf180mcu_fd_sc_mcu9t5v0__dffq_2
* cell instance $108 m0 *1 1092.56,504
X$108 2245 2135 2145 2130 2138 gf180mcu_fd_sc_mcu9t5v0__dffq_2
* cell instance $109 m0 *1 485.52,1108.8
X$109 15996 17559 17826 11958 17709 17837 gf180mcu_fd_sc_mcu9t5v0__dffrnq_2
* cell instance $110 m0 *1 556.08,1108.8
X$110 15131 17704 17566 11958 17709 17837 gf180mcu_fd_sc_mcu9t5v0__dffrnq_2
* cell instance $111 m0 *1 670.32,1108.8
X$111 16641 17707 17946 11958 17709 17837 gf180mcu_fd_sc_mcu9t5v0__dffrnq_2
* cell instance $112 m0 *1 507.92,1108.8
X$112 15996 17701 17702 11958 17709 17837 gf180mcu_fd_sc_mcu9t5v0__dffrnq_2
* cell instance $113 m0 *1 735.28,1108.8
X$113 14160 17836 17570 12383 17709 17837 gf180mcu_fd_sc_mcu9t5v0__dffrnq_2
* cell instance $114 m0 *1 1092.56,1481.76
X$114 27638 28641 28214 13331 28635 28661 gf180mcu_fd_sc_mcu9t5v0__dffrnq_2
* cell instance $115 m0 *1 1092,1501.92
X$115 27959 28995 28996 13331 28989 29062 gf180mcu_fd_sc_mcu9t5v0__dffrnq_2
* cell instance $116 r0 *1 1086.4,1098.72
X$116 15275 17587 17585 13331 17709 17521 gf180mcu_fd_sc_mcu9t5v0__dffrnq_2
* cell instance $117 m0 *1 1128.4,1108.8
X$117 18153 17721 17588 13331 17709 17837 gf180mcu_fd_sc_mcu9t5v0__dffrnq_2
* cell instance $118 m0 *1 1090.32,1048.32
X$118 15275 15863 16158 13331 15898 16008 gf180mcu_fd_sc_mcu9t5v0__dffrnq_2
* cell instance $119 r0 *1 1104.32,1118.88
X$119 18153 17845 18152 13331 18268 18104 gf180mcu_fd_sc_mcu9t5v0__dffrnq_2
* cell instance $120 m0 *1 1204,1108.8
X$120 14677 17592 17722 13331 17709 17837 gf180mcu_fd_sc_mcu9t5v0__dffrnq_2
* cell instance $121 m0 *1 1093.12,1088.64
X$121 14182 17250 16971 13331 17123 17289 gf180mcu_fd_sc_mcu9t5v0__dffrnq_2
* cell instance $122 m0 *1 1090.32,1028.16
X$122 14182 15280 15150 13331 15271 15402 gf180mcu_fd_sc_mcu9t5v0__dffrnq_2
* cell instance $123 m0 *1 1101.52,1008
X$123 14182 14665 14862 13331 14708 14857 gf180mcu_fd_sc_mcu9t5v0__dffrnq_2
* cell instance $124 r0 *1 1100.96,1350.72
X$124 24096 25008 25009 13331 25158 25000 gf180mcu_fd_sc_mcu9t5v0__dffrnq_2
* cell instance $125 m0 *1 1095.36,1219.68
X$125 19174 20947 20948 13331 20936 21123 gf180mcu_fd_sc_mcu9t5v0__dffrnq_2
* cell instance $126 r0 *1 1101.52,1270.08
X$126 24096 22715 13898 13331 22700 22577 gf180mcu_fd_sc_mcu9t5v0__dffrnq_2
* cell instance $127 m0 *1 1100.96,1229.76
X$127 20345 21370 14015 13331 21241 21412 gf180mcu_fd_sc_mcu9t5v0__dffrnq_2
* cell instance $128 m0 *1 1090.32,1199.52
X$128 20345 20386 14132 13331 20379 20507 gf180mcu_fd_sc_mcu9t5v0__dffrnq_2
* cell instance $129 m0 *1 1099.84,1330.56
X$129 24096 24243 18603 13331 24232 24414 gf180mcu_fd_sc_mcu9t5v0__dffrnq_2
* cell instance $130 m0 *1 1093.68,1310.4
X$130 23164 23514 18604 13331 23623 23797 gf180mcu_fd_sc_mcu9t5v0__dffrnq_2
* cell instance $131 m0 *1 1095.36,1622.88
X$131 30494 30654 30656 12383 30634 30705 gf180mcu_fd_sc_mcu9t5v0__dffrnq_2
* cell instance $132 m0 *1 1104.32,1703.52
X$132 30922 31617 31821 12383 31769 31827 gf180mcu_fd_sc_mcu9t5v0__dffrnq_2
* cell instance $133 m0 *1 1104.88,1653.12
X$133 30177 31043 30972 18834 31054 31118 gf180mcu_fd_sc_mcu9t5v0__dffrnq_2
* cell instance $134 r0 *1 1102.08,1370.88
X$134 24096 25587 22175 13331 25705 25581 gf180mcu_fd_sc_mcu9t5v0__dffrnq_2
* cell instance $135 r0 *1 1098.16,1542.24
X$135 27638 29641 29631 13331 29714 29636 gf180mcu_fd_sc_mcu9t5v0__dffrnq_2
* cell instance $136 m0 *1 1104.32,1441.44
X$136 27638 27520 26957 13331 27517 27666 gf180mcu_fd_sc_mcu9t5v0__dffrnq_2
* cell instance $137 r0 *1 1104.32,1461.6
X$137 27638 28388 26958 13331 28378 28239 gf180mcu_fd_sc_mcu9t5v0__dffrnq_2
* cell instance $138 m0 *1 1720.88,1108.8
X$138 15043 17739 16208 14696 17709 17837 gf180mcu_fd_sc_mcu9t5v0__dffrnq_2
* cell instance $139 r0 *1 1093.12,1391.04
X$139 24096 26177 26308 13331 26331 26166 gf180mcu_fd_sc_mcu9t5v0__dffrnq_2
* cell instance $140 m0 *1 1095.36,1572.48
X$140 27959 30032 29640 12383 29973 30039 gf180mcu_fd_sc_mcu9t5v0__dffrnq_2
* cell instance $141 m0 *1 1098.16,1159.2
X$141 19174 19175 19414 13331 19171 19282 gf180mcu_fd_sc_mcu9t5v0__dffrnq_2
* cell instance $142 m0 *1 811.44,1108.8
X$142 16142 17710 17571 13331 17709 17837 gf180mcu_fd_sc_mcu9t5v0__dffrnq_2
* cell instance $143 m0 *1 701.12,1108.8
X$143 16641 17708 17569 11958 17709 17837 gf180mcu_fd_sc_mcu9t5v0__dffrnq_2
* cell instance $144 m0 *1 575.12,1108.8
X$144 16641 17565 17828 11958 17709 17837 gf180mcu_fd_sc_mcu9t5v0__dffrnq_2
* cell instance $145 r0 *1 1095.36,856.8
X$145 10851 10833 10714 4491 gf180mcu_fd_sc_mcu9t5v0__buf_8
* cell instance $146 m0 *1 1099.84,907.2
X$146 12027 11971 12019 7818 gf180mcu_fd_sc_mcu9t5v0__buf_8
* cell instance $147 r0 *1 1092,887.04
X$147 11358 11720 11600 4493 gf180mcu_fd_sc_mcu9t5v0__buf_8
* cell instance $148 r0 *1 1072.96,816.48
X$148 9857 9841 9810 2573 gf180mcu_fd_sc_mcu9t5v0__buf_20
* cell instance $149 r0 *1 1103.76,846.72
X$149 10696 10676 10570 8984 gf180mcu_fd_sc_mcu9t5v0__buf_8
* cell instance $150 r0 *1 1100.96,917.28
X$150 12267 12508 12253 8331 gf180mcu_fd_sc_mcu9t5v0__buf_8
* cell instance $151 r0 *1 1090.88,866.88
X$151 11189 11181 11079 8216 gf180mcu_fd_sc_mcu9t5v0__buf_8
* cell instance $152 m0 *1 1101.52,887.04
X$152 11575 11461 11600 5434 gf180mcu_fd_sc_mcu9t5v0__buf_8
* cell instance $153 m0 *1 720.72,1108.8
X$153 17395 17709 17837 17835 gf180mcu_fd_sc_mcu9t5v0__buf_8
* cell instance $154 m0 *1 1100.4,1602.72
X$154 30410 30361 30419 23921 gf180mcu_fd_sc_mcu9t5v0__buf_8
* cell instance $155 m0 *1 1094.8,1592.64
X$155 30162 30231 30295 30096 gf180mcu_fd_sc_mcu9t5v0__buf_8
* cell instance $156 m0 *1 1102.64,1562.4
X$156 29906 29841 29903 29845 gf180mcu_fd_sc_mcu9t5v0__buf_8
* cell instance $157 r0 *1 400.4,1103.76
X$157 17824 17837 17709 17700 gf180mcu_fd_sc_mcu9t5v0__buf_8
* cell instance $158 r0 *1 375.2,1103.76
X$158 18259 17837 17709 17824 gf180mcu_fd_sc_mcu9t5v0__buf_1
* cell instance $159 m90 *1 1845,1504.12
X$159 3 18139 28660 22168 22832 15578 28660 28660 16957 22828 19745 28660 16509
+ 28683 29060 29164 29165 1 29166 28660 28634 28374 28633 28375 25265 16959
+ 28660 22830 1 22829 18587 28660 28660 17401 22833 1 23314 28660 16510 1 1 1 1
+ 1 1 1 1 1 1 1 1 1 1 1 1 1 1 1 1 1 1 1 1 3 1 1 1 33548
+ gf180mcu_fd_ip_sram__sram256x8m8wm1
* cell instance $160 r0 *1 1230.88,1653.12
X$160 30922 31136 31112 13180 31125 31118 gf180mcu_fd_sc_mcu9t5v0__dffrnq_2
* cell instance $161 r0 *1 1153.04,1653.12
X$161 31132 30974 28684 31125 31118 31133 gf180mcu_fd_sc_mcu9t5v0__mux2_1
* cell instance $162 r0 *1 1145.76,1653.12
X$162 31132 31029 18277 31125 31118 31045 gf180mcu_fd_sc_mcu9t5v0__mux2_1
* cell instance $163 r0 *1 1123.92,1653.12
X$163 30177 30973 30974 12383 31125 31118 gf180mcu_fd_sc_mcu9t5v0__dffrnq_2
* cell instance $164 r0 *1 1174.32,1653.12
X$164 31030 31125 31118 31111 gf180mcu_fd_sc_mcu9t5v0__clkinv_1
* cell instance $165 r0 *1 1182.16,1653.12
X$165 30177 31134 31248 13180 31125 31118 gf180mcu_fd_sc_mcu9t5v0__dffrnq_2
* cell instance $166 r0 *1 1211.84,1653.12
X$166 30922 30504 31135 13180 31125 31118 gf180mcu_fd_sc_mcu9t5v0__dffrnq_2
* cell instance $167 r0 *1 1201.76,1653.12
X$167 31118 31125 gf180mcu_fd_sc_mcu9t5v0__filltie
* cell instance $168 r0 *1 1263.36,1653.12
X$168 30901 31138 31125 31118 30240 gf180mcu_fd_sc_mcu9t5v0__nand2_1
* cell instance $169 r0 *1 1260,1653.12
X$169 30901 30166 31125 31118 31137 gf180mcu_fd_sc_mcu9t5v0__nand2_1
* cell instance $170 r0 *1 1331.68,1653.12
X$170 31197 31114 31125 31118 30977 30664 gf180mcu_fd_sc_mcu9t5v0__xor3_1
* cell instance $171 r0 *1 1346.24,1653.12
X$171 31116 31125 31118 31140 gf180mcu_fd_sc_mcu9t5v0__clkinv_1
* cell instance $172 r0 *1 1348.48,1653.12
X$172 31140 31115 31062 31125 31118 31141 gf180mcu_fd_sc_mcu9t5v0__aoi21_1
* cell instance $173 r0 *1 1309.28,1653.12
X$173 31137 31125 31118 31113 30293 gf180mcu_fd_sc_mcu9t5v0__xor2_1
* cell instance $174 r0 *1 1316,1653.12
X$174 31195 31125 31118 29280 gf180mcu_fd_sc_mcu9t5v0__buf_8
* cell instance $175 m90 *1 1392.72,1653.12
X$175 31118 31125 gf180mcu_fd_sc_mcu9t5v0__endcap
* cell instance $176 r0 *1 1654.8,1360.8
X$176 25300 25340 25302 14696 25430 25268 gf180mcu_fd_sc_mcu9t5v0__dffrnq_2
* cell instance $177 m0 *1 1646.96,1471.68
X$177 27791 28526 28228 14696 28378 28530 gf180mcu_fd_sc_mcu9t5v0__dffrnq_2
* cell instance $178 r0 *1 1655.36,1471.68
X$178 20543 28228 22862 28635 28530 28526 gf180mcu_fd_sc_mcu9t5v0__mux2_1
* cell instance $179 m0 *1 1638.56,1451.52
X$179 27237 28013 28014 14696 27807 27945 gf180mcu_fd_sc_mcu9t5v0__dffrnq_2
* cell instance $180 r0 *1 1655.92,1441.44
X$180 27237 27678 27650 14696 27807 27666 gf180mcu_fd_sc_mcu9t5v0__dffrnq_2
* cell instance $181 r0 *1 1642.48,1391.04
X$181 25300 26189 26325 14696 26331 26166 gf180mcu_fd_sc_mcu9t5v0__dffrnq_2
* cell instance $182 m0 *1 1656.48,1401.12
X$182 26494 26325 15890 26331 26456 26493 gf180mcu_fd_sc_mcu9t5v0__mux2_1
* cell instance $183 m0 *1 1638.56,1421.28
X$183 25300 26974 26920 14696 26942 27078 gf180mcu_fd_sc_mcu9t5v0__dffrnq_2
* cell instance $184 m0 *1 1650.32,1391.04
X$184 20111 26325 22907 25997 26166 26189 gf180mcu_fd_sc_mcu9t5v0__mux2_1
* cell instance $185 r0 *1 1641.92,1370.88
X$185 25300 25859 23697 14696 25705 25581 gf180mcu_fd_sc_mcu9t5v0__dffrnq_2
* cell instance $186 r0 *1 1653.12,1401.12
X$186 25300 26493 26494 14696 26632 26456 gf180mcu_fd_sc_mcu9t5v0__dffrnq_2
* cell instance $187 r0 *1 1656.48,1229.76
X$187 19752 21439 21148 14696 21537 21412 gf180mcu_fd_sc_mcu9t5v0__dffrnq_2
* cell instance $188 r0 *1 1655.36,1300.32
X$188 23522 24135 15890 23623 23504 23659 gf180mcu_fd_sc_mcu9t5v0__mux2_1
* cell instance $189 m0 *1 1643.04,1330.56
X$189 23521 24318 24135 14696 24232 24414 gf180mcu_fd_sc_mcu9t5v0__dffrnq_2
* cell instance $190 r0 *1 1641.36,1350.72
X$190 25300 25147 24982 14696 25158 25000 gf180mcu_fd_sc_mcu9t5v0__dffrnq_2
* cell instance $191 m0 *1 1650.32,1310.4
X$191 23521 23659 23522 14696 23623 23797 gf180mcu_fd_sc_mcu9t5v0__dffrnq_2
* cell instance $192 r0 *1 1655.92,1280.16
X$192 23221 22139 14872 23038 22885 22908 gf180mcu_fd_sc_mcu9t5v0__mux2_1
* cell instance $193 r0 *1 1653.12,1260
X$193 21024 22438 21257 14696 22449 22295 gf180mcu_fd_sc_mcu9t5v0__dffrnq_2
* cell instance $194 m0 *1 1639.68,1290.24
X$194 21024 23056 23030 14696 23038 23200 gf180mcu_fd_sc_mcu9t5v0__dffrnq_2
* cell instance $195 m0 *1 1646.96,1280.16
X$195 21024 22908 22139 14696 22700 22885 gf180mcu_fd_sc_mcu9t5v0__dffrnq_2
* cell instance $196 m0 *1 1639.68,1249.92
X$196 19752 21898 20403 14696 21884 21997 gf180mcu_fd_sc_mcu9t5v0__dffrnq_2
* cell instance $197 r0 *1 1650.88,1179.36
X$197 18172 20062 19436 14696 20028 19901 gf180mcu_fd_sc_mcu9t5v0__dffrnq_2
* cell instance $198 m0 *1 1655.92,1179.36
X$198 20111 19436 16818 19729 19901 20062 gf180mcu_fd_sc_mcu9t5v0__mux2_1
* cell instance $199 m0 *1 1638.56,1219.68
X$199 18172 21146 17266 14696 20936 21123 gf180mcu_fd_sc_mcu9t5v0__dffrnq_2
* cell instance $200 r0 *1 1655.36,1159.2
X$200 19466 19436 19448 19282 18861 gf180mcu_fd_sc_mcu9t5v0__nand2_1
* cell instance $201 m0 *1 1649.2,1118.88
X$201 18172 18173 17736 14696 17985 18104 gf180mcu_fd_sc_mcu9t5v0__dffrnq_2
* cell instance $202 m0 *1 1655.92,1139.04
X$202 17977 17609 18638 18637 18553 18731 18639 gf180mcu_fd_sc_mcu9t5v0__oai31_1
* cell instance $203 r0 *1 1654.8,1118.88
X$203 17736 18125 16821 18268 18104 18173 gf180mcu_fd_sc_mcu9t5v0__mux2_1
* cell instance $204 m0 *1 1656.48,1149.12
X$204 18861 18984 18636 18841 18996 17609 gf180mcu_fd_sc_mcu9t5v0__aoi21_1
* cell instance $205 r0 *1 1656.48,1139.04
X$205 18636 18861 18984 18841 18731 18638 gf180mcu_fd_sc_mcu9t5v0__and3_1
* cell instance $206 r180 *1 2210,2210
X$206 gf180mcu_fd_io__cor
* cell instance $207 r0 *1 1688.4,1854.72
X$207 33242 33329 gf180mcu_fd_sc_mcu9t5v0__filltie
* cell instance $208 r0 *1 1808.24,1854.72
X$208 33242 33329 gf180mcu_fd_sc_mcu9t5v0__filltie
* cell instance $209 m90 *1 1864.8,1854.72
X$209 33886 33820 gf180mcu_fd_sc_mcu9t5v0__endcap
* cell instance $210 r0 *1 1375.36,1663.2
X$210 31271 31337 31321 31239 30932 gf180mcu_fd_sc_mcu9t5v0__xnor2_1
* cell instance $211 r0 *1 1378.16,1764
X$211 32624 32567 32561 32560 29930 gf180mcu_fd_sc_mcu9t5v0__or2_1
* cell instance $212 m0 *1 1373.68,1693.44
X$212 31558 31528 31708 31604 31710 31678 gf180mcu_fd_sc_mcu9t5v0__oai21_2
* cell instance $213 r0 *1 1377.04,1683.36
X$213 31678 31559 31560 31604 31529 30185 gf180mcu_fd_sc_mcu9t5v0__aoi21_2
* cell instance $214 m0 *1 1376.48,1774.08
X$214 32624 32561 32661 32567 30188 gf180mcu_fd_sc_mcu9t5v0__xor2_1
* cell instance $215 m0 *1 1376.48,1703.52
X$215 31560 31769 31827 31826 31837 gf180mcu_fd_sc_mcu9t5v0__xor2_1
* cell instance $216 r0 *1 1377.04,1703.52
X$216 31837 31894 31827 21026 gf180mcu_fd_sc_mcu9t5v0__buf_8
* cell instance $217 r0 *1 1377.04,1673.28
X$217 31460 31464 31388 16689 gf180mcu_fd_sc_mcu9t5v0__buf_8
* cell instance $218 m0 *1 1377.04,1673.28
X$218 31270 31200 31271 31321 31388 31351 gf180mcu_fd_sc_mcu9t5v0__oai21_1
* cell instance $219 r0 *1 1238.72,1764
X$219 32455 32464 32565 32561 32560 32564 gf180mcu_fd_sc_mcu9t5v0__aoi21_1
* cell instance $220 r0 *1 1238.72,1774.08
X$220 32566 32666 32663 32661 32567 32564 gf180mcu_fd_sc_mcu9t5v0__xnor3_1
* cell instance $221 m0 *1 1241.52,1784.16
X$221 32564 32663 32709 32716 gf180mcu_fd_sc_mcu9t5v0__clkinv_1
* cell instance $222 r0 *1 1242.08,1784.16
X$222 32566 32715 32760 32753 32709 32759 gf180mcu_fd_sc_mcu9t5v0__oai21_1
* cell instance $223 r0 *1 1201.76,1794.24
X$223 32804 32842 gf180mcu_fd_sc_mcu9t5v0__filltie
* cell instance $224 m0 *1 1242.64,1693.44
X$224 31694 31604 31710 31401 31622 gf180mcu_fd_sc_mcu9t5v0__xor2_1
* cell instance $225 m0 *1 1239.84,1733.76
X$225 32110 31977 32169 32228 32109 32174 gf180mcu_fd_sc_mcu9t5v0__xor3_1
* cell instance $226 m0 *1 1242.64,1713.6
X$226 31135 30505 31894 31972 31978 gf180mcu_fd_sc_mcu9t5v0__nand2_1
* cell instance $227 r0 *1 1240.4,1673.28
X$227 30166 31464 31388 31347 gf180mcu_fd_sc_mcu9t5v0__buf_8
* cell instance $228 m0 *1 1239.84,1753.92
X$228 32411 32357 31905 32352 32453 32410 gf180mcu_fd_sc_mcu9t5v0__aoi21_1
* cell instance $229 m0 *1 1229.76,1663.2
X$229 30922 30642 31194 13180 31125 31239 gf180mcu_fd_sc_mcu9t5v0__dffrnq_2
* cell instance $230 m0 *1 1321.6,1824.48
X$230 33081 33002 gf180mcu_fd_sc_mcu9t5v0__filltie
* cell instance $231 m0 *1 1321.6,1834.56
X$231 33161 33082 gf180mcu_fd_sc_mcu9t5v0__filltie
* cell instance $232 m0 *1 1321.6,1804.32
X$232 32921 32842 gf180mcu_fd_sc_mcu9t5v0__filltie
* cell instance $233 m0 *1 1321.6,1844.64
X$233 33241 33162 gf180mcu_fd_sc_mcu9t5v0__filltie
* cell instance $234 m0 *1 1321.6,1854.72
X$234 33242 33244 gf180mcu_fd_sc_mcu9t5v0__filltie
* cell instance $235 r0 *1 1328.88,1854.72
X$235 33242 33329 gf180mcu_fd_sc_mcu9t5v0__filltie
* cell instance $236 m0 *1 1321.6,1864.8
X$236 33328 33329 gf180mcu_fd_sc_mcu9t5v0__filltie
* cell instance $237 m0 *1 1321.6,1814.4
X$237 33001 32922 gf180mcu_fd_sc_mcu9t5v0__filltie
* cell instance $238 r0 *1 1201.76,1844.64
X$238 33241 33244 gf180mcu_fd_sc_mcu9t5v0__filltie
* cell instance $239 r0 *1 1201.76,1814.4
X$239 33001 33002 gf180mcu_fd_sc_mcu9t5v0__filltie
* cell instance $240 r0 *1 1209.04,1854.72
X$240 33242 33329 gf180mcu_fd_sc_mcu9t5v0__filltie
* cell instance $241 r0 *1 1201.76,1834.56
X$241 33161 33162 gf180mcu_fd_sc_mcu9t5v0__filltie
* cell instance $242 m0 *1 1201.76,1864.8
X$242 33328 33329 gf180mcu_fd_sc_mcu9t5v0__filltie
* cell instance $243 r0 *1 1201.76,1804.32
X$243 32921 32922 gf180mcu_fd_sc_mcu9t5v0__filltie
* cell instance $244 r0 *1 1201.76,1824.48
X$244 33081 33082 gf180mcu_fd_sc_mcu9t5v0__filltie
* cell instance $245 m0 *1 1163.68,1723.68
X$245 30922 32044 31886 13180 32037 32105 gf180mcu_fd_sc_mcu9t5v0__dffrnq_2
* cell instance $246 r0 *1 1168.72,1693.44
X$246 30922 31774 31553 13180 31769 31710 gf180mcu_fd_sc_mcu9t5v0__dffrnq_2
* cell instance $247 r0 *1 1197.28,1723.68
X$247 31334 32221 32169 32105 32222 gf180mcu_fd_sc_mcu9t5v0__and2_1
* cell instance $248 r0 *1 1170.4,1713.6
X$248 31886 31550 18277 32037 31972 32044 gf180mcu_fd_sc_mcu9t5v0__mux2_1
* cell instance $249 r0 *1 1201.76,1723.68
X$249 32105 32169 gf180mcu_fd_sc_mcu9t5v0__filltie
* cell instance $250 m0 *1 1169.84,1693.44
X$250 22858 31604 31710 30922 gf180mcu_fd_sc_mcu9t5v0__clkbuf_8
* cell instance $251 m0 *1 1169.84,1703.52
X$251 30922 31769 31827 gf180mcu_fd_sc_mcu9t5v0__inv_3
* cell instance $252 r0 *1 1223.04,1723.68
X$252 31776 32120 32169 32105 32172 gf180mcu_fd_sc_mcu9t5v0__or2_1
* cell instance $253 r0 *1 1134.56,1723.68
X$253 30922 32108 31986 13180 32169 32105 gf180mcu_fd_sc_mcu9t5v0__dffrnq_2
* cell instance $254 r0 *1 1114.4,1723.68
X$254 30922 32107 30921 13180 32169 32105 gf180mcu_fd_sc_mcu9t5v0__dffrnq_2
* cell instance $255 r0 *1 1170.96,1673.28
X$255 30922 31397 31456 13180 31464 31388 gf180mcu_fd_sc_mcu9t5v0__dffrnq_2
* cell instance $256 m0 *1 1173.76,1673.28
X$256 31456 31267 18277 31321 31388 31397 gf180mcu_fd_sc_mcu9t5v0__mux2_1
* cell instance $257 m0 *1 1222.48,1774.08
X$257 32619 32563 32562 32561 32661 32713 gf180mcu_fd_sc_mcu9t5v0__oai21_1
* cell instance $258 r0 *1 1197.28,1753.92
X$258 32408 32354 32461 32459 32453 32460 gf180mcu_fd_sc_mcu9t5v0__oai21_1
* cell instance $259 m0 *1 1199.52,1764
X$259 32408 31824 32459 32560 32617 gf180mcu_fd_sc_mcu9t5v0__xnor2_1
* cell instance $260 r0 *1 1201.76,1753.92
X$260 32453 32459 gf180mcu_fd_sc_mcu9t5v0__filltie
* cell instance $261 r0 *1 1205.12,1753.92
X$261 32462 32354 32459 32453 32463 gf180mcu_fd_sc_mcu9t5v0__xnor2_1
* cell instance $262 r0 *1 1216.32,1764
X$262 32454 32463 32561 32560 32563 gf180mcu_fd_sc_mcu9t5v0__xnor2_1
* cell instance $263 r0 *1 1201.76,1774.08
X$263 32661 32663 gf180mcu_fd_sc_mcu9t5v0__filltie
* cell instance $264 m0 *1 1205.12,1774.08
X$264 32460 32617 32561 32661 32662 gf180mcu_fd_sc_mcu9t5v0__nand2_1
* cell instance $265 r0 *1 1201.76,1733.76
X$265 32228 32299 gf180mcu_fd_sc_mcu9t5v0__filltie
* cell instance $266 r0 *1 1222.48,1733.76
X$266 31776 32120 32299 32228 32223 gf180mcu_fd_sc_mcu9t5v0__and2_1
* cell instance $267 r0 *1 1201.76,1743.84
X$267 32351 32352 gf180mcu_fd_sc_mcu9t5v0__filltie
* cell instance $268 r0 *1 1197.28,1733.76
X$268 31621 32222 32231 32299 32228 32251 gf180mcu_fd_sc_mcu9t5v0__oai21_1
* cell instance $269 r0 *1 1195.04,1743.84
X$269 32251 31901 32352 32351 32354 gf180mcu_fd_sc_mcu9t5v0__xnor2_1
* cell instance $270 r0 *1 1202.88,1743.84
X$270 32251 31901 32352 32351 32461 gf180mcu_fd_sc_mcu9t5v0__nand2_1
* cell instance $271 m0 *1 1221.36,1733.76
X$271 32046 32120 32169 32228 32233 31776 gf180mcu_fd_sc_mcu9t5v0__xnor3_1
* cell instance $272 r0 *1 1217.44,1743.84
X$272 32171 32045 32352 32351 32356 gf180mcu_fd_sc_mcu9t5v0__nand2_1
* cell instance $273 m0 *1 1192.8,1733.76
X$273 31334 32221 32169 32228 32231 gf180mcu_fd_sc_mcu9t5v0__or2_1
* cell instance $274 m0 *1 1216.88,1733.76
X$274 32046 32223 32172 32169 32228 32171 gf180mcu_fd_sc_mcu9t5v0__oai21_1
* cell instance $275 m0 *1 1197.28,1733.76
X$275 31621 32221 32169 32228 32232 31334 gf180mcu_fd_sc_mcu9t5v0__xnor3_1
* cell instance $276 r0 *1 1210.16,1743.84
X$276 31903 32232 32352 32351 32355 gf180mcu_fd_sc_mcu9t5v0__xnor2_1
* cell instance $277 r0 *1 1201.76,1784.16
X$277 32709 32753 gf180mcu_fd_sc_mcu9t5v0__filltie
* cell instance $278 m0 *1 1200.64,1774.08
X$278 32460 32617 32561 32661 32618 gf180mcu_fd_sc_mcu9t5v0__or2_1
* cell instance $279 r0 *1 1220.24,1743.84
X$279 32171 32045 32352 32351 32409 gf180mcu_fd_sc_mcu9t5v0__xnor2_1
* cell instance $280 r0 *1 1211.84,1753.92
X$280 32462 32459 32453 32408 gf180mcu_fd_sc_mcu9t5v0__clkinv_1
* cell instance $281 m0 *1 1205.68,1784.16
X$281 32662 32618 32663 32709 32710 gf180mcu_fd_sc_mcu9t5v0__nand2_1
* cell instance $282 r0 *1 1219.68,1753.92
X$282 32462 32355 32459 32453 32464 gf180mcu_fd_sc_mcu9t5v0__xnor2_1
* cell instance $283 m0 *1 1209.04,1784.16
X$283 32665 32710 32663 32709 32712 gf180mcu_fd_sc_mcu9t5v0__xnor2_1
* cell instance $284 m0 *1 1212.4,1743.84
X$284 31903 32232 32299 32351 32346 gf180mcu_fd_sc_mcu9t5v0__nand2_1
* cell instance $285 r0 *1 1220.8,1784.16
X$285 32713 32712 32753 32709 32756 gf180mcu_fd_sc_mcu9t5v0__nand2_1
* cell instance $286 m0 *1 1221.92,1784.16
X$286 32713 32712 32663 32709 32714 gf180mcu_fd_sc_mcu9t5v0__or2_1
* cell instance $287 r0 *1 1213.52,1764
X$287 32454 32463 32561 32560 32562 gf180mcu_fd_sc_mcu9t5v0__nand2_1
* cell instance $288 r0 *1 1230.88,1784.16
X$288 32756 32714 32753 32709 32757 gf180mcu_fd_sc_mcu9t5v0__nand2_1
* cell instance $289 r0 *1 1234.8,1743.84
X$289 32098 31906 31905 32352 32351 32357 gf180mcu_fd_sc_mcu9t5v0__aoi21_1
* cell instance $290 r0 *1 1201.76,1764
X$290 32560 32561 gf180mcu_fd_sc_mcu9t5v0__filltie
* cell instance $291 m0 *1 1206.24,1764
X$291 32462 31824 32459 32560 32711 gf180mcu_fd_sc_mcu9t5v0__nor2_1
* cell instance $292 r0 *1 1204.56,1774.08
X$292 32662 32618 32665 32663 32661 32664 gf180mcu_fd_sc_mcu9t5v0__mux2_1
* cell instance $293 r0 *1 1223.6,1784.16
X$293 32714 32756 32566 32753 32709 32754 gf180mcu_fd_sc_mcu9t5v0__mux2_1
* cell instance $294 m0 *1 1234.24,1794.24
X$294 32566 32757 32753 32804 32758 gf180mcu_fd_sc_mcu9t5v0__xnor2_1
* cell instance $295 m0 *1 1233.12,1753.92
X$295 32109 32357 32352 32453 32462 gf180mcu_fd_sc_mcu9t5v0__xnor2_1
* cell instance $296 r0 *1 1229.2,1753.92
X$296 32462 32409 32459 32453 32465 gf180mcu_fd_sc_mcu9t5v0__xnor2_1
* cell instance $297 m0 *1 1223.04,1753.92
X$297 32408 32409 32356 32352 32453 32455 gf180mcu_fd_sc_mcu9t5v0__oai21_1
* cell instance $298 m0 *1 1214.64,1753.92
X$298 32408 32355 32346 32352 32453 32454 gf180mcu_fd_sc_mcu9t5v0__oai21_1
* cell instance $299 r0 *1 1228.08,1774.08
X$299 32665 32563 32663 32661 32666 gf180mcu_fd_sc_mcu9t5v0__xnor2_1
* cell instance $300 m0 *1 1238.16,1774.08
X$300 32619 32620 32561 32661 32565 gf180mcu_fd_sc_mcu9t5v0__nor2_1
* cell instance $301 r0 *1 1207.92,1784.16
X$301 32711 32754 32753 32709 32755 32664 gf180mcu_fd_sc_mcu9t5v0__xnor3_1
* cell instance $302 r0 *1 1232,1764
X$302 32455 32464 32561 32560 32620 gf180mcu_fd_sc_mcu9t5v0__xnor2_1
* cell instance $303 m0 *1 1121.68,1733.76
X$303 12383 32169 32228 13180 gf180mcu_fd_sc_mcu9t5v0__buf_20
* cell instance $304 r0 *1 1150.24,1683.36
X$304 31986 18277 31551 29288 30975 31195 31604 31529 31552
+ gf180mcu_fd_sc_mcu9t5v0__aoi222_1
* cell instance $305 m0 *1 1113.28,1693.44
X$305 30177 31618 31673 12383 31604 31710 gf180mcu_fd_sc_mcu9t5v0__dffrnq_2
* cell instance $306 r0 *1 1127.84,1693.44
X$306 30177 31619 31550 13180 31769 31710 gf180mcu_fd_sc_mcu9t5v0__dffrnq_2
* cell instance $307 m0 *1 1108.24,1713.6
X$307 30922 31899 31926 12383 31894 31972 gf180mcu_fd_sc_mcu9t5v0__dffrnq_2
* cell instance $308 m0 *1 1136.24,1723.68
X$308 31986 32097 31057 32037 32105 32108 gf180mcu_fd_sc_mcu9t5v0__mux2_1
* cell instance $309 r0 *1 1158.08,1683.36
X$309 31552 31604 31529 31522 gf180mcu_fd_sc_mcu9t5v0__clkinv_1
* cell instance $310 m0 *1 1120,1673.28
X$310 31267 30639 31321 31388 31344 gf180mcu_fd_sc_mcu9t5v0__nand2_1
* cell instance $311 m0 *1 1136.24,1663.2
X$311 30898 31243 31057 31125 31239 31246 gf180mcu_fd_sc_mcu9t5v0__mux2_1
* cell instance $312 m0 *1 1115.52,1673.28
X$312 30771 31266 31344 31321 31388 31343 gf180mcu_fd_sc_mcu9t5v0__oai21_1
* cell instance $313 m0 *1 1111.6,1663.2
X$313 30771 31190 31191 31125 31239 31245 gf180mcu_fd_sc_mcu9t5v0__oai21_1
* cell instance $314 r0 *1 1108.24,1663.2
X$314 30177 31245 31192 12383 31321 31239 gf180mcu_fd_sc_mcu9t5v0__dffrnq_2
* cell instance $315 r0 *1 1127.28,1663.2
X$315 30177 31343 31267 13180 31321 31239 gf180mcu_fd_sc_mcu9t5v0__dffrnq_2
* cell instance $316 m0 *1 1134.56,1673.28
X$316 30177 31246 30898 13180 31321 31388 gf180mcu_fd_sc_mcu9t5v0__dffrnq_2
* cell instance $317 m0 *1 1118.32,1663.2
X$317 31192 30639 31125 31239 31191 gf180mcu_fd_sc_mcu9t5v0__nand2_1
* cell instance $318 m0 *1 1158.08,1663.2
X$318 31193 31192 18277 31125 31239 31247 gf180mcu_fd_sc_mcu9t5v0__mux2_1
* cell instance $319 r0 *1 1130.64,1683.36
X$319 31550 31616 31057 31604 31529 31619 gf180mcu_fd_sc_mcu9t5v0__mux2_1
* cell instance $320 r0 *1 1154.72,1663.2
X$320 30177 31247 31193 13180 31321 31239 gf180mcu_fd_sc_mcu9t5v0__dffrnq_2
* cell instance $321 r0 *1 1154.72,1703.52
X$321 30922 31834 31822 13180 31894 31827 gf180mcu_fd_sc_mcu9t5v0__dffrnq_2
* cell instance $322 r0 *1 1105.44,1683.36
X$322 30771 31548 31672 31604 31529 31617 gf180mcu_fd_sc_mcu9t5v0__oai21_1
* cell instance $323 r0 *1 1118.88,1683.36
X$323 31673 30639 31604 31529 31549 gf180mcu_fd_sc_mcu9t5v0__nand2_1
* cell instance $324 r0 *1 1112.72,1683.36
X$324 30771 31533 31549 31604 31529 31618 gf180mcu_fd_sc_mcu9t5v0__oai21_1
* cell instance $325 m0 *1 1132.88,1703.52
X$325 30922 31714 31690 13180 31769 31827 gf180mcu_fd_sc_mcu9t5v0__dffrnq_2
* cell instance $326 r0 *1 1152.48,1693.44
X$326 31987 31690 28684 31769 31710 31551 gf180mcu_fd_sc_mcu9t5v0__mux2_1
* cell instance $327 r0 *1 1150.24,1713.6
X$327 31987 31986 18277 32037 31972 32043 gf180mcu_fd_sc_mcu9t5v0__mux2_1
* cell instance $328 r0 *1 1109.92,1703.52
X$328 31926 31833 31057 31894 31827 31899 gf180mcu_fd_sc_mcu9t5v0__mux2_1
* cell instance $329 m0 *1 1117.2,1723.68
X$329 30921 32102 31057 32037 32105 32107 gf180mcu_fd_sc_mcu9t5v0__mux2_1
* cell instance $330 m0 *1 1110.48,1693.44
X$330 31821 30639 31604 31710 31672 gf180mcu_fd_sc_mcu9t5v0__nand2_1
* cell instance $331 m0 *1 1135.68,1693.44
X$331 31690 31673 18277 31604 31710 31714 gf180mcu_fd_sc_mcu9t5v0__mux2_1
* cell instance $332 m0 *1 1158.08,1703.52
X$332 31822 31821 18277 31769 31827 31834 gf180mcu_fd_sc_mcu9t5v0__mux2_1
* cell instance $333 m0 *1 1144.64,1723.68
X$333 30922 32043 31987 13180 32037 32105 gf180mcu_fd_sc_mcu9t5v0__dffrnq_2
* cell instance $334 m0 *1 1151.92,1683.36
X$334 30177 31522 31195 13180 31464 31529 gf180mcu_fd_sc_mcu9t5v0__dffrnq_2
* cell instance $335 r0 *1 1221.36,1683.36
X$335 30572 31470 31604 31529 31765 gf180mcu_fd_sc_mcu9t5v0__nand2_1
* cell instance $336 r0 *1 1202.88,1693.44
X$336 31621 31692 31693 31769 31710 31823 gf180mcu_fd_sc_mcu9t5v0__oai21_1
* cell instance $337 m0 *1 1219.68,1713.6
X$337 31268 30505 31927 31894 31972 31904 gf180mcu_fd_sc_mcu9t5v0__nand3_1
* cell instance $338 m0 *1 1202.88,1703.52
X$338 31775 31823 31524 31769 31827 31824 gf180mcu_fd_sc_mcu9t5v0__aoi21_1
* cell instance $339 m0 *1 1183.28,1713.6
X$339 31691 31894 31972 31988 gf180mcu_fd_sc_mcu9t5v0__clkinv_1
* cell instance $340 r0 *1 1175.44,1703.52
X$340 31886 31822 28684 31894 31827 31900 gf180mcu_fd_sc_mcu9t5v0__mux2_1
* cell instance $341 r0 *1 1211.28,1713.6
X$341 31268 30505 32037 31972 31989 gf180mcu_fd_sc_mcu9t5v0__nand2_1
* cell instance $342 r0 *1 1214.08,1703.52
X$342 31765 31902 31904 31894 31827 31903 gf180mcu_fd_sc_mcu9t5v0__oai21_1
* cell instance $343 m0 *1 1210.16,1713.6
X$343 30657 31046 31894 31972 31902 gf180mcu_fd_sc_mcu9t5v0__nand2_1
* cell instance $344 m0 *1 1212.96,1713.6
X$344 31765 31894 31972 31902 31927 gf180mcu_fd_sc_mcu9t5v0__xor2_1
* cell instance $345 r0 *1 1214.08,1713.6
X$345 31989 31927 32037 31972 32045 gf180mcu_fd_sc_mcu9t5v0__xnor2_1
* cell instance $346 r0 *1 1198.4,1713.6
X$346 31534 30505 32037 31972 31621 gf180mcu_fd_sc_mcu9t5v0__nand2_1
* cell instance $347 r0 *1 1188.88,1703.52
X$347 31621 31398 31894 31827 31901 31674 gf180mcu_fd_sc_mcu9t5v0__xnor3_1
* cell instance $348 m0 *1 1224.16,1693.44
X$348 31550 18277 31900 29288 30975 31060 31604 31710 31554
+ gf180mcu_fd_sc_mcu9t5v0__aoi222_1
* cell instance $349 r0 *1 1202.88,1713.6
X$349 31268 31046 32037 31972 32221 gf180mcu_fd_sc_mcu9t5v0__nand2_1
* cell instance $350 m0 *1 1176.56,1703.52
X$350 31553 31926 18277 31769 31827 31774 gf180mcu_fd_sc_mcu9t5v0__mux2_1
* cell instance $351 r0 *1 1227.52,1703.52
X$351 31534 31032 31031 31894 31827 31905 gf180mcu_fd_sc_mcu9t5v0__and3_1
* cell instance $352 r0 *1 1196.72,1673.28
X$352 30975 31464 31388 30164 gf180mcu_fd_sc_mcu9t5v0__clkinv_1
* cell instance $353 r0 *1 1205.68,1663.2
X$353 31268 31321 31239 30523 gf180mcu_fd_sc_mcu9t5v0__clkinv_1
* cell instance $354 r0 *1 1228.64,1673.28
X$354 30572 30165 31464 31388 31776 gf180mcu_fd_sc_mcu9t5v0__nand2_1
* cell instance $355 r0 *1 1201.76,1663.2
X$355 31239 31321 gf180mcu_fd_sc_mcu9t5v0__filltie
* cell instance $356 r0 *1 1198.96,1663.2
X$356 30572 30628 31321 31239 31334 gf180mcu_fd_sc_mcu9t5v0__nand2_1
* cell instance $357 m0 *1 1202.88,1673.28
X$357 30572 30523 31321 31388 31398 gf180mcu_fd_sc_mcu9t5v0__nand2_1
* cell instance $358 r0 *1 1201.76,1673.28
X$358 31388 31464 gf180mcu_fd_sc_mcu9t5v0__filltie
* cell instance $359 m0 *1 1207.92,1683.36
X$359 31534 31464 31529 31523 gf180mcu_fd_sc_mcu9t5v0__clkinv_1
* cell instance $360 m0 *1 1203.44,1683.36
X$360 30572 31523 31535 31464 31529 31524 gf180mcu_fd_sc_mcu9t5v0__aoi21_1
* cell instance $361 m0 *1 1230.32,1683.36
X$361 31135 31464 31529 31470 gf180mcu_fd_sc_mcu9t5v0__clkinv_1
* cell instance $362 r0 *1 1198.96,1683.36
X$362 31534 31046 31604 31529 31674 gf180mcu_fd_sc_mcu9t5v0__nand2_1
* cell instance $363 m0 *1 1202.88,1663.2
X$363 30922 30573 31268 13180 31125 31239 gf180mcu_fd_sc_mcu9t5v0__dffrnq_2
* cell instance $364 r0 *1 1207.36,1673.28
X$364 31523 30164 31399 31464 31388 31457 gf180mcu_fd_sc_mcu9t5v0__oai21_1
* cell instance $365 m0 *1 1184.4,1693.44
X$365 31926 18277 31620 29288 30975 30505 31604 31710 31691
+ gf180mcu_fd_sc_mcu9t5v0__aoi222_1
* cell instance $366 m0 *1 1211.28,1683.36
X$366 30922 31457 31534 13180 31464 31529 gf180mcu_fd_sc_mcu9t5v0__dffrnq_2
* cell instance $367 r0 *1 1188.88,1663.2
X$367 31248 31131 18277 31321 31239 31134 gf180mcu_fd_sc_mcu9t5v0__mux2_1
* cell instance $368 m0 *1 1188.32,1663.2
X$368 30433 31125 31239 31046 gf180mcu_fd_sc_mcu9t5v0__buf_8
* cell instance $369 m0 *1 1210.16,1673.28
X$369 29288 30301 31321 31388 31399 gf180mcu_fd_sc_mcu9t5v0__nand2_1
* cell instance $370 m0 *1 1239.84,1693.44
X$370 31347 30505 31604 31710 31715 gf180mcu_fd_sc_mcu9t5v0__nand2_1
* cell instance $371 m0 *1 1239.84,1713.6
X$371 31268 31032 31894 31972 31977 gf180mcu_fd_sc_mcu9t5v0__nand2_1
* cell instance $372 m0 *1 1239.84,1723.68
X$372 30657 31031 32037 32105 32110 gf180mcu_fd_sc_mcu9t5v0__nand2_1
* cell instance $373 r0 *1 1228.08,1713.6
X$373 31135 31046 32037 31972 32120 gf180mcu_fd_sc_mcu9t5v0__nand2_1
* cell instance $374 r0 *1 1201.76,1703.52
X$374 31827 31894 gf180mcu_fd_sc_mcu9t5v0__filltie
* cell instance $375 r0 *1 1230.88,1683.36
X$375 31554 31604 31529 31136 gf180mcu_fd_sc_mcu9t5v0__clkinv_1
* cell instance $376 r0 *1 1182.72,1683.36
X$376 31553 31456 28684 31604 31529 31620 gf180mcu_fd_sc_mcu9t5v0__mux2_1
* cell instance $377 m0 *1 1198.96,1703.52
X$377 31534 30505 31046 31769 31827 31775 gf180mcu_fd_sc_mcu9t5v0__nand3_1
* cell instance $378 r0 *1 1238.16,1673.28
X$378 31347 31464 31388 30165 gf180mcu_fd_sc_mcu9t5v0__clkinv_1
* cell instance $379 r0 *1 1223.04,1713.6
X$379 30657 30505 32037 31972 32046 gf180mcu_fd_sc_mcu9t5v0__nand2_1
* cell instance $380 r0 *1 1177.68,1713.6
X$380 30922 31988 30505 13180 32037 31972 gf180mcu_fd_sc_mcu9t5v0__dffrnq_2
* cell instance $381 m0 *1 1231.44,1723.68
X$381 31534 31060 32037 32105 32109 gf180mcu_fd_sc_mcu9t5v0__nand2_1
* cell instance $382 r0 *1 1201.76,1683.36
X$382 31529 31604 gf180mcu_fd_sc_mcu9t5v0__filltie
* cell instance $383 r0 *1 1233.12,1703.52
X$383 31534 31032 31894 31827 31906 gf180mcu_fd_sc_mcu9t5v0__nand2_1
* cell instance $384 m0 *1 1234.24,1723.68
X$384 31534 31031 32037 32105 32098 gf180mcu_fd_sc_mcu9t5v0__nand2_1
* cell instance $385 r0 *1 1201.76,1693.44
X$385 31710 31769 gf180mcu_fd_sc_mcu9t5v0__filltie
* cell instance $386 m0 *1 1196.72,1693.44
X$386 31674 31398 31604 31710 31692 gf180mcu_fd_sc_mcu9t5v0__and2_1
* cell instance $387 r0 *1 1201.76,1713.6
X$387 31972 32037 gf180mcu_fd_sc_mcu9t5v0__filltie
* cell instance $388 m0 *1 1201.2,1693.44
X$388 31674 31398 31604 31710 31693 gf180mcu_fd_sc_mcu9t5v0__or2_1
* cell instance $389 r0 *1 1202.88,1683.36
X$389 31621 31674 31604 31529 31535 gf180mcu_fd_sc_mcu9t5v0__nand2_1
* cell instance $390 r0 *1 1295.84,1723.68
X$390 31990 32051 32169 32105 32179 gf180mcu_fd_sc_mcu9t5v0__and2_1
* cell instance $391 r0 *1 1314.88,1723.68
X$391 31534 30901 31268 31473 32169 32105 32122 gf180mcu_fd_sc_mcu9t5v0__aoi22_1
* cell instance $392 r0 *1 1322.72,1723.68
X$392 32181 32122 32169 32105 31915 gf180mcu_fd_sc_mcu9t5v0__nor2_1
* cell instance $393 r0 *1 1309.84,1703.52
X$393 30657 31473 31894 31827 31889 gf180mcu_fd_sc_mcu9t5v0__nand2_1
* cell instance $394 m0 *1 1312.08,1733.76
X$394 30901 31473 32178 32169 32228 32224 gf180mcu_fd_sc_mcu9t5v0__aoi21_1
* cell instance $395 r0 *1 1340.64,1723.68
X$395 32052 32235 32169 32105 32125 gf180mcu_fd_sc_mcu9t5v0__xnor2_1
* cell instance $396 r0 *1 1332.24,1723.68
X$396 32224 32169 32105 32225 gf180mcu_fd_sc_mcu9t5v0__clkinv_1
* cell instance $397 r0 *1 1334.48,1723.68
X$397 32181 32123 32124 32169 32105 32182 gf180mcu_fd_sc_mcu9t5v0__aoi21_1
* cell instance $398 r0 *1 1309.84,1723.68
X$398 31534 30901 31268 31473 32169 32105 32180 gf180mcu_fd_sc_mcu9t5v0__nand4_1
* cell instance $399 r0 *1 1274,1723.68
X$399 32176 32048 32169 32105 32121 gf180mcu_fd_sc_mcu9t5v0__or2_1
* cell instance $400 r0 *1 1251.04,1723.68
X$400 32103 31909 32169 32105 32175 gf180mcu_fd_sc_mcu9t5v0__nand2_1
* cell instance $401 r0 *1 1244.88,1723.68
X$401 32110 31977 32169 32105 32173 gf180mcu_fd_sc_mcu9t5v0__and2_1
* cell instance $402 r0 *1 1293.04,1723.68
X$402 30657 31060 32169 32105 32100 gf180mcu_fd_sc_mcu9t5v0__nand2_1
* cell instance $403 m0 *1 1312.08,1673.28
X$403 30901 30657 31321 31388 31350 gf180mcu_fd_sc_mcu9t5v0__nand2_1
* cell instance $404 m0 *1 1309.28,1663.2
X$404 31349 31137 31125 31239 31197 gf180mcu_fd_sc_mcu9t5v0__nor2_1
* cell instance $405 r0 *1 1307.04,1673.28
X$405 31195 31464 31388 31473 gf180mcu_fd_sc_mcu9t5v0__buf_8
* cell instance $406 r0 *1 1347.92,1733.76
X$406 32238 32125 32237 32299 32228 32305 gf180mcu_fd_sc_mcu9t5v0__oai21_1
* cell instance $407 r0 *1 1323.84,1743.84
X$407 32360 32364 32352 32351 32236 gf180mcu_fd_sc_mcu9t5v0__xnor2_1
* cell instance $408 m0 *1 1321.6,1784.16
X$408 32709 32663 gf180mcu_fd_sc_mcu9t5v0__filltie
* cell instance $409 m0 *1 1354.64,1743.84
X$409 32305 32304 32299 32351 32256 gf180mcu_fd_sc_mcu9t5v0__xnor2_1
* cell instance $410 r0 *1 1318.24,1743.84
X$410 32361 32362 32352 32351 32363 gf180mcu_fd_sc_mcu9t5v0__nand2_1
* cell instance $411 m0 *1 1319.36,1733.76
X$411 32180 32169 32228 32181 gf180mcu_fd_sc_mcu9t5v0__clkinv_1
* cell instance $412 m0 *1 1321.6,1794.24
X$412 32804 32753 gf180mcu_fd_sc_mcu9t5v0__filltie
* cell instance $413 r0 *1 1357.44,1733.76
X$413 32182 32256 32255 32299 32228 32226 gf180mcu_fd_sc_mcu9t5v0__oai21_1
* cell instance $414 m0 *1 1321.6,1733.76
X$414 32228 32169 gf180mcu_fd_sc_mcu9t5v0__filltie
* cell instance $415 m0 *1 1330.56,1733.76
X$415 32181 32224 32169 32228 32183 32179 gf180mcu_fd_sc_mcu9t5v0__xnor3_1
* cell instance $416 m0 *1 1321.6,1774.08
X$416 32661 32561 gf180mcu_fd_sc_mcu9t5v0__filltie
* cell instance $417 m0 *1 1348.48,1733.76
X$417 32183 32125 32169 32228 31993 gf180mcu_fd_sc_mcu9t5v0__xnor2_1
* cell instance $418 m0 *1 1363.04,1733.76
X$418 32226 32169 32228 32227 gf180mcu_fd_sc_mcu9t5v0__clkinv_1
* cell instance $419 r0 *1 1361.92,1733.76
X$419 32182 32256 32299 32228 31994 gf180mcu_fd_sc_mcu9t5v0__xnor2_1
* cell instance $420 m0 *1 1321.6,1743.84
X$420 32351 32299 gf180mcu_fd_sc_mcu9t5v0__filltie
* cell instance $421 r0 *1 1316.56,1764
X$421 32571 32561 32560 32522 gf180mcu_fd_sc_mcu9t5v0__clkinv_1
* cell instance $422 m0 *1 1327.76,1733.76
X$422 32179 32225 32169 32228 32123 gf180mcu_fd_sc_mcu9t5v0__nand2_1
* cell instance $423 r0 *1 1333.92,1733.76
X$423 32179 32225 32299 32228 32124 gf180mcu_fd_sc_mcu9t5v0__nor2_1
* cell instance $424 r0 *1 1354.64,1733.76
X$424 32305 32304 32299 32228 32255 gf180mcu_fd_sc_mcu9t5v0__nand2_1
* cell instance $425 m0 *1 1346.24,1733.76
X$425 32183 32169 32228 32238 gf180mcu_fd_sc_mcu9t5v0__clkinv_1
* cell instance $426 m0 *1 1343.44,1733.76
X$426 32052 32235 32169 32228 32237 gf180mcu_fd_sc_mcu9t5v0__nand2_1
* cell instance $427 m0 *1 1372,1733.76
X$427 32227 32236 32169 32228 31558 gf180mcu_fd_sc_mcu9t5v0__nor2_1
* cell instance $428 m0 *1 1364.16,1753.92
X$428 32415 32416 32352 32453 31708 gf180mcu_fd_sc_mcu9t5v0__xnor2_1
* cell instance $429 m0 *1 1345.68,1753.92
X$429 32476 32472 32352 32453 30187 gf180mcu_fd_sc_mcu9t5v0__nor2_1
* cell instance $430 m0 *1 1365.28,1733.76
X$430 32226 32169 32228 32236 31527 gf180mcu_fd_sc_mcu9t5v0__xor2_1
* cell instance $431 r0 *1 1368.08,1743.84
X$431 32415 32365 32352 32351 31559 gf180mcu_fd_sc_mcu9t5v0__nand2_1
* cell instance $432 r0 *1 1342.88,1753.92
X$432 32475 32459 32453 32472 31560 gf180mcu_fd_sc_mcu9t5v0__xor2_1
* cell instance $433 r0 *1 1340.64,1753.92
X$433 32475 32459 32453 32476 gf180mcu_fd_sc_mcu9t5v0__clkinv_1
* cell instance $434 m0 *1 1312.64,1753.92
X$434 32473 32352 32453 32362 gf180mcu_fd_sc_mcu9t5v0__clkinv_1
* cell instance $435 m0 *1 1322.72,1753.92
X$435 32360 32364 32363 32352 32453 32415 gf180mcu_fd_sc_mcu9t5v0__oai21_1
* cell instance $436 m0 *1 1321.6,1753.92
X$436 32453 32352 gf180mcu_fd_sc_mcu9t5v0__filltie
* cell instance $437 m0 *1 1314.88,1753.92
X$437 32361 32352 32453 32473 32364 gf180mcu_fd_sc_mcu9t5v0__xor2_1
* cell instance $438 m0 *1 1321.6,1764
X$438 32560 32459 gf180mcu_fd_sc_mcu9t5v0__filltie
* cell instance $439 m0 *1 1361.92,1753.92
X$439 32416 32352 32453 32365 gf180mcu_fd_sc_mcu9t5v0__clkinv_1
* cell instance $440 m0 *1 1322.72,1764
X$440 32521 32522 32459 32560 32474 gf180mcu_fd_sc_mcu9t5v0__xnor2_1
* cell instance $441 m0 *1 1318.8,1764
X$441 32521 32522 32459 32560 32523 gf180mcu_fd_sc_mcu9t5v0__nand2_1
* cell instance $442 r0 *1 1328.88,1753.92
X$442 32471 32474 32459 32453 32416 gf180mcu_fd_sc_mcu9t5v0__xnor2_1
* cell instance $443 r0 *1 1324.4,1753.92
X$443 32471 32474 32523 32459 32453 32475 gf180mcu_fd_sc_mcu9t5v0__oai21_1
* cell instance $444 r0 *1 1281.28,1764
X$444 32570 32519 32561 32560 32571 gf180mcu_fd_sc_mcu9t5v0__xnor2_1
* cell instance $445 m0 *1 1254.96,1733.76
X$445 32174 32252 32175 32169 32228 32253 gf180mcu_fd_sc_mcu9t5v0__oai21_1
* cell instance $446 m0 *1 1295.84,1764
X$446 32569 32347 32459 32560 32470 gf180mcu_fd_sc_mcu9t5v0__xnor2_1
* cell instance $447 m0 *1 1297.52,1774.08
X$447 32574 32622 32561 32661 32623 gf180mcu_fd_sc_mcu9t5v0__nor2_1
* cell instance $448 r0 *1 1294.16,1764
X$448 32569 32466 32561 32560 32574 gf180mcu_fd_sc_mcu9t5v0__nand2_1
* cell instance $449 m0 *1 1251.6,1794.24
X$449 32759 32753 32804 32761 gf180mcu_fd_sc_mcu9t5v0__clkinv_1
* cell instance $450 m0 *1 1251.6,1743.84
X$450 31979 32104 32173 32109 32299 32351 32347 gf180mcu_fd_sc_mcu9t5v0__oai22_1
* cell instance $451 m0 *1 1300.88,1774.08
X$451 32573 32623 32561 32661 32624 gf180mcu_fd_sc_mcu9t5v0__nor2_1
* cell instance $452 m0 *1 1260.56,1774.08
X$452 32569 32410 32561 32661 32665 gf180mcu_fd_sc_mcu9t5v0__xnor2_1
* cell instance $453 r0 *1 1290.8,1764
X$453 32572 32621 32561 32560 32573 gf180mcu_fd_sc_mcu9t5v0__nor2_1
* cell instance $454 r0 *1 1246.56,1784.16
X$454 32761 32758 32755 32753 32709 30110 gf180mcu_fd_sc_mcu9t5v0__oai21_1
* cell instance $455 m0 *1 1268.96,1733.76
X$455 32047 31979 32169 32228 32234 gf180mcu_fd_sc_mcu9t5v0__nor2_1
* cell instance $456 r0 *1 1274.56,1733.76
X$456 32234 32176 32299 32228 32254 gf180mcu_fd_sc_mcu9t5v0__nor2_1
* cell instance $457 r0 *1 1294.16,1743.84
X$457 32178 32254 32352 32351 32359 gf180mcu_fd_sc_mcu9t5v0__nand2_1
* cell instance $458 r0 *1 1296.96,1743.84
X$458 32178 32254 32352 32351 32360 gf180mcu_fd_sc_mcu9t5v0__or2_1
* cell instance $459 m0 *1 1275.68,1733.76
X$459 32121 31911 31910 32169 32228 32177 gf180mcu_fd_sc_mcu9t5v0__oai21_1
* cell instance $460 r0 *1 1258.32,1764
X$460 32178 32410 32561 32560 32566 gf180mcu_fd_sc_mcu9t5v0__or2_1
* cell instance $461 m0 *1 1243.76,1784.16
X$461 32716 32666 32663 32709 32715 gf180mcu_fd_sc_mcu9t5v0__nor2_1
* cell instance $462 m0 *1 1244.88,1794.24
X$462 32716 32666 32753 32804 32760 gf180mcu_fd_sc_mcu9t5v0__nand2_1
* cell instance $463 r0 *1 1255.52,1764
X$463 32568 32566 32561 32560 32619 gf180mcu_fd_sc_mcu9t5v0__nand2_1
* cell instance $464 r0 *1 1254.96,1753.92
X$464 32411 32456 32459 32453 32468 gf180mcu_fd_sc_mcu9t5v0__xnor2_1
* cell instance $465 m0 *1 1303.12,1743.84
X$465 32350 32299 32351 32349 32304 gf180mcu_fd_sc_mcu9t5v0__xor2_1
* cell instance $466 m0 *1 1289.12,1774.08
X$466 32572 32621 32561 32661 32622 gf180mcu_fd_sc_mcu9t5v0__xnor2_1
* cell instance $467 m0 *1 1269.52,1774.08
X$467 32178 32561 32661 32569 gf180mcu_fd_sc_mcu9t5v0__clkinv_1
* cell instance $468 m0 *1 1250.48,1774.08
X$468 32619 32620 32561 32661 32621 gf180mcu_fd_sc_mcu9t5v0__xnor2_1
* cell instance $469 r0 *1 1306.48,1743.84
X$469 32359 32360 32352 32351 32350 gf180mcu_fd_sc_mcu9t5v0__nand2_1
* cell instance $470 r0 *1 1248.8,1733.76
X$470 32103 31909 32299 32228 32252 gf180mcu_fd_sc_mcu9t5v0__xnor2_1
* cell instance $471 m0 *1 1302.56,1764
X$471 32569 32347 32459 32560 32471 gf180mcu_fd_sc_mcu9t5v0__nand2_1
* cell instance $472 r0 *1 1256.08,1733.76
X$472 32174 32299 32228 32252 32303 gf180mcu_fd_sc_mcu9t5v0__xor2_1
* cell instance $473 m0 *1 1287.44,1743.84
X$473 32177 32303 32299 32351 32349 gf180mcu_fd_sc_mcu9t5v0__xnor2_1
* cell instance $474 m0 *1 1261.12,1753.92
X$474 31928 32233 32352 32453 32412 gf180mcu_fd_sc_mcu9t5v0__xnor2_1
* cell instance $475 m0 *1 1244.32,1753.92
X$475 32109 32352 32453 32411 gf180mcu_fd_sc_mcu9t5v0__clkinv_1
* cell instance $476 m0 *1 1258.32,1753.92
X$476 31928 32233 32352 32453 32457 gf180mcu_fd_sc_mcu9t5v0__nand2_1
* cell instance $477 m0 *1 1249.92,1753.92
X$477 32104 32352 32453 31906 32456 gf180mcu_fd_sc_mcu9t5v0__xor2_1
* cell instance $478 m0 *1 1269.52,1753.92
X$478 32412 32468 32352 32453 32413 gf180mcu_fd_sc_mcu9t5v0__xnor2_1
* cell instance $479 m0 *1 1276.24,1753.92
X$479 32253 32352 32453 32413 32414 gf180mcu_fd_sc_mcu9t5v0__xor2_1
* cell instance $480 m0 *1 1282.96,1753.92
X$480 32358 32413 32352 32453 32458 gf180mcu_fd_sc_mcu9t5v0__or2_1
* cell instance $481 m0 *1 1284.64,1743.84
X$481 32177 32303 32299 32351 32348 gf180mcu_fd_sc_mcu9t5v0__nand2_1
* cell instance $482 m0 *1 1280.16,1733.76
X$482 32121 32169 32228 31911 32235 gf180mcu_fd_sc_mcu9t5v0__xor2_1
* cell instance $483 r0 *1 1298.64,1753.92
X$483 32414 32470 32458 32459 32453 32521 gf180mcu_fd_sc_mcu9t5v0__oai21_1
* cell instance $484 r0 *1 1303.12,1753.92
X$484 32414 32470 32459 32453 32473 gf180mcu_fd_sc_mcu9t5v0__xnor2_1
* cell instance $485 r0 *1 1300.32,1764
X$485 32574 32622 32561 32560 32472 gf180mcu_fd_sc_mcu9t5v0__xnor2_1
* cell instance $486 r0 *1 1251.04,1784.16
X$486 32759 32753 32709 32758 30102 gf180mcu_fd_sc_mcu9t5v0__xor2_1
* cell instance $487 r0 *1 1276.24,1743.84
X$487 32253 32352 32351 32358 gf180mcu_fd_sc_mcu9t5v0__clkinv_1
* cell instance $488 r0 *1 1302,1743.84
X$488 32350 32349 32348 32352 32351 32361 gf180mcu_fd_sc_mcu9t5v0__oai21_1
* cell instance $489 r0 *1 1268.4,1753.92
X$489 32412 32468 32457 32459 32453 32469 gf180mcu_fd_sc_mcu9t5v0__oai21_1
* cell instance $490 m0 *1 1307.6,1733.76
X$490 30901 31473 31534 32169 32228 32178 gf180mcu_fd_sc_mcu9t5v0__oai21_1
* cell instance $491 m0 *1 1253.84,1764
X$491 32411 32456 32459 32560 32467 gf180mcu_fd_sc_mcu9t5v0__nand2_1
* cell instance $492 r0 *1 1250.48,1753.92
X$492 32104 31906 32467 32459 32453 32466 gf180mcu_fd_sc_mcu9t5v0__oai21_1
* cell instance $493 r0 *1 1274.56,1764
X$493 32569 32466 32561 32560 32570 gf180mcu_fd_sc_mcu9t5v0__xnor2_1
* cell instance $494 m0 *1 1274.56,1764
X$494 32469 32465 32459 32560 32519 gf180mcu_fd_sc_mcu9t5v0__xnor2_1
* cell instance $495 m0 *1 1281.28,1764
X$495 32570 32519 32459 32560 32520 gf180mcu_fd_sc_mcu9t5v0__nor2_1
* cell instance $496 m0 *1 1277.36,1774.08
X$496 32469 32465 32520 32561 32661 32572 gf180mcu_fd_sc_mcu9t5v0__aoi21_1
* cell instance $497 m0 *1 1257.76,1774.08
X$497 32178 32410 32561 32661 32568 gf180mcu_fd_sc_mcu9t5v0__nand2_1
* cell instance $498 m0 *1 1276.24,1673.28
X$498 31347 31060 31321 31388 31458 gf180mcu_fd_sc_mcu9t5v0__nand2_1
* cell instance $499 m0 *1 1258.88,1673.28
X$499 31138 31032 31031 30531 31321 31388 31345 gf180mcu_fd_sc_mcu9t5v0__aoi22_1
* cell instance $500 m0 *1 1246.56,1673.28
X$500 31138 31046 31321 31388 31401 gf180mcu_fd_sc_mcu9t5v0__nand2_1
* cell instance $501 m0 *1 1262.24,1663.2
X$501 31138 31195 31125 31239 31113 gf180mcu_fd_sc_mcu9t5v0__nand2_1
* cell instance $502 r0 *1 1271.2,1673.28
X$502 31458 31402 31345 31464 31388 31471 gf180mcu_fd_sc_mcu9t5v0__nor3_1
* cell instance $503 r0 *1 1290.8,1663.2
X$503 30531 30505 31321 31239 31336 gf180mcu_fd_sc_mcu9t5v0__nand2_1
* cell instance $504 r0 *1 1303.68,1713.6
X$504 31991 32037 31972 31992 31932 gf180mcu_fd_sc_mcu9t5v0__xor2_1
* cell instance $505 r0 *1 1246.56,1663.2
X$505 31138 31321 31239 31269 gf180mcu_fd_sc_mcu9t5v0__inv_1
* cell instance $506 m0 *1 1285.76,1673.28
X$506 31348 30978 31321 31388 31403 gf180mcu_fd_sc_mcu9t5v0__and2_1
* cell instance $507 r0 *1 1263.36,1663.2
X$507 31138 31031 31321 31239 31335 gf180mcu_fd_sc_mcu9t5v0__nand2_1
* cell instance $508 r0 *1 1248.8,1663.2
X$508 31194 31321 31239 31138 gf180mcu_fd_sc_mcu9t5v0__buf_8
* cell instance $509 r0 *1 1291.92,1673.28
X$509 31348 30978 31464 31388 31404 gf180mcu_fd_sc_mcu9t5v0__or2_1
* cell instance $510 m0 *1 1302,1683.36
X$510 30303 31405 31464 31529 31536 gf180mcu_fd_sc_mcu9t5v0__nand2_1
* cell instance $511 r0 *1 1296.4,1673.28
X$511 31336 31403 31404 31464 31388 31472 gf180mcu_fd_sc_mcu9t5v0__oai21_1
* cell instance $512 r0 *1 1296.96,1703.52
X$512 31472 31777 31894 31827 31991 gf180mcu_fd_sc_mcu9t5v0__xnor2_1
* cell instance $513 m0 *1 1294.72,1723.68
X$513 32100 32037 32105 32050 31992 gf180mcu_fd_sc_mcu9t5v0__xor2_1
* cell instance $514 r0 *1 1282.96,1713.6
X$514 31347 31031 32037 31972 32049 gf180mcu_fd_sc_mcu9t5v0__nand2_1
* cell instance $515 r0 *1 1262.24,1683.36
X$515 30572 30435 31604 31529 31624 gf180mcu_fd_sc_mcu9t5v0__nand2_1
* cell instance $516 r0 *1 1286.32,1693.44
X$516 31701 31699 31769 31710 31778 31335 gf180mcu_fd_sc_mcu9t5v0__xnor3_1
* cell instance $517 r0 *1 1248.8,1683.36
X$517 30572 30524 31604 31529 31694 gf180mcu_fd_sc_mcu9t5v0__nand2_1
* cell instance $518 m0 *1 1306.48,1673.28
X$518 31135 31195 31321 31388 31349 gf180mcu_fd_sc_mcu9t5v0__nand2_2
* cell instance $519 m0 *1 1290.24,1673.28
X$519 31336 30978 31321 31388 31405 31348 gf180mcu_fd_sc_mcu9t5v0__xnor3_1
* cell instance $520 r0 *1 1244.88,1683.36
X$520 31347 30505 31622 31604 31529 31623 gf180mcu_fd_sc_mcu9t5v0__nand3_1
* cell instance $521 r0 *1 1298.08,1683.36
X$521 30303 31405 31604 31529 31555 gf180mcu_fd_sc_mcu9t5v0__xnor2_1
* cell instance $522 r0 *1 1299.2,1713.6
X$522 31992 31991 31912 32037 31972 32052 gf180mcu_fd_sc_mcu9t5v0__oai21_1
* cell instance $523 m0 *1 1285.76,1713.6
X$523 31135 31032 31894 31972 31980 gf180mcu_fd_sc_mcu9t5v0__nand2_1
* cell instance $524 m0 *1 1288,1723.68
X$524 32049 32037 32105 31980 32050 gf180mcu_fd_sc_mcu9t5v0__xor2_1
* cell instance $525 m0 *1 1245.44,1713.6
X$525 31400 31894 31972 31907 31908 gf180mcu_fd_sc_mcu9t5v0__xor2_1
* cell instance $526 r0 *1 1294.16,1703.52
X$526 31472 31777 31894 31827 31912 gf180mcu_fd_sc_mcu9t5v0__nand2_1
* cell instance $527 m0 *1 1304.8,1693.44
X$527 31778 31555 31536 31604 31710 31888 gf180mcu_fd_sc_mcu9t5v0__oai21_1
* cell instance $528 m0 *1 1288.56,1693.44
X$528 31701 31700 31702 31604 31710 31716 gf180mcu_fd_sc_mcu9t5v0__aoi21_1
* cell instance $529 r0 *1 1243.76,1703.52
X$529 31347 31046 31894 31827 31907 gf180mcu_fd_sc_mcu9t5v0__nand2_1
* cell instance $530 r0 *1 1249.36,1713.6
X$530 31135 30505 31908 32037 31972 31929 gf180mcu_fd_sc_mcu9t5v0__nand3_1
* cell instance $531 m0 *1 1253.28,1723.68
X$531 31268 31031 32037 32105 32104 gf180mcu_fd_sc_mcu9t5v0__nand2_1
* cell instance $532 r0 *1 1289.12,1713.6
X$532 32049 31980 32037 31972 31990 gf180mcu_fd_sc_mcu9t5v0__or2_1
* cell instance $533 r0 *1 1304.8,1683.36
X$533 31778 31555 31604 31529 31526 gf180mcu_fd_sc_mcu9t5v0__xnor2_1
* cell instance $534 r0 *1 1267.28,1713.6
X$534 31135 31031 32037 31972 32047 gf180mcu_fd_sc_mcu9t5v0__nand2_1
* cell instance $535 m0 *1 1265.6,1713.6
X$535 30657 31032 31894 31972 31979 gf180mcu_fd_sc_mcu9t5v0__nand2_1
* cell instance $536 r0 *1 1262.24,1693.44
X$536 31766 31695 31769 31710 31777 31624 gf180mcu_fd_sc_mcu9t5v0__xnor3_1
* cell instance $537 m0 *1 1266.16,1723.68
X$537 32047 32037 32105 31979 32099 gf180mcu_fd_sc_mcu9t5v0__xor2_1
* cell instance $538 m0 *1 1272.88,1723.68
X$538 31268 31060 32099 32037 32105 32176 gf180mcu_fd_sc_mcu9t5v0__and3_1
* cell instance $539 r0 *1 1270.08,1713.6
X$539 31268 31060 32099 32037 31972 32048 gf180mcu_fd_sc_mcu9t5v0__aoi21_1
* cell instance $540 m0 *1 1260,1693.44
X$540 31624 31695 31604 31710 31696 gf180mcu_fd_sc_mcu9t5v0__and2_1
* cell instance $541 m0 *1 1264.48,1693.44
X$541 31624 31695 31604 31710 31697 gf180mcu_fd_sc_mcu9t5v0__or2_1
* cell instance $542 m0 *1 1265.6,1703.52
X$542 31766 31696 31697 31769 31827 31825 gf180mcu_fd_sc_mcu9t5v0__oai21_1
* cell instance $543 r0 *1 1293.6,1713.6
X$543 30657 31060 32050 32037 31972 32051 gf180mcu_fd_sc_mcu9t5v0__nand3_1
* cell instance $544 r0 *1 1243.76,1693.44
X$544 31715 31622 31769 31710 31887 gf180mcu_fd_sc_mcu9t5v0__xnor2_1
* cell instance $545 r0 *1 1270.08,1703.52
X$545 31825 31887 31894 31827 31911 gf180mcu_fd_sc_mcu9t5v0__xnor2_1
* cell instance $546 r0 *1 1267.28,1703.52
X$546 31825 31887 31894 31827 31910 gf180mcu_fd_sc_mcu9t5v0__nand2_1
* cell instance $547 m0 *1 1252.16,1713.6
X$547 31400 31907 31929 31894 31972 31928 gf180mcu_fd_sc_mcu9t5v0__oai21_1
* cell instance $548 r0 *1 1281.84,1693.44
X$548 31135 31060 31769 31710 31701 gf180mcu_fd_sc_mcu9t5v0__and2_1
* cell instance $549 m0 *1 1285.2,1703.52
X$549 31347 31032 31769 31827 31699 gf180mcu_fd_sc_mcu9t5v0__nand2_1
* cell instance $550 r0 *1 1246.56,1703.52
X$550 31978 31908 31894 31827 31909 gf180mcu_fd_sc_mcu9t5v0__xnor2_1
* cell instance $551 m0 *1 1249.36,1693.44
X$551 31694 31401 31623 31604 31710 32103 gf180mcu_fd_sc_mcu9t5v0__oai21_1
* cell instance $552 m0 *1 1285.76,1693.44
X$552 31335 31699 31604 31710 31700 gf180mcu_fd_sc_mcu9t5v0__nand2_1
* cell instance $553 m0 *1 1288,1703.52
X$553 31335 31699 31769 31827 31702 gf180mcu_fd_sc_mcu9t5v0__nor2_1
* cell instance $554 r0 *1 1294.16,1663.2
X$554 30901 31135 31347 31195 31321 31239 31196 gf180mcu_fd_sc_mcu9t5v0__aoi22_1
* cell instance $555 m0 *1 1274.56,1683.36
X$555 31402 31471 31464 31529 31698 gf180mcu_fd_sc_mcu9t5v0__nor2_1
* cell instance $556 m0 *1 1256.08,1673.28
X$556 31138 30505 31321 31388 31766 gf180mcu_fd_sc_mcu9t5v0__nand2_1
* cell instance $557 m0 *1 1270.08,1673.28
X$557 30531 31046 31321 31388 31695 gf180mcu_fd_sc_mcu9t5v0__nand2_1
* cell instance $558 m0 *1 1272.88,1673.28
X$558 31402 31345 31321 31388 31346 gf180mcu_fd_sc_mcu9t5v0__nor2_1
* cell instance $559 r0 *1 1275.68,1673.28
X$559 31458 31346 31464 31388 30528 gf180mcu_fd_sc_mcu9t5v0__xnor2_1
* cell instance $560 m0 *1 1263.92,1673.28
X$560 31138 30531 31032 31031 31321 31388 31402 gf180mcu_fd_sc_mcu9t5v0__and4_1
* cell instance $561 m0 *1 1243.76,1673.28
X$561 30572 31269 31321 31388 31400 gf180mcu_fd_sc_mcu9t5v0__nand2_1
* cell instance $562 r0 *1 1335.04,1673.28
X$562 30508 31526 31464 31388 31556 31115 gf180mcu_fd_sc_mcu9t5v0__xor3_1
* cell instance $563 m0 *1 1332.24,1663.2
X$563 31197 31139 31125 31239 31198 gf180mcu_fd_sc_mcu9t5v0__nand2_1
* cell instance $564 m0 *1 1335.04,1663.2
X$564 30977 31114 31198 31125 31239 31034 gf180mcu_fd_sc_mcu9t5v0__oai21_1
* cell instance $565 m0 *1 1337.84,1683.36
X$565 30508 31526 31464 31529 31474 gf180mcu_fd_sc_mcu9t5v0__nor2_1
* cell instance $566 m0 *1 1317.12,1683.36
X$566 30572 31406 31459 31464 31529 31525 gf180mcu_fd_sc_mcu9t5v0__aoi21_1
* cell instance $567 m0 *1 1354.08,1663.2
X$567 31141 31249 31125 31239 31199 gf180mcu_fd_sc_mcu9t5v0__or2_1
* cell instance $568 m0 *1 1321.6,1723.68
X$568 32105 32037 gf180mcu_fd_sc_mcu9t5v0__filltie
* cell instance $569 r0 *1 1360.8,1683.36
X$569 31677 31557 31604 31529 31270 gf180mcu_fd_sc_mcu9t5v0__nor2_1
* cell instance $570 m0 *1 1375.36,1713.6
X$570 31917 31982 31894 31972 31475 gf180mcu_fd_sc_mcu9t5v0__nand2_1
* cell instance $571 m0 *1 1361.36,1663.2
X$571 31049 31199 31201 31125 31239 31200 gf180mcu_fd_sc_mcu9t5v0__aoi21_1
* cell instance $572 m0 *1 1366.96,1663.2
X$572 31201 31199 31049 31125 31239 31250 gf180mcu_fd_sc_mcu9t5v0__and3_1
* cell instance $573 m0 *1 1331.68,1713.6
X$573 31836 31894 31972 31930 31931 gf180mcu_fd_sc_mcu9t5v0__xor2_1
* cell instance $574 m0 *1 1365.28,1683.36
X$574 31351 31475 31527 31464 31529 31528 gf180mcu_fd_sc_mcu9t5v0__aoi21_2
* cell instance $575 r0 *1 1347.36,1683.36
X$575 31626 31627 31604 31529 31249 gf180mcu_fd_sc_mcu9t5v0__xnor2_1
* cell instance $576 m0 *1 1370.32,1693.44
X$576 31559 31678 31604 31710 31826 gf180mcu_fd_sc_mcu9t5v0__nand2_1
* cell instance $577 r0 *1 1370.32,1663.2
X$577 31200 31250 31321 31239 27386 gf180mcu_fd_sc_mcu9t5v0__nor2_1
* cell instance $578 r0 *1 1370.88,1683.36
X$578 31558 31528 31708 31604 31529 31628 gf180mcu_fd_sc_mcu9t5v0__or3_1
* cell instance $579 r0 *1 1370.32,1673.28
X$579 31475 31351 31527 31464 31388 31476 gf180mcu_fd_sc_mcu9t5v0__and3_1
* cell instance $580 r0 *1 1375.92,1693.44
X$580 31678 31628 31769 31710 30778 gf180mcu_fd_sc_mcu9t5v0__nand2_1
* cell instance $581 m0 *1 1343.44,1713.6
X$581 31888 31932 31894 31972 31934 gf180mcu_fd_sc_mcu9t5v0__nor2_1
* cell instance $582 m0 *1 1374.8,1683.36
X$582 31528 31476 31464 31529 31460 gf180mcu_fd_sc_mcu9t5v0__nor2_1
* cell instance $583 r0 *1 1366.96,1663.2
X$583 31270 31200 31321 31239 31337 gf180mcu_fd_sc_mcu9t5v0__nor2_1
* cell instance $584 m0 *1 1368.64,1713.6
X$584 31917 31994 31894 31972 31271 gf180mcu_fd_sc_mcu9t5v0__xnor2_1
* cell instance $585 r0 *1 1369.76,1713.6
X$585 31994 32037 31972 31982 gf180mcu_fd_sc_mcu9t5v0__clkinv_1
* cell instance $586 m0 *1 1340.64,1713.6
X$586 31888 31932 31894 31972 31933 gf180mcu_fd_sc_mcu9t5v0__nand2_1
* cell instance $587 m0 *1 1346.8,1713.6
X$587 31981 31934 31933 31894 31972 31935 gf180mcu_fd_sc_mcu9t5v0__oai21_1
* cell instance $588 r0 *1 1327.76,1713.6
X$588 31716 32037 31972 31914 gf180mcu_fd_sc_mcu9t5v0__clkinv_1
* cell instance $589 r0 *1 1346.24,1713.6
X$589 31931 32037 31972 31981 gf180mcu_fd_sc_mcu9t5v0__clkinv_1
* cell instance $590 r0 *1 1312.64,1703.52
X$590 30901 31268 31894 31827 31913 gf180mcu_fd_sc_mcu9t5v0__nand2_1
* cell instance $591 m0 *1 1359.12,1693.44
X$591 31677 31557 31604 31710 31201 gf180mcu_fd_sc_mcu9t5v0__xnor2_1
* cell instance $592 r0 *1 1328.88,1703.52
X$592 31914 31915 31891 31894 31827 31890 gf180mcu_fd_sc_mcu9t5v0__aoi21_1
* cell instance $593 m0 *1 1324.96,1713.6
X$593 31716 31894 31972 31915 31930 gf180mcu_fd_sc_mcu9t5v0__xor2_1
* cell instance $594 r0 *1 1359.68,1713.6
X$594 31935 31993 32037 31972 31892 gf180mcu_fd_sc_mcu9t5v0__nor2_1
* cell instance $595 m0 *1 1355.2,1713.6
X$595 31935 31890 31894 31972 31916 31993 gf180mcu_fd_sc_mcu9t5v0__xnor3_1
* cell instance $596 r0 *1 1325.52,1683.36
X$596 31525 31604 31529 31625 31556 gf180mcu_fd_sc_mcu9t5v0__xor2_1
* cell instance $597 r0 *1 1330,1713.6
X$597 31836 31930 32037 31972 31891 gf180mcu_fd_sc_mcu9t5v0__nor2_1
* cell instance $598 r0 *1 1315.44,1703.52
X$598 31889 31894 31827 31913 31835 gf180mcu_fd_sc_mcu9t5v0__xor2_1
* cell instance $599 m0 *1 1319.36,1703.52
X$599 31835 31769 31827 31675 gf180mcu_fd_sc_mcu9t5v0__clkinv_1
* cell instance $600 r0 *1 1339.52,1703.52
X$600 31888 31931 31894 31827 31705 31932 gf180mcu_fd_sc_mcu9t5v0__xnor3_1
* cell instance $601 m0 *1 1342.32,1693.44
X$601 31676 31705 31604 31710 31706 gf180mcu_fd_sc_mcu9t5v0__nor2_1
* cell instance $602 m0 *1 1321.6,1703.52
X$602 31827 31769 gf180mcu_fd_sc_mcu9t5v0__filltie
* cell instance $603 m0 *1 1318.24,1693.44
X$603 31698 31675 31604 31710 31703 gf180mcu_fd_sc_mcu9t5v0__nor2_1
* cell instance $604 m0 *1 1321.6,1693.44
X$604 31710 31604 gf180mcu_fd_sc_mcu9t5v0__filltie
* cell instance $605 r0 *1 1324.96,1693.44
X$605 31525 31625 31769 31710 31704 gf180mcu_fd_sc_mcu9t5v0__nor2_1
* cell instance $606 r0 *1 1363.04,1713.6
X$606 31935 31993 32037 31972 31918 gf180mcu_fd_sc_mcu9t5v0__nand2_1
* cell instance $607 m0 *1 1329.44,1693.44
X$607 31703 31704 31604 31710 31626 gf180mcu_fd_sc_mcu9t5v0__nor2_1
* cell instance $608 m0 *1 1345.68,1693.44
X$608 31676 31705 31604 31710 31627 gf180mcu_fd_sc_mcu9t5v0__xnor2_1
* cell instance $609 m0 *1 1312.64,1663.2
X$609 31197 31196 31125 31239 30983 gf180mcu_fd_sc_mcu9t5v0__nor2_1
* cell instance $610 r0 *1 1363.04,1703.52
X$610 31890 31892 31918 31894 31827 31917 gf180mcu_fd_sc_mcu9t5v0__oai21_1
* cell instance $611 r0 *1 1348.48,1693.44
X$611 31626 31627 31769 31710 31707 gf180mcu_fd_sc_mcu9t5v0__nor2_1
* cell instance $612 m0 *1 1321.6,1683.36
X$612 31529 31464 gf180mcu_fd_sc_mcu9t5v0__filltie
* cell instance $613 m0 *1 1352.4,1693.44
X$613 31706 31707 31604 31710 31677 gf180mcu_fd_sc_mcu9t5v0__nor2_1
* cell instance $614 r0 *1 1339.52,1683.36
X$614 31556 31537 31474 31604 31529 31676 gf180mcu_fd_sc_mcu9t5v0__aoi21_1
* cell instance $615 r0 *1 1360.8,1703.52
X$615 31916 31894 31827 31557 gf180mcu_fd_sc_mcu9t5v0__clkinv_1
* cell instance $616 m0 *1 1321.6,1713.6
X$616 31972 31894 gf180mcu_fd_sc_mcu9t5v0__filltie
* cell instance $617 r0 *1 1322.16,1703.52
X$617 31889 31913 31894 31827 31836 gf180mcu_fd_sc_mcu9t5v0__or2_1
* cell instance $618 m0 *1 1321.6,1673.28
X$618 31388 31321 gf180mcu_fd_sc_mcu9t5v0__filltie
* cell instance $619 m0 *1 1314.88,1673.28
X$619 31350 31349 31321 31388 31406 gf180mcu_fd_sc_mcu9t5v0__nand2_1
* cell instance $620 m0 *1 1321.6,1663.2
X$620 31239 31125 gf180mcu_fd_sc_mcu9t5v0__filltie
* cell instance $621 r0 *1 1352.4,1663.2
X$621 31249 31321 31239 31141 31050 gf180mcu_fd_sc_mcu9t5v0__xor2_1
* cell instance $622 r0 *1 1316.56,1663.2
X$622 30572 31350 31321 31239 31114 31349 gf180mcu_fd_sc_mcu9t5v0__xnor3_1
* cell instance $623 r0 *1 1321.6,1673.28
X$623 31350 31349 31464 31388 31459 gf180mcu_fd_sc_mcu9t5v0__nor2_1
* cell instance $624 m0 *1 1322.72,1693.44
X$624 31698 31675 31604 31710 31625 gf180mcu_fd_sc_mcu9t5v0__xnor2_1
* cell instance $625 m0 *1 1335.04,1683.36
X$625 30508 31526 31464 31529 31537 gf180mcu_fd_sc_mcu9t5v0__nand2_1
* cell instance $626 r180 *1 1392.72,1834.56
X$626 33161 33082 gf180mcu_fd_sc_mcu9t5v0__endcap
* cell instance $627 m90 *1 1392.72,1834.56
X$627 33161 33162 gf180mcu_fd_sc_mcu9t5v0__endcap
* cell instance $628 r180 *1 1392.72,1764
X$628 32560 32459 gf180mcu_fd_sc_mcu9t5v0__endcap
* cell instance $629 m90 *1 1392.72,1743.84
X$629 32351 32352 gf180mcu_fd_sc_mcu9t5v0__endcap
* cell instance $630 r180 *1 1392.72,1753.92
X$630 32453 32352 gf180mcu_fd_sc_mcu9t5v0__endcap
* cell instance $631 r180 *1 1392.72,1663.2
X$631 31239 31125 gf180mcu_fd_sc_mcu9t5v0__endcap
* cell instance $632 m90 *1 1392.72,1663.2
X$632 31239 31321 gf180mcu_fd_sc_mcu9t5v0__endcap
* cell instance $633 r180 *1 1392.72,1844.64
X$633 33241 33162 gf180mcu_fd_sc_mcu9t5v0__endcap
* cell instance $634 m90 *1 1392.72,1844.64
X$634 33241 33244 gf180mcu_fd_sc_mcu9t5v0__endcap
* cell instance $635 r180 *1 1392.72,1854.72
X$635 33242 33244 gf180mcu_fd_sc_mcu9t5v0__endcap
* cell instance $636 m90 *1 1392.72,1764
X$636 32560 32561 gf180mcu_fd_sc_mcu9t5v0__endcap
* cell instance $637 r180 *1 1392.72,1774.08
X$637 32661 32561 gf180mcu_fd_sc_mcu9t5v0__endcap
* cell instance $638 r180 *1 1392.72,1673.28
X$638 31388 31321 gf180mcu_fd_sc_mcu9t5v0__endcap
* cell instance $639 m90 *1 1392.72,1673.28
X$639 31388 31464 gf180mcu_fd_sc_mcu9t5v0__endcap
* cell instance $640 m90 *1 1392.72,1693.44
X$640 31710 31769 gf180mcu_fd_sc_mcu9t5v0__endcap
* cell instance $641 r180 *1 1392.72,1703.52
X$641 31827 31769 gf180mcu_fd_sc_mcu9t5v0__endcap
* cell instance $642 r180 *1 1392.72,1804.32
X$642 32921 32842 gf180mcu_fd_sc_mcu9t5v0__endcap
* cell instance $643 r180 *1 1392.72,1683.36
X$643 31529 31464 gf180mcu_fd_sc_mcu9t5v0__endcap
* cell instance $644 m90 *1 1392.72,1683.36
X$644 31529 31604 gf180mcu_fd_sc_mcu9t5v0__endcap
* cell instance $645 r0 *1 1448.72,1854.72
X$645 33242 33329 gf180mcu_fd_sc_mcu9t5v0__filltie
* cell instance $646 r180 *1 1392.72,1794.24
X$646 32804 32753 gf180mcu_fd_sc_mcu9t5v0__endcap
* cell instance $647 r180 *1 1392.72,1693.44
X$647 31710 31604 gf180mcu_fd_sc_mcu9t5v0__endcap
* cell instance $648 m90 *1 1392.72,1794.24
X$648 32804 32842 gf180mcu_fd_sc_mcu9t5v0__endcap
* cell instance $649 r0 *1 1568.56,1854.72
X$649 33242 33329 gf180mcu_fd_sc_mcu9t5v0__filltie
* cell instance $650 m90 *1 1392.72,1703.52
X$650 31827 31894 gf180mcu_fd_sc_mcu9t5v0__endcap
* cell instance $651 r180 *1 1392.72,1713.6
X$651 31972 31894 gf180mcu_fd_sc_mcu9t5v0__endcap
* cell instance $652 m90 *1 1392.72,1713.6
X$652 31972 32037 gf180mcu_fd_sc_mcu9t5v0__endcap
* cell instance $653 r180 *1 1392.72,1864.8
X$653 33328 33329 gf180mcu_fd_sc_mcu9t5v0__endcap
* cell instance $654 r180 *1 1392.72,1723.68
X$654 32105 32037 gf180mcu_fd_sc_mcu9t5v0__endcap
* cell instance $655 m90 *1 1392.72,1723.68
X$655 32105 32169 gf180mcu_fd_sc_mcu9t5v0__endcap
* cell instance $656 m90 *1 1392.72,1753.92
X$656 32453 32459 gf180mcu_fd_sc_mcu9t5v0__endcap
* cell instance $657 m90 *1 1392.72,1804.32
X$657 32921 32922 gf180mcu_fd_sc_mcu9t5v0__endcap
* cell instance $658 m90 *1 1392.72,1774.08
X$658 32661 32663 gf180mcu_fd_sc_mcu9t5v0__endcap
* cell instance $659 r180 *1 1392.72,1814.4
X$659 33001 32922 gf180mcu_fd_sc_mcu9t5v0__endcap
* cell instance $660 r180 *1 1392.72,1784.16
X$660 32709 32663 gf180mcu_fd_sc_mcu9t5v0__endcap
* cell instance $661 m90 *1 1392.72,1814.4
X$661 33001 33002 gf180mcu_fd_sc_mcu9t5v0__endcap
* cell instance $662 r180 *1 1392.72,1824.48
X$662 33081 33002 gf180mcu_fd_sc_mcu9t5v0__endcap
* cell instance $663 m90 *1 1392.72,1784.16
X$663 32709 32753 gf180mcu_fd_sc_mcu9t5v0__endcap
* cell instance $664 r180 *1 1392.72,1733.76
X$664 32228 32169 gf180mcu_fd_sc_mcu9t5v0__endcap
* cell instance $665 m90 *1 1392.72,1733.76
X$665 32228 32299 gf180mcu_fd_sc_mcu9t5v0__endcap
* cell instance $666 r180 *1 1392.72,1743.84
X$666 32351 32299 gf180mcu_fd_sc_mcu9t5v0__endcap
* cell instance $667 m90 *1 1392.72,1824.48
X$667 33081 33082 gf180mcu_fd_sc_mcu9t5v0__endcap
* cell instance $668 m0 *1 1377.04,1643.04
X$668 30932 30912 30982 16688 gf180mcu_fd_sc_mcu9t5v0__buf_8
* cell instance $669 r0 *1 1360.8,1380.96
X$669 25896 23388 26019 25997 25870 26018 gf180mcu_fd_sc_mcu9t5v0__oai21_1
* cell instance $670 m0 *1 1363.04,1189.44
X$670 18000 20098 20047 13180 20028 20217 gf180mcu_fd_sc_mcu9t5v0__dffrnq_2
* cell instance $671 m0 *1 1363.04,1350.72
X$671 23176 24726 24975 13180 24828 25000 gf180mcu_fd_sc_mcu9t5v0__dffrnq_2
* cell instance $672 r0 *1 1379.28,1501.92
X$672 28112 25715 23921 29146 29062 29163 gf180mcu_fd_sc_mcu9t5v0__aoi21_1
* cell instance $673 r0 *1 1380.4,1522.08
X$673 29365 23921 29364 29163 29408 29335 29423 gf180mcu_fd_sc_mcu9t5v0__aoi22_1
* cell instance $674 m0 *1 1369.2,1552.32
X$674 29929 29711 29554 13180 29714 29769 gf180mcu_fd_sc_mcu9t5v0__dffrnq_2
* cell instance $675 m0 *1 1372.56,1532.16
X$675 29929 29423 29419 13180 29408 29482 gf180mcu_fd_sc_mcu9t5v0__dffrnq_2
* cell instance $676 m0 *1 1369.76,1562.4
X$676 29929 30164 28517 13180 29841 29903 gf180mcu_fd_sc_mcu9t5v0__dffrnq_2
* cell instance $677 r0 *1 1374.8,1592.64
X$677 30778 30361 30295 16690 gf180mcu_fd_sc_mcu9t5v0__buf_8
* cell instance $678 m0 *1 1374.8,1612.8
X$678 30533 30513 30489 30570 21395 gf180mcu_fd_sc_mcu9t5v0__xnor2_1
* cell instance $679 r0 *1 1378.72,1572.48
X$679 30038 29930 30102 30106 30039 30037 gf180mcu_fd_sc_mcu9t5v0__aoi21_2
* cell instance $680 m0 *1 1377.04,1572.48
X$680 30037 29987 29973 30039 23805 gf180mcu_fd_sc_mcu9t5v0__nor2_4
* cell instance $681 r0 *1 1424.64,1380.96
X$681 23928 26021 24844 14696 25997 25870 gf180mcu_fd_sc_mcu9t5v0__dffrnq_2
* cell instance $682 m0 *1 1373.68,1431.36
X$682 27527 27213 27367 27262 gf180mcu_fd_sc_mcu9t5v0__clkbuf_8
* cell instance $683 r0 *1 1379.28,1431.36
X$683 27383 24975 27517 27367 27508 gf180mcu_fd_sc_mcu9t5v0__and2_1
* cell instance $684 r0 *1 1380.96,1451.52
X$684 27834 28009 28682 28103 27945 28010 gf180mcu_fd_sc_mcu9t5v0__and3_1
* cell instance $685 m0 *1 1375.36,1481.76
X$685 28517 28635 28661 28508 gf180mcu_fd_sc_mcu9t5v0__buf_8
* cell instance $686 m0 *1 1375.92,1491.84
X$686 28936 28874 28937 28656 22024 gf180mcu_fd_sc_mcu9t5v0__xor2_1
* cell instance $687 r0 *1 1395.52,1380.96
X$687 26062 26183 26185 25997 25870 25898 gf180mcu_fd_sc_mcu9t5v0__nand3_1
* cell instance $688 r0 *1 1411.2,1380.96
X$688 23921 26020 25997 25870 25851 gf180mcu_fd_sc_mcu9t5v0__nor2_1
* cell instance $689 r0 *1 1378.72,1411.2
X$689 27105 23180 26942 26757 26909 gf180mcu_fd_sc_mcu9t5v0__nand2_1
* cell instance $690 r0 *1 1391.6,1380.96
X$690 26059 25897 25997 25870 26063 gf180mcu_fd_sc_mcu9t5v0__nand2_1
* cell instance $691 m0 *1 1368.64,1370.88
X$691 27262 25445 25332 13180 25430 25581 gf180mcu_fd_sc_mcu9t5v0__dffrnq_2
* cell instance $692 r0 *1 1378.16,1391.04
X$692 26316 23704 26331 26166 26317 gf180mcu_fd_sc_mcu9t5v0__and2_1
* cell instance $693 m0 *1 1379.84,1391.04
X$693 26315 25997 26166 23388 26060 gf180mcu_fd_sc_mcu9t5v0__xor2_1
* cell instance $694 m0 *1 1419.6,1380.96
X$694 25719 23921 25898 25851 25705 25870 25852 gf180mcu_fd_sc_mcu9t5v0__aoi22_1
* cell instance $695 r0 *1 1419.6,1380.96
X$695 25720 23921 25898 26017 25997 25870 26021 gf180mcu_fd_sc_mcu9t5v0__aoi22_1
* cell instance $696 r0 *1 1448.72,1380.96
X$696 25870 25997 gf180mcu_fd_sc_mcu9t5v0__filltie
* cell instance $697 m0 *1 1435.84,1380.96
X$697 23928 25852 25601 14696 25705 25870 gf180mcu_fd_sc_mcu9t5v0__dffrnq_2
* cell instance $698 m0 *1 1473.92,1380.96
X$698 25899 22303 14872 25705 25870 25721 gf180mcu_fd_sc_mcu9t5v0__mux2_1
* cell instance $699 m0 *1 1549.52,1380.96
X$699 25853 25857 25722 14696 25705 25870 gf180mcu_fd_sc_mcu9t5v0__dffrnq_2
* cell instance $700 m0 *1 1531.6,1380.96
X$700 16688 25855 22862 25705 25870 25900 gf180mcu_fd_sc_mcu9t5v0__mux2_1
* cell instance $701 r0 *1 1548.4,1380.96
X$701 25901 25856 25997 25870 25902 gf180mcu_fd_sc_mcu9t5v0__and2_1
* cell instance $702 m0 *1 1538.88,1380.96
X$702 25855 25603 25705 25870 25856 gf180mcu_fd_sc_mcu9t5v0__xnor2_1
* cell instance $703 r0 *1 1524.88,1380.96
X$703 25853 25900 25855 14696 25997 25870 gf180mcu_fd_sc_mcu9t5v0__dffrnq_2
* cell instance $704 m0 *1 1506.96,1380.96
X$704 25853 25854 25603 14696 25705 25870 gf180mcu_fd_sc_mcu9t5v0__dffrnq_2
* cell instance $705 m0 *1 1546.16,1380.96
X$705 25901 25856 25705 25870 25604 gf180mcu_fd_sc_mcu9t5v0__nor2_1
* cell instance $706 m0 *1 1615.6,1380.96
X$706 25606 25858 25705 25870 25903 gf180mcu_fd_sc_mcu9t5v0__or2_1
* cell instance $707 m0 *1 1596.56,1380.96
X$707 25853 25726 25606 14696 25705 25870 gf180mcu_fd_sc_mcu9t5v0__dffrnq_2
* cell instance $708 m0 *1 1568.56,1380.96
X$708 25870 25705 gf180mcu_fd_sc_mcu9t5v0__filltie
* cell instance $709 m0 *1 1577.52,1380.96
X$709 25853 25724 25723 14696 25705 25870 gf180mcu_fd_sc_mcu9t5v0__dffrnq_2
* cell instance $710 r0 *1 1164.24,1380.96
X$710 26471 25888 17977 25997 25870 26046 gf180mcu_fd_sc_mcu9t5v0__mux2_1
* cell instance $711 r0 *1 1138.48,1380.96
X$711 24096 26011 24966 13331 25997 25870 gf180mcu_fd_sc_mcu9t5v0__dffrnq_2
* cell instance $712 m0 *1 1111.6,1380.96
X$712 25887 25883 18277 25705 25870 25886 gf180mcu_fd_sc_mcu9t5v0__mux2_1
* cell instance $713 m0 *1 1120,1380.96
X$713 24096 25711 25712 13331 25705 25870 gf180mcu_fd_sc_mcu9t5v0__dffrnq_2
* cell instance $714 r0 *1 1107.68,1380.96
X$714 24096 25886 25887 13331 25997 25870 gf180mcu_fd_sc_mcu9t5v0__dffrnq_2
* cell instance $715 m0 *1 1219.12,1380.96
X$715 26012 25705 25870 25890 gf180mcu_fd_sc_mcu9t5v0__clkinv_1
* cell instance $716 m0 *1 1209.6,1380.96
X$716 25890 23921 25714 25716 25705 25870 25845 gf180mcu_fd_sc_mcu9t5v0__aoi22_1
* cell instance $717 m0 *1 1185.52,1380.96
X$717 25589 25438 25705 25870 26349 gf180mcu_fd_sc_mcu9t5v0__xnor2_1
* cell instance $718 r0 *1 1210.16,1380.96
X$718 23802 25845 26012 13180 25997 25870 gf180mcu_fd_sc_mcu9t5v0__dffrnq_2
* cell instance $719 r0 *1 1209.04,1380.96
X$719 25870 25997 gf180mcu_fd_sc_mcu9t5v0__filltie
* cell instance $720 m0 *1 1178.24,1380.96
X$720 25888 21427 14872 25705 25870 25889 gf180mcu_fd_sc_mcu9t5v0__mux2_1
* cell instance $721 r0 *1 1176,1380.96
X$721 24096 25889 21427 13180 25997 25870 gf180mcu_fd_sc_mcu9t5v0__dffrnq_2
* cell instance $722 m0 *1 1237.04,1380.96
X$722 18614 25847 23211 24963 25705 25870 25846 gf180mcu_fd_sc_mcu9t5v0__aoi22_1
* cell instance $723 m0 *1 1285.76,1380.96
X$723 25594 25444 25705 25870 25892 gf180mcu_fd_sc_mcu9t5v0__xnor2_1
* cell instance $724 m0 *1 1275.12,1380.96
X$724 26013 25705 25870 25593 gf180mcu_fd_sc_mcu9t5v0__clkinv_1
* cell instance $725 m0 *1 1292.48,1380.96
X$725 26052 25718 25705 25870 25717 gf180mcu_fd_sc_mcu9t5v0__nand2_1
* cell instance $726 r0 *1 1262.8,1380.96
X$726 23176 26014 26013 13180 25997 25870 gf180mcu_fd_sc_mcu9t5v0__dffrnq_2
* cell instance $727 r0 *1 1286.32,1380.96
X$727 26053 25892 25997 25870 26054 gf180mcu_fd_sc_mcu9t5v0__nand2_1
* cell instance $728 m0 *1 1305.92,1380.96
X$728 26900 25558 25891 23921 25705 25870 25849
+ gf180mcu_fd_sc_mcu9t5v0__aoi211_1
* cell instance $729 m0 *1 1360.8,1380.96
X$729 25850 22854 25705 25870 25560 gf180mcu_fd_sc_mcu9t5v0__nand2_1
* cell instance $730 r0 *1 1346.24,1380.96
X$730 23921 25894 25895 25893 25997 25870 26057 gf180mcu_fd_sc_mcu9t5v0__oai31_1
* cell instance $731 r0 *1 1317.68,1380.96
X$731 26015 22855 23921 25997 25870 26017 gf180mcu_fd_sc_mcu9t5v0__aoi21_1
* cell instance $732 m0 *1 1328.88,1380.96
X$732 25870 25705 gf180mcu_fd_sc_mcu9t5v0__filltie
* cell instance $733 r0 *1 1311.52,1380.96
X$733 26055 22855 25997 25870 26016 gf180mcu_fd_sc_mcu9t5v0__nand2_1
* cell instance $734 r0 *1 1378.72,1229.76
X$734 18000 21431 21432 13180 21537 21412 gf180mcu_fd_sc_mcu9t5v0__dffrnq_2
* cell instance $735 m0 *1 1375.36,1320.48
X$735 21603 24101 23705 13180 23957 24118 gf180mcu_fd_sc_mcu9t5v0__dffrnq_2
* cell instance $736 m0 *1 1364.16,1310.4
X$736 21603 23517 23704 13180 23623 23797 gf180mcu_fd_sc_mcu9t5v0__dffrnq_2
* cell instance $737 m0 *1 1374.8,1340.64
X$737 23928 24601 24602 13180 24528 24712 gf180mcu_fd_sc_mcu9t5v0__dffrnq_2
* cell instance $738 r0 *1 1378.72,1320.48
X$738 23705 24245 18277 24232 24118 24101 gf180mcu_fd_sc_mcu9t5v0__mux2_1
* cell instance $739 r0 *1 1380.4,1340.64
X$739 25332 24602 17977 24828 24712 24601 gf180mcu_fd_sc_mcu9t5v0__mux2_1
* cell instance $740 m0 *1 1374.24,1290.24
X$740 21603 23053 23025 13180 23038 23200 gf180mcu_fd_sc_mcu9t5v0__dffrnq_2
* cell instance $741 m0 *1 1380.4,1260
X$741 24602 16677 14872 22124 22295 22137 gf180mcu_fd_sc_mcu9t5v0__mux2_1
* cell instance $742 r0 *1 1377.6,1280.16
X$742 22589 23025 17977 23038 22885 23053 gf180mcu_fd_sc_mcu9t5v0__mux2_1
* cell instance $743 r0 *1 1374.8,1249.92
X$743 18000 22137 16677 13180 22124 21997 gf180mcu_fd_sc_mcu9t5v0__dffrnq_2
* cell instance $744 r0 *1 1374.24,1270.08
X$744 21603 22724 16021 13180 22700 22577 gf180mcu_fd_sc_mcu9t5v0__dffrnq_2
* cell instance $745 m0 *1 1368.08,1169.28
X$745 18000 19456 19457 13180 19448 19605 gf180mcu_fd_sc_mcu9t5v0__dffrnq_2
* cell instance $746 r0 *1 1372.56,1199.52
X$746 18000 20665 20666 13180 20637 20507 gf180mcu_fd_sc_mcu9t5v0__dffrnq_2
* cell instance $747 m0 *1 1375.92,1209.6
X$747 20666 20714 20715 20637 20822 20665 gf180mcu_fd_sc_mcu9t5v0__mux2_1
* cell instance $748 r0 *1 1376.48,1179.36
X$748 19927 18614 18412 10210 20028 19901 19928 gf180mcu_fd_sc_mcu9t5v0__aoi22_1
* cell instance $749 m0 *1 1368.64,1229.76
X$749 21004 21241 21412 14685 gf180mcu_fd_sc_mcu9t5v0__buf_8
* cell instance $750 r0 *1 1380.96,1108.8
X$750 18411 17545 17977 17985 17837 18001 gf180mcu_fd_sc_mcu9t5v0__mux2_1
* cell instance $751 r0 *1 1374.24,1159.2
X$751 22828 19457 19910 19448 19282 19456 gf180mcu_fd_sc_mcu9t5v0__mux2_1
* cell instance $752 r0 *1 1379.84,1149.12
X$752 20666 17103 14872 19171 18996 19010 gf180mcu_fd_sc_mcu9t5v0__mux2_1
* cell instance $753 r0 *1 1373.12,1128.96
X$753 18000 18410 18411 13180 18553 18386 gf180mcu_fd_sc_mcu9t5v0__dffrnq_2
* cell instance $754 m0 *1 1376.48,1128.96
X$754 18411 18409 18277 18268 18386 18410 gf180mcu_fd_sc_mcu9t5v0__mux2_1
* cell instance $755 m0 *1 1373.68,1149.12
X$755 18000 19010 17103 13180 18841 18996 gf180mcu_fd_sc_mcu9t5v0__dffrnq_2
* cell instance $756 m0 *1 1375.36,1118.88
X$756 18000 18001 17545 13180 17985 18104 gf180mcu_fd_sc_mcu9t5v0__dffrnq_2
* cell instance $757 m0 *1 1625.68,1380.96
X$757 25300 25728 25858 14696 25705 25870 gf180mcu_fd_sc_mcu9t5v0__dffrnq_2
* cell instance $758 m0 *1 1648.08,1380.96
X$758 14872 26660 25607 25705 25870 25859 gf180mcu_fd_sc_mcu9t5v0__oai21_1
* cell instance $759 m0 *1 1620.08,1380.96
X$759 25606 25858 25705 25870 25904 gf180mcu_fd_sc_mcu9t5v0__and2_1
* cell instance $760 r0 *1 1619.52,1380.96
X$760 25727 25903 25904 25997 25870 26022 gf180mcu_fd_sc_mcu9t5v0__aoi21_1
* cell instance $761 m0 *1 1514.8,1431.36
X$761 30667 27213 27367 20111 gf180mcu_fd_sc_mcu9t5v0__buf_8
* cell instance $762 m0 *1 1518.72,1471.68
X$762 28396 28366 28378 28530 28398 gf180mcu_fd_sc_mcu9t5v0__nor2_1
* cell instance $763 r0 *1 1507.52,1441.44
X$763 27791 27674 17270 14696 27807 27666 gf180mcu_fd_sc_mcu9t5v0__dffrnq_2
* cell instance $764 r0 *1 1503.04,1461.6
X$764 27791 28250 28395 14696 28378 28239 gf180mcu_fd_sc_mcu9t5v0__dffrnq_2
* cell instance $765 r0 *1 1509.76,1471.68
X$765 28398 28635 28530 28536 gf180mcu_fd_sc_mcu9t5v0__buf_8
* cell instance $766 m0 *1 1517.6,1411.2
X$766 27673 15558 14872 26632 26757 26783 gf180mcu_fd_sc_mcu9t5v0__mux2_1
* cell instance $767 r180 *1 1392.72,1522.08
X$767 29335 29285 gf180mcu_fd_sc_mcu9t5v0__endcap
* cell instance $768 r0 *1 1515.36,1411.2
X$768 25853 26783 15558 14696 26942 26757 gf180mcu_fd_sc_mcu9t5v0__dffrnq_2
* cell instance $769 r0 *1 1503.6,1391.04
X$769 25853 26319 23915 14696 26331 26166 gf180mcu_fd_sc_mcu9t5v0__dffrnq_2
* cell instance $770 r0 *1 1382.08,1632.96
X$770 30913 30907 30912 30837 18125 gf180mcu_fd_sc_mcu9t5v0__xnor2_1
* cell instance $771 m90 *1 1392.72,1622.88
X$771 30705 30767 gf180mcu_fd_sc_mcu9t5v0__endcap
* cell instance $772 r180 *1 1392.72,1542.24
X$772 29636 29559 gf180mcu_fd_sc_mcu9t5v0__endcap
* cell instance $773 m90 *1 1392.72,1542.24
X$773 29636 29714 gf180mcu_fd_sc_mcu9t5v0__endcap
* cell instance $774 r0 *1 1388.8,1622.88
X$774 30665 30666 30767 30705 30777 gf180mcu_fd_sc_mcu9t5v0__nand2_1
* cell instance $775 r180 *1 1392.72,1653.12
X$775 31118 31054 gf180mcu_fd_sc_mcu9t5v0__endcap
* cell instance $776 r180 *1 1392.72,1552.32
X$776 29769 29714 gf180mcu_fd_sc_mcu9t5v0__endcap
* cell instance $777 m90 *1 1392.72,1552.32
X$777 29769 29841 gf180mcu_fd_sc_mcu9t5v0__endcap
* cell instance $778 r180 *1 1392.72,1562.4
X$778 29903 29841 gf180mcu_fd_sc_mcu9t5v0__endcap
* cell instance $779 m90 *1 1392.72,1562.4
X$779 29903 29973 gf180mcu_fd_sc_mcu9t5v0__endcap
* cell instance $780 r180 *1 1392.72,1572.48
X$780 30039 29973 gf180mcu_fd_sc_mcu9t5v0__endcap
* cell instance $781 m90 *1 1392.72,1572.48
X$781 30039 30106 gf180mcu_fd_sc_mcu9t5v0__endcap
* cell instance $782 r180 *1 1392.72,1582.56
X$782 30159 30106 gf180mcu_fd_sc_mcu9t5v0__endcap
* cell instance $783 m90 *1 1392.72,1582.56
X$783 30159 30231 gf180mcu_fd_sc_mcu9t5v0__endcap
* cell instance $784 r180 *1 1392.72,1592.64
X$784 30295 30231 gf180mcu_fd_sc_mcu9t5v0__endcap
* cell instance $785 m90 *1 1392.72,1592.64
X$785 30295 30361 gf180mcu_fd_sc_mcu9t5v0__endcap
* cell instance $786 r180 *1 1392.72,1602.72
X$786 30419 30361 gf180mcu_fd_sc_mcu9t5v0__endcap
* cell instance $787 m90 *1 1392.72,1602.72
X$787 30419 30489 gf180mcu_fd_sc_mcu9t5v0__endcap
* cell instance $788 r0 *1 1386,1572.48
X$788 30037 30110 30106 30039 26529 gf180mcu_fd_sc_mcu9t5v0__or2_2
* cell instance $789 r180 *1 1392.72,1612.8
X$789 30570 30489 gf180mcu_fd_sc_mcu9t5v0__endcap
* cell instance $790 m90 *1 1392.72,1612.8
X$790 30570 30634 gf180mcu_fd_sc_mcu9t5v0__endcap
* cell instance $791 r0 *1 1385.44,1562.4
X$791 29930 30038 30102 29973 29903 29987 gf180mcu_fd_sc_mcu9t5v0__and3_2
* cell instance $792 m0 *1 1384.88,1582.56
X$792 30188 30186 30106 30159 27835 gf180mcu_fd_sc_mcu9t5v0__xnor2_1
* cell instance $793 r180 *1 1392.72,1622.88
X$793 30705 30634 gf180mcu_fd_sc_mcu9t5v0__endcap
* cell instance $794 r0 *1 1385.44,1522.08
X$794 29419 29408 29335 29365 gf180mcu_fd_sc_mcu9t5v0__clkinv_1
* cell instance $795 r0 *1 1383.76,1582.56
X$795 30187 30185 30188 30231 30159 30038 gf180mcu_fd_sc_mcu9t5v0__oai21_2
* cell instance $796 m90 *1 1392.72,1522.08
X$796 29335 29408 gf180mcu_fd_sc_mcu9t5v0__endcap
* cell instance $797 r180 *1 1392.72,1532.16
X$797 29482 29408 gf180mcu_fd_sc_mcu9t5v0__endcap
* cell instance $798 m90 *1 1392.72,1532.16
X$798 29482 29559 gf180mcu_fd_sc_mcu9t5v0__endcap
* cell instance $799 r180 *1 1392.72,1632.96
X$799 30837 30767 gf180mcu_fd_sc_mcu9t5v0__endcap
* cell instance $800 m90 *1 1392.72,1632.96
X$800 30837 30912 gf180mcu_fd_sc_mcu9t5v0__endcap
* cell instance $801 r180 *1 1392.72,1643.04
X$801 30982 30912 gf180mcu_fd_sc_mcu9t5v0__endcap
* cell instance $802 m90 *1 1392.72,1643.04
X$802 30982 31054 gf180mcu_fd_sc_mcu9t5v0__endcap
* cell instance $803 m0 *1 1491.84,1451.52
X$803 27791 27973 27974 14696 27807 27945 gf180mcu_fd_sc_mcu9t5v0__dffrnq_2
* cell instance $804 m0 *1 1438.08,1391.04
X$804 23928 26065 20962 14696 25997 26166 gf180mcu_fd_sc_mcu9t5v0__dffrnq_2
* cell instance $805 m0 *1 1448.16,1421.28
X$805 23928 26967 26916 14696 26942 27078 gf180mcu_fd_sc_mcu9t5v0__dffrnq_2
* cell instance $806 m0 *1 1438.64,1461.6
X$806 28223 28225 28226 14696 28103 28239 gf180mcu_fd_sc_mcu9t5v0__dffrnq_2
* cell instance $807 m0 *1 1440.88,1441.44
X$807 28223 27646 27672 14696 27517 27666 gf180mcu_fd_sc_mcu9t5v0__dffrnq_2
* cell instance $808 m0 *1 1393.28,1451.52
X$808 27262 28012 27388 13180 27807 27945 gf180mcu_fd_sc_mcu9t5v0__dffrnq_2
* cell instance $809 m0 *1 1423.52,1451.52
X$809 27836 27971 27807 27945 27972 gf180mcu_fd_sc_mcu9t5v0__nand2_1
* cell instance $810 m0 *1 1426.32,1451.52
X$810 28223 27972 27837 14696 27807 27945 gf180mcu_fd_sc_mcu9t5v0__dffrnq_2
* cell instance $811 m0 *1 1480.64,1451.52
X$811 27837 27673 17977 27807 27945 27792 gf180mcu_fd_sc_mcu9t5v0__mux2_1
* cell instance $812 r0 *1 1449.84,1431.36
X$812 28223 27510 18003 14696 27517 27367 gf180mcu_fd_sc_mcu9t5v0__dffrnq_2
* cell instance $813 m0 *1 1445.36,1451.52
X$813 27967 27672 17977 27807 27945 27646 gf180mcu_fd_sc_mcu9t5v0__mux2_1
* cell instance $814 m0 *1 1472.8,1461.6
X$814 28245 28227 28103 28239 28114 gf180mcu_fd_sc_mcu9t5v0__nor2_1
* cell instance $815 m0 *1 1451.52,1471.68
X$815 28396 28226 28395 28517 28378 28530 28520 gf180mcu_fd_sc_mcu9t5v0__nand4_1
* cell instance $816 r0 *1 1455.44,1461.6
X$816 28366 28397 28378 28239 28365 gf180mcu_fd_sc_mcu9t5v0__xnor2_1
* cell instance $817 r0 *1 1456.56,1471.68
X$817 28396 28366 28635 28530 28658 gf180mcu_fd_sc_mcu9t5v0__nand2_1
* cell instance $818 m0 *1 1466.64,1471.68
X$818 28366 28397 28378 28530 28521 gf180mcu_fd_sc_mcu9t5v0__nand2_1
* cell instance $819 r0 *1 1492.96,1461.6
X$819 28397 28245 28378 28239 28250 gf180mcu_fd_sc_mcu9t5v0__nor2_1
* cell instance $820 r0 *1 1459.36,1471.68
X$820 28658 28521 28635 28530 28646 gf180mcu_fd_sc_mcu9t5v0__nand2_1
* cell instance $821 r0 *1 1487.92,1471.68
X$821 28659 28635 28530 25730 gf180mcu_fd_sc_mcu9t5v0__buf_8
* cell instance $822 m0 *1 1482.32,1471.68
X$822 28522 28366 28378 28530 28394 gf180mcu_fd_sc_mcu9t5v0__nor2_1
* cell instance $823 m0 *1 1457.68,1461.6
X$823 28226 28103 28239 28366 gf180mcu_fd_sc_mcu9t5v0__buf_8
* cell instance $824 r0 *1 1470,1461.6
X$824 28223 28114 28396 14696 28378 28239 gf180mcu_fd_sc_mcu9t5v0__dffrnq_2
* cell instance $825 m0 *1 1480.08,1471.68
X$825 28396 28378 28530 28522 gf180mcu_fd_sc_mcu9t5v0__clkinv_1
* cell instance $826 m0 *1 1485.68,1471.68
X$826 28522 28366 28397 28508 28378 28530 28523 gf180mcu_fd_sc_mcu9t5v0__nand4_1
* cell instance $827 m0 *1 1493.52,1471.68
X$827 28523 28378 28530 22862 gf180mcu_fd_sc_mcu9t5v0__buf_8
* cell instance $828 r0 *1 1495.2,1451.52
X$828 28113 27974 17977 28103 27945 27973 gf180mcu_fd_sc_mcu9t5v0__mux2_1
* cell instance $829 m0 *1 1471.12,1471.68
X$829 28522 28521 28378 28530 28227 gf180mcu_fd_sc_mcu9t5v0__xnor2_1
* cell instance $830 m0 *1 1457.12,1481.76
X$830 28397 28658 28635 28661 28684 gf180mcu_fd_sc_mcu9t5v0__nand2_1
* cell instance $831 r0 *1 1401.12,1471.68
X$831 28653 28546 28635 28530 25600 28681 gf180mcu_fd_sc_mcu9t5v0__xnor3_1
* cell instance $832 m0 *1 1403.36,1471.68
X$832 28656 28518 28378 28530 22909 gf180mcu_fd_sc_mcu9t5v0__nor2_1
* cell instance $833 r0 *1 1404.48,1451.52
X$833 27388 23921 28103 27945 28011 gf180mcu_fd_sc_mcu9t5v0__nand2_1
* cell instance $834 r180 *1 1392.72,1512
X$834 29212 29146 gf180mcu_fd_sc_mcu9t5v0__endcap
* cell instance $835 m90 *1 1392.72,1512
X$835 29212 29285 gf180mcu_fd_sc_mcu9t5v0__endcap
* cell instance $836 m0 *1 1390.48,1481.76
X$836 28681 28546 28635 28661 28519 gf180mcu_fd_sc_mcu9t5v0__and2_1
* cell instance $837 r180 *1 1392.72,1501.92
X$837 29062 28989 gf180mcu_fd_sc_mcu9t5v0__endcap
* cell instance $838 m90 *1 1392.72,1481.76
X$838 28661 28874 gf180mcu_fd_sc_mcu9t5v0__endcap
* cell instance $839 r0 *1 1396.64,1471.68
X$839 28544 28657 28635 28530 28656 gf180mcu_fd_sc_mcu9t5v0__and2_1
* cell instance $840 r0 *1 1392.16,1471.68
X$840 28681 28546 28635 28530 28547 gf180mcu_fd_sc_mcu9t5v0__or2_1
* cell instance $841 m0 *1 1398.88,1471.68
X$841 28653 28519 28547 28378 28530 28657 gf180mcu_fd_sc_mcu9t5v0__oai21_1
* cell instance $842 m0 *1 1383.76,1471.68
X$842 28516 28378 28530 17553 gf180mcu_fd_sc_mcu9t5v0__buf_8
* cell instance $843 r180 *1 1392.72,1491.84
X$843 28937 28874 gf180mcu_fd_sc_mcu9t5v0__endcap
* cell instance $844 r0 *1 1407.28,1451.52
X$844 13180 28103 27945 14696 gf180mcu_fd_sc_mcu9t5v0__buf_20
* cell instance $845 m0 *1 1424.08,1471.68
X$845 28389 28378 28530 27109 gf180mcu_fd_sc_mcu9t5v0__buf_8
* cell instance $846 r0 *1 1424.64,1471.68
X$846 28520 28635 28530 28389 gf180mcu_fd_sc_mcu9t5v0__buf_8
* cell instance $847 m0 *1 1412.88,1461.6
X$847 28223 28224 28364 14696 28103 28239 gf180mcu_fd_sc_mcu9t5v0__dffrnq_2
* cell instance $848 r0 *1 1388.8,1451.52
X$848 23921 27509 28010 28011 28103 27945 28012 gf180mcu_fd_sc_mcu9t5v0__oai31_1
* cell instance $849 r0 *1 1448.72,1451.52
X$849 27945 28103 gf180mcu_fd_sc_mcu9t5v0__filltie
* cell instance $850 r0 *1 1448.72,1461.6
X$850 28239 28378 gf180mcu_fd_sc_mcu9t5v0__filltie
* cell instance $851 r0 *1 1416.24,1461.6
X$851 29077 28364 17977 28378 28239 28224 gf180mcu_fd_sc_mcu9t5v0__mux2_1
* cell instance $852 r0 *1 1448.72,1471.68
X$852 28530 28635 gf180mcu_fd_sc_mcu9t5v0__filltie
* cell instance $853 m90 *1 1392.72,1501.92
X$853 29062 29146 gf180mcu_fd_sc_mcu9t5v0__endcap
* cell instance $854 m90 *1 1392.72,1491.84
X$854 28937 28989 gf180mcu_fd_sc_mcu9t5v0__endcap
* cell instance $855 r0 *1 1444.24,1461.6
X$855 28245 28365 28378 28239 28225 gf180mcu_fd_sc_mcu9t5v0__nor2_1
* cell instance $856 r0 *1 1388.8,1471.68
X$856 28544 28657 28635 28530 28518 gf180mcu_fd_sc_mcu9t5v0__nor2_1
* cell instance $857 m0 *1 1448.72,1481.76
X$857 28661 28635 gf180mcu_fd_sc_mcu9t5v0__filltie
* cell instance $858 m0 *1 1394.96,1481.76
X$858 29167 28661 28635 28683 gf180mcu_fd_sc_mcu9t5v0__clkbuf_16
* cell instance $859 m0 *1 1395.52,1391.04
X$859 26062 26185 26183 25997 26166 26020 gf180mcu_fd_sc_mcu9t5v0__aoi21_1
* cell instance $860 m0 *1 1390.48,1411.2
X$860 26657 26909 26779 26632 26757 26480 gf180mcu_fd_sc_mcu9t5v0__and3_1
* cell instance $861 m0 *1 1393.28,1421.28
X$861 27262 26966 26481 14696 26942 27078 gf180mcu_fd_sc_mcu9t5v0__dffrnq_2
* cell instance $862 r0 *1 1405.6,1391.04
X$862 27262 26353 26064 14696 26331 26166 gf180mcu_fd_sc_mcu9t5v0__dffrnq_2
* cell instance $863 m0 *1 1439.76,1401.12
X$863 26914 20962 14872 26331 26456 26065 gf180mcu_fd_sc_mcu9t5v0__mux2_1
* cell instance $864 r0 *1 1448.72,1421.28
X$864 27078 27213 gf180mcu_fd_sc_mcu9t5v0__filltie
* cell instance $865 r0 *1 1448.72,1401.12
X$865 26456 26632 gf180mcu_fd_sc_mcu9t5v0__filltie
* cell instance $866 r0 *1 1401.68,1411.2
X$866 26481 23921 26942 26757 26912 gf180mcu_fd_sc_mcu9t5v0__nand2_1
* cell instance $867 r0 *1 1448.72,1411.2
X$867 26757 26942 gf180mcu_fd_sc_mcu9t5v0__filltie
* cell instance $868 m0 *1 1415.12,1391.04
X$868 26064 23921 25997 26166 26186 gf180mcu_fd_sc_mcu9t5v0__nand2_1
* cell instance $869 m0 *1 1398.32,1401.12
X$869 23921 26061 26480 26186 26331 26456 26353 gf180mcu_fd_sc_mcu9t5v0__oai31_1
* cell instance $870 r0 *1 1392.16,1421.28
X$870 18277 26779 27213 27078 26911 gf180mcu_fd_sc_mcu9t5v0__nand2_1
* cell instance $871 r0 *1 1435.84,1411.2
X$871 26915 26914 17977 26942 26757 26913 gf180mcu_fd_sc_mcu9t5v0__mux2_1
* cell instance $872 r0 *1 1448.72,1391.04
X$872 26166 26331 gf180mcu_fd_sc_mcu9t5v0__filltie
* cell instance $873 r0 *1 1383.76,1431.36
X$873 27508 27509 27107 27517 27367 26779 gf180mcu_fd_sc_mcu9t5v0__oai21_1
* cell instance $874 m0 *1 1420.16,1431.36
X$874 27262 27265 26915 14696 27213 27367 gf180mcu_fd_sc_mcu9t5v0__dffrnq_2
* cell instance $875 m0 *1 1427.44,1401.12
X$875 28364 18164 14872 26331 26456 26482 gf180mcu_fd_sc_mcu9t5v0__mux2_1
* cell instance $876 r0 *1 1409.52,1411.2
X$876 27262 26780 23339 14696 26942 26757 gf180mcu_fd_sc_mcu9t5v0__dffrnq_2
* cell instance $877 r0 *1 1401.12,1431.36
X$877 27262 27387 27264 14696 27517 27367 gf180mcu_fd_sc_mcu9t5v0__dffrnq_2
* cell instance $878 r0 *1 1422.96,1401.12
X$878 27262 26482 18164 14696 26632 26456 gf180mcu_fd_sc_mcu9t5v0__dffrnq_2
* cell instance $879 r0 *1 1423.52,1431.36
X$879 26915 27498 18277 27517 27367 27265 gf180mcu_fd_sc_mcu9t5v0__mux2_1
* cell instance $880 r0 *1 1388.24,1431.36
X$880 27107 27508 27509 27517 27367 26910 gf180mcu_fd_sc_mcu9t5v0__nor3_1
* cell instance $881 m0 *1 1405.04,1431.36
X$881 29854 27264 17977 27213 27367 27387 gf180mcu_fd_sc_mcu9t5v0__mux2_1
* cell instance $882 r0 *1 1402.24,1441.44
X$882 27835 27807 27666 21618 gf180mcu_fd_sc_mcu9t5v0__buf_8
* cell instance $883 m0 *1 1429.12,1421.28
X$883 27262 26913 26914 14696 26942 27078 gf180mcu_fd_sc_mcu9t5v0__dffrnq_2
* cell instance $884 m0 *1 1387.12,1391.04
X$884 26060 25997 26166 26059 gf180mcu_fd_sc_mcu9t5v0__clkinv_1
* cell instance $885 r0 *1 1448.72,1431.36
X$885 27367 27517 gf180mcu_fd_sc_mcu9t5v0__filltie
* cell instance $886 r0 *1 1448.72,1441.44
X$886 27666 27807 gf180mcu_fd_sc_mcu9t5v0__filltie
* cell instance $887 r0 *1 1428.56,1441.44
X$887 27837 23921 27807 27666 27836 gf180mcu_fd_sc_mcu9t5v0__nand2_1
* cell instance $888 m0 *1 1412.32,1411.2
X$888 27264 23339 14872 26632 26757 26780 gf180mcu_fd_sc_mcu9t5v0__mux2_1
* cell instance $889 m0 *1 1386,1411.2
X$889 26909 26779 26657 26632 26757 26061 gf180mcu_fd_sc_mcu9t5v0__aoi21_1
* cell instance $890 r0 *1 1389.92,1391.04
X$890 26317 26061 26331 26166 25897 gf180mcu_fd_sc_mcu9t5v0__nor2_1
* cell instance $891 m0 *1 1389.36,1391.04
X$891 26317 26061 26060 25997 26166 26062 gf180mcu_fd_sc_mcu9t5v0__oai21_1
* cell instance $892 r0 *1 1394.4,1411.2
X$892 26910 26911 26912 26942 26757 26966 gf180mcu_fd_sc_mcu9t5v0__oai21_1
* cell instance $893 m0 *1 1400,1391.04
X$893 18277 26063 26062 25997 26166 24307 gf180mcu_fd_sc_mcu9t5v0__nand3_1
* cell instance $894 m0 *1 1454.88,1401.12
X$894 24310 26354 26318 14696 26331 26456 gf180mcu_fd_sc_mcu9t5v0__dffrnq_2
* cell instance $895 r0 *1 1452.08,1401.12
X$895 26529 26632 26456 22861 gf180mcu_fd_sc_mcu9t5v0__buf_8
* cell instance $896 r0 *1 1452.08,1411.2
X$896 26916 26963 18277 26942 26757 26967 gf180mcu_fd_sc_mcu9t5v0__mux2_1
* cell instance $897 r0 *1 1489.6,1401.12
X$897 25853 26483 26484 14696 26632 26456 gf180mcu_fd_sc_mcu9t5v0__dffrnq_2
* cell instance $898 r0 *1 1458.24,1391.04
X$898 26916 26318 17977 26331 26166 26354 gf180mcu_fd_sc_mcu9t5v0__mux2_1
* cell instance $899 m0 *1 1471.68,1421.28
X$899 25853 26968 26969 14696 26942 27078 gf180mcu_fd_sc_mcu9t5v0__dffrnq_2
* cell instance $900 m0 *1 1471.12,1391.04
X$900 26318 17849 14872 25997 26166 26187 gf180mcu_fd_sc_mcu9t5v0__mux2_1
* cell instance $901 m0 *1 1494.08,1401.12
X$901 26481 26484 17977 26331 26456 26483 gf180mcu_fd_sc_mcu9t5v0__mux2_1
* cell instance $902 m0 *1 1493.52,1421.28
X$902 25853 26970 23168 14696 26942 27078 gf180mcu_fd_sc_mcu9t5v0__dffrnq_2
* cell instance $903 r0 *1 1501.36,1411.2
X$903 26917 23168 14872 26942 26757 26970 gf180mcu_fd_sc_mcu9t5v0__mux2_1
* cell instance $904 r0 *1 1470,1411.2
X$904 25853 26781 17273 14696 26942 26757 gf180mcu_fd_sc_mcu9t5v0__dffrnq_2
* cell instance $905 m0 *1 1495.76,1431.36
X$905 27386 27213 27367 16935 gf180mcu_fd_sc_mcu9t5v0__buf_8
* cell instance $906 r0 *1 1484.56,1391.04
X$906 25853 26188 14991 14696 26331 26166 gf180mcu_fd_sc_mcu9t5v0__dffrnq_2
* cell instance $907 r0 *1 1450.96,1441.44
X$907 27672 18003 14872 27807 27666 27510 gf180mcu_fd_sc_mcu9t5v0__mux2_1
* cell instance $908 m0 *1 1463.84,1441.44
X$908 28223 27647 26782 14696 27517 27666 gf180mcu_fd_sc_mcu9t5v0__dffrnq_2
* cell instance $909 m0 *1 1487.36,1391.04
X$909 26969 14991 14872 25997 26166 26188 gf180mcu_fd_sc_mcu9t5v0__mux2_1
* cell instance $910 r0 *1 1478.4,1441.44
X$910 27791 27792 27673 14696 27807 27666 gf180mcu_fd_sc_mcu9t5v0__dffrnq_2
* cell instance $911 r0 *1 1468.32,1441.44
X$911 28515 26782 17977 27807 27666 27647 gf180mcu_fd_sc_mcu9t5v0__mux2_1
* cell instance $912 m0 *1 1506.96,1441.44
X$912 27974 17270 14872 27517 27666 27674 gf180mcu_fd_sc_mcu9t5v0__mux2_1
* cell instance $913 r0 *1 1475.04,1421.28
X$913 27388 26969 17977 27213 27078 26968 gf180mcu_fd_sc_mcu9t5v0__mux2_1
* cell instance $914 r0 *1 1465.52,1391.04
X$914 24310 26187 17849 14696 26331 26166 gf180mcu_fd_sc_mcu9t5v0__dffrnq_2
* cell instance $915 m0 *1 1474.48,1411.2
X$915 26782 17273 14872 26632 26757 26781 gf180mcu_fd_sc_mcu9t5v0__mux2_1
* cell instance $916 m0 *1 1511.44,1401.12
X$916 26485 23915 14872 26331 26456 26319 gf180mcu_fd_sc_mcu9t5v0__mux2_1
* cell instance $917 r0 *1 1555.12,1391.04
X$917 25853 26320 26356 14696 26331 26166 gf180mcu_fd_sc_mcu9t5v0__dffrnq_2
* cell instance $918 m0 *1 1546.16,1411.2
X$918 26784 26531 26632 26757 26355 gf180mcu_fd_sc_mcu9t5v0__nor2_1
* cell instance $919 m0 *1 1615.04,1401.12
X$919 26491 26323 26331 26456 26322 26659 gf180mcu_fd_sc_mcu9t5v0__xnor3_1
* cell instance $920 r0 *1 1520.96,1401.12
X$920 25853 26486 26487 14696 26632 26456 gf180mcu_fd_sc_mcu9t5v0__dffrnq_2
* cell instance $921 m0 *1 1561.28,1431.36
X$921 18125 27266 22862 27213 27367 27235 gf180mcu_fd_sc_mcu9t5v0__mux2_1
* cell instance $922 m0 *1 1548.96,1401.12
X$922 26530 26487 26355 26331 26456 25901 gf180mcu_fd_sc_mcu9t5v0__aoi21_1
* cell instance $923 r0 *1 1552.88,1391.04
X$923 20537 26331 26166 21864 gf180mcu_fd_sc_mcu9t5v0__clkinv_1
* cell instance $924 m0 *1 1535.52,1431.36
X$924 21017 27109 27213 27367 26971 gf180mcu_fd_sc_mcu9t5v0__nand2_1
* cell instance $925 r0 *1 1548.96,1401.12
X$925 26784 26531 26632 26456 26488 gf180mcu_fd_sc_mcu9t5v0__xnor2_1
* cell instance $926 m0 *1 1589.28,1431.36
X$926 27268 27267 27213 27367 27112 gf180mcu_fd_sc_mcu9t5v0__and2_1
* cell instance $927 r0 *1 1529.92,1421.28
X$927 27791 27108 21017 14696 27213 27078 gf180mcu_fd_sc_mcu9t5v0__dffrnq_2
* cell instance $928 m0 *1 1585.92,1431.36
X$928 27268 27267 27213 27367 27236 gf180mcu_fd_sc_mcu9t5v0__nor2_1
* cell instance $929 m0 *1 1611.68,1431.36
X$929 27269 27213 27367 27793 27114 gf180mcu_fd_sc_mcu9t5v0__xor2_1
* cell instance $930 m0 *1 1554,1471.68
X$930 28525 28378 28530 22436 gf180mcu_fd_sc_mcu9t5v0__buf_8
* cell instance $931 r0 *1 1576.4,1411.2
X$931 26973 26918 26942 26757 26532 gf180mcu_fd_sc_mcu9t5v0__nor2_1
* cell instance $932 m0 *1 1568.56,1391.04
X$932 26166 25997 gf180mcu_fd_sc_mcu9t5v0__filltie
* cell instance $933 m0 *1 1568.56,1421.28
X$933 27078 26942 gf180mcu_fd_sc_mcu9t5v0__filltie
* cell instance $934 r0 *1 1583.68,1421.28
X$934 26919 27111 27112 27213 27078 27110 gf180mcu_fd_sc_mcu9t5v0__aoi21_1
* cell instance $935 m0 *1 1574.16,1401.12
X$935 26357 26356 26331 26456 26321 gf180mcu_fd_sc_mcu9t5v0__xnor2_1
* cell instance $936 r0 *1 1603.28,1401.12
X$936 25853 26534 26659 14696 26632 26456 gf180mcu_fd_sc_mcu9t5v0__dffrnq_2
* cell instance $937 m0 *1 1568.56,1441.44
X$937 27666 27517 gf180mcu_fd_sc_mcu9t5v0__filltie
* cell instance $938 m0 *1 1571.92,1421.28
X$938 26973 27110 26942 27078 26917 26918 gf180mcu_fd_sc_mcu9t5v0__xnor3_1
* cell instance $939 m0 *1 1610.56,1411.2
X$939 26658 26659 18562 26632 26757 26534 gf180mcu_fd_sc_mcu9t5v0__mux2_1
* cell instance $940 m0 *1 1587.6,1451.52
X$940 27791 27841 27268 14696 27807 27945 gf180mcu_fd_sc_mcu9t5v0__dffrnq_2
* cell instance $941 m0 *1 1585.92,1401.12
X$941 25853 26359 26357 14696 26331 26456 gf180mcu_fd_sc_mcu9t5v0__dffrnq_2
* cell instance $942 r0 *1 1579.76,1411.2
X$942 26919 26942 26757 27111 26485 gf180mcu_fd_sc_mcu9t5v0__xor2_1
* cell instance $943 m0 *1 1561.28,1401.12
X$943 26356 21864 26331 26456 26489 gf180mcu_fd_sc_mcu9t5v0__nand2_1
* cell instance $944 m0 *1 1564.08,1451.52
X$944 27791 27807 27945 gf180mcu_fd_sc_mcu9t5v0__inv_3
* cell instance $945 m0 *1 1568.56,1401.12
X$945 26456 26331 gf180mcu_fd_sc_mcu9t5v0__filltie
* cell instance $946 r0 *1 1594.88,1421.28
X$946 27791 27113 26973 14696 27213 27078 gf180mcu_fd_sc_mcu9t5v0__dffrnq_2
* cell instance $947 r0 *1 1593.2,1391.04
X$947 26357 26322 15890 26331 26166 26359 gf180mcu_fd_sc_mcu9t5v0__mux2_1
* cell instance $948 m0 *1 1602.72,1421.28
X$948 26973 27114 15890 26942 27078 27113 gf180mcu_fd_sc_mcu9t5v0__mux2_1
* cell instance $949 r0 *1 1575.84,1401.12
X$949 26321 26532 26533 26490 26632 26456 25337 gf180mcu_fd_sc_mcu9t5v0__oai31_1
* cell instance $950 r0 *1 1588.16,1421.28
X$950 27112 27236 27213 27078 27111 gf180mcu_fd_sc_mcu9t5v0__nor2_1
* cell instance $951 m0 *1 1584.8,1421.28
X$951 26973 26918 26919 27111 27112 26942 27078 26533
+ gf180mcu_fd_sc_mcu9t5v0__aoi221_1
* cell instance $952 m0 *1 1571.36,1401.12
X$952 26357 26356 26331 26456 26490 gf180mcu_fd_sc_mcu9t5v0__nand2_1
* cell instance $953 r0 *1 1574.72,1391.04
X$953 26321 26358 26331 26166 25899 gf180mcu_fd_sc_mcu9t5v0__xnor2_1
* cell instance $954 m0 *1 1580.88,1401.12
X$954 26532 26533 26331 26456 26358 gf180mcu_fd_sc_mcu9t5v0__nor2_1
* cell instance $955 m0 *1 1568.56,1411.2
X$955 26757 26632 gf180mcu_fd_sc_mcu9t5v0__filltie
* cell instance $956 m0 *1 1568.56,1451.52
X$956 27945 27807 gf180mcu_fd_sc_mcu9t5v0__filltie
* cell instance $957 m0 *1 1561.28,1441.44
X$957 26918 27840 20537 27517 27666 27676 gf180mcu_fd_sc_mcu9t5v0__mux2_1
* cell instance $958 m0 *1 1568.56,1461.6
X$958 28239 28103 gf180mcu_fd_sc_mcu9t5v0__filltie
* cell instance $959 m0 *1 1568.56,1471.68
X$959 28530 28378 gf180mcu_fd_sc_mcu9t5v0__filltie
* cell instance $960 r0 *1 1575.84,1431.36
X$960 27267 27266 20537 27517 27367 27530 gf180mcu_fd_sc_mcu9t5v0__mux2_1
* cell instance $961 m0 *1 1568.56,1481.76
X$961 28661 28635 gf180mcu_fd_sc_mcu9t5v0__filltie
* cell instance $962 m0 *1 1586.48,1461.6
X$962 18125 28252 22907 28103 28239 28251 gf180mcu_fd_sc_mcu9t5v0__mux2_1
* cell instance $963 m0 *1 1569.68,1451.52
X$963 20723 27807 27945 27791 gf180mcu_fd_sc_mcu9t5v0__clkbuf_8
* cell instance $964 r0 *1 1590.96,1441.44
X$964 27268 28252 15890 27807 27666 27841 gf180mcu_fd_sc_mcu9t5v0__mux2_1
* cell instance $965 m0 *1 1573.6,1441.44
X$965 27791 27530 27267 14696 27517 27666 gf180mcu_fd_sc_mcu9t5v0__dffrnq_2
* cell instance $966 m0 *1 1601.6,1471.68
X$966 27791 15890 20537 14696 28378 28530 gf180mcu_fd_sc_mcu9t5v0__dffrnq_2
* cell instance $967 r0 *1 1559.04,1441.44
X$967 27791 27676 26918 14696 27807 27666 gf180mcu_fd_sc_mcu9t5v0__dffrnq_2
* cell instance $968 r0 *1 1609.44,1441.44
X$968 25730 27793 18562 27807 27666 27842 gf180mcu_fd_sc_mcu9t5v0__mux2_1
* cell instance $969 r0 *1 1569.68,1471.68
X$969 28524 28635 28530 22907 gf180mcu_fd_sc_mcu9t5v0__buf_8
* cell instance $970 r0 *1 1564.64,1461.6
X$970 28367 28378 28239 22434 gf180mcu_fd_sc_mcu9t5v0__buf_8
* cell instance $971 r0 *1 1579.2,1461.6
X$971 27791 28251 28252 14696 28378 28239 gf180mcu_fd_sc_mcu9t5v0__dffrnq_2
* cell instance $972 r0 *1 1546.16,1471.68
X$972 28508 28539 28635 28530 28524 gf180mcu_fd_sc_mcu9t5v0__nand2_1
* cell instance $973 r0 *1 1546.72,1461.6
X$973 28250 28394 28378 28239 16818 gf180mcu_fd_sc_mcu9t5v0__nand2_1
* cell instance $974 m0 *1 1537.2,1441.44
X$974 27791 27648 27839 14696 27517 27666 gf180mcu_fd_sc_mcu9t5v0__dffrnq_2
* cell instance $975 r0 *1 1526.56,1441.44
X$975 27791 27675 27838 14696 27807 27666 gf180mcu_fd_sc_mcu9t5v0__dffrnq_2
* cell instance $976 r0 *1 1549.52,1461.6
X$976 28397 28508 28394 28378 28239 16821 gf180mcu_fd_sc_mcu9t5v0__and3_1
* cell instance $977 r0 *1 1613.92,1421.28
X$977 27791 27115 27269 14696 27213 27078 gf180mcu_fd_sc_mcu9t5v0__dffrnq_2
* cell instance $978 r0 *1 1617.28,1441.44
X$978 27791 27843 27844 14696 27807 27666 gf180mcu_fd_sc_mcu9t5v0__dffrnq_2
* cell instance $979 m0 *1 1522.08,1471.68
X$979 28366 28378 28530 28399 gf180mcu_fd_sc_mcu9t5v0__clkinv_1
* cell instance $980 m0 *1 1606.64,1451.52
X$980 27791 27842 27793 14696 27807 27945 gf180mcu_fd_sc_mcu9t5v0__dffrnq_2
* cell instance $981 m0 *1 1555.12,1401.12
X$981 21864 26488 26489 26331 26456 26320 gf180mcu_fd_sc_mcu9t5v0__oai21_1
* cell instance $982 m0 *1 1555.12,1451.52
X$982 27839 27807 27945 27838 27840 gf180mcu_fd_sc_mcu9t5v0__xor2_1
* cell instance $983 m0 *1 1528.24,1441.44
X$983 25730 27838 27109 27517 27666 27675 gf180mcu_fd_sc_mcu9t5v0__mux2_1
* cell instance $984 r0 *1 1555.12,1461.6
X$984 28250 28398 28378 28239 28367 gf180mcu_fd_sc_mcu9t5v0__nand2_1
* cell instance $985 m0 *1 1540.56,1451.52
X$985 28223 27807 27945 gf180mcu_fd_sc_mcu9t5v0__clkinv_12
* cell instance $986 m0 *1 1526,1461.6
X$986 28396 28366 28250 28103 28239 18562 gf180mcu_fd_sc_mcu9t5v0__nand3_1
* cell instance $987 r0 *1 1545.6,1441.44
X$987 17553 27839 22862 27807 27666 27648 gf180mcu_fd_sc_mcu9t5v0__mux2_1
* cell instance $988 r0 *1 1540.56,1451.52
X$988 20723 28103 27945 28223 gf180mcu_fd_sc_mcu9t5v0__clkbuf_8
* cell instance $989 r0 *1 1548.96,1471.68
X$989 28397 28508 28398 28635 28530 28525 gf180mcu_fd_sc_mcu9t5v0__nand3_1
* cell instance $990 m0 *1 1537.76,1451.52
X$990 27839 27838 27807 27945 26784 gf180mcu_fd_sc_mcu9t5v0__nand2_1
* cell instance $991 r0 *1 1527.68,1461.6
X$991 28396 28399 28397 28378 28239 28400 gf180mcu_fd_sc_mcu9t5v0__nor3_1
* cell instance $992 m0 *1 1538.88,1471.68
X$992 28400 28378 28530 28539 gf180mcu_fd_sc_mcu9t5v0__buf_8
* cell instance $993 m0 *1 1524.32,1471.68
X$993 28395 28378 28530 28397 gf180mcu_fd_sc_mcu9t5v0__buf_8
* cell instance $994 m0 *1 1618.96,1431.36
X$994 27269 27793 27213 27367 26323 gf180mcu_fd_sc_mcu9t5v0__nand2_1
* cell instance $995 m0 *1 1531.6,1421.28
X$995 27109 16690 26971 26942 27078 27108 gf180mcu_fd_sc_mcu9t5v0__oai21_1
* cell instance $996 m0 *1 1616.16,1421.28
X$996 17553 27269 22907 26942 27078 27115 gf180mcu_fd_sc_mcu9t5v0__mux2_1
* cell instance $997 r0 *1 1554.56,1421.28
X$997 27791 27235 27266 14696 27213 27078 gf180mcu_fd_sc_mcu9t5v0__dffrnq_2
* cell instance $998 m0 *1 1544.48,1421.28
X$998 25853 26972 26530 14696 26942 27078 gf180mcu_fd_sc_mcu9t5v0__dffrnq_2
* cell instance $999 r0 *1 1620.08,1391.04
X$999 26323 26360 26324 26331 26166 25727 gf180mcu_fd_sc_mcu9t5v0__oai21_1
* cell instance $1000 m0 *1 1525.44,1401.12
X$1000 26487 26658 20719 26331 26456 26486 gf180mcu_fd_sc_mcu9t5v0__mux2_1
* cell instance $1001 r0 *1 1622.32,1401.12
X$1001 26491 26659 26632 26456 26360 gf180mcu_fd_sc_mcu9t5v0__nor2_1
* cell instance $1002 m0 *1 1534.4,1401.12
X$1002 20723 26331 26456 25853 gf180mcu_fd_sc_mcu9t5v0__clkbuf_8
* cell instance $1003 m0 *1 1643.6,1431.36
X$1003 26920 27270 20537 27213 27367 26974 gf180mcu_fd_sc_mcu9t5v0__mux2_1
* cell instance $1004 m0 *1 1636.32,1431.36
X$1004 20111 27270 22862 27213 27367 27238 gf180mcu_fd_sc_mcu9t5v0__mux2_1
* cell instance $1005 m0 *1 1636.32,1441.44
X$1005 27649 27844 20537 27517 27666 27677 gf180mcu_fd_sc_mcu9t5v0__mux2_1
* cell instance $1006 r0 *1 1636.32,1441.44
X$1006 27237 27677 27649 14696 27807 27666 gf180mcu_fd_sc_mcu9t5v0__dffrnq_2
* cell instance $1007 r0 *1 1646.4,1451.52
X$1007 21395 28014 22907 28103 27945 28013 gf180mcu_fd_sc_mcu9t5v0__mux2_1
* cell instance $1008 m0 *1 1625.68,1451.52
X$1008 21395 27844 22862 27807 27945 27843 gf180mcu_fd_sc_mcu9t5v0__mux2_1
* cell instance $1009 m0 *1 1627.92,1401.12
X$1009 26491 26659 26331 26456 26324 gf180mcu_fd_sc_mcu9t5v0__nand2_1
* cell instance $1010 r0 *1 1534.4,1391.04
X$1010 25853 26331 26166 gf180mcu_fd_sc_mcu9t5v0__inv_3
* cell instance $1011 m0 *1 1634.64,1401.12
X$1011 16935 26491 22907 26331 26456 26492 gf180mcu_fd_sc_mcu9t5v0__mux2_1
* cell instance $1012 r0 *1 1548.96,1411.2
X$1012 16935 26530 22862 26942 26757 26972 gf180mcu_fd_sc_mcu9t5v0__mux2_1
* cell instance $1013 r0 *1 1630.16,1401.12
X$1013 25300 26492 26491 14696 26632 26456 gf180mcu_fd_sc_mcu9t5v0__dffrnq_2
* cell instance $1014 r0 *1 1632.96,1421.28
X$1014 27237 27238 27270 14696 27213 27078 gf180mcu_fd_sc_mcu9t5v0__dffrnq_2
* cell instance $1015 r0 *1 1542.24,1401.12
X$1015 26530 26487 26632 26456 26531 gf180mcu_fd_sc_mcu9t5v0__xnor2_1
* cell instance $1016 m0 *1 1568.56,1431.36
X$1016 27367 27213 gf180mcu_fd_sc_mcu9t5v0__filltie
* cell instance $1017 m0 *1 1373.12,1522.08
X$1017 29351 29058 29285 29335 20543 gf180mcu_fd_sc_mcu9t5v0__xnor2_1
* cell instance $1018 r0 *1 1234.24,1592.64
X$1018 30035 30360 29053 13180 30361 30295 gf180mcu_fd_sc_mcu9t5v0__dffrnq_2
* cell instance $1019 r0 *1 1225.28,1562.4
X$1019 30035 29926 28645 13180 29973 29903 gf180mcu_fd_sc_mcu9t5v0__dffrnq_2
* cell instance $1020 r0 *1 1229.76,1522.08
X$1020 28219 29418 29294 13180 29408 29335 gf180mcu_fd_sc_mcu9t5v0__dffrnq_2
* cell instance $1021 r0 *1 1228.64,1391.04
X$1021 23802 26179 24549 13180 26331 26166 gf180mcu_fd_sc_mcu9t5v0__dffrnq_2
* cell instance $1022 r0 *1 1230.88,1411.2
X$1022 23802 26656 26897 13180 26942 26757 gf180mcu_fd_sc_mcu9t5v0__dffrnq_2
* cell instance $1023 m0 *1 1291.36,1522.08
X$1023 28219 29295 29296 13180 29285 29335 gf180mcu_fd_sc_mcu9t5v0__dffrnq_2
* cell instance $1024 m0 *1 1242.64,1592.64
X$1024 29053 23921 30231 30295 30413 gf180mcu_fd_sc_mcu9t5v0__nand2_1
* cell instance $1025 m0 *1 1237.6,1612.8
X$1025 30524 30164 30525 30364 30101 30489 30570 30574
+ gf180mcu_fd_sc_mcu9t5v0__oai221_1
* cell instance $1026 m0 *1 1240.96,1582.56
X$1026 30035 30152 30166 13180 30106 30159 gf180mcu_fd_sc_mcu9t5v0__dffrnq_2
* cell instance $1027 m0 *1 1240.96,1552.32
X$1027 30035 29765 29707 13180 29714 29769 gf180mcu_fd_sc_mcu9t5v0__dffrnq_2
* cell instance $1028 m0 *1 1277.36,1522.08
X$1028 23177 29071 29285 29335 29349 gf180mcu_fd_sc_mcu9t5v0__nand2_1
* cell instance $1029 m0 *1 1280.16,1522.08
X$1029 23177 29071 29285 29335 29480 gf180mcu_fd_sc_mcu9t5v0__or2_1
* cell instance $1030 m0 *1 1234.8,1512
X$1030 28219 29157 29217 13180 29146 29212 gf180mcu_fd_sc_mcu9t5v0__dffrnq_2
* cell instance $1031 m0 *1 1237.04,1522.08
X$1031 29294 23921 29285 29335 29362 gf180mcu_fd_sc_mcu9t5v0__nand2_1
* cell instance $1032 m0 *1 1322.72,1522.08
X$1032 19745 29141 28672 29285 29335 29278 gf180mcu_fd_sc_mcu9t5v0__mux2_1
* cell instance $1033 m0 *1 1321.6,1522.08
X$1033 29335 29285 gf180mcu_fd_sc_mcu9t5v0__filltie
* cell instance $1034 m0 *1 1352.96,1522.08
X$1034 29350 29282 29285 29335 29283 gf180mcu_fd_sc_mcu9t5v0__nand2_1
* cell instance $1035 m0 *1 1109.36,1522.08
X$1035 18614 29170 29285 29335 29358 gf180mcu_fd_sc_mcu9t5v0__nand2_1
* cell instance $1036 m0 *1 1112.16,1522.08
X$1036 27638 29291 29346 13331 29285 29335 gf180mcu_fd_sc_mcu9t5v0__dffrnq_2
* cell instance $1037 m0 *1 1155.84,1522.08
X$1037 29346 29285 29335 29154 29132 gf180mcu_fd_sc_mcu9t5v0__xor2_1
* cell instance $1038 m0 *1 1145.76,1522.08
X$1038 29346 29154 29285 29335 29347 gf180mcu_fd_sc_mcu9t5v0__xnor2_1
* cell instance $1039 m0 *1 1153.04,1522.08
X$1039 29132 29275 29285 29335 29348 gf180mcu_fd_sc_mcu9t5v0__nand2_1
* cell instance $1040 m0 *1 1179.36,1522.08
X$1040 18277 29292 29285 29335 29293 gf180mcu_fd_sc_mcu9t5v0__nand2_1
* cell instance $1041 r0 *1 1242.64,1481.76
X$1041 28360 28394 28781 28874 28661 28880 gf180mcu_fd_sc_mcu9t5v0__aoi21_1
* cell instance $1042 m0 *1 1239.28,1491.84
X$1042 27789 28646 28539 29294 28536 28929 28874 28937 28941
+ gf180mcu_fd_sc_mcu9t5v0__aoi222_1
* cell instance $1043 m0 *1 1239.84,1471.68
X$1043 26013 28394 28512 28378 28530 28511 gf180mcu_fd_sc_mcu9t5v0__aoi21_1
* cell instance $1044 r0 *1 1237.6,1471.68
X$1044 27106 28646 28539 28645 28536 27823 28635 28530 28537
+ gf180mcu_fd_sc_mcu9t5v0__aoi222_1
* cell instance $1045 m0 *1 1239.28,1391.04
X$1045 18614 26051 22717 24963 25997 26166 26180
+ gf180mcu_fd_sc_mcu9t5v0__aoi22_1
* cell instance $1046 m0 *1 1235.92,1622.88
X$1046 29929 30574 30658 13180 30634 30705 gf180mcu_fd_sc_mcu9t5v0__dffrnq_2
* cell instance $1047 m0 *1 1237.04,1632.96
X$1047 30829 30767 30837 31032 gf180mcu_fd_sc_mcu9t5v0__buf_8
* cell instance $1048 m0 *1 1310.96,1632.96
X$1048 30660 30644 30767 30837 30529 gf180mcu_fd_sc_mcu9t5v0__xnor2_1
* cell instance $1049 m0 *1 1322.72,1592.64
X$1049 30294 30293 30231 30295 30182 gf180mcu_fd_sc_mcu9t5v0__xnor2_1
* cell instance $1050 m0 *1 1314.88,1592.64
X$1050 30240 30231 30295 30292 30241 gf180mcu_fd_sc_mcu9t5v0__xor2_1
* cell instance $1051 m0 *1 1341.76,1592.64
X$1051 30184 30241 30231 30295 30243 30155 gf180mcu_fd_sc_mcu9t5v0__xnor3_1
* cell instance $1052 m0 *1 1311.52,1582.56
X$1052 29929 30106 30159 gf180mcu_fd_sc_mcu9t5v0__clkinv_8
* cell instance $1053 r0 *1 1310.4,1562.4
X$1053 29929 29910 29854 13180 29973 29903 gf180mcu_fd_sc_mcu9t5v0__dffrnq_2
* cell instance $1054 m0 *1 1302,1612.8
X$1054 30629 30528 30489 30570 30437 30661 gf180mcu_fd_sc_mcu9t5v0__xor3_2
* cell instance $1055 m0 *1 1321.6,1592.64
X$1055 30295 30231 gf180mcu_fd_sc_mcu9t5v0__filltie
* cell instance $1056 m0 *1 1281.84,1592.64
X$1056 30506 30367 30291 30231 30295 30303 gf180mcu_fd_sc_mcu9t5v0__oai21_1
* cell instance $1057 m0 *1 1290.8,1592.64
X$1057 30572 30179 30231 30295 31348 gf180mcu_fd_sc_mcu9t5v0__nand2_1
* cell instance $1058 m0 *1 1288.56,1592.64
X$1058 30239 30231 30295 30179 gf180mcu_fd_sc_mcu9t5v0__inv_1
* cell instance $1059 r0 *1 1299.2,1542.24
X$1059 28219 29647 29645 13180 29714 29636 gf180mcu_fd_sc_mcu9t5v0__dffrnq_2
* cell instance $1060 m0 *1 1312.08,1622.88
X$1060 30660 30644 30661 30634 30705 30662 gf180mcu_fd_sc_mcu9t5v0__and3_1
* cell instance $1061 m0 *1 1374.8,1632.96
X$1061 30576 30779 30767 30837 30931 gf180mcu_fd_sc_mcu9t5v0__nand2_1
* cell instance $1062 m0 *1 1322.72,1643.04
X$1062 30905 30930 30980 30912 30982 30906 gf180mcu_fd_sc_mcu9t5v0__aoi21_1
* cell instance $1063 m0 *1 1317.12,1643.04
X$1063 30927 30983 30912 30982 30980 gf180mcu_fd_sc_mcu9t5v0__and2_1
* cell instance $1064 m0 *1 1330.56,1653.12
X$1064 30977 31054 31118 31114 31139 gf180mcu_fd_sc_mcu9t5v0__xor2_1
* cell instance $1065 m0 *1 1341.2,1653.12
X$1065 31116 31115 31054 31118 31047 gf180mcu_fd_sc_mcu9t5v0__xnor2_1
* cell instance $1066 r0 *1 1347.36,1643.04
X$1066 31034 31047 31054 30982 31062 gf180mcu_fd_sc_mcu9t5v0__and2_1
* cell instance $1067 m0 *1 1321.6,1602.72
X$1067 30419 30361 gf180mcu_fd_sc_mcu9t5v0__filltie
* cell instance $1068 r0 *1 1335.6,1602.72
X$1068 30527 29280 30489 30419 30418 gf180mcu_fd_sc_mcu9t5v0__nand2_1
* cell instance $1069 m0 *1 1321.6,1612.8
X$1069 30570 30489 gf180mcu_fd_sc_mcu9t5v0__filltie
* cell instance $1070 m0 *1 1332.8,1602.72
X$1070 30417 30418 30361 30419 30184 gf180mcu_fd_sc_mcu9t5v0__or2_1
* cell instance $1071 m0 *1 1337.28,1602.72
X$1071 30417 30418 30361 30419 29495 gf180mcu_fd_sc_mcu9t5v0__xnor2_1
* cell instance $1072 r0 *1 1339.52,1602.72
X$1072 29350 30527 30489 30419 29585 gf180mcu_fd_sc_mcu9t5v0__nand2_1
* cell instance $1073 r0 *1 1348.48,1612.8
X$1073 30510 30631 30634 30570 30532 gf180mcu_fd_sc_mcu9t5v0__nor2_1
* cell instance $1074 r0 *1 1351.84,1612.8
X$1074 30510 30631 30634 30570 30630 gf180mcu_fd_sc_mcu9t5v0__nand2_1
* cell instance $1075 m0 *1 1345.12,1612.8
X$1075 30509 30532 30630 30489 30570 30576 gf180mcu_fd_sc_mcu9t5v0__oai21_1
* cell instance $1076 m0 *1 1347.92,1653.12
X$1076 31034 31047 31054 31118 31048 gf180mcu_fd_sc_mcu9t5v0__xnor2_1
* cell instance $1077 m0 *1 1312.64,1653.12
X$1077 31137 31113 31054 31118 30905 gf180mcu_fd_sc_mcu9t5v0__nor2_1
* cell instance $1078 m0 *1 1322.72,1612.8
X$1078 30531 29280 30489 30570 30292 gf180mcu_fd_sc_mcu9t5v0__nand2_1
* cell instance $1079 m0 *1 1325.52,1602.72
X$1079 30294 30293 30242 30361 30419 30509 gf180mcu_fd_sc_mcu9t5v0__aoi21_1
* cell instance $1080 m0 *1 1318.8,1612.8
X$1080 30530 30529 30489 30570 30575 gf180mcu_fd_sc_mcu9t5v0__nand2_1
* cell instance $1081 r0 *1 1322.16,1592.64
X$1081 30181 30293 30361 30295 30368 30294 gf180mcu_fd_sc_mcu9t5v0__xnor3_1
* cell instance $1082 m0 *1 1351.28,1602.72
X$1082 30368 30436 30361 30419 30441 gf180mcu_fd_sc_mcu9t5v0__nand2_1
* cell instance $1083 r0 *1 1350.16,1602.72
X$1083 30441 30489 30419 30510 gf180mcu_fd_sc_mcu9t5v0__clkinv_1
* cell instance $1084 m0 *1 1325.52,1612.8
X$1084 29350 30531 30489 30570 30417 gf180mcu_fd_sc_mcu9t5v0__nand2_1
* cell instance $1085 r0 *1 1352.4,1592.64
X$1085 30368 30436 30361 30295 30103 gf180mcu_fd_sc_mcu9t5v0__xnor2_1
* cell instance $1086 r0 *1 1333.92,1632.96
X$1086 30901 30912 30837 29350 gf180mcu_fd_sc_mcu9t5v0__buf_8
* cell instance $1087 r0 *1 1358,1643.04
X$1087 30764 31048 31054 30982 31063 gf180mcu_fd_sc_mcu9t5v0__nor2_1
* cell instance $1088 m0 *1 1368.08,1643.04
X$1088 30777 30931 30913 30912 30982 30981 gf180mcu_fd_sc_mcu9t5v0__aoi21_1
* cell instance $1089 r0 *1 1374.24,1643.04
X$1089 31063 30981 31050 31054 30982 31049 gf180mcu_fd_sc_mcu9t5v0__oai21_1
* cell instance $1090 r0 *1 1375.92,1602.72
X$1090 30244 29058 30489 30419 30513 gf180mcu_fd_sc_mcu9t5v0__nor2_1
* cell instance $1091 m0 *1 1369.2,1653.12
X$1091 31063 30981 31054 31118 31117 gf180mcu_fd_sc_mcu9t5v0__nor2_1
* cell instance $1092 m0 *1 1372.56,1653.12
X$1092 31050 31117 31054 31118 28516 gf180mcu_fd_sc_mcu9t5v0__xnor2_1
* cell instance $1093 r0 *1 1375.36,1632.96
X$1093 30931 30777 30912 30837 30907 gf180mcu_fd_sc_mcu9t5v0__nand2_1
* cell instance $1094 r0 *1 1371.44,1612.8
X$1094 30511 30634 30570 30533 30442 gf180mcu_fd_sc_mcu9t5v0__xor2_2
* cell instance $1095 r0 *1 1352.4,1602.72
X$1095 30441 30631 30489 30419 30511 30509 gf180mcu_fd_sc_mcu9t5v0__xnor3_1
* cell instance $1096 r0 *1 1317.12,1632.96
X$1096 30905 30983 30912 30837 30927 30663 gf180mcu_fd_sc_mcu9t5v0__xor3_1
* cell instance $1097 m0 *1 1349.6,1612.8
X$1097 30533 30244 29058 30511 30489 30570 30665 30512
+ gf180mcu_fd_sc_mcu9t5v0__oai32_4
* cell instance $1098 r0 *1 1361.36,1643.04
X$1098 30764 31048 31054 30982 30913 gf180mcu_fd_sc_mcu9t5v0__xnor2_1
* cell instance $1099 m0 *1 1357.44,1632.96
X$1099 30763 30767 30837 30833 30835 gf180mcu_fd_sc_mcu9t5v0__xor2_1
* cell instance $1100 r0 *1 1363.04,1632.96
X$1100 30906 30835 30912 30837 30765 gf180mcu_fd_sc_mcu9t5v0__nor2_1
* cell instance $1101 m0 *1 1365.28,1632.96
X$1101 30906 30835 30767 30837 30766 gf180mcu_fd_sc_mcu9t5v0__xnor2_1
* cell instance $1102 m0 *1 1322.72,1622.88
X$1102 30530 30663 30634 30705 30529 30631 gf180mcu_fd_sc_mcu9t5v0__xor3_2
* cell instance $1103 r0 *1 1378.16,1622.88
X$1103 30766 30767 30705 30779 gf180mcu_fd_sc_mcu9t5v0__clkinv_1
* cell instance $1104 r0 *1 1322.16,1622.88
X$1104 30530 30529 30767 30705 30762 gf180mcu_fd_sc_mcu9t5v0__nor2_1
* cell instance $1105 r0 *1 1371.44,1622.88
X$1105 30576 30766 30767 30705 30666 gf180mcu_fd_sc_mcu9t5v0__xnor2_1
* cell instance $1106 m0 *1 1373.68,1622.88
X$1106 30665 30634 30705 30666 30667 gf180mcu_fd_sc_mcu9t5v0__xor2_1
* cell instance $1107 m0 *1 1321.6,1632.96
X$1107 30837 30767 gf180mcu_fd_sc_mcu9t5v0__filltie
* cell instance $1108 m0 *1 1321.6,1643.04
X$1108 30982 30912 gf180mcu_fd_sc_mcu9t5v0__filltie
* cell instance $1109 m0 *1 1321.6,1653.12
X$1109 31118 31054 gf180mcu_fd_sc_mcu9t5v0__filltie
* cell instance $1110 m0 *1 1355.2,1632.96
X$1110 30833 30767 30837 30834 gf180mcu_fd_sc_mcu9t5v0__clkinv_1
* cell instance $1111 r0 *1 1326.64,1622.88
X$1111 30663 30575 30762 30767 30705 30833 gf180mcu_fd_sc_mcu9t5v0__aoi21_1
* cell instance $1112 r0 *1 1372.56,1602.72
X$1112 30442 30489 30419 30512 gf180mcu_fd_sc_mcu9t5v0__clkinv_1
* cell instance $1113 m0 *1 1321.6,1622.88
X$1113 30705 30634 gf180mcu_fd_sc_mcu9t5v0__filltie
* cell instance $1114 r0 *1 1342.32,1622.88
X$1114 30708 30661 30767 30705 30763 30664 gf180mcu_fd_sc_mcu9t5v0__xnor3_1
* cell instance $1115 r0 *1 1335.6,1622.88
X$1115 30708 30661 30767 30705 30709 gf180mcu_fd_sc_mcu9t5v0__xnor2_1
* cell instance $1116 m0 *1 1344,1622.88
X$1116 30664 30709 30662 30634 30705 31116 gf180mcu_fd_sc_mcu9t5v0__aoi21_1
* cell instance $1117 m0 *1 1312.64,1643.04
X$1117 30927 30983 30912 30982 30930 gf180mcu_fd_sc_mcu9t5v0__or2_1
* cell instance $1118 r0 *1 1359.12,1622.88
X$1118 30834 30763 30765 30767 30705 30764 gf180mcu_fd_sc_mcu9t5v0__aoi21_1
* cell instance $1119 m0 *1 1253.84,1643.04
X$1119 30658 30829 30912 30982 30831 gf180mcu_fd_sc_mcu9t5v0__nand2_1
* cell instance $1120 r0 *1 1295.84,1643.04
X$1120 30979 30928 31054 30982 30180 31061 gf180mcu_fd_sc_mcu9t5v0__xnor3_1
* cell instance $1121 m0 *1 1265.04,1632.96
X$1121 30526 30832 30767 30837 30830 gf180mcu_fd_sc_mcu9t5v0__nand2_1
* cell instance $1122 m0 *1 1254.4,1632.96
X$1122 30831 30830 30767 30837 30843 gf180mcu_fd_sc_mcu9t5v0__nand2_1
* cell instance $1123 m0 *1 1260.56,1632.96
X$1123 30831 30830 30767 30837 30844 gf180mcu_fd_sc_mcu9t5v0__nor2_1
* cell instance $1124 m0 *1 1256.64,1643.04
X$1124 30924 30843 30844 30912 30982 30977 gf180mcu_fd_sc_mcu9t5v0__aoi21_1
* cell instance $1125 r0 *1 1287.44,1643.04
X$1125 29282 31060 31032 29277 31054 30982 29556
+ gf180mcu_fd_sc_mcu9t5v0__aoi22_1
* cell instance $1126 r0 *1 1276.24,1643.04
X$1126 29277 31032 31054 30982 31033 gf180mcu_fd_sc_mcu9t5v0__nand2_1
* cell instance $1127 r0 *1 1258.32,1632.96
X$1127 30831 30830 30912 30837 30924 30660 gf180mcu_fd_sc_mcu9t5v0__xor3_2
* cell instance $1128 m0 *1 1294.16,1643.04
X$1128 30527 31060 30912 30982 30928 gf180mcu_fd_sc_mcu9t5v0__nand2_1
* cell instance $1129 r0 *1 1281.84,1643.04
X$1129 29282 31032 30832 29277 31054 30982 30929
+ gf180mcu_fd_sc_mcu9t5v0__aoi22_1
* cell instance $1130 m0 *1 1270.64,1643.04
X$1130 30526 31046 30912 30982 30978 gf180mcu_fd_sc_mcu9t5v0__nand2_1
* cell instance $1131 m0 *1 1280.72,1643.04
X$1131 30845 31033 30928 30929 30912 30982 30294
+ gf180mcu_fd_sc_mcu9t5v0__oai22_2
* cell instance $1132 r0 *1 1275.68,1632.96
X$1132 30904 30845 30912 30837 30846 30925 gf180mcu_fd_sc_mcu9t5v0__xnor3_1
* cell instance $1133 r0 *1 1293.04,1643.04
X$1133 29277 31060 31054 30982 28653 gf180mcu_fd_sc_mcu9t5v0__nand2_1
* cell instance $1134 r0 *1 1304.8,1632.96
X$1134 30979 28653 30912 30837 30155 gf180mcu_fd_sc_mcu9t5v0__nor2_1
* cell instance $1135 r0 *1 1302.56,1602.72
X$1135 30629 30437 30489 30419 30440 gf180mcu_fd_sc_mcu9t5v0__and2_1
* cell instance $1136 r0 *1 1289.12,1612.8
X$1136 30414 29277 30505 30433 30634 30570 30629 gf180mcu_fd_sc_mcu9t5v0__and4_1
* cell instance $1137 r0 *1 1284.08,1602.72
X$1137 30522 30167 30489 30419 30416 gf180mcu_fd_sc_mcu9t5v0__nand2_1
* cell instance $1138 m0 *1 1290.8,1622.88
X$1138 29277 30505 30634 30705 30659 gf180mcu_fd_sc_mcu9t5v0__nand2_1
* cell instance $1139 m0 *1 1288,1602.72
X$1139 30416 30506 30361 30419 30437 30415 gf180mcu_fd_sc_mcu9t5v0__xnor3_1
* cell instance $1140 m0 *1 1285.2,1602.72
X$1140 30414 30433 30361 30419 30415 gf180mcu_fd_sc_mcu9t5v0__nand2_1
* cell instance $1141 r0 *1 1298.08,1602.72
X$1141 30629 30437 30489 30419 30507 gf180mcu_fd_sc_mcu9t5v0__or2_1
* cell instance $1142 m0 *1 1267.28,1612.8
X$1142 30526 30489 30570 30527 gf180mcu_fd_sc_mcu9t5v0__buf_8
* cell instance $1143 r0 *1 1304.24,1612.8
X$1143 30629 30643 30634 30570 30644 gf180mcu_fd_sc_mcu9t5v0__nor2_1
* cell instance $1144 r0 *1 1307.04,1602.72
X$1144 30528 30507 30440 30489 30419 30508 gf180mcu_fd_sc_mcu9t5v0__aoi21_1
* cell instance $1145 r0 *1 1279.6,1592.64
X$1145 30239 30361 30295 30414 gf180mcu_fd_sc_mcu9t5v0__buf_8
* cell instance $1146 r0 *1 1291.92,1622.88
X$1146 30659 30846 30767 30705 30436 gf180mcu_fd_sc_mcu9t5v0__xnor2_1
* cell instance $1147 m0 *1 1267.84,1643.04
X$1147 30526 31032 30912 30982 30904 gf180mcu_fd_sc_mcu9t5v0__nand2_1
* cell instance $1148 m0 *1 1263.92,1612.8
X$1148 30526 30489 30570 30435 gf180mcu_fd_sc_mcu9t5v0__inv_2
* cell instance $1149 m0 *1 1251.04,1602.72
X$1149 30435 30164 29073 30364 29980 30361 30419 30434
+ gf180mcu_fd_sc_mcu9t5v0__oai221_1
* cell instance $1150 r0 *1 1284.08,1612.8
X$1150 29282 30505 30433 29277 30634 30570 30643
+ gf180mcu_fd_sc_mcu9t5v0__aoi22_1
* cell instance $1151 m0 *1 1280.16,1632.96
X$1151 30414 30832 30767 30837 30845 gf180mcu_fd_sc_mcu9t5v0__nand2_1
* cell instance $1152 r0 *1 1271.76,1602.72
X$1152 30526 30505 30489 30419 30506 gf180mcu_fd_sc_mcu9t5v0__nand2_1
* cell instance $1153 m0 *1 1275.12,1602.72
X$1153 30572 30167 30433 30414 30361 30419 30367
+ gf180mcu_fd_sc_mcu9t5v0__aoi22_1
* cell instance $1154 m0 *1 1280.16,1602.72
X$1154 30572 30414 30167 30433 30361 30419 30291
+ gf180mcu_fd_sc_mcu9t5v0__nand4_1
* cell instance $1155 m0 *1 1282.96,1653.12
X$1155 29277 30832 31054 31118 31061 gf180mcu_fd_sc_mcu9t5v0__nand2_1
* cell instance $1156 m0 *1 1246.56,1653.12
X$1156 31112 31054 31118 31060 gf180mcu_fd_sc_mcu9t5v0__buf_8
* cell instance $1157 r0 *1 1251.04,1602.72
X$1157 29929 30434 30526 13180 30489 30419 gf180mcu_fd_sc_mcu9t5v0__dffrnq_2
* cell instance $1158 m0 *1 1254.96,1622.88
X$1158 30658 30634 30705 30531 gf180mcu_fd_sc_mcu9t5v0__buf_8
* cell instance $1159 m0 *1 1309.28,1622.88
X$1159 30660 30644 30634 30705 30708 gf180mcu_fd_sc_mcu9t5v0__nand2_1
* cell instance $1160 m0 *1 1284.64,1632.96
X$1160 30904 30845 30767 30837 30926 gf180mcu_fd_sc_mcu9t5v0__and2_1
* cell instance $1161 r0 *1 1261.12,1643.04
X$1161 30531 31054 30982 30524 gf180mcu_fd_sc_mcu9t5v0__inv_1
* cell instance $1162 r0 *1 1253.84,1643.04
X$1162 31194 31112 31054 30982 30924 gf180mcu_fd_sc_mcu9t5v0__and2_1
* cell instance $1163 r0 *1 1298.64,1622.88
X$1163 29277 30505 30846 30767 30705 30530 gf180mcu_fd_sc_mcu9t5v0__nand3_1
* cell instance $1164 r0 *1 1279.04,1643.04
X$1164 30531 31060 31054 30982 30925 gf180mcu_fd_sc_mcu9t5v0__nand2_1
* cell instance $1165 m0 *1 1275.12,1643.04
X$1165 30830 30979 30926 30925 30912 30982 30927
+ gf180mcu_fd_sc_mcu9t5v0__oai22_1
* cell instance $1166 m0 *1 1285.76,1653.12
X$1166 29282 31032 31054 31118 30979 gf180mcu_fd_sc_mcu9t5v0__nand2_1
* cell instance $1167 m0 *1 1282.96,1562.4
X$1167 29645 26053 18277 29853 29841 29903 30359
+ gf180mcu_fd_sc_mcu9t5v0__oai211_1
* cell instance $1168 r0 *1 1291.36,1562.4
X$1168 29929 29909 29835 13180 29973 29903 gf180mcu_fd_sc_mcu9t5v0__dffrnq_2
* cell instance $1169 r0 *1 1296.4,1542.24
X$1169 26962 29215 29714 29636 29709 gf180mcu_fd_sc_mcu9t5v0__nand2_1
* cell instance $1170 r0 *1 1296.4,1582.56
X$1170 30239 30231 30159 29282 gf180mcu_fd_sc_mcu9t5v0__buf_8
* cell instance $1171 r0 *1 1284.08,1542.24
X$1171 29708 29420 29578 29714 29636 29646 gf180mcu_fd_sc_mcu9t5v0__and3_1
* cell instance $1172 m0 *1 1267.28,1532.16
X$1172 29473 29476 29408 29482 29478 gf180mcu_fd_sc_mcu9t5v0__nor2_1
* cell instance $1173 m0 *1 1272.32,1532.16
X$1173 29479 29478 29408 29482 26963 gf180mcu_fd_sc_mcu9t5v0__xnor2_1
* cell instance $1174 r0 *1 1252.72,1522.08
X$1174 27967 23921 29408 29335 29475 gf180mcu_fd_sc_mcu9t5v0__nand2_1
* cell instance $1175 r0 *1 1246.56,1532.16
X$1175 23921 29476 29492 29475 29559 29482 29477
+ gf180mcu_fd_sc_mcu9t5v0__oai31_1
* cell instance $1176 m0 *1 1247.12,1532.16
X$1176 28219 29477 27967 13180 29408 29482 gf180mcu_fd_sc_mcu9t5v0__dffrnq_2
* cell instance $1177 r0 *1 1248.8,1562.4
X$1177 29980 29927 29973 29903 29901 gf180mcu_fd_sc_mcu9t5v0__nand2_1
* cell instance $1178 m0 *1 1280.16,1532.16
X$1178 29349 29480 29408 29482 29479 gf180mcu_fd_sc_mcu9t5v0__nand2_1
* cell instance $1179 r0 *1 1280.16,1522.08
X$1179 23177 29217 29408 29335 29420 gf180mcu_fd_sc_mcu9t5v0__nand2_1
* cell instance $1180 r0 *1 1249.36,1542.24
X$1180 29707 23921 29714 29636 29717 gf180mcu_fd_sc_mcu9t5v0__nand2_1
* cell instance $1181 r0 *1 1250.48,1552.32
X$1181 29137 23921 29841 29769 29927 gf180mcu_fd_sc_mcu9t5v0__nand2_1
* cell instance $1182 r0 *1 1266.72,1552.32
X$1182 29293 29928 29841 29769 29902 gf180mcu_fd_sc_mcu9t5v0__nand2_1
* cell instance $1183 r0 *1 1264.48,1552.32
X$1183 28782 29841 29769 29833 gf180mcu_fd_sc_mcu9t5v0__clkinv_1
* cell instance $1184 r0 *1 1269.52,1552.32
X$1184 29852 28539 29833 29841 29769 29834 gf180mcu_fd_sc_mcu9t5v0__aoi21_1
* cell instance $1185 r0 *1 1268.96,1562.4
X$1185 29852 23921 29973 29903 29928 gf180mcu_fd_sc_mcu9t5v0__nand2_1
* cell instance $1186 r0 *1 1270.08,1532.16
X$1186 29473 29476 29479 29559 29482 29578 gf180mcu_fd_sc_mcu9t5v0__oai21_1
* cell instance $1187 r0 *1 1279.6,1542.24
X$1187 29420 29578 29708 29714 29636 29644 gf180mcu_fd_sc_mcu9t5v0__aoi21_1
* cell instance $1188 r0 *1 1252.72,1582.56
X$1188 30179 30164 29985 30364 29414 30231 30159 30238
+ gf180mcu_fd_sc_mcu9t5v0__oai221_1
* cell instance $1189 m0 *1 1284.64,1532.16
X$1189 29349 29408 29482 29493 gf180mcu_fd_sc_mcu9t5v0__clkinv_1
* cell instance $1190 r0 *1 1281.84,1532.16
X$1190 29480 29417 29493 29559 29482 29579 gf180mcu_fd_sc_mcu9t5v0__aoi21_1
* cell instance $1191 m0 *1 1284.08,1552.32
X$1191 29708 29579 29714 29769 29766 gf180mcu_fd_sc_mcu9t5v0__nor2_1
* cell instance $1192 m0 *1 1288,1542.24
X$1192 29708 29559 29636 29633 gf180mcu_fd_sc_mcu9t5v0__clkinv_1
* cell instance $1193 m0 *1 1282.4,1542.24
X$1193 29480 29417 29633 29493 29559 29636 29584
+ gf180mcu_fd_sc_mcu9t5v0__aoi211_1
* cell instance $1194 r0 *1 1286.88,1572.48
X$1194 30154 30106 30039 30167 gf180mcu_fd_sc_mcu9t5v0__inv_1
* cell instance $1195 r0 *1 1285.2,1552.32
X$1195 29766 29584 26053 29841 29769 29853 gf180mcu_fd_sc_mcu9t5v0__oai21_1
* cell instance $1196 m0 *1 1263.92,1542.24
X$1196 29479 29559 29636 29417 29577 gf180mcu_fd_sc_mcu9t5v0__xor2_1
* cell instance $1197 m0 *1 1266.72,1582.56
X$1197 30167 30164 29834 30364 29293 30106 30159 30153
+ gf180mcu_fd_sc_mcu9t5v0__oai221_1
* cell instance $1198 r0 *1 1262.8,1532.16
X$1198 29217 29577 26053 29559 29482 29576 gf180mcu_fd_sc_mcu9t5v0__mux2_1
* cell instance $1199 m0 *1 1292.48,1582.56
X$1199 30154 30106 30159 29277 gf180mcu_fd_sc_mcu9t5v0__buf_8
* cell instance $1200 m0 *1 1273.44,1582.56
X$1200 29929 30153 30154 13180 30106 30159 gf180mcu_fd_sc_mcu9t5v0__dffrnq_2
* cell instance $1201 m0 *1 1299.2,1552.32
X$1201 29835 29714 29769 29709 29553 gf180mcu_fd_sc_mcu9t5v0__xor2_1
* cell instance $1202 r0 *1 1302.56,1532.16
X$1202 18614 29553 27832 29559 29482 29580 gf180mcu_fd_sc_mcu9t5v0__aoi21_1
* cell instance $1203 r0 *1 1259.44,1582.56
X$1203 30035 30238 30239 13180 30231 30159 gf180mcu_fd_sc_mcu9t5v0__dffrnq_2
* cell instance $1204 m0 *1 1262.8,1562.4
X$1204 28219 29902 29852 13180 29841 29903 gf180mcu_fd_sc_mcu9t5v0__dffrnq_2
* cell instance $1205 m0 *1 1301.44,1542.24
X$1205 29645 29580 26904 29559 29636 29647 gf180mcu_fd_sc_mcu9t5v0__mux2_1
* cell instance $1206 m0 *1 1243.76,1562.4
X$1206 30035 29901 29137 13180 29841 29903 gf180mcu_fd_sc_mcu9t5v0__dffrnq_2
* cell instance $1207 m0 *1 1298.08,1562.4
X$1207 22168 29835 28672 29841 29903 29909 gf180mcu_fd_sc_mcu9t5v0__mux2_1
* cell instance $1208 r0 *1 1324.4,1582.56
X$1208 30181 30182 30231 30159 30242 gf180mcu_fd_sc_mcu9t5v0__nor2_1
* cell instance $1209 r0 *1 1356.88,1552.32
X$1209 29929 29837 28113 13180 29841 29769 gf180mcu_fd_sc_mcu9t5v0__dffrnq_2
* cell instance $1210 r0 *1 1318.8,1532.16
X$1210 27995 29581 29559 29482 29583 gf180mcu_fd_sc_mcu9t5v0__nor2_1
* cell instance $1211 r0 *1 1322.16,1532.16
X$1211 29554 29583 29559 29482 28678 gf180mcu_fd_sc_mcu9t5v0__xnor2_1
* cell instance $1212 r0 *1 1318.8,1582.56
X$1212 30240 30292 30231 30159 30181 gf180mcu_fd_sc_mcu9t5v0__or2_1
* cell instance $1213 r0 *1 1340.64,1582.56
X$1213 30155 30241 30231 30159 30183 gf180mcu_fd_sc_mcu9t5v0__xnor2_1
* cell instance $1214 r0 *1 1360.24,1572.48
X$1214 30157 30103 30106 30039 30043 gf180mcu_fd_sc_mcu9t5v0__or2_1
* cell instance $1215 r0 *1 1329.44,1562.4
X$1215 22832 29778 28672 29973 29903 29986 gf180mcu_fd_sc_mcu9t5v0__mux2_1
* cell instance $1216 r0 *1 1356.32,1582.56
X$1216 30243 30180 30231 30159 30157 gf180mcu_fd_sc_mcu9t5v0__nand2_1
* cell instance $1217 m0 *1 1358.56,1582.56
X$1217 30157 30156 30106 30159 29351 30103 gf180mcu_fd_sc_mcu9t5v0__xnor3_1
* cell instance $1218 r0 *1 1375.36,1582.56
X$1218 29351 30231 30159 30244 gf180mcu_fd_sc_mcu9t5v0__clkinv_1
* cell instance $1219 r0 *1 1368.64,1522.08
X$1219 29220 29363 28545 29408 29335 28222 gf180mcu_fd_sc_mcu9t5v0__aoi21_1
* cell instance $1220 m0 *1 1366.96,1532.16
X$1220 28545 29220 29363 29408 29482 29422 gf180mcu_fd_sc_mcu9t5v0__and3_1
* cell instance $1221 r0 *1 1373.12,1522.08
X$1221 25282 28222 29422 29408 29335 29364 gf180mcu_fd_sc_mcu9t5v0__or3_1
* cell instance $1222 r0 *1 1347.36,1582.56
X$1222 30184 30183 30231 30159 30168 gf180mcu_fd_sc_mcu9t5v0__nor2_1
* cell instance $1223 r0 *1 1359.12,1582.56
X$1223 30243 30180 30231 30159 29174 gf180mcu_fd_sc_mcu9t5v0__xnor2_1
* cell instance $1224 r0 *1 1347.92,1562.4
X$1224 29929 29855 29077 13180 29973 29903 gf180mcu_fd_sc_mcu9t5v0__dffrnq_2
* cell instance $1225 m0 *1 1321.6,1572.48
X$1225 30039 29973 gf180mcu_fd_sc_mcu9t5v0__filltie
* cell instance $1226 r0 *1 1368.08,1542.24
X$1226 22828 29554 28672 29714 29636 29711 gf180mcu_fd_sc_mcu9t5v0__mux2_1
* cell instance $1227 m0 *1 1366.96,1562.4
X$1227 28113 23921 29841 29903 29836 gf180mcu_fd_sc_mcu9t5v0__nand2_1
* cell instance $1228 r0 *1 1365.84,1582.56
X$1228 30156 30169 30043 30231 30159 30442 gf180mcu_fd_sc_mcu9t5v0__oai21_1
* cell instance $1229 r0 *1 1372,1582.56
X$1229 30187 30185 30231 30159 30186 gf180mcu_fd_sc_mcu9t5v0__nor2_1
* cell instance $1230 m0 *1 1321.6,1582.56
X$1230 30159 30106 gf180mcu_fd_sc_mcu9t5v0__filltie
* cell instance $1231 m0 *1 1354.08,1582.56
X$1231 30157 30103 30106 30159 30169 gf180mcu_fd_sc_mcu9t5v0__and2_1
* cell instance $1232 m0 *1 1321.6,1562.4
X$1232 29903 29841 gf180mcu_fd_sc_mcu9t5v0__filltie
* cell instance $1233 r0 *1 1319.36,1552.32
X$1233 29835 29215 26962 29841 29769 29710 gf180mcu_fd_sc_mcu9t5v0__oai21_1
* cell instance $1234 r0 *1 1322.72,1542.24
X$1234 29778 29714 29636 29710 28933 gf180mcu_fd_sc_mcu9t5v0__xor2_1
* cell instance $1235 m0 *1 1335.04,1552.32
X$1235 29645 29714 29769 29767 gf180mcu_fd_sc_mcu9t5v0__clkinv_1
* cell instance $1236 m0 *1 1337.28,1552.32
X$1236 22856 29767 29714 29769 29648 gf180mcu_fd_sc_mcu9t5v0__nor2_1
* cell instance $1237 r0 *1 1335.6,1542.24
X$1237 29648 29584 29057 29714 29636 29363 gf180mcu_fd_sc_mcu9t5v0__oai21_1
* cell instance $1238 m0 *1 1313.76,1562.4
X$1238 29845 29854 23921 29841 29903 29910 gf180mcu_fd_sc_mcu9t5v0__mux2_1
* cell instance $1239 m0 *1 1337.84,1542.24
X$1239 29057 29648 29584 29559 29636 29635 gf180mcu_fd_sc_mcu9t5v0__nor3_1
* cell instance $1240 r0 *1 1344.56,1542.24
X$1240 26053 29363 29714 29636 29634 gf180mcu_fd_sc_mcu9t5v0__nand2_1
* cell instance $1241 m0 *1 1334.48,1542.24
X$1241 29635 29634 29559 29636 29279 gf180mcu_fd_sc_mcu9t5v0__nor2_1
* cell instance $1242 m0 *1 1341.76,1532.16
X$1242 29282 29280 29408 29482 29555 gf180mcu_fd_sc_mcu9t5v0__nand2_1
* cell instance $1243 r0 *1 1343.44,1532.16
X$1243 29585 29555 29559 29482 29481 gf180mcu_fd_sc_mcu9t5v0__or2_1
* cell instance $1244 m0 *1 1354.64,1532.16
X$1244 29481 29495 29408 29482 29221 gf180mcu_fd_sc_mcu9t5v0__or2_1
* cell instance $1245 r0 *1 1349.04,1532.16
X$1245 29481 29495 29559 29482 29557 gf180mcu_fd_sc_mcu9t5v0__xnor2_1
* cell instance $1246 r0 *1 1355.76,1532.16
X$1246 30155 29557 29556 29559 29482 29175 gf180mcu_fd_sc_mcu9t5v0__or3_1
* cell instance $1247 m0 *1 1351.84,1542.24
X$1247 30155 29556 29557 29559 29636 29421 gf180mcu_fd_sc_mcu9t5v0__oai21_1
* cell instance $1248 m0 *1 1348.48,1562.4
X$1248 29077 29851 18277 29841 29903 29855 gf180mcu_fd_sc_mcu9t5v0__mux2_1
* cell instance $1249 r0 *1 1340.64,1532.16
X$1249 29585 29555 29559 29482 29494 gf180mcu_fd_sc_mcu9t5v0__nand2_1
* cell instance $1250 m0 *1 1349.04,1532.16
X$1250 29481 29494 29408 29482 28546 gf180mcu_fd_sc_mcu9t5v0__nand2_1
* cell instance $1251 m0 *1 1323.84,1552.32
X$1251 22856 29645 29714 29769 29708 gf180mcu_fd_sc_mcu9t5v0__xnor2_1
* cell instance $1252 r0 *1 1340.08,1542.24
X$1252 22856 29645 29644 29714 29636 29005 gf180mcu_fd_sc_mcu9t5v0__aoi21_1
* cell instance $1253 m0 *1 1324.4,1542.24
X$1253 29554 29559 29636 29582 gf180mcu_fd_sc_mcu9t5v0__clkinv_1
* cell instance $1254 m0 *1 1317.12,1552.32
X$1254 29778 29835 29215 29714 29769 29581 gf180mcu_fd_sc_mcu9t5v0__nor3_1
* cell instance $1255 r0 *1 1316,1532.16
X$1255 29582 29581 29559 29482 29075 gf180mcu_fd_sc_mcu9t5v0__nand2_1
* cell instance $1256 m0 *1 1321.6,1532.16
X$1256 29482 29408 gf180mcu_fd_sc_mcu9t5v0__filltie
* cell instance $1257 m0 *1 1321.6,1542.24
X$1257 29636 29559 gf180mcu_fd_sc_mcu9t5v0__filltie
* cell instance $1258 m0 *1 1321.6,1552.32
X$1258 29769 29714 gf180mcu_fd_sc_mcu9t5v0__filltie
* cell instance $1259 r0 *1 1316,1572.48
X$1259 22858 30106 30039 29929 gf180mcu_fd_sc_mcu9t5v0__clkbuf_8
* cell instance $1260 r0 *1 1347.92,1552.32
X$1260 23921 29644 29646 29836 29841 29769 29837
+ gf180mcu_fd_sc_mcu9t5v0__oai31_1
* cell instance $1261 m0 *1 1346.24,1582.56
X$1261 30155 30241 30168 30106 30159 30156 gf180mcu_fd_sc_mcu9t5v0__aoi21_1
* cell instance $1262 m0 *1 1323.84,1572.48
X$1262 29929 29986 29778 13180 29973 30039 gf180mcu_fd_sc_mcu9t5v0__dffrnq_2
* cell instance $1263 m0 *1 1202.88,1592.64
X$1263 22858 30231 30295 30035 gf180mcu_fd_sc_mcu9t5v0__clkbuf_8
* cell instance $1264 m0 *1 1171.52,1592.64
X$1264 30357 27377 18277 30231 30295 30299 gf180mcu_fd_sc_mcu9t5v0__mux2_1
* cell instance $1265 m0 *1 1182.16,1592.64
X$1265 30035 30234 30236 13180 30231 30295 gf180mcu_fd_sc_mcu9t5v0__dffrnq_2
* cell instance $1266 m0 *1 1129.52,1592.64
X$1266 30151 30231 30295 18277 gf180mcu_fd_sc_mcu9t5v0__buf_20
* cell instance $1267 m0 *1 1110.48,1592.64
X$1267 30177 30178 30289 13331 30231 30295 gf180mcu_fd_sc_mcu9t5v0__dffrnq_2
* cell instance $1268 r0 *1 1170.96,1643.04
X$1268 31029 18277 31133 29288 30975 31046 31054 30982 31030
+ gf180mcu_fd_sc_mcu9t5v0__aoi222_1
* cell instance $1269 m0 *1 1169.84,1542.24
X$1269 29716 29272 29567 29559 29636 29572 gf180mcu_fd_sc_mcu9t5v0__aoi21_1
* cell instance $1270 r0 *1 1170.96,1622.88
X$1270 30761 30758 18277 30767 30705 30775 gf180mcu_fd_sc_mcu9t5v0__mux2_1
* cell instance $1271 m0 *1 1219.68,1592.64
X$1271 30035 30290 30237 13180 30231 30295 gf180mcu_fd_sc_mcu9t5v0__dffrnq_2
* cell instance $1272 m0 *1 1170.96,1653.12
X$1272 30177 31111 13180 31118 30433 31054 gf180mcu_fd_sc_mcu9t5v0__dffrnq_4
* cell instance $1273 m0 *1 1164.24,1582.56
X$1273 30035 30033 25288 13180 30106 30159 gf180mcu_fd_sc_mcu9t5v0__dffrnq_2
* cell instance $1274 r0 *1 1169.28,1542.24
X$1274 30035 29572 29775 13180 29714 29636 gf180mcu_fd_sc_mcu9t5v0__dffrnq_2
* cell instance $1275 r0 *1 1166.48,1592.64
X$1275 30035 30299 30357 13180 30361 30295 gf180mcu_fd_sc_mcu9t5v0__dffrnq_2
* cell instance $1276 r0 *1 1159.76,1632.96
X$1276 30177 30900 30901 13180 30912 30837 gf180mcu_fd_sc_mcu9t5v0__dffrnq_2
* cell instance $1277 m0 *1 1168.16,1632.96
X$1277 30035 30775 30761 13180 30767 30837 gf180mcu_fd_sc_mcu9t5v0__dffrnq_2
* cell instance $1278 r0 *1 1225.84,1592.64
X$1278 18277 29576 30361 30295 30503 gf180mcu_fd_sc_mcu9t5v0__nand2_1
* cell instance $1279 r0 *1 1209.04,1612.8
X$1279 30628 30164 30366 30364 30503 30634 30570 30641
+ gf180mcu_fd_sc_mcu9t5v0__oai221_1
* cell instance $1280 m0 *1 1212.4,1622.88
X$1280 30035 30641 30657 13180 30634 30705 gf180mcu_fd_sc_mcu9t5v0__dffrnq_2
* cell instance $1281 r0 *1 1201.76,1622.88
X$1281 30705 30767 gf180mcu_fd_sc_mcu9t5v0__filltie
* cell instance $1282 m0 *1 1178.8,1602.72
X$1282 19292 30361 30419 22721 gf180mcu_fd_sc_mcu9t5v0__clkinv_1
* cell instance $1283 m0 *1 1237.6,1602.72
X$1283 30101 30413 30361 30419 30360 gf180mcu_fd_sc_mcu9t5v0__nand2_1
* cell instance $1284 r0 *1 1198.96,1592.64
X$1284 30358 23921 30361 30295 30365 gf180mcu_fd_sc_mcu9t5v0__nand2_1
* cell instance $1285 r0 *1 1182.72,1632.96
X$1285 30035 30902 30828 13180 30912 30837 gf180mcu_fd_sc_mcu9t5v0__dffrnq_2
* cell instance $1286 r0 *1 1230.88,1612.8
X$1286 31269 30164 28511 30364 29982 30634 30570 30642
+ gf180mcu_fd_sc_mcu9t5v0__oai221_1
* cell instance $1287 r0 *1 1214.08,1622.88
X$1287 30657 30767 30705 30628 gf180mcu_fd_sc_mcu9t5v0__clkinv_1
* cell instance $1288 r0 *1 1184.96,1602.72
X$1288 30572 30501 30164 30489 30419 30502 gf180mcu_fd_sc_mcu9t5v0__mux2_1
* cell instance $1289 m0 *1 1191.12,1643.04
X$1289 30828 30921 18277 30912 30982 30902 gf180mcu_fd_sc_mcu9t5v0__mux2_1
* cell instance $1290 r0 *1 1221.36,1643.04
X$1290 30832 31054 30982 31031 gf180mcu_fd_sc_mcu9t5v0__buf_8
* cell instance $1291 r0 *1 1201.76,1643.04
X$1291 30982 31054 gf180mcu_fd_sc_mcu9t5v0__filltie
* cell instance $1292 m0 *1 1192.8,1632.96
X$1292 30828 30761 28684 30767 30837 30776 gf180mcu_fd_sc_mcu9t5v0__mux2_1
* cell instance $1293 r0 *1 1214.08,1632.96
X$1293 30921 18277 30776 29288 30975 31031 30912 30837 30842
+ gf180mcu_fd_sc_mcu9t5v0__aoi222_1
* cell instance $1294 r0 *1 1201.76,1602.72
X$1294 30419 30489 gf180mcu_fd_sc_mcu9t5v0__filltie
* cell instance $1295 r0 *1 1211.84,1632.96
X$1295 30842 30912 30837 30923 gf180mcu_fd_sc_mcu9t5v0__clkinv_1
* cell instance $1296 m0 *1 1192.24,1653.12
X$1296 31248 31193 28684 31054 31118 31122 gf180mcu_fd_sc_mcu9t5v0__mux2_1
* cell instance $1297 m0 *1 1222.48,1653.12
X$1297 31131 18277 31122 29288 30975 31032 31054 31118 30976
+ gf180mcu_fd_sc_mcu9t5v0__aoi222_1
* cell instance $1298 m0 *1 1204,1643.04
X$1298 30922 30923 30832 13180 30912 30982 gf180mcu_fd_sc_mcu9t5v0__dffrnq_2
* cell instance $1299 r0 *1 1223.6,1632.96
X$1299 29929 30903 30829 13180 30912 30837 gf180mcu_fd_sc_mcu9t5v0__dffrnq_2
* cell instance $1300 r0 *1 1187.2,1612.8
X$1300 30522 30634 30570 30572 gf180mcu_fd_sc_mcu9t5v0__buf_8
* cell instance $1301 m0 *1 1226.4,1643.04
X$1301 30976 30912 30982 30903 gf180mcu_fd_sc_mcu9t5v0__clkinv_1
* cell instance $1302 r0 *1 1201.76,1632.96
X$1302 30837 30912 gf180mcu_fd_sc_mcu9t5v0__filltie
* cell instance $1303 r0 *1 1204,1592.64
X$1303 30358 28539 28536 30357 30301 30361 30295 30366
+ gf180mcu_fd_sc_mcu9t5v0__aoi221_1
* cell instance $1304 r0 *1 1221.92,1602.72
X$1304 31470 30164 28880 30364 29491 30489 30419 30504
+ gf180mcu_fd_sc_mcu9t5v0__oai221_1
* cell instance $1305 r0 *1 1201.76,1612.8
X$1305 30570 30634 gf180mcu_fd_sc_mcu9t5v0__filltie
* cell instance $1306 m0 *1 1206.8,1612.8
X$1306 30364 30300 30164 30523 30359 30489 30570 30573
+ gf180mcu_fd_sc_mcu9t5v0__oai221_1
* cell instance $1307 r0 *1 1206.24,1602.72
X$1307 30503 30365 30489 30419 30412 gf180mcu_fd_sc_mcu9t5v0__nand2_1
* cell instance $1308 r0 *1 1201.76,1592.64
X$1308 30295 30361 gf180mcu_fd_sc_mcu9t5v0__filltie
* cell instance $1309 r0 *1 1210.16,1592.64
X$1309 30237 28539 28536 30236 30301 30361 30295 30300
+ gf180mcu_fd_sc_mcu9t5v0__aoi221_1
* cell instance $1310 m0 *1 1176.56,1612.8
X$1310 30035 30502 30522 13180 30489 30570 gf180mcu_fd_sc_mcu9t5v0__dffrnq_2
* cell instance $1311 m0 *1 1196.72,1602.72
X$1311 30035 30412 30358 13180 30361 30419 gf180mcu_fd_sc_mcu9t5v0__dffrnq_2
* cell instance $1312 r0 *1 1223.04,1592.64
X$1312 30359 30302 30361 30295 30290 gf180mcu_fd_sc_mcu9t5v0__nand2_1
* cell instance $1313 m0 *1 1123.92,1653.12
X$1313 12383 31054 31118 18834 gf180mcu_fd_sc_mcu9t5v0__buf_20
* cell instance $1314 m0 *1 1136.24,1602.72
X$1314 30427 30429 23921 30361 30419 30428 gf180mcu_fd_sc_mcu9t5v0__mux2_1
* cell instance $1315 r0 *1 1158.08,1612.8
X$1315 30640 30627 30634 30570 30500 gf180mcu_fd_sc_mcu9t5v0__nand2_1
* cell instance $1316 m0 *1 1155.28,1602.72
X$1316 30432 30429 28684 30361 30419 30430 gf180mcu_fd_sc_mcu9t5v0__mux2_1
* cell instance $1317 r0 *1 1141.28,1622.88
X$1317 30760 30898 18277 30767 30705 30774 gf180mcu_fd_sc_mcu9t5v0__mux2_1
* cell instance $1318 r0 *1 1148.56,1622.88
X$1318 30760 30759 28684 30767 30705 30899 gf180mcu_fd_sc_mcu9t5v0__mux2_1
* cell instance $1319 m0 *1 1126.72,1643.04
X$1319 30974 30972 18277 30912 30982 30973 gf180mcu_fd_sc_mcu9t5v0__mux2_1
* cell instance $1320 m0 *1 1152.48,1602.72
X$1320 23921 30430 30361 30419 30431 gf180mcu_fd_sc_mcu9t5v0__nand2_1
* cell instance $1321 r0 *1 1148.56,1632.96
X$1321 30898 18277 30899 29288 30975 30901 30912 30837 30841
+ gf180mcu_fd_sc_mcu9t5v0__aoi222_1
* cell instance $1322 r0 *1 1160.88,1612.8
X$1322 30627 30431 30634 30570 30501 gf180mcu_fd_sc_mcu9t5v0__nand2_1
* cell instance $1323 r0 *1 1153.04,1612.8
X$1323 29272 30634 30570 26904 gf180mcu_fd_sc_mcu9t5v0__inv_1
* cell instance $1324 r0 *1 1155.28,1612.8
X$1324 30839 18277 30634 30570 30627 gf180mcu_fd_sc_mcu9t5v0__nand2_1
* cell instance $1325 m0 *1 1135.68,1612.8
X$1325 12383 30489 30570 13331 gf180mcu_fd_sc_mcu9t5v0__buf_20
* cell instance $1326 r0 *1 1154.72,1602.72
X$1326 30035 30500 30432 12383 30489 30419 gf180mcu_fd_sc_mcu9t5v0__dffrnq_2
* cell instance $1327 m0 *1 1136.24,1632.96
X$1327 30177 30774 30760 13180 30767 30837 gf180mcu_fd_sc_mcu9t5v0__dffrnq_2
* cell instance $1328 r0 *1 1106.56,1643.04
X$1328 30771 31059 31044 31054 30982 31043 gf180mcu_fd_sc_mcu9t5v0__oai21_1
* cell instance $1329 r0 *1 1141.28,1643.04
X$1329 30177 31045 31132 13180 31054 30982 gf180mcu_fd_sc_mcu9t5v0__dffrnq_2
* cell instance $1330 m0 *1 1117.76,1602.72
X$1330 30427 29773 30770 30361 30419 30426 gf180mcu_fd_sc_mcu9t5v0__mux2_1
* cell instance $1331 r0 *1 1112.16,1622.88
X$1331 30758 30757 30770 30767 30705 30773 gf180mcu_fd_sc_mcu9t5v0__mux2_1
* cell instance $1332 r0 *1 1114.4,1602.72
X$1332 30177 30426 30427 13331 30489 30419 gf180mcu_fd_sc_mcu9t5v0__dffrnq_2
* cell instance $1333 r0 *1 1126.72,1643.04
X$1333 22858 31054 30982 30177 gf180mcu_fd_sc_mcu9t5v0__clkbuf_8
* cell instance $1334 r0 *1 1133.44,1602.72
X$1334 30177 30428 30429 12383 30489 30419 gf180mcu_fd_sc_mcu9t5v0__dffrnq_2
* cell instance $1335 m0 *1 1123.92,1622.88
X$1335 30759 30656 18277 30634 30705 30707 gf180mcu_fd_sc_mcu9t5v0__mux2_1
* cell instance $1336 r0 *1 1105.44,1612.8
X$1336 30656 30639 30634 30570 30655 gf180mcu_fd_sc_mcu9t5v0__nand2_1
* cell instance $1337 r0 *1 1157.52,1632.96
X$1337 30841 30912 30837 30900 gf180mcu_fd_sc_mcu9t5v0__clkinv_1
* cell instance $1338 r0 *1 1116.08,1643.04
X$1338 30972 30639 31054 30982 31044 gf180mcu_fd_sc_mcu9t5v0__nand2_1
* cell instance $1339 m0 *1 1162.56,1602.72
X$1339 30432 23921 30361 30419 30640 gf180mcu_fd_sc_mcu9t5v0__nand2_1
* cell instance $1340 r0 *1 1121.68,1622.88
X$1340 30177 30707 30759 12383 30767 30705 gf180mcu_fd_sc_mcu9t5v0__dffrnq_2
* cell instance $1341 m0 *1 1143.52,1602.72
X$1341 29288 30096 30361 30419 30975 gf180mcu_fd_sc_mcu9t5v0__nor2_1
* cell instance $1342 m0 *1 1109.92,1632.96
X$1342 30177 30773 30758 12383 30767 30837 gf180mcu_fd_sc_mcu9t5v0__dffrnq_2
* cell instance $1343 r0 *1 1115.52,1532.16
X$1343 27638 29550 29569 13331 29559 29482 gf180mcu_fd_sc_mcu9t5v0__dffrnq_2
* cell instance $1344 m0 *1 1120.56,1532.16
X$1344 29486 29272 29358 29468 29408 29482 29568
+ gf180mcu_fd_sc_mcu9t5v0__aoi22_1
* cell instance $1345 r0 *1 1109.92,1532.16
X$1345 18614 22854 22411 29549 29559 29482 29550
+ gf180mcu_fd_sc_mcu9t5v0__oai31_1
* cell instance $1346 r0 *1 1132.88,1552.32
X$1346 29831 29841 29769 29847 gf180mcu_fd_sc_mcu9t5v0__clkinv_1
* cell instance $1347 r0 *1 1155.28,1542.24
X$1347 29642 29714 29636 29705 gf180mcu_fd_sc_mcu9t5v0__clkinv_1
* cell instance $1348 r0 *1 1148.56,1532.16
X$1348 29154 29559 29482 29552 gf180mcu_fd_sc_mcu9t5v0__clkinv_1
* cell instance $1349 r0 *1 1150.8,1532.16
X$1349 29346 29552 29559 29482 29570 gf180mcu_fd_sc_mcu9t5v0__nand2_1
* cell instance $1350 r0 *1 1119.44,1552.32
X$1350 29847 29272 29150 29841 29769 29846 gf180mcu_fd_sc_mcu9t5v0__aoi21_1
* cell instance $1351 r0 *1 1157.52,1532.16
X$1351 29346 29154 29559 29482 29571 gf180mcu_fd_sc_mcu9t5v0__nand2_1
* cell instance $1352 m0 *1 1115.52,1582.56
X$1352 30092 30106 30159 24836 gf180mcu_fd_sc_mcu9t5v0__buf_8
* cell instance $1353 r0 *1 1150.24,1522.08
X$1353 28925 29274 29347 29408 29335 29359 gf180mcu_fd_sc_mcu9t5v0__oai21_1
* cell instance $1354 r0 *1 1161.44,1552.32
X$1354 29571 29276 29642 29841 29769 29849 gf180mcu_fd_sc_mcu9t5v0__aoi21_1
* cell instance $1355 m0 *1 1127.28,1542.24
X$1355 27638 29568 29551 13331 29559 29636 gf180mcu_fd_sc_mcu9t5v0__dffrnq_2
* cell instance $1356 r0 *1 1141.84,1552.32
X$1356 29898 29704 29848 29841 29769 29759 gf180mcu_fd_sc_mcu9t5v0__oai21_1
* cell instance $1357 m0 *1 1140.72,1552.32
X$1357 29486 29569 29759 29714 29769 29758 gf180mcu_fd_sc_mcu9t5v0__oai21_1
* cell instance $1358 m0 *1 1121.68,1542.24
X$1358 29569 22854 29559 29636 29549 gf180mcu_fd_sc_mcu9t5v0__nand2_1
* cell instance $1359 r0 *1 1161.44,1562.4
X$1359 29642 29571 29276 29973 29903 29979 gf180mcu_fd_sc_mcu9t5v0__and3_1
* cell instance $1360 m0 *1 1154.16,1542.24
X$1360 29570 29359 29559 29636 29643 gf180mcu_fd_sc_mcu9t5v0__nand2_1
* cell instance $1361 r0 *1 1157.52,1542.24
X$1361 29642 29643 29714 29636 29706 gf180mcu_fd_sc_mcu9t5v0__xnor2_1
* cell instance $1362 m0 *1 1163.12,1562.4
X$1362 29831 29631 29849 29841 29903 29900 gf180mcu_fd_sc_mcu9t5v0__aoi21_1
* cell instance $1363 m0 *1 1165.92,1552.32
X$1363 26053 29706 29714 29769 29774 gf180mcu_fd_sc_mcu9t5v0__nand2_1
* cell instance $1364 m0 *1 1164.24,1572.48
X$1364 23921 29849 29979 30042 29973 30039 30033
+ gf180mcu_fd_sc_mcu9t5v0__oai31_1
* cell instance $1365 m0 *1 1117.2,1562.4
X$1365 27638 29846 29831 13331 29841 29903 gf180mcu_fd_sc_mcu9t5v0__dffrnq_2
* cell instance $1366 r0 *1 1107.12,1552.32
X$1366 29845 29897 29841 29769 25282 gf180mcu_fd_sc_mcu9t5v0__nand2_1
* cell instance $1367 r0 *1 1142.4,1572.48
X$1367 29551 26053 18277 30041 30106 30039 30101
+ gf180mcu_fd_sc_mcu9t5v0__oai211_1
* cell instance $1368 m0 *1 1140.72,1562.4
X$1368 29848 29898 29704 29841 29903 29899 gf180mcu_fd_sc_mcu9t5v0__or3_1
* cell instance $1369 r0 *1 1167.04,1552.32
X$1369 29831 26053 18277 29774 29841 29769 29980
+ gf180mcu_fd_sc_mcu9t5v0__oai211_1
* cell instance $1370 m0 *1 1146.88,1562.4
X$1370 29759 29899 29841 29903 29908 gf180mcu_fd_sc_mcu9t5v0__nand2_1
* cell instance $1371 m0 *1 1136.24,1562.4
X$1371 29847 29631 29841 29903 29898 gf180mcu_fd_sc_mcu9t5v0__nor2_1
* cell instance $1372 m0 *1 1156.4,1562.4
X$1372 29831 29631 29841 29903 29642 gf180mcu_fd_sc_mcu9t5v0__xnor2_1
* cell instance $1373 r0 *1 1158.08,1522.08
X$1373 29359 29348 29408 29335 29413 gf180mcu_fd_sc_mcu9t5v0__nand2_1
* cell instance $1374 m0 *1 1158.64,1532.16
X$1374 26053 29413 29408 29482 29487 gf180mcu_fd_sc_mcu9t5v0__nand2_1
* cell instance $1375 m0 *1 1161.44,1532.16
X$1375 29346 26053 18277 29487 29408 29482 29414
+ gf180mcu_fd_sc_mcu9t5v0__oai211_1
* cell instance $1376 r0 *1 1112.72,1582.56
X$1376 30284 18277 18272 30231 30159 30178 gf180mcu_fd_sc_mcu9t5v0__oai21_1
* cell instance $1377 r0 *1 1169.84,1572.48
X$1377 25288 23921 30106 30039 30042 gf180mcu_fd_sc_mcu9t5v0__nand2_1
* cell instance $1378 r0 *1 1138.48,1562.4
X$1378 29551 29569 29973 29903 29848 gf180mcu_fd_sc_mcu9t5v0__xnor2_1
* cell instance $1379 m0 *1 1138.48,1582.56
X$1379 29640 30106 30159 25715 gf180mcu_fd_sc_mcu9t5v0__buf_8
* cell instance $1380 m0 *1 1112.72,1582.56
X$1380 26004 30106 30159 30092 gf180mcu_fd_sc_mcu9t5v0__clkinv_1
* cell instance $1381 r0 *1 1120,1582.56
X$1381 30289 30231 30159 30284 gf180mcu_fd_sc_mcu9t5v0__clkinv_1
* cell instance $1382 r0 *1 1150.24,1542.24
X$1382 29570 29359 29705 29714 29636 29704 gf180mcu_fd_sc_mcu9t5v0__aoi21_1
* cell instance $1383 r0 *1 1145.2,1562.4
X$1383 29551 29569 29973 29903 29921 gf180mcu_fd_sc_mcu9t5v0__nand2_1
* cell instance $1384 r0 *1 1140.16,1532.16
X$1384 29551 29559 29482 29486 gf180mcu_fd_sc_mcu9t5v0__clkinv_1
* cell instance $1385 m0 *1 1144.08,1572.48
X$1385 26053 29908 29973 30039 30041 gf180mcu_fd_sc_mcu9t5v0__nand2_1
* cell instance $1386 m0 *1 1230.88,1532.16
X$1386 29470 29474 29575 29408 29482 29492 gf180mcu_fd_sc_mcu9t5v0__and3_1
* cell instance $1387 m0 *1 1229.76,1552.32
X$1387 29488 26053 18277 29764 29714 29769 29777
+ gf180mcu_fd_sc_mcu9t5v0__oai211_1
* cell instance $1388 m0 *1 1234.24,1582.56
X$1388 30165 30164 29173 30364 29777 30106 30159 30152
+ gf180mcu_fd_sc_mcu9t5v0__oai221_1
* cell instance $1389 m0 *1 1197.28,1572.48
X$1389 29760 29921 29922 29973 30039 29923 gf180mcu_fd_sc_mcu9t5v0__and3_1
* cell instance $1390 m0 *1 1238.16,1552.32
X$1390 29777 29717 29714 29769 29765 gf180mcu_fd_sc_mcu9t5v0__nand2_1
* cell instance $1391 m0 *1 1215.76,1552.32
X$1391 29776 29925 29762 29714 29769 29575 gf180mcu_fd_sc_mcu9t5v0__oai21_1
* cell instance $1392 r0 *1 1211.84,1532.16
X$1392 29050 29559 29482 29472 gf180mcu_fd_sc_mcu9t5v0__clkinv_1
* cell instance $1393 m0 *1 1203.44,1532.16
X$1393 29470 29408 29482 29490 gf180mcu_fd_sc_mcu9t5v0__clkinv_1
* cell instance $1394 m0 *1 1174.32,1532.16
X$1394 30035 29360 29488 13180 29408 29482 gf180mcu_fd_sc_mcu9t5v0__dffrnq_2
* cell instance $1395 r0 *1 1188.88,1562.4
X$1395 29760 29758 29973 29903 29981 gf180mcu_fd_sc_mcu9t5v0__xnor2_1
* cell instance $1396 m0 *1 1184.96,1552.32
X$1396 29775 29714 29769 29716 gf180mcu_fd_sc_mcu9t5v0__clkinv_1
* cell instance $1397 m0 *1 1205.68,1532.16
X$1397 29489 29416 26053 29408 29482 29471 gf180mcu_fd_sc_mcu9t5v0__oai21_1
* cell instance $1398 m0 *1 1214.64,1532.16
X$1398 29133 26053 18277 29471 29408 29482 29491
+ gf180mcu_fd_sc_mcu9t5v0__oai211_1
* cell instance $1399 r0 *1 1194.48,1552.32
X$1399 29716 28928 29841 29769 29832 gf180mcu_fd_sc_mcu9t5v0__nor2_1
* cell instance $1400 m0 *1 1196.72,1552.32
X$1400 29760 29758 29573 29832 29714 29769 29469
+ gf180mcu_fd_sc_mcu9t5v0__aoi211_1
* cell instance $1401 r0 *1 1214.08,1552.32
X$1401 29776 29925 29841 29769 29850 gf180mcu_fd_sc_mcu9t5v0__nor2_1
* cell instance $1402 m0 *1 1196.72,1532.16
X$1402 29415 28774 29490 29469 29408 29482 29489
+ gf180mcu_fd_sc_mcu9t5v0__aoi211_1
* cell instance $1403 r0 *1 1201.76,1522.08
X$1403 29335 29408 gf180mcu_fd_sc_mcu9t5v0__filltie
* cell instance $1404 r0 *1 1202.88,1522.08
X$1404 29490 29361 29408 29335 29416 gf180mcu_fd_sc_mcu9t5v0__and2_1
* cell instance $1405 m0 *1 1190,1552.32
X$1405 29775 28928 29714 29769 29760 gf180mcu_fd_sc_mcu9t5v0__xnor2_1
* cell instance $1406 r0 *1 1201.76,1532.16
X$1406 29482 29559 gf180mcu_fd_sc_mcu9t5v0__filltie
* cell instance $1407 r0 *1 1209.04,1522.08
X$1407 29133 29050 29408 29335 29470 gf180mcu_fd_sc_mcu9t5v0__xnor2_1
* cell instance $1408 r0 *1 1201.76,1542.24
X$1408 29636 29714 gf180mcu_fd_sc_mcu9t5v0__filltie
* cell instance $1409 m0 *1 1220.8,1552.32
X$1409 29762 29632 25282 29714 29769 29763 gf180mcu_fd_sc_mcu9t5v0__aoi21_1
* cell instance $1410 r0 *1 1201.76,1552.32
X$1410 29769 29841 gf180mcu_fd_sc_mcu9t5v0__filltie
* cell instance $1411 m0 *1 1226.4,1532.16
X$1411 29474 29575 29470 29408 29482 29476 gf180mcu_fd_sc_mcu9t5v0__aoi21_1
* cell instance $1412 r0 *1 1220.24,1552.32
X$1412 29762 29850 29841 29769 29851 gf180mcu_fd_sc_mcu9t5v0__xnor2_1
* cell instance $1413 m0 *1 1225.28,1552.32
X$1413 29762 29632 29763 29714 29769 29764 gf180mcu_fd_sc_mcu9t5v0__oai21_1
* cell instance $1414 m0 *1 1187.2,1552.32
X$1414 29760 29758 29714 29769 29761 gf180mcu_fd_sc_mcu9t5v0__nand2_1
* cell instance $1415 r0 *1 1194.48,1542.24
X$1415 29716 28928 29761 29714 29636 29632 gf180mcu_fd_sc_mcu9t5v0__oai21_1
* cell instance $1416 m0 *1 1202.32,1552.32
X$1416 29775 28928 29714 29769 29776 gf180mcu_fd_sc_mcu9t5v0__and2_1
* cell instance $1417 r0 *1 1197.84,1532.16
X$1417 29415 28774 29559 29482 29574 gf180mcu_fd_sc_mcu9t5v0__nand2_1
* cell instance $1418 r0 *1 1220.24,1542.24
X$1418 29488 29714 29636 28774 29762 gf180mcu_fd_sc_mcu9t5v0__xor2_1
* cell instance $1419 m0 *1 1210.16,1532.16
X$1419 29133 29472 29489 29408 29482 29417 gf180mcu_fd_sc_mcu9t5v0__aoi21_1
* cell instance $1420 m0 *1 1197.84,1542.24
X$1420 29573 29632 29574 29559 29636 29361 gf180mcu_fd_sc_mcu9t5v0__oai21_1
* cell instance $1421 m0 *1 1193.36,1532.16
X$1421 29488 29408 29482 29415 gf180mcu_fd_sc_mcu9t5v0__clkinv_1
* cell instance $1422 m0 *1 1179.92,1562.4
X$1422 29848 29841 29903 29900 27498 gf180mcu_fd_sc_mcu9t5v0__xor2_1
* cell instance $1423 m0 *1 1220.24,1532.16
X$1423 29133 29050 29408 29482 29473 gf180mcu_fd_sc_mcu9t5v0__and2_1
* cell instance $1424 r0 *1 1226.4,1532.16
X$1424 29488 28774 29559 29482 29474 gf180mcu_fd_sc_mcu9t5v0__nand2_1
* cell instance $1425 r0 *1 1175.44,1522.08
X$1425 29415 29272 29357 29408 29335 29360 gf180mcu_fd_sc_mcu9t5v0__aoi21_1
* cell instance $1426 r0 *1 1181.6,1562.4
X$1426 29848 29900 29973 29903 29922 gf180mcu_fd_sc_mcu9t5v0__or2_1
* cell instance $1427 m0 *1 1191.68,1572.48
X$1427 29775 26053 18277 30034 29973 30039 29982
+ gf180mcu_fd_sc_mcu9t5v0__oai211_1
* cell instance $1428 r0 *1 1196.72,1562.4
X$1428 29921 29922 29760 29973 29903 29925 gf180mcu_fd_sc_mcu9t5v0__aoi21_1
* cell instance $1429 r0 *1 1202.88,1582.56
X$1429 30035 30231 30159 gf180mcu_fd_sc_mcu9t5v0__clkbuf_4
* cell instance $1430 r0 *1 1223.04,1582.56
X$1430 30237 23921 30231 30159 30302 gf180mcu_fd_sc_mcu9t5v0__nand2_1
* cell instance $1431 r0 *1 1213.52,1562.4
X$1431 29984 23921 29973 29903 29924 gf180mcu_fd_sc_mcu9t5v0__nand2_1
* cell instance $1432 r0 *1 1194.48,1532.16
X$1432 29415 28774 29559 29482 29573 gf180mcu_fd_sc_mcu9t5v0__nor2_1
* cell instance $1433 r0 *1 1226.96,1522.08
X$1433 29491 29362 29408 29335 29418 gf180mcu_fd_sc_mcu9t5v0__nand2_1
* cell instance $1434 r0 *1 1192.24,1582.56
X$1434 30236 23921 30231 30159 30235 gf180mcu_fd_sc_mcu9t5v0__nand2_1
* cell instance $1435 r0 *1 1207.36,1562.4
X$1435 23921 29925 29923 29924 29973 29903 29983
+ gf180mcu_fd_sc_mcu9t5v0__oai31_1
* cell instance $1436 r0 *1 1188.32,1582.56
X$1436 30235 27522 30231 30159 30234 gf180mcu_fd_sc_mcu9t5v0__nand2_1
* cell instance $1437 m0 *1 1207.36,1572.48
X$1437 30035 29983 29984 13180 29973 30039 gf180mcu_fd_sc_mcu9t5v0__dffrnq_2
* cell instance $1438 m0 *1 1188.88,1572.48
X$1438 26053 29981 29973 30039 30034 gf180mcu_fd_sc_mcu9t5v0__nand2_1
* cell instance $1439 r0 *1 1201.76,1572.48
X$1439 30039 30106 gf180mcu_fd_sc_mcu9t5v0__filltie
* cell instance $1440 m0 *1 1229.76,1572.48
X$1440 29982 30036 29973 30039 29926 gf180mcu_fd_sc_mcu9t5v0__nand2_1
* cell instance $1441 r0 *1 1201.76,1582.56
X$1441 30159 30231 gf180mcu_fd_sc_mcu9t5v0__filltie
* cell instance $1442 r0 *1 1201.76,1562.4
X$1442 29903 29973 gf180mcu_fd_sc_mcu9t5v0__filltie
* cell instance $1443 m0 *1 1234.24,1562.4
X$1443 28645 23921 29841 29903 30036 gf180mcu_fd_sc_mcu9t5v0__nand2_1
* cell instance $1444 m0 *1 1220.24,1451.52
X$1444 22833 27965 26961 27807 27945 28217 gf180mcu_fd_sc_mcu9t5v0__mux2_1
* cell instance $1445 m0 *1 1207.36,1451.52
X$1445 27998 27829 27807 27945 24970 gf180mcu_fd_sc_mcu9t5v0__xnor2_1
* cell instance $1446 m0 *1 1217.44,1451.52
X$1446 27964 27828 27807 27945 26896 gf180mcu_fd_sc_mcu9t5v0__nand2_1
* cell instance $1447 m0 *1 1173.2,1491.84
X$1447 27638 28778 28928 13180 28874 28937 gf180mcu_fd_sc_mcu9t5v0__dffrnq_2
* cell instance $1448 r0 *1 1172.08,1481.76
X$1448 18614 22854 21423 28777 28874 28661 28778
+ gf180mcu_fd_sc_mcu9t5v0__oai31_1
* cell instance $1449 m0 *1 1178.24,1451.52
X$1449 27996 27827 26962 27807 27945 27997 gf180mcu_fd_sc_mcu9t5v0__oai21_1
* cell instance $1450 m0 *1 1108.24,1451.52
X$1450 23921 27228 27786 27822 27807 27945 27961
+ gf180mcu_fd_sc_mcu9t5v0__oai31_1
* cell instance $1451 m0 *1 1151.36,1451.52
X$1451 27825 27807 27945 27826 gf180mcu_fd_sc_mcu9t5v0__clkinv_1
* cell instance $1452 m0 *1 1148.56,1451.52
X$1452 27826 27962 27807 27945 27827 gf180mcu_fd_sc_mcu9t5v0__nand2_1
* cell instance $1453 m0 *1 1144.64,1451.52
X$1453 27995 27962 27807 27945 27824 gf180mcu_fd_sc_mcu9t5v0__nor2_1
* cell instance $1454 m0 *1 1161.44,1451.52
X$1454 26962 27827 27807 27945 27963 gf180mcu_fd_sc_mcu9t5v0__nand2_1
* cell instance $1455 m0 *1 1113.84,1451.52
X$1455 27638 27961 27823 13331 27807 27945 gf180mcu_fd_sc_mcu9t5v0__dffrnq_2
* cell instance $1456 r0 *1 1173.76,1512
X$1456 28925 25561 26053 29285 29212 29292 gf180mcu_fd_sc_mcu9t5v0__mux2_1
* cell instance $1457 m0 *1 1173.2,1512
X$1457 27638 29155 29133 13180 29146 29212 gf180mcu_fd_sc_mcu9t5v0__dffrnq_2
* cell instance $1458 r0 *1 1168.72,1421.28
X$1458 26769 27094 27213 27078 27232 gf180mcu_fd_sc_mcu9t5v0__xnor2_1
* cell instance $1459 m0 *1 1172.08,1431.36
X$1459 26653 27232 26053 27213 27367 27377 gf180mcu_fd_sc_mcu9t5v0__mux2_1
* cell instance $1460 m0 *1 1156.96,1461.6
X$1460 27233 28108 27996 13180 28103 28239 gf180mcu_fd_sc_mcu9t5v0__dffrnq_2
* cell instance $1461 m0 *1 1167.6,1471.68
X$1461 27233 28393 28247 13180 28378 28530 gf180mcu_fd_sc_mcu9t5v0__dffrnq_2
* cell instance $1462 m0 *1 1158.64,1391.04
X$1462 24096 26046 25888 13180 25997 26166 gf180mcu_fd_sc_mcu9t5v0__dffrnq_2
* cell instance $1463 m0 *1 1164.24,1451.52
X$1463 27996 27807 27945 27963 27641 gf180mcu_fd_sc_mcu9t5v0__xor2_1
* cell instance $1464 r0 *1 1168.16,1411.2
X$1464 26653 26942 26757 25280 26769 gf180mcu_fd_sc_mcu9t5v0__xor2_1
* cell instance $1465 r0 *1 1155.84,1431.36
X$1465 27233 27376 26653 13180 27517 27367 gf180mcu_fd_sc_mcu9t5v0__dffrnq_2
* cell instance $1466 m0 *1 1214.08,1451.52
X$1466 27995 27828 27807 27945 27829 gf180mcu_fd_sc_mcu9t5v0__nor2_1
* cell instance $1467 r0 *1 1199.52,1451.52
X$1467 22828 27998 26961 28103 27945 28109 gf180mcu_fd_sc_mcu9t5v0__mux2_1
* cell instance $1468 r0 *1 1174.88,1461.6
X$1468 22832 28247 26961 28378 28239 28393 gf180mcu_fd_sc_mcu9t5v0__mux2_1
* cell instance $1469 r0 *1 1179.92,1481.76
X$1469 28928 22854 28874 28661 28777 gf180mcu_fd_sc_mcu9t5v0__nand2_1
* cell instance $1470 r0 *1 1181.04,1451.52
X$1470 28247 28103 27945 27997 26347 gf180mcu_fd_sc_mcu9t5v0__xor2_1
* cell instance $1471 r0 *1 1211.28,1461.6
X$1471 27233 28378 28239 gf180mcu_fd_sc_mcu9t5v0__inv_3
* cell instance $1472 m0 *1 1192.24,1461.6
X$1472 27233 28109 27998 13180 28103 28239 gf180mcu_fd_sc_mcu9t5v0__dffrnq_2
* cell instance $1473 m0 *1 1214.08,1461.6
X$1473 27233 28217 27965 13180 28103 28239 gf180mcu_fd_sc_mcu9t5v0__dffrnq_2
* cell instance $1474 r0 *1 1209.04,1451.52
X$1474 27945 28103 gf180mcu_fd_sc_mcu9t5v0__filltie
* cell instance $1475 m0 *1 1218,1481.76
X$1475 23314 28674 26961 28635 28661 28673 gf180mcu_fd_sc_mcu9t5v0__mux2_1
* cell instance $1476 r0 *1 1209.04,1461.6
X$1476 28239 28378 gf180mcu_fd_sc_mcu9t5v0__filltie
* cell instance $1477 r0 *1 1209.04,1471.68
X$1477 28530 28635 gf180mcu_fd_sc_mcu9t5v0__filltie
* cell instance $1478 r0 *1 1211.84,1481.76
X$1478 27233 28673 28674 13180 28874 28661 gf180mcu_fd_sc_mcu9t5v0__dffrnq_2
* cell instance $1479 r0 *1 1230.32,1461.6
X$1479 27965 28378 28239 28249 gf180mcu_fd_sc_mcu9t5v0__clkinv_1
* cell instance $1480 m0 *1 1204.56,1512
X$1480 29134 29146 29212 29172 gf180mcu_fd_sc_mcu9t5v0__clkinv_1
* cell instance $1481 m0 *1 1210.16,1512
X$1481 29172 29171 29146 29212 29215 gf180mcu_fd_sc_mcu9t5v0__nand2_1
* cell instance $1482 m0 *1 1228.08,1501.92
X$1482 28930 23921 28989 29062 29072 gf180mcu_fd_sc_mcu9t5v0__nand2_1
* cell instance $1483 m0 *1 1225.84,1512
X$1483 29414 29072 29146 29212 29158 gf180mcu_fd_sc_mcu9t5v0__nand2_1
* cell instance $1484 m0 *1 1206.8,1512
X$1484 27995 29171 29146 29212 29135 gf180mcu_fd_sc_mcu9t5v0__nor2_1
* cell instance $1485 r0 *1 1205.68,1501.92
X$1485 29134 29135 18444 29146 29062 29156 gf180mcu_fd_sc_mcu9t5v0__aoi21_1
* cell instance $1486 r0 *1 1194.48,1501.92
X$1486 19917 29134 28672 29146 29062 29052 gf180mcu_fd_sc_mcu9t5v0__mux2_1
* cell instance $1487 r0 *1 1201.76,1501.92
X$1487 29062 29146 gf180mcu_fd_sc_mcu9t5v0__filltie
* cell instance $1488 r0 *1 1201.76,1512
X$1488 29212 29285 gf180mcu_fd_sc_mcu9t5v0__filltie
* cell instance $1489 r0 *1 1210.16,1501.92
X$1489 29134 29135 29156 29146 29062 29136 gf180mcu_fd_sc_mcu9t5v0__oai21_1
* cell instance $1490 r0 *1 1215.76,1501.92
X$1490 29071 29272 29136 29000 29146 29062 29157
+ gf180mcu_fd_sc_mcu9t5v0__aoi22_1
* cell instance $1491 m0 *1 1188.88,1501.92
X$1491 27233 29052 29134 13180 28989 29062 gf180mcu_fd_sc_mcu9t5v0__dffrnq_2
* cell instance $1492 m0 *1 1229.76,1491.84
X$1492 25329 28394 28536 28535 28539 28930 28874 28937 29216
+ gf180mcu_fd_sc_mcu9t5v0__aoi222_1
* cell instance $1493 r0 *1 1234.24,1451.52
X$1493 27965 27999 28103 27945 26051 gf180mcu_fd_sc_mcu9t5v0__xnor2_1
* cell instance $1494 m0 *1 1233.12,1461.6
X$1494 28249 27261 27995 28103 28239 28248 gf180mcu_fd_sc_mcu9t5v0__aoi21_1
* cell instance $1495 r0 *1 1201.76,1491.84
X$1495 28937 28989 gf180mcu_fd_sc_mcu9t5v0__filltie
* cell instance $1496 r0 *1 1213.52,1491.84
X$1496 29272 28879 28989 28937 29000 gf180mcu_fd_sc_mcu9t5v0__nor2_1
* cell instance $1497 r0 *1 1220.8,1501.92
X$1497 28219 29158 28930 13180 29146 29062 gf180mcu_fd_sc_mcu9t5v0__dffrnq_2
* cell instance $1498 m0 *1 1209.04,1481.76
X$1498 28661 28635 gf180mcu_fd_sc_mcu9t5v0__filltie
* cell instance $1499 r0 *1 1201.76,1481.76
X$1499 28661 28874 gf180mcu_fd_sc_mcu9t5v0__filltie
* cell instance $1500 r0 *1 1176,1501.92
X$1500 29133 28998 26904 29146 29062 29155 gf180mcu_fd_sc_mcu9t5v0__mux2_1
* cell instance $1501 r0 *1 1206.8,1451.52
X$1501 27998 28103 27945 27964 gf180mcu_fd_sc_mcu9t5v0__clkinv_1
* cell instance $1502 r0 *1 1224.72,1471.68
X$1502 28674 28248 18444 28635 28530 28644 gf180mcu_fd_sc_mcu9t5v0__aoi21_1
* cell instance $1503 r0 *1 1202.88,1481.76
X$1503 28929 23921 28874 28661 28780 gf180mcu_fd_sc_mcu9t5v0__nand2_1
* cell instance $1504 m0 *1 1194.48,1491.84
X$1504 27233 28779 28929 13180 28874 28937 gf180mcu_fd_sc_mcu9t5v0__dffrnq_2
* cell instance $1505 r0 *1 1220.24,1471.68
X$1505 28674 28248 28644 28635 28530 27966 gf180mcu_fd_sc_mcu9t5v0__oai21_1
* cell instance $1506 r0 *1 1197.28,1481.76
X$1506 28392 28780 28874 28661 28779 gf180mcu_fd_sc_mcu9t5v0__nand2_1
* cell instance $1507 r0 *1 1211.28,1451.52
X$1507 22858 28103 27945 27233 gf180mcu_fd_sc_mcu9t5v0__clkbuf_8
* cell instance $1508 m0 *1 1191.68,1471.68
X$1508 28510 27087 18277 28378 28530 28509 gf180mcu_fd_sc_mcu9t5v0__mux2_1
* cell instance $1509 r0 *1 1193.92,1481.76
X$1509 18614 24246 28874 28661 28879 gf180mcu_fd_sc_mcu9t5v0__nor2_1
* cell instance $1510 r0 *1 1176.56,1451.52
X$1510 28247 27996 27827 28103 27945 27828 gf180mcu_fd_sc_mcu9t5v0__nor3_1
* cell instance $1511 r0 *1 1190,1471.68
X$1511 27233 28509 28510 13180 28635 28530 gf180mcu_fd_sc_mcu9t5v0__dffrnq_2
* cell instance $1512 r0 *1 1230.88,1451.52
X$1512 27995 27261 28103 27945 27999 gf180mcu_fd_sc_mcu9t5v0__nor2_1
* cell instance $1513 r0 *1 1134.56,1501.92
X$1513 18614 22854 22129 29131 29146 29062 29153
+ gf180mcu_fd_sc_mcu9t5v0__oai31_1
* cell instance $1514 r0 *1 1162,1451.52
X$1514 22168 27996 26961 28103 27945 28108 gf180mcu_fd_sc_mcu9t5v0__mux2_1
* cell instance $1515 m0 *1 1122.24,1501.92
X$1515 29050 22854 28989 29062 29049 gf180mcu_fd_sc_mcu9t5v0__nand2_1
* cell instance $1516 m0 *1 1114.96,1501.92
X$1516 18614 22854 22011 29049 28989 29062 29069
+ gf180mcu_fd_sc_mcu9t5v0__oai31_1
* cell instance $1517 m0 *1 1117.76,1512
X$1517 29214 29212 29146 29167 gf180mcu_fd_sc_mcu9t5v0__clkbuf_16
* cell instance $1518 r0 *1 1112.72,1512
X$1518 29272 29269 29273 29285 29212 29291 gf180mcu_fd_sc_mcu9t5v0__oai21_1
* cell instance $1519 m0 *1 1141.84,1501.92
X$1519 18614 22854 21841 29051 28989 29062 28999
+ gf180mcu_fd_sc_mcu9t5v0__oai31_1
* cell instance $1520 r0 *1 1154.16,1512
X$1520 28925 29274 29285 29212 29275 gf180mcu_fd_sc_mcu9t5v0__nor2_1
* cell instance $1521 r0 *1 1151.92,1512
X$1521 28927 29285 29212 29274 gf180mcu_fd_sc_mcu9t5v0__clkinv_1
* cell instance $1522 m0 *1 1127.28,1501.92
X$1522 22858 28989 29062 27638 gf180mcu_fd_sc_mcu9t5v0__clkbuf_8
* cell instance $1523 m0 *1 1162.56,1501.92
X$1523 28925 28927 28989 29062 29070 gf180mcu_fd_sc_mcu9t5v0__nand2_1
* cell instance $1524 r0 *1 1132.32,1512
X$1524 27638 29153 29154 13331 29285 29212 gf180mcu_fd_sc_mcu9t5v0__dffrnq_2
* cell instance $1525 r0 *1 1132.88,1451.52
X$1525 28216 26174 18277 28103 27945 28107 gf180mcu_fd_sc_mcu9t5v0__mux2_1
* cell instance $1526 m0 *1 1142.4,1471.68
X$1526 19917 27825 26961 28378 28530 28643 gf180mcu_fd_sc_mcu9t5v0__mux2_1
* cell instance $1527 r0 *1 1165.36,1501.92
X$1527 28925 29146 29062 28927 25561 gf180mcu_fd_sc_mcu9t5v0__xor2_1
* cell instance $1528 m0 *1 1129.52,1461.6
X$1528 27638 28107 28216 13331 28103 28239 gf180mcu_fd_sc_mcu9t5v0__dffrnq_2
* cell instance $1529 r0 *1 1116.64,1471.68
X$1529 27638 28642 28535 13331 28635 28530 gf180mcu_fd_sc_mcu9t5v0__dffrnq_2
* cell instance $1530 r0 *1 1160.88,1481.76
X$1530 28776 23921 28874 28661 28775 gf180mcu_fd_sc_mcu9t5v0__nand2_1
* cell instance $1531 r0 *1 1135.68,1471.68
X$1531 27638 28643 27825 13331 28635 28530 gf180mcu_fd_sc_mcu9t5v0__dffrnq_2
* cell instance $1532 r0 *1 1127.28,1491.84
X$1532 27638 28989 28937 gf180mcu_fd_sc_mcu9t5v0__clkbuf_4
* cell instance $1533 r0 *1 1141.28,1491.84
X$1533 27638 28999 28927 13331 28989 28937 gf180mcu_fd_sc_mcu9t5v0__dffrnq_2
* cell instance $1534 r0 *1 1115.52,1501.92
X$1534 27638 29069 29050 13331 29146 29062 gf180mcu_fd_sc_mcu9t5v0__dffrnq_2
* cell instance $1535 r0 *1 1151.92,1461.6
X$1535 26053 27375 28378 28239 28391 gf180mcu_fd_sc_mcu9t5v0__nand2_1
* cell instance $1536 m0 *1 1152.48,1471.68
X$1536 26958 26053 18277 28391 28378 28530 28392
+ gf180mcu_fd_sc_mcu9t5v0__oai211_1
* cell instance $1537 r0 *1 1140.16,1501.92
X$1537 29154 22854 29146 29062 29131 gf180mcu_fd_sc_mcu9t5v0__nand2_1
* cell instance $1538 r0 *1 1158.64,1501.92
X$1538 29132 29070 29146 29062 24245 gf180mcu_fd_sc_mcu9t5v0__xnor2_1
* cell instance $1539 m0 *1 1124.48,1491.84
X$1539 27638 28926 28774 13331 28874 28937 gf180mcu_fd_sc_mcu9t5v0__dffrnq_2
* cell instance $1540 m0 *1 1119.44,1471.68
X$1540 28389 28378 28530 28387 gf180mcu_fd_sc_mcu9t5v0__clkinv_1
* cell instance $1541 m0 *1 1118.88,1491.84
X$1541 18614 22854 22459 28877 28874 28937 28926
+ gf180mcu_fd_sc_mcu9t5v0__oai31_1
* cell instance $1542 m0 *1 1112.72,1461.6
X$1542 26958 26004 28103 28239 28359 gf180mcu_fd_sc_mcu9t5v0__nand2_1
* cell instance $1543 m0 *1 1154.16,1491.84
X$1543 27638 28878 28776 13331 28874 28937 gf180mcu_fd_sc_mcu9t5v0__dffrnq_2
* cell instance $1544 m0 *1 1146.32,1491.84
X$1544 28927 22854 28874 28937 29051 gf180mcu_fd_sc_mcu9t5v0__nand2_1
* cell instance $1545 r0 *1 1160.88,1512
X$1545 28925 28927 29132 29285 29212 29276 gf180mcu_fd_sc_mcu9t5v0__nand3_1
* cell instance $1546 r0 *1 1127.84,1481.76
X$1546 28774 22854 28874 28661 28877 gf180mcu_fd_sc_mcu9t5v0__nand2_1
* cell instance $1547 r0 *1 1155.28,1481.76
X$1547 28390 28775 28874 28661 28878 gf180mcu_fd_sc_mcu9t5v0__nand2_1
* cell instance $1548 m0 *1 1123.36,1471.68
X$1548 28535 23921 28378 28530 28534 gf180mcu_fd_sc_mcu9t5v0__nand2_1
* cell instance $1549 r0 *1 1120.56,1512
X$1549 29346 29272 29285 29212 29273 gf180mcu_fd_sc_mcu9t5v0__nand2_1
* cell instance $1550 r0 *1 1113.84,1471.68
X$1550 27224 28534 28635 28530 28642 gf180mcu_fd_sc_mcu9t5v0__nand2_1
* cell instance $1551 m0 *1 1112.72,1411.2
X$1551 26892 26517 26632 26757 26521 gf180mcu_fd_sc_mcu9t5v0__and2_1
* cell instance $1552 r0 *1 1108.24,1421.28
X$1552 27227 27088 25282 27213 27078 27228 gf180mcu_fd_sc_mcu9t5v0__aoi21_1
* cell instance $1553 m0 *1 1114.96,1421.28
X$1553 26892 26956 26942 27078 27089 gf180mcu_fd_sc_mcu9t5v0__nand2_1
* cell instance $1554 m0 *1 1152.48,1401.12
X$1554 23921 26649 26652 26469 26331 26456 26470
+ gf180mcu_fd_sc_mcu9t5v0__oai31_1
* cell instance $1555 r0 *1 1118.32,1421.28
X$1555 27089 27227 26468 27213 27078 27090 gf180mcu_fd_sc_mcu9t5v0__aoi21_1
* cell instance $1556 m0 *1 1163.12,1411.2
X$1556 26768 26649 26769 26632 26757 26523 gf180mcu_fd_sc_mcu9t5v0__oai21_1
* cell instance $1557 r0 *1 1130.08,1421.28
X$1557 26957 27091 27090 27213 27078 27231 gf180mcu_fd_sc_mcu9t5v0__aoi21_1
* cell instance $1558 m0 *1 1128.96,1401.12
X$1558 24096 26310 26346 13180 26331 26456 gf180mcu_fd_sc_mcu9t5v0__dffrnq_2
* cell instance $1559 r0 *1 1117.76,1401.12
X$1559 26468 26521 26344 26632 26456 26522 gf180mcu_fd_sc_mcu9t5v0__or3_1
* cell instance $1560 m0 *1 1118.88,1421.28
X$1560 26957 26942 27078 26003 26468 gf180mcu_fd_sc_mcu9t5v0__xor2_1
* cell instance $1561 r0 *1 1125.6,1401.12
X$1561 26345 26522 26632 26456 26309 gf180mcu_fd_sc_mcu9t5v0__nand2_1
* cell instance $1562 r0 *1 1138.48,1391.04
X$1562 26346 23921 26331 26166 26311 gf180mcu_fd_sc_mcu9t5v0__nand2_1
* cell instance $1563 r0 *1 1130.64,1391.04
X$1563 23921 26309 26311 26331 26166 26310 gf180mcu_fd_sc_mcu9t5v0__oai21_1
* cell instance $1564 r0 *1 1140.16,1421.28
X$1564 25279 27213 27078 27092 gf180mcu_fd_sc_mcu9t5v0__clkinv_1
* cell instance $1565 r0 *1 1142.4,1421.28
X$1565 26958 27092 27213 27078 27093 gf180mcu_fd_sc_mcu9t5v0__nand2_1
* cell instance $1566 r0 *1 1145.2,1421.28
X$1566 27095 27231 27093 27213 27078 27094 gf180mcu_fd_sc_mcu9t5v0__oai21_1
* cell instance $1567 m0 *1 1149.12,1441.44
X$1567 18614 27639 23912 27517 27666 27640 gf180mcu_fd_sc_mcu9t5v0__aoi21_1
* cell instance $1568 m0 *1 1142.96,1391.04
X$1568 26346 24966 17977 25997 26166 26011 gf180mcu_fd_sc_mcu9t5v0__mux2_1
* cell instance $1569 m0 *1 1142.4,1411.2
X$1569 26651 26650 26345 26632 26757 26652 gf180mcu_fd_sc_mcu9t5v0__and3_1
* cell instance $1570 r0 *1 1115.52,1421.28
X$1570 27089 27227 27213 27078 27229 gf180mcu_fd_sc_mcu9t5v0__nand2_1
* cell instance $1571 r0 *1 1145.2,1441.44
X$1571 27825 27824 27807 27666 27639 gf180mcu_fd_sc_mcu9t5v0__xnor2_1
* cell instance $1572 m0 *1 1132.32,1441.44
X$1572 26957 26053 18277 27496 27517 27666 28390
+ gf180mcu_fd_sc_mcu9t5v0__oai211_1
* cell instance $1573 r0 *1 1113.28,1441.44
X$1573 26892 26053 27807 27666 27786 gf180mcu_fd_sc_mcu9t5v0__nor2_1
* cell instance $1574 r0 *1 1106.56,1431.36
X$1574 26957 27494 24836 27517 27367 27520 gf180mcu_fd_sc_mcu9t5v0__mux2_1
* cell instance $1575 r0 *1 1121.68,1441.44
X$1575 27823 23921 27807 27666 27822 gf180mcu_fd_sc_mcu9t5v0__nand2_1
* cell instance $1576 r0 *1 1131.2,1431.36
X$1576 26053 27230 27517 27367 27496 gf180mcu_fd_sc_mcu9t5v0__nand2_1
* cell instance $1577 m0 *1 1161.44,1401.12
X$1577 26471 23921 26331 26456 26469 gf180mcu_fd_sc_mcu9t5v0__nand2_1
* cell instance $1578 r0 *1 1122.8,1421.28
X$1578 26468 27213 27078 27229 27230 gf180mcu_fd_sc_mcu9t5v0__xor2_1
* cell instance $1579 m0 *1 1118.88,1401.12
X$1579 26521 26344 26468 26331 26456 26345 gf180mcu_fd_sc_mcu9t5v0__oai21_1
* cell instance $1580 m0 *1 1140.72,1421.28
X$1580 26958 25279 26942 27078 26651 gf180mcu_fd_sc_mcu9t5v0__xnor2_1
* cell instance $1581 m0 *1 1158.64,1431.36
X$1581 26653 27640 24836 27213 27367 27376 gf180mcu_fd_sc_mcu9t5v0__mux2_1
* cell instance $1582 m0 *1 1168.16,1441.44
X$1582 18614 27641 24125 27517 27666 27497 gf180mcu_fd_sc_mcu9t5v0__aoi21_1
* cell instance $1583 m0 *1 1144.08,1431.36
X$1583 27095 27231 27213 27367 27375 gf180mcu_fd_sc_mcu9t5v0__xnor2_1
* cell instance $1584 r0 *1 1152.48,1401.12
X$1584 24096 26470 26471 13180 26632 26456 gf180mcu_fd_sc_mcu9t5v0__dffrnq_2
* cell instance $1585 m0 *1 1167.6,1411.2
X$1585 26769 26768 26649 26632 26757 26524 gf180mcu_fd_sc_mcu9t5v0__or3_1
* cell instance $1586 m0 *1 1151.92,1421.28
X$1586 26958 25279 26942 27078 26768 gf180mcu_fd_sc_mcu9t5v0__and2_1
* cell instance $1587 r0 *1 1149.68,1421.28
X$1587 26651 27213 27078 27095 gf180mcu_fd_sc_mcu9t5v0__clkinv_1
* cell instance $1588 m0 *1 1137.92,1411.2
X$1588 26650 26345 26651 26632 26757 26649 gf180mcu_fd_sc_mcu9t5v0__aoi21_1
* cell instance $1589 m0 *1 1128.96,1421.28
X$1589 26003 26942 27078 27091 gf180mcu_fd_sc_mcu9t5v0__clkinv_1
* cell instance $1590 m0 *1 1131.76,1421.28
X$1590 26957 26003 26942 27078 26650 gf180mcu_fd_sc_mcu9t5v0__nand2_1
* cell instance $1591 r0 *1 1113.28,1411.2
X$1591 26517 26942 26757 26956 gf180mcu_fd_sc_mcu9t5v0__clkinv_1
* cell instance $1592 r0 *1 1209.04,1411.2
X$1592 26757 26942 gf180mcu_fd_sc_mcu9t5v0__filltie
* cell instance $1593 r0 *1 1223.6,1431.36
X$1593 22829 27380 26961 27517 27367 27523 gf180mcu_fd_sc_mcu9t5v0__mux2_1
* cell instance $1594 r0 *1 1204.56,1401.12
X$1594 18444 23700 26004 26632 26456 26525 gf180mcu_fd_sc_mcu9t5v0__aoi21_1
* cell instance $1595 r0 *1 1225.84,1401.12
X$1595 26526 26004 27966 26525 26632 26456 26656
+ gf180mcu_fd_sc_mcu9t5v0__aoi22_1
* cell instance $1596 m0 *1 1230.32,1411.2
X$1596 27379 26632 26757 26655 24839 gf180mcu_fd_sc_mcu9t5v0__xor2_1
* cell instance $1597 r0 *1 1209.04,1391.04
X$1597 26166 26331 gf180mcu_fd_sc_mcu9t5v0__filltie
* cell instance $1598 m0 *1 1220.24,1441.44
X$1598 27233 27523 27380 13180 27517 27666 gf180mcu_fd_sc_mcu9t5v0__dffrnq_2
* cell instance $1599 m0 *1 1196.16,1391.04
X$1599 23802 26047 26048 13180 25997 26166 gf180mcu_fd_sc_mcu9t5v0__dffrnq_2
* cell instance $1600 r0 *1 1209.04,1421.28
X$1600 27078 27213 gf180mcu_fd_sc_mcu9t5v0__filltie
* cell instance $1601 m0 *1 1182.72,1421.28
X$1601 26894 27094 26959 26942 27078 26960 gf180mcu_fd_sc_mcu9t5v0__oai21_1
* cell instance $1602 r0 *1 1210.16,1431.36
X$1602 22830 27379 26961 27517 27367 27260 gf180mcu_fd_sc_mcu9t5v0__mux2_1
* cell instance $1603 m0 *1 1187.2,1421.28
X$1603 26349 26942 27078 26960 27096 gf180mcu_fd_sc_mcu9t5v0__xor2_1
* cell instance $1604 r0 *1 1218,1431.36
X$1604 27379 26770 26896 26962 27517 27367 27499
+ gf180mcu_fd_sc_mcu9t5v0__oai31_1
* cell instance $1605 r0 *1 1180.48,1411.2
X$1605 26893 25280 26942 26757 26959 gf180mcu_fd_sc_mcu9t5v0__nand2_1
* cell instance $1606 r0 *1 1186.64,1411.2
X$1606 26894 27094 26349 26959 26942 26757 25553
+ gf180mcu_fd_sc_mcu9t5v0__oai211_1
* cell instance $1607 r0 *1 1226.4,1411.2
X$1607 26770 26896 26962 26942 26757 26655 gf180mcu_fd_sc_mcu9t5v0__oai21_1
* cell instance $1608 m0 *1 1183.28,1411.2
X$1608 26653 26632 26757 26893 gf180mcu_fd_sc_mcu9t5v0__clkinv_1
* cell instance $1609 r0 *1 1183.28,1411.2
X$1609 26893 25280 26942 26757 26894 gf180mcu_fd_sc_mcu9t5v0__nor2_1
* cell instance $1610 r0 *1 1189.44,1431.36
X$1610 25589 26053 18277 27378 27517 27367 27522
+ gf180mcu_fd_sc_mcu9t5v0__oai211_1
* cell instance $1611 r0 *1 1182.16,1431.36
X$1611 25589 27497 24836 27517 27367 27521 gf180mcu_fd_sc_mcu9t5v0__mux2_1
* cell instance $1612 r0 *1 1209.04,1431.36
X$1612 27367 27517 gf180mcu_fd_sc_mcu9t5v0__filltie
* cell instance $1613 m0 *1 1180.48,1441.44
X$1613 27233 27521 25589 13180 27517 27666 gf180mcu_fd_sc_mcu9t5v0__dffrnq_2
* cell instance $1614 r0 *1 1209.04,1441.44
X$1614 27666 27807 gf180mcu_fd_sc_mcu9t5v0__filltie
* cell instance $1615 m0 *1 1231.44,1391.04
X$1615 24549 26049 24836 25997 26166 26179 gf180mcu_fd_sc_mcu9t5v0__mux2_1
* cell instance $1616 r0 *1 1220.8,1411.2
X$1616 26962 26896 26942 26757 26654 gf180mcu_fd_sc_mcu9t5v0__nand2_1
* cell instance $1617 m0 *1 1204,1411.2
X$1617 23802 26895 26770 13180 26632 26757 gf180mcu_fd_sc_mcu9t5v0__dffrnq_2
* cell instance $1618 r0 *1 1178.8,1401.12
X$1618 26523 26524 26632 26456 24544 gf180mcu_fd_sc_mcu9t5v0__nand2_1
* cell instance $1619 m0 *1 1187.2,1401.12
X$1619 26349 26348 26523 26331 26456 26350 gf180mcu_fd_sc_mcu9t5v0__and3_1
* cell instance $1620 r0 *1 1210.16,1411.2
X$1620 19745 26770 26961 26942 26757 26895 gf180mcu_fd_sc_mcu9t5v0__mux2_1
* cell instance $1621 r0 *1 1205.12,1391.04
X$1621 26048 23921 26331 26166 26312 gf180mcu_fd_sc_mcu9t5v0__nand2_1
* cell instance $1622 r0 *1 1193.92,1391.04
X$1622 23921 25439 26350 26312 26331 26166 26047
+ gf180mcu_fd_sc_mcu9t5v0__oai31_1
* cell instance $1623 m0 *1 1223.04,1411.2
X$1623 26770 26632 26757 26654 26050 gf180mcu_fd_sc_mcu9t5v0__xor2_1
* cell instance $1624 m0 *1 1226.96,1431.36
X$1624 27380 27379 26770 26896 27213 27367 27261 gf180mcu_fd_sc_mcu9t5v0__nor4_1
* cell instance $1625 m0 *1 1191.12,1431.36
X$1625 26053 27096 27213 27367 27378 gf180mcu_fd_sc_mcu9t5v0__nand2_1
* cell instance $1626 m0 *1 1200.64,1431.36
X$1626 27233 27260 27379 13180 27213 27367 gf180mcu_fd_sc_mcu9t5v0__dffrnq_2
* cell instance $1627 r0 *1 1232.56,1431.36
X$1627 27380 27517 27367 27499 25847 gf180mcu_fd_sc_mcu9t5v0__xor2_1
* cell instance $1628 m0 *1 1223.6,1391.04
X$1628 18614 26050 23019 24963 25997 26166 26049
+ gf180mcu_fd_sc_mcu9t5v0__aoi22_1
* cell instance $1629 m0 *1 1182.72,1401.12
X$1629 26348 26523 26349 26331 26456 25439 gf180mcu_fd_sc_mcu9t5v0__aoi21_1
* cell instance $1630 r0 *1 1182.72,1401.12
X$1630 26653 25280 26632 26456 26348 gf180mcu_fd_sc_mcu9t5v0__nand2_1
* cell instance $1631 r0 *1 1209.04,1401.12
X$1631 26456 26632 gf180mcu_fd_sc_mcu9t5v0__filltie
* cell instance $1632 m0 *1 1230.32,1401.12
X$1632 28244 26331 26456 20715 gf180mcu_fd_sc_mcu9t5v0__inv_1
* cell instance $1633 r0 *1 1298.64,1401.12
X$1633 23176 26476 26015 13180 26632 26456 gf180mcu_fd_sc_mcu9t5v0__dffrnq_2
* cell instance $1634 m0 *1 1309.84,1431.36
X$1634 27101 18590 18614 27213 27367 26901 gf180mcu_fd_sc_mcu9t5v0__aoi21_1
* cell instance $1635 m0 *1 1300.32,1481.76
X$1635 28219 28650 28651 13180 28635 28661 gf180mcu_fd_sc_mcu9t5v0__dffrnq_2
* cell instance $1636 m0 *1 1309.84,1441.44
X$1636 27262 27526 27789 13180 27517 27666 gf180mcu_fd_sc_mcu9t5v0__dffrnq_2
* cell instance $1637 m0 *1 1309.84,1461.6
X$1637 28219 28006 27105 13180 28103 28239 gf180mcu_fd_sc_mcu9t5v0__dffrnq_2
* cell instance $1638 r0 *1 1305.92,1471.68
X$1638 22833 28651 28672 28635 28530 28650 gf180mcu_fd_sc_mcu9t5v0__mux2_1
* cell instance $1639 m0 *1 1341.2,1451.52
X$1639 27105 25715 23921 27807 27945 27969 gf180mcu_fd_sc_mcu9t5v0__aoi21_1
* cell instance $1640 m0 *1 1345.68,1451.52
X$1640 27970 23921 27670 27969 27807 27945 28008
+ gf180mcu_fd_sc_mcu9t5v0__aoi22_1
* cell instance $1641 m0 *1 1328.88,1451.52
X$1641 27945 27807 gf180mcu_fd_sc_mcu9t5v0__filltie
* cell instance $1642 m0 *1 1273.44,1451.52
X$1642 28219 27830 27831 13180 27807 27945 gf180mcu_fd_sc_mcu9t5v0__dffrnq_2
* cell instance $1643 m0 *1 1310.4,1421.28
X$1643 27103 23921 26182 26477 26942 27078 27102
+ gf180mcu_fd_sc_mcu9t5v0__aoi22_1
* cell instance $1644 r0 *1 1302,1421.28
X$1644 27262 27102 27234 13180 27213 27078 gf180mcu_fd_sc_mcu9t5v0__dffrnq_2
* cell instance $1645 m0 *1 1308.72,1391.04
X$1645 26055 22855 25997 26166 26182 gf180mcu_fd_sc_mcu9t5v0__or2_1
* cell instance $1646 r0 *1 1310.4,1491.84
X$1646 27995 29001 28989 28937 29003 gf180mcu_fd_sc_mcu9t5v0__nor2_1
* cell instance $1647 m0 *1 1308.72,1501.92
X$1647 29056 29003 28989 29062 26964 gf180mcu_fd_sc_mcu9t5v0__xnor2_1
* cell instance $1648 r0 *1 1341.76,1471.68
X$1648 28538 28635 28530 28363 gf180mcu_fd_sc_mcu9t5v0__clkinv_1
* cell instance $1649 r0 *1 1341.2,1461.6
X$1649 28363 23921 28221 27833 28378 28239 28362
+ gf180mcu_fd_sc_mcu9t5v0__aoi22_1
* cell instance $1650 r0 *1 1376.48,1451.52
X$1650 28009 28682 27834 28103 27945 27509 gf180mcu_fd_sc_mcu9t5v0__aoi21_1
* cell instance $1651 m0 *1 1337.28,1481.76
X$1651 28112 28677 26904 28635 28661 28679 gf180mcu_fd_sc_mcu9t5v0__mux2_1
* cell instance $1652 m0 *1 1328.88,1481.76
X$1652 28661 28635 gf180mcu_fd_sc_mcu9t5v0__filltie
* cell instance $1653 m0 *1 1355.2,1471.68
X$1653 28515 23921 28378 28530 28543 gf180mcu_fd_sc_mcu9t5v0__nand2_1
* cell instance $1654 m0 *1 1351.84,1481.76
X$1654 23921 28680 28944 28543 28635 28661 28654
+ gf180mcu_fd_sc_mcu9t5v0__oai31_1
* cell instance $1655 r0 *1 1340.08,1451.52
X$1655 27262 28008 28005 13180 28103 27945 gf180mcu_fd_sc_mcu9t5v0__dffrnq_2
* cell instance $1656 r0 *1 1313.76,1481.76
X$1656 26962 28785 28874 28661 28652 gf180mcu_fd_sc_mcu9t5v0__nand2_1
* cell instance $1657 r0 *1 1350.72,1512
X$1657 29350 29277 29285 29212 28659 gf180mcu_fd_sc_mcu9t5v0__and2_1
* cell instance $1658 r0 *1 1315.44,1471.68
X$1658 28651 28635 28530 28652 26903 gf180mcu_fd_sc_mcu9t5v0__xor2_1
* cell instance $1659 r0 *1 1317.68,1501.92
X$1659 29296 29146 29062 29142 28361 gf180mcu_fd_sc_mcu9t5v0__xor2_1
* cell instance $1660 r0 *1 1338.4,1481.76
X$1660 28219 28679 28112 13180 28874 28661 gf180mcu_fd_sc_mcu9t5v0__dffrnq_2
* cell instance $1661 m0 *1 1330,1471.68
X$1661 27262 28362 28538 13180 28378 28530 gf180mcu_fd_sc_mcu9t5v0__dffrnq_2
* cell instance $1662 r0 *1 1370.88,1481.76
X$1662 28935 28680 28545 28874 28661 28682 gf180mcu_fd_sc_mcu9t5v0__oai21_1
* cell instance $1663 m0 *1 1321.6,1491.84
X$1663 28937 28874 gf180mcu_fd_sc_mcu9t5v0__filltie
* cell instance $1664 m0 *1 1328.88,1461.6
X$1664 28239 28103 gf180mcu_fd_sc_mcu9t5v0__filltie
* cell instance $1665 m0 *1 1328.88,1471.68
X$1665 28530 28378 gf180mcu_fd_sc_mcu9t5v0__filltie
* cell instance $1666 m0 *1 1369.76,1481.76
X$1666 28545 28935 28680 28655 28635 28661 27971
+ gf180mcu_fd_sc_mcu9t5v0__oai31_1
* cell instance $1667 m0 *1 1323.84,1481.76
X$1667 18614 28678 23387 28220 28635 28661 28677
+ gf180mcu_fd_sc_mcu9t5v0__aoi22_1
* cell instance $1668 r0 *1 1318.8,1461.6
X$1668 18614 28361 23974 28220 28378 28239 28007
+ gf180mcu_fd_sc_mcu9t5v0__aoi22_1
* cell instance $1669 r0 *1 1319.36,1451.52
X$1669 27105 28007 26904 28103 27945 28006 gf180mcu_fd_sc_mcu9t5v0__mux2_1
* cell instance $1670 r0 *1 1347.92,1512
X$1670 29277 29280 29285 29212 29281 gf180mcu_fd_sc_mcu9t5v0__nand2_1
* cell instance $1671 m0 *1 1322.72,1501.92
X$1671 26962 29075 28989 29062 29076 gf180mcu_fd_sc_mcu9t5v0__nand2_1
* cell instance $1672 r0 *1 1325.52,1501.92
X$1672 29141 29146 29062 29076 27506 gf180mcu_fd_sc_mcu9t5v0__xor2_1
* cell instance $1673 m0 *1 1321.6,1501.92
X$1673 29062 28989 gf180mcu_fd_sc_mcu9t5v0__filltie
* cell instance $1674 m0 *1 1321.6,1512
X$1674 29212 29146 gf180mcu_fd_sc_mcu9t5v0__filltie
* cell instance $1675 m0 *1 1345.68,1501.92
X$1675 28934 24100 28989 29062 29057 gf180mcu_fd_sc_mcu9t5v0__xnor2_1
* cell instance $1676 m0 *1 1361.92,1461.6
X$1676 26053 28110 28103 28239 28221 gf180mcu_fd_sc_mcu9t5v0__nand2_1
* cell instance $1677 m0 *1 1359.12,1491.84
X$1677 28934 24100 28874 28937 28935 gf180mcu_fd_sc_mcu9t5v0__and2_1
* cell instance $1678 m0 *1 1369.76,1471.68
X$1678 28112 28378 28530 25850 28545 gf180mcu_fd_sc_mcu9t5v0__xor2_1
* cell instance $1679 r0 *1 1313.76,1512
X$1679 28219 29278 29141 13180 29285 29212 gf180mcu_fd_sc_mcu9t5v0__dffrnq_2
* cell instance $1680 m0 *1 1349.04,1461.6
X$1680 28005 28103 28239 27970 gf180mcu_fd_sc_mcu9t5v0__clkinv_1
* cell instance $1681 r0 *1 1356.32,1512
X$1681 29283 29285 29212 29281 26658 gf180mcu_fd_sc_mcu9t5v0__xor2_1
* cell instance $1682 r0 *1 1320.48,1481.76
X$1682 4952 23179 28874 28661 28932 gf180mcu_fd_sc_mcu9t5v0__nand2_1
* cell instance $1683 r0 *1 1347.92,1491.84
X$1683 29057 29005 28989 28937 28944 gf180mcu_fd_sc_mcu9t5v0__and2_1
* cell instance $1684 r0 *1 1330.56,1491.84
X$1684 28934 28943 26904 28989 28937 29004 gf180mcu_fd_sc_mcu9t5v0__mux2_1
* cell instance $1685 r0 *1 1344.56,1491.84
X$1685 29057 29005 28989 28937 28680 gf180mcu_fd_sc_mcu9t5v0__nor2_1
* cell instance $1686 m0 *1 1366.4,1461.6
X$1686 27834 27507 28103 28239 28110 gf180mcu_fd_sc_mcu9t5v0__xnor2_1
* cell instance $1687 m0 *1 1364.16,1512
X$1687 29221 29175 29174 29146 29212 29143 gf180mcu_fd_sc_mcu9t5v0__aoi21_1
* cell instance $1688 m0 *1 1368.64,1512
X$1688 29174 29221 29175 29146 29212 29162 gf180mcu_fd_sc_mcu9t5v0__and3_1
* cell instance $1689 r0 *1 1375.36,1501.92
X$1689 29143 29162 29146 29062 28936 gf180mcu_fd_sc_mcu9t5v0__nor2_1
* cell instance $1690 r0 *1 1366.96,1501.92
X$1690 29175 29421 29146 29062 28544 gf180mcu_fd_sc_mcu9t5v0__and2_1
* cell instance $1691 m0 *1 1375.36,1501.92
X$1691 28936 28656 29143 28989 29062 29058 gf180mcu_fd_sc_mcu9t5v0__aoi21_1
* cell instance $1692 r0 *1 1313.2,1501.92
X$1692 29296 29141 29075 29146 29062 29001 gf180mcu_fd_sc_mcu9t5v0__nor3_1
* cell instance $1693 r0 *1 1356.88,1501.92
X$1693 24100 29146 29062 29161 gf180mcu_fd_sc_mcu9t5v0__clkinv_1
* cell instance $1694 m0 *1 1323.84,1491.84
X$1694 18614 28933 28932 28220 28874 28937 28943
+ gf180mcu_fd_sc_mcu9t5v0__aoi22_1
* cell instance $1695 r0 *1 1351.84,1471.68
X$1695 27262 28654 28515 13180 28635 28530 gf180mcu_fd_sc_mcu9t5v0__dffrnq_2
* cell instance $1696 m0 *1 1373.12,1461.6
X$1696 28112 28111 28222 28103 28239 27507 gf180mcu_fd_sc_mcu9t5v0__aoi21_1
* cell instance $1697 m0 *1 1359.12,1512
X$1697 28934 29161 29146 29212 29220 gf180mcu_fd_sc_mcu9t5v0__nand2_1
* cell instance $1698 r0 *1 1368.64,1451.52
X$1698 25850 28103 27945 28111 gf180mcu_fd_sc_mcu9t5v0__clkinv_1
* cell instance $1699 r0 *1 1332.8,1512
X$1699 28934 25715 23921 29279 29285 29212 29055
+ gf180mcu_fd_sc_mcu9t5v0__aoi211_1
* cell instance $1700 r0 *1 1372,1471.68
X$1700 18277 28682 28635 28530 28655 gf180mcu_fd_sc_mcu9t5v0__and2_1
* cell instance $1701 m0 *1 1377.6,1461.6
X$1701 28112 25850 28103 28239 28009 gf180mcu_fd_sc_mcu9t5v0__nand2_1
* cell instance $1702 m0 *1 1355.2,1512
X$1702 29282 29280 28659 29146 29212 28681 gf180mcu_fd_sc_mcu9t5v0__nand3_1
* cell instance $1703 r0 *1 1332.24,1501.92
X$1703 28219 29004 28934 13180 29146 29062 gf180mcu_fd_sc_mcu9t5v0__dffrnq_2
* cell instance $1704 m0 *1 1317.12,1512
X$1704 29141 29075 26962 29146 29212 29142 gf180mcu_fd_sc_mcu9t5v0__oai21_1
* cell instance $1705 m0 *1 1286.32,1461.6
X$1705 28219 27968 27790 28103 28239 gf180mcu_fd_sc_mcu9t5v0__dffq_2
* cell instance $1706 m0 *1 1274,1512
X$1706 28219 29160 29219 13180 29146 29212 gf180mcu_fd_sc_mcu9t5v0__dffrnq_2
* cell instance $1707 r0 *1 1280.72,1512
X$1707 29219 23921 29285 29212 29139 gf180mcu_fd_sc_mcu9t5v0__nand2_1
* cell instance $1708 m0 *1 1305.36,1461.6
X$1708 27790 18590 18614 28103 28239 28220 gf180mcu_fd_sc_mcu9t5v0__aoi21_1
* cell instance $1709 r0 *1 1279.6,1501.92
X$1709 29139 29138 29146 29062 29160 gf180mcu_fd_sc_mcu9t5v0__nand2_1
* cell instance $1710 m0 *1 1299.2,1501.92
X$1710 22829 29056 28672 28989 29062 29140 gf180mcu_fd_sc_mcu9t5v0__mux2_1
* cell instance $1711 r0 *1 1277.92,1481.76
X$1711 28219 28784 28648 13180 28874 28661 gf180mcu_fd_sc_mcu9t5v0__dffrnq_2
* cell instance $1712 r0 *1 1251.04,1501.92
X$1712 27787 28394 28539 29137 28931 29146 29062 29073
+ gf180mcu_fd_sc_mcu9t5v0__aoi221_1
* cell instance $1713 m0 *1 1262.8,1481.76
X$1713 28675 28635 28661 28676 gf180mcu_fd_sc_mcu9t5v0__clkinv_1
* cell instance $1714 m0 *1 1265.04,1481.76
X$1714 28005 28646 28676 28635 28661 30525 gf180mcu_fd_sc_mcu9t5v0__aoi21_1
* cell instance $1715 r0 *1 1296.4,1461.6
X$1715 29272 28541 28378 28239 26475 gf180mcu_fd_sc_mcu9t5v0__nor2_1
* cell instance $1716 m0 *1 1280.16,1471.68
X$1716 27234 28646 28378 28530 28514 gf180mcu_fd_sc_mcu9t5v0__nand2_1
* cell instance $1717 m0 *1 1255.52,1512
X$1717 29216 29146 29212 29218 gf180mcu_fd_sc_mcu9t5v0__clkinv_1
* cell instance $1718 m0 *1 1268.4,1461.6
X$1718 28218 28103 28239 28004 gf180mcu_fd_sc_mcu9t5v0__clkinv_1
* cell instance $1719 r0 *1 1258.32,1451.52
X$1719 28004 23921 26898 28001 28103 27945 28003
+ gf180mcu_fd_sc_mcu9t5v0__aoi22_1
* cell instance $1720 m0 *1 1247.12,1491.84
X$1720 28941 28874 28937 28781 gf180mcu_fd_sc_mcu9t5v0__clkinv_1
* cell instance $1721 r0 *1 1305.92,1491.84
X$1721 29002 29001 28989 28937 28785 gf180mcu_fd_sc_mcu9t5v0__nand2_1
* cell instance $1722 r0 *1 1267.28,1491.84
X$1722 28219 29054 28783 13180 28989 28937 gf180mcu_fd_sc_mcu9t5v0__dffrnq_2
* cell instance $1723 r0 *1 1248.24,1471.68
X$1723 28538 28646 28536 27821 28635 28530 28647
+ gf180mcu_fd_sc_mcu9t5v0__aoi22_1
* cell instance $1724 r0 *1 1259.44,1512
X$1724 29419 28646 29218 29285 29212 29985 gf180mcu_fd_sc_mcu9t5v0__aoi21_1
* cell instance $1725 r0 *1 1274.56,1512
X$1725 29217 29285 29212 29071 gf180mcu_fd_sc_mcu9t5v0__clkinv_1
* cell instance $1726 r0 *1 1256.08,1461.6
X$1726 28360 28378 28239 28002 gf180mcu_fd_sc_mcu9t5v0__clkinv_1
* cell instance $1727 r0 *1 1258.88,1481.76
X$1727 28783 28646 28394 26012 28536 28216 28874 28661 28782
+ gf180mcu_fd_sc_mcu9t5v0__aoi222_1
* cell instance $1728 r0 *1 1245.44,1471.68
X$1728 28537 28635 28530 28512 gf180mcu_fd_sc_mcu9t5v0__clkinv_1
* cell instance $1729 r0 *1 1293.04,1471.68
X$1729 28648 28540 18614 28635 28530 28542 gf180mcu_fd_sc_mcu9t5v0__oai21_1
* cell instance $1730 m0 *1 1274.56,1471.68
X$1730 28514 28513 28378 28530 30301 gf180mcu_fd_sc_mcu9t5v0__nand2_1
* cell instance $1731 m0 *1 1258.88,1512
X$1731 29219 28394 29159 29146 29212 29173 gf180mcu_fd_sc_mcu9t5v0__aoi21_1
* cell instance $1732 r0 *1 1298.08,1512
X$1732 22830 29296 28672 29285 29212 29295 gf180mcu_fd_sc_mcu9t5v0__mux2_1
* cell instance $1733 m0 *1 1284.64,1501.92
X$1733 22858 28989 29062 28219 gf180mcu_fd_sc_mcu9t5v0__clkbuf_8
* cell instance $1734 r0 *1 1289.68,1501.92
X$1734 28219 29140 29056 13180 29146 29062 gf180mcu_fd_sc_mcu9t5v0__dffrnq_2
* cell instance $1735 m0 *1 1306.48,1501.92
X$1735 29056 28989 29062 29002 gf180mcu_fd_sc_mcu9t5v0__clkinv_1
* cell instance $1736 r0 *1 1307.6,1481.76
X$1736 28651 28785 28874 28661 28649 gf180mcu_fd_sc_mcu9t5v0__nor2_1
* cell instance $1737 m0 *1 1243.76,1461.6
X$1737 27233 28000 28360 13180 28103 28239 gf180mcu_fd_sc_mcu9t5v0__dffrnq_2
* cell instance $1738 m0 *1 1253.28,1501.92
X$1738 26352 28646 28539 29707 28536 28776 28989 29062 29074
+ gf180mcu_fd_sc_mcu9t5v0__aoi222_1
* cell instance $1739 r0 *1 1260,1461.6
X$1739 27233 28003 28218 13180 28378 28239 gf180mcu_fd_sc_mcu9t5v0__dffrnq_2
* cell instance $1740 r0 *1 1288.56,1471.68
X$1740 28648 28540 28542 28635 28530 28541 gf180mcu_fd_sc_mcu9t5v0__aoi21_1
* cell instance $1741 r0 *1 1253.28,1451.52
X$1741 28002 23921 27525 28001 28103 27945 28000
+ gf180mcu_fd_sc_mcu9t5v0__aoi22_1
* cell instance $1742 m0 *1 1252.16,1491.84
X$1742 28647 28874 28937 28931 gf180mcu_fd_sc_mcu9t5v0__clkinv_1
* cell instance $1743 r0 *1 1260,1501.92
X$1743 29074 29146 29062 29159 gf180mcu_fd_sc_mcu9t5v0__clkinv_1
* cell instance $1744 m0 *1 1272.88,1491.84
X$1744 28783 18277 28874 28937 28942 gf180mcu_fd_sc_mcu9t5v0__nor2_1
* cell instance $1745 m0 *1 1253.84,1481.76
X$1745 25556 28394 28536 28510 28539 29053 28635 28661 28675
+ gf180mcu_fd_sc_mcu9t5v0__aoi222_1
* cell instance $1746 m0 *1 1284.64,1481.76
X$1746 23314 28648 28672 28635 28661 28784 gf180mcu_fd_sc_mcu9t5v0__mux2_1
* cell instance $1747 m0 *1 1272.88,1501.92
X$1747 28942 29055 28989 29062 29054 gf180mcu_fd_sc_mcu9t5v0__nor2_1
* cell instance $1748 m0 *1 1271.76,1471.68
X$1748 28218 28394 28378 28530 28513 gf180mcu_fd_sc_mcu9t5v0__nand2_1
* cell instance $1749 r0 *1 1300.88,1471.68
X$1749 27995 28649 28635 28530 28540 gf180mcu_fd_sc_mcu9t5v0__nor2_1
* cell instance $1750 r0 *1 1284.64,1501.92
X$1750 28219 29146 29062 gf180mcu_fd_sc_mcu9t5v0__clkinv_3
* cell instance $1751 r0 *1 1254.96,1441.44
X$1751 27787 27807 27666 27502 gf180mcu_fd_sc_mcu9t5v0__clkinv_1
* cell instance $1752 r0 *1 1254.4,1431.36
X$1752 26053 24591 27517 27367 27501 gf180mcu_fd_sc_mcu9t5v0__nand2_1
* cell instance $1753 r0 *1 1271.76,1431.36
X$1753 27504 20214 27517 27367 27503 gf180mcu_fd_sc_mcu9t5v0__nand2_1
* cell instance $1754 r0 *1 1244.88,1431.36
X$1754 24549 25715 23921 27517 27367 27500 gf180mcu_fd_sc_mcu9t5v0__aoi21_1
* cell instance $1755 r0 *1 1268.4,1431.36
X$1755 24718 27503 27517 27367 27642 gf180mcu_fd_sc_mcu9t5v0__nand2_1
* cell instance $1756 r0 *1 1276.8,1441.44
X$1756 27831 20214 27807 27666 27788 gf180mcu_fd_sc_mcu9t5v0__nand2_1
* cell instance $1757 r0 *1 1274,1441.44
X$1757 24718 27788 27807 27666 27830 gf180mcu_fd_sc_mcu9t5v0__nand2_1
* cell instance $1758 r0 *1 1249.36,1431.36
X$1758 27502 23921 27501 27500 27517 27367 27524
+ gf180mcu_fd_sc_mcu9t5v0__aoi22_1
* cell instance $1759 m0 *1 1280.16,1391.04
X$1759 26052 26053 18277 26054 25997 26166 29138
+ gf180mcu_fd_sc_mcu9t5v0__oai211_1
* cell instance $1760 r0 *1 1252.72,1411.2
X$1760 26897 26771 26942 26757 26898 gf180mcu_fd_sc_mcu9t5v0__nand2_1
* cell instance $1761 r0 *1 1268.96,1421.28
X$1761 27097 24718 27213 27078 27098 gf180mcu_fd_sc_mcu9t5v0__nand2_1
* cell instance $1762 m0 *1 1253.28,1411.2
X$1762 26526 26771 26632 26757 25891 gf180mcu_fd_sc_mcu9t5v0__nor2_1
* cell instance $1763 m0 *1 1287.44,1421.28
X$1763 23176 27100 27101 26942 27078 gf180mcu_fd_sc_mcu9t5v0__dffq_2
* cell instance $1764 m0 *1 1273.44,1401.12
X$1764 26527 20214 26331 26456 26473 gf180mcu_fd_sc_mcu9t5v0__nand2_1
* cell instance $1765 m0 *1 1268.96,1401.12
X$1765 24718 26473 26331 26456 26472 gf180mcu_fd_sc_mcu9t5v0__nand2_1
* cell instance $1766 m0 *1 1243.76,1441.44
X$1766 27233 27524 27787 13180 27517 27666 gf180mcu_fd_sc_mcu9t5v0__dffrnq_2
* cell instance $1767 m0 *1 1248.24,1411.2
X$1767 23648 26632 26757 26771 gf180mcu_fd_sc_mcu9t5v0__clkinv_1
* cell instance $1768 r0 *1 1284.08,1401.12
X$1768 26527 26528 19862 26632 26456 26474 gf180mcu_fd_sc_mcu9t5v0__mux2_1
* cell instance $1769 r0 *1 1255.52,1411.2
X$1769 26772 26898 26942 26757 26900 gf180mcu_fd_sc_mcu9t5v0__nand2_1
* cell instance $1770 m0 *1 1303.12,1441.44
X$1770 27643 18590 4952 23052 18614 27517 27666 27832
+ gf180mcu_fd_sc_mcu9t5v0__aoi221_1
* cell instance $1771 r0 *1 1250.48,1411.2
X$1771 26897 26942 26757 26526 gf180mcu_fd_sc_mcu9t5v0__clkinv_1
* cell instance $1772 r0 *1 1294.16,1391.04
X$1772 26528 18590 26331 26166 26313 gf180mcu_fd_sc_mcu9t5v0__and2_1
* cell instance $1773 m0 *1 1279.04,1401.12
X$1773 23176 26474 26528 26331 26456 gf180mcu_fd_sc_mcu9t5v0__dffq_2
* cell instance $1774 r0 *1 1290.8,1421.28
X$1774 27099 27101 19862 27213 27078 27100 gf180mcu_fd_sc_mcu9t5v0__mux2_1
* cell instance $1775 m0 *1 1248.8,1391.04
X$1775 26052 26180 24836 25997 26166 26181 gf180mcu_fd_sc_mcu9t5v0__mux2_1
* cell instance $1776 r0 *1 1271.76,1421.28
X$1776 27233 27098 27099 13180 27213 27078 gf180mcu_fd_sc_mcu9t5v0__dffrnq_2
* cell instance $1777 r0 *1 1298.64,1391.04
X$1777 26313 24597 18444 26331 26166 26351 gf180mcu_fd_sc_mcu9t5v0__oai21_1
* cell instance $1778 m0 *1 1250.48,1411.2
X$1778 26526 23648 26632 26757 26772 gf180mcu_fd_sc_mcu9t5v0__nand2_1
* cell instance $1779 r0 *1 1265.04,1401.12
X$1779 23802 26472 26527 13180 26632 26456 gf180mcu_fd_sc_mcu9t5v0__dffrnq_2
* cell instance $1780 m0 *1 1260,1421.28
X$1780 26053 26900 25848 26942 27078 27525 gf180mcu_fd_sc_mcu9t5v0__nand3_1
* cell instance $1781 r0 *1 1260,1411.2
X$1781 25282 26900 25848 26942 26757 26899 gf180mcu_fd_sc_mcu9t5v0__nor3_1
* cell instance $1782 m0 *1 1254.4,1421.28
X$1782 26897 25715 23921 26899 26942 27078 28001
+ gf180mcu_fd_sc_mcu9t5v0__aoi211_1
* cell instance $1783 m0 *1 1276.8,1421.28
X$1783 27099 20214 26942 27078 27097 gf180mcu_fd_sc_mcu9t5v0__nand2_1
* cell instance $1784 r0 *1 1249.36,1391.04
X$1784 23802 26181 26052 13180 26331 26166 gf180mcu_fd_sc_mcu9t5v0__dffrnq_2
* cell instance $1785 r0 *1 1291.36,1441.44
X$1785 27262 27669 27643 27807 27666 gf180mcu_fd_sc_mcu9t5v0__dffq_2
* cell instance $1786 m0 *1 1299.2,1401.12
X$1786 26055 29272 26351 26475 26331 26456 26476
+ gf180mcu_fd_sc_mcu9t5v0__aoi22_1
* cell instance $1787 m0 *1 1263.92,1441.44
X$1787 27233 27642 27504 13180 27517 27666 gf180mcu_fd_sc_mcu9t5v0__dffrnq_2
* cell instance $1788 r0 *1 1284.08,1441.44
X$1788 27504 27790 19862 27807 27666 27968 gf180mcu_fd_sc_mcu9t5v0__mux2_1
* cell instance $1789 m0 *1 1290.8,1441.44
X$1789 27831 27643 19862 27517 27666 27669 gf180mcu_fd_sc_mcu9t5v0__mux2_1
* cell instance $1790 r0 *1 1354.08,1421.28
X$1790 27106 27213 27078 26906 gf180mcu_fd_sc_mcu9t5v0__clkinv_1
* cell instance $1791 r0 *1 1332.24,1411.2
X$1791 23176 26774 26316 13180 26942 26757 gf180mcu_fd_sc_mcu9t5v0__dffrnq_2
* cell instance $1792 r0 *1 1325.52,1391.04
X$1792 23176 26478 26315 13180 26331 26166 gf180mcu_fd_sc_mcu9t5v0__dffrnq_2
* cell instance $1793 m0 *1 1372,1411.2
X$1793 26778 23180 26632 26757 26777 gf180mcu_fd_sc_mcu9t5v0__nor2_1
* cell instance $1794 r0 *1 1374.24,1411.2
X$1794 26777 26908 26657 26942 26757 26776 gf180mcu_fd_sc_mcu9t5v0__oai21_1
* cell instance $1795 r0 *1 1327.2,1431.36
X$1795 18614 27506 25291 26901 27517 27367 27381
+ gf180mcu_fd_sc_mcu9t5v0__aoi22_1
* cell instance $1796 m0 *1 1328.88,1411.2
X$1796 26757 26632 gf180mcu_fd_sc_mcu9t5v0__filltie
* cell instance $1797 r0 *1 1348.48,1391.04
X$1797 26315 26053 26331 26166 25895 gf180mcu_fd_sc_mcu9t5v0__nor2_1
* cell instance $1798 r0 *1 1369.76,1431.36
X$1798 27385 27507 27107 27529 27517 27367 26908
+ gf180mcu_fd_sc_mcu9t5v0__aoi211_1
* cell instance $1799 r0 *1 1365.28,1431.36
X$1799 27263 24975 27517 27367 27385 gf180mcu_fd_sc_mcu9t5v0__or2_1
* cell instance $1800 r0 *1 1364.16,1411.2
X$1800 26053 26776 26942 26757 26907 gf180mcu_fd_sc_mcu9t5v0__and2_1
* cell instance $1801 m0 *1 1328.88,1431.36
X$1801 27367 27213 gf180mcu_fd_sc_mcu9t5v0__filltie
* cell instance $1802 m0 *1 1330,1441.44
X$1802 27527 27517 27666 gf180mcu_fd_sc_mcu9t5v0__clkinv_12
* cell instance $1803 m0 *1 1314.32,1431.36
X$1803 27234 27213 27367 27103 gf180mcu_fd_sc_mcu9t5v0__clkinv_1
* cell instance $1804 r0 *1 1372,1401.12
X$1804 26316 23704 26632 26456 26657 gf180mcu_fd_sc_mcu9t5v0__xnor2_1
* cell instance $1805 m0 *1 1344.56,1441.44
X$1805 27383 25715 23921 27517 27666 27833 gf180mcu_fd_sc_mcu9t5v0__aoi21_1
* cell instance $1806 r0 *1 1368.08,1391.04
X$1806 26059 26184 26331 26166 26019 gf180mcu_fd_sc_mcu9t5v0__nand2_1
* cell instance $1807 m0 *1 1373.12,1441.44
X$1807 27384 27517 27666 27529 gf180mcu_fd_sc_mcu9t5v0__clkinv_1
* cell instance $1808 r0 *1 1326.08,1441.44
X$1808 25335 27666 27807 27527 gf180mcu_fd_sc_mcu9t5v0__clkbuf_16
* cell instance $1809 r0 *1 1367.52,1441.44
X$1809 27263 24975 27807 27666 27671 gf180mcu_fd_sc_mcu9t5v0__nor2_1
* cell instance $1810 r0 *1 1335.6,1431.36
X$1810 27262 27382 27383 13180 27517 27367 gf180mcu_fd_sc_mcu9t5v0__dffrnq_2
* cell instance $1811 r0 *1 1317.68,1431.36
X$1811 27505 23921 26056 26477 27517 27367 27526
+ gf180mcu_fd_sc_mcu9t5v0__aoi22_1
* cell instance $1812 m0 *1 1336.16,1431.36
X$1812 27383 27381 26904 27213 27367 27382 gf180mcu_fd_sc_mcu9t5v0__mux2_1
* cell instance $1813 r0 *1 1319.92,1411.2
X$1813 18614 26903 24552 26901 26942 26757 26902
+ gf180mcu_fd_sc_mcu9t5v0__aoi22_1
* cell instance $1814 m0 *1 1375.36,1441.44
X$1814 27107 27517 27666 27644 gf180mcu_fd_sc_mcu9t5v0__clkinv_1
* cell instance $1815 m0 *1 1350.16,1411.2
X$1815 26316 25715 23921 26632 26757 26775 gf180mcu_fd_sc_mcu9t5v0__aoi21_1
* cell instance $1816 m0 *1 1314.88,1391.04
X$1816 26016 26182 25997 26166 26183 gf180mcu_fd_sc_mcu9t5v0__nand2_1
* cell instance $1817 m0 *1 1373.12,1401.12
X$1817 26316 26331 26456 26479 gf180mcu_fd_sc_mcu9t5v0__clkinv_1
* cell instance $1818 m0 *1 1377.04,1391.04
X$1818 26315 23388 25997 26166 26185 gf180mcu_fd_sc_mcu9t5v0__nand2_1
* cell instance $1819 m0 *1 1328.88,1441.44
X$1819 27666 27517 gf180mcu_fd_sc_mcu9t5v0__filltie
* cell instance $1820 r0 *1 1351.84,1411.2
X$1820 26906 23921 26905 26775 26942 26757 26965
+ gf180mcu_fd_sc_mcu9t5v0__aoi22_1
* cell instance $1821 r0 *1 1370.88,1441.44
X$1821 27529 27671 27807 27666 27834 gf180mcu_fd_sc_mcu9t5v0__nor2_1
* cell instance $1822 r0 *1 1321.04,1441.44
X$1822 27789 27807 27666 27505 gf180mcu_fd_sc_mcu9t5v0__clkinv_1
* cell instance $1823 m0 *1 1340.08,1391.04
X$1823 23176 26057 26352 13180 25997 26166 gf180mcu_fd_sc_mcu9t5v0__dffrnq_2
* cell instance $1824 m0 *1 1328.88,1391.04
X$1824 26166 25997 gf180mcu_fd_sc_mcu9t5v0__filltie
* cell instance $1825 r0 *1 1368.64,1411.2
X$1825 26657 26777 26908 26907 26942 26757 26905
+ gf180mcu_fd_sc_mcu9t5v0__oai31_1
* cell instance $1826 m0 *1 1367.52,1391.04
X$1826 26059 26184 25997 26166 26058 gf180mcu_fd_sc_mcu9t5v0__or2_1
* cell instance $1827 m0 *1 1371.44,1421.28
X$1827 27105 26942 27078 26778 gf180mcu_fd_sc_mcu9t5v0__clkinv_1
* cell instance $1828 r0 *1 1345.68,1391.04
X$1828 26352 23921 26331 26166 25893 gf180mcu_fd_sc_mcu9t5v0__nand2_1
* cell instance $1829 m0 *1 1373.68,1421.28
X$1829 27105 26942 27078 23180 27107 gf180mcu_fd_sc_mcu9t5v0__xor2_1
* cell instance $1830 m0 *1 1326.08,1401.12
X$1830 4952 24304 26331 26456 27104 gf180mcu_fd_sc_mcu9t5v0__nand2_1
* cell instance $1831 r0 *1 1361.92,1431.36
X$1831 25282 26908 27517 27367 27528 gf180mcu_fd_sc_mcu9t5v0__nor2_1
* cell instance $1832 r0 *1 1361.92,1391.04
X$1832 26315 26331 26166 25896 gf180mcu_fd_sc_mcu9t5v0__clkinv_1
* cell instance $1833 m0 *1 1363.04,1391.04
X$1833 26019 26058 25282 25997 26166 25894 gf180mcu_fd_sc_mcu9t5v0__aoi21_1
* cell instance $1834 m0 *1 1369.2,1431.36
X$1834 27262 27213 27367 gf180mcu_fd_sc_mcu9t5v0__inv_3
* cell instance $1835 m0 *1 1364.16,1431.36
X$1835 27383 27213 27367 27263 gf180mcu_fd_sc_mcu9t5v0__clkinv_1
* cell instance $1836 m0 *1 1366.4,1431.36
X$1836 27263 24975 27213 27367 27384 gf180mcu_fd_sc_mcu9t5v0__nand2_1
* cell instance $1837 m0 *1 1345.68,1421.28
X$1837 27262 26965 27106 13180 26942 27078 gf180mcu_fd_sc_mcu9t5v0__dffrnq_2
* cell instance $1838 m0 *1 1364.16,1441.44
X$1838 27644 27671 27645 27528 27517 27666 27670
+ gf180mcu_fd_sc_mcu9t5v0__oai31_1
* cell instance $1839 m0 *1 1323.84,1421.28
X$1839 18614 26964 27104 26901 26942 27078 26773
+ gf180mcu_fd_sc_mcu9t5v0__aoi22_1
* cell instance $1840 m0 *1 1323.28,1391.04
X$1840 26053 26183 26018 25997 26166 26056 gf180mcu_fd_sc_mcu9t5v0__nand3_1
* cell instance $1841 r0 *1 1324.96,1411.2
X$1841 26315 26902 26904 26942 26757 26478 gf180mcu_fd_sc_mcu9t5v0__mux2_1
* cell instance $1842 m0 *1 1328.88,1401.12
X$1842 26456 26331 gf180mcu_fd_sc_mcu9t5v0__filltie
* cell instance $1843 m0 *1 1333.36,1411.2
X$1843 26316 26773 26904 26632 26757 26774 gf180mcu_fd_sc_mcu9t5v0__mux2_1
* cell instance $1844 m0 *1 1328.88,1421.28
X$1844 27078 26942 gf180mcu_fd_sc_mcu9t5v0__filltie
* cell instance $1845 r0 *1 1321.04,1391.04
X$1845 25282 26183 26018 26331 26166 26314 gf180mcu_fd_sc_mcu9t5v0__nor3_1
* cell instance $1846 m0 *1 1369.76,1441.44
X$1846 27529 27507 27517 27666 27645 gf180mcu_fd_sc_mcu9t5v0__nor2_1
* cell instance $1847 m0 *1 1368.64,1401.12
X$1847 26479 23704 26776 26331 26456 26184 gf180mcu_fd_sc_mcu9t5v0__oai21_1
* cell instance $1848 m0 *1 1316.56,1401.12
X$1848 26015 25715 23921 26314 26331 26456 26477
+ gf180mcu_fd_sc_mcu9t5v0__aoi211_1
* cell instance $1849 r0 *1 1313.2,1391.04
X$1849 26015 26331 26166 26055 gf180mcu_fd_sc_mcu9t5v0__clkinv_1
* cell instance $1850 r0 *1 1232.56,1360.8
X$1850 22858 25430 25268 23802 gf180mcu_fd_sc_mcu9t5v0__clkbuf_8
* cell instance $1851 r0 *1 1360.8,1239.84
X$1851 18000 21735 15415 13180 21884 21719 gf180mcu_fd_sc_mcu9t5v0__dffrnq_2
* cell instance $1852 r0 *1 1230.32,1249.92
X$1852 20345 22017 20957 13180 22124 21997 gf180mcu_fd_sc_mcu9t5v0__dffrnq_2
* cell instance $1853 m0 *1 1228.64,1239.84
X$1853 20345 21549 21550 13180 21537 21719 gf180mcu_fd_sc_mcu9t5v0__dffrnq_2
* cell instance $1854 r0 *1 1230.88,1310.4
X$1854 23802 23920 23803 13180 23957 23797 gf180mcu_fd_sc_mcu9t5v0__dffrnq_2
* cell instance $1855 r0 *1 1230.88,1209.6
X$1855 20706 20953 20936 20822 20091 20957 gf180mcu_fd_sc_mcu9t5v0__xnor3_1
* cell instance $1856 m0 *1 1231.44,1118.88
X$1856 18157 17961 17958 13331 17985 18104 gf180mcu_fd_sc_mcu9t5v0__dffrnq_2
* cell instance $1857 r0 *1 1232,1219.68
X$1857 18157 21009 20524 13180 21241 21123 gf180mcu_fd_sc_mcu9t5v0__dffrnq_2
* cell instance $1858 m0 *1 1232.56,1139.04
X$1858 18558 18553 18731 17595 gf180mcu_fd_sc_mcu9t5v0__buf_8
* cell instance $1859 r0 *1 1226.4,1149.12
X$1859 18157 19138 7963 13331 19171 18996 gf180mcu_fd_sc_mcu9t5v0__dffrnq_2
* cell instance $1860 r0 *1 1294.16,1239.84
X$1860 18157 21733 17597 13180 21884 21719 gf180mcu_fd_sc_mcu9t5v0__dffrnq_2
* cell instance $1861 r0 *1 1240.4,1330.56
X$1861 24295 24296 24528 24414 24546 gf180mcu_fd_sc_mcu9t5v0__nand2_1
* cell instance $1862 m0 *1 1239.28,1330.56
X$1862 24295 23515 24232 24414 24250 gf180mcu_fd_sc_mcu9t5v0__and2_1
* cell instance $1863 r0 *1 1242.08,1350.72
X$1863 23802 25012 24595 13180 25158 25000 gf180mcu_fd_sc_mcu9t5v0__dffrnq_2
* cell instance $1864 r0 *1 1237.6,1280.16
X$1864 5913 22852 23038 22885 23050 gf180mcu_fd_sc_mcu9t5v0__xnor2_1
* cell instance $1865 r0 *1 1241.52,1270.08
X$1865 22592 22464 22700 22577 22717 gf180mcu_fd_sc_mcu9t5v0__nand2_1
* cell instance $1866 r0 *1 1281.84,1239.84
X$1866 21732 21854 17977 21884 21719 21853 gf180mcu_fd_sc_mcu9t5v0__mux2_1
* cell instance $1867 m0 *1 1241.52,1280.16
X$1867 22902 22853 22852 22700 22885 22591 gf180mcu_fd_sc_mcu9t5v0__nand3_1
* cell instance $1868 m0 *1 1239.28,1290.24
X$1868 7095 23174 23175 23038 23200 23211 gf180mcu_fd_sc_mcu9t5v0__oai21_1
* cell instance $1869 m0 *1 1242.08,1270.08
X$1869 22591 5171 22449 22577 22421 gf180mcu_fd_sc_mcu9t5v0__nor2_1
* cell instance $1870 r0 *1 1340.64,1239.84
X$1870 21603 21855 16532 13180 21884 21719 gf180mcu_fd_sc_mcu9t5v0__dffrnq_2
* cell instance $1871 r0 *1 1321.6,1239.84
X$1871 21603 21734 21556 13180 21884 21719 gf180mcu_fd_sc_mcu9t5v0__dffrnq_2
* cell instance $1872 r0 *1 1167.04,1239.84
X$1872 21597 21601 21884 21719 21602 gf180mcu_fd_sc_mcu9t5v0__nand2_1
* cell instance $1873 r0 *1 1117.2,1239.84
X$1873 21597 21850 21884 21719 21729 gf180mcu_fd_sc_mcu9t5v0__nand2_1
* cell instance $1874 r0 *1 1130.08,1239.84
X$1874 22014 21730 21884 21719 21851 21598 gf180mcu_fd_sc_mcu9t5v0__xnor3_1
* cell instance $1875 r0 *1 1145.2,1239.84
X$1875 21000 21852 21851 20346 21884 21719 21596
+ gf180mcu_fd_sc_mcu9t5v0__oai22_1
* cell instance $1876 r0 *1 1110.48,1239.84
X$1876 21597 21884 21719 21850 21728 gf180mcu_fd_sc_mcu9t5v0__xor2_1
* cell instance $1877 r0 *1 1209.04,1239.84
X$1877 21719 21884 gf180mcu_fd_sc_mcu9t5v0__filltie
* cell instance $1878 r0 *1 1190,1239.84
X$1878 21426 21427 21884 21719 21731 gf180mcu_fd_sc_mcu9t5v0__nor2_1
* cell instance $1879 r0 *1 1193.36,1239.84
X$1879 21426 21427 21884 21719 21547 gf180mcu_fd_sc_mcu9t5v0__nand2_1
* cell instance $1880 r0 *1 1184.4,1239.84
X$1880 20345 21884 21719 gf180mcu_fd_sc_mcu9t5v0__inv_4
* cell instance $1881 r0 *1 1242.64,1169.28
X$1881 19616 19742 14685 19729 19605 18450 gf180mcu_fd_sc_mcu9t5v0__mux2_1
* cell instance $1882 r0 *1 1238.16,1189.44
X$1882 20228 20227 20351 20352 20379 20217 20229
+ gf180mcu_fd_sc_mcu9t5v0__aoi211_1
* cell instance $1883 m0 *1 1240.96,1189.44
X$1883 20228 20227 20351 20028 20217 20093 gf180mcu_fd_sc_mcu9t5v0__aoi21_1
* cell instance $1884 m0 *1 1238.72,1209.6
X$1884 20524 20707 20637 20822 20705 gf180mcu_fd_sc_mcu9t5v0__xnor2_1
* cell instance $1885 r0 *1 1240.96,1159.2
X$1885 19419 19418 19448 19282 19300 gf180mcu_fd_sc_mcu9t5v0__and2_1
* cell instance $1886 r0 *1 1238.16,1128.96
X$1886 18157 18400 18401 13331 18553 18386 gf180mcu_fd_sc_mcu9t5v0__dffrnq_2
* cell instance $1887 m0 *1 1238.16,1370.88
X$1887 23802 25554 25555 13180 25430 25581 gf180mcu_fd_sc_mcu9t5v0__dffrnq_2
* cell instance $1888 r0 *1 1242.08,1370.88
X$1888 25555 25846 24836 25705 25581 25554 gf180mcu_fd_sc_mcu9t5v0__mux2_1
* cell instance $1889 r0 *1 1322.72,1310.4
X$1889 12656 23804 23926 23957 23797 23974 gf180mcu_fd_sc_mcu9t5v0__oai21_1
* cell instance $1890 r0 *1 1341.76,1310.4
X$1890 18614 22854 22311 24132 23957 23797 23975
+ gf180mcu_fd_sc_mcu9t5v0__oai31_1
* cell instance $1891 r0 *1 1327.2,1310.4
X$1891 12656 23804 20996 23957 23797 23926 gf180mcu_fd_sc_mcu9t5v0__aoi21_1
* cell instance $1892 r0 *1 1277.92,1310.4
X$1892 24098 23213 23957 23797 23925 gf180mcu_fd_sc_mcu9t5v0__nand2_1
* cell instance $1893 r0 *1 1280.72,1310.4
X$1893 18614 23213 22594 23925 23957 23797 24097
+ gf180mcu_fd_sc_mcu9t5v0__oai31_1
* cell instance $1894 r0 *1 1270.64,1310.4
X$1894 21732 23921 23957 23797 23924 gf180mcu_fd_sc_mcu9t5v0__nand2_1
* cell instance $1895 r0 *1 1260,1310.4
X$1895 23922 23923 23924 23957 23797 23701 gf180mcu_fd_sc_mcu9t5v0__oai21_1
* cell instance $1896 m0 *1 1311.52,1290.24
X$1896 10582 23022 23038 23200 23179 gf180mcu_fd_sc_mcu9t5v0__xnor2_1
* cell instance $1897 m0 *1 1309.84,1280.16
X$1897 21603 22722 22723 13180 22700 22885 gf180mcu_fd_sc_mcu9t5v0__dffrnq_2
* cell instance $1898 m0 *1 1308.16,1260
X$1898 22833 22189 19910 22124 22295 22309 gf180mcu_fd_sc_mcu9t5v0__mux2_1
* cell instance $1899 r0 *1 1302.56,1260
X$1899 21603 22309 22189 13180 22449 22295 gf180mcu_fd_sc_mcu9t5v0__dffrnq_2
* cell instance $1900 r0 *1 1309.84,1280.16
X$1900 23021 22898 23038 22885 23022 gf180mcu_fd_sc_mcu9t5v0__and2_1
* cell instance $1901 m0 *1 1294.16,1310.4
X$1901 23176 23650 23702 13180 23623 23797 gf180mcu_fd_sc_mcu9t5v0__dffrnq_2
* cell instance $1902 r0 *1 1296.4,1320.48
X$1902 23176 24252 22595 13180 24232 24118 gf180mcu_fd_sc_mcu9t5v0__dffrnq_2
* cell instance $1903 r0 *1 1307.04,1370.88
X$1903 26900 25558 25705 25581 25596 gf180mcu_fd_sc_mcu9t5v0__xnor2_1
* cell instance $1904 r0 *1 1324.96,1320.48
X$1904 10329 24131 24232 24118 24304 gf180mcu_fd_sc_mcu9t5v0__xnor2_1
* cell instance $1905 r0 *1 1317.12,1330.56
X$1905 24422 12283 16443 24528 24414 24551 gf180mcu_fd_sc_mcu9t5v0__oai21_1
* cell instance $1906 r0 *1 1321.6,1330.56
X$1906 24422 12283 24303 24528 24414 24552 gf180mcu_fd_sc_mcu9t5v0__oai21_1
* cell instance $1907 m0 *1 1360.24,1350.72
X$1907 24975 22854 24828 25000 24725 gf180mcu_fd_sc_mcu9t5v0__nand2_1
* cell instance $1908 r0 *1 1344.56,1320.48
X$1908 24100 22854 24232 24118 24132 gf180mcu_fd_sc_mcu9t5v0__nand2_1
* cell instance $1909 m0 *1 1314.32,1360.8
X$1909 22858 25158 25268 23176 gf180mcu_fd_sc_mcu9t5v0__clkbuf_8
* cell instance $1910 m0 *1 1330,1360.8
X$1910 4952 23927 25158 25268 25291 gf180mcu_fd_sc_mcu9t5v0__nand2_1
* cell instance $1911 m0 *1 1328.88,1330.56
X$1911 24414 24232 gf180mcu_fd_sc_mcu9t5v0__filltie
* cell instance $1912 r0 *1 1331.68,1320.48
X$1912 16443 10329 24232 24118 24253 gf180mcu_fd_sc_mcu9t5v0__nand2_1
* cell instance $1913 m0 *1 1336.72,1350.72
X$1913 25136 24842 17977 24828 25000 24841 gf180mcu_fd_sc_mcu9t5v0__mux2_1
* cell instance $1914 m0 *1 1347.92,1340.64
X$1914 24842 16169 14872 24528 24712 24553 gf180mcu_fd_sc_mcu9t5v0__mux2_1
* cell instance $1915 r0 *1 1317.12,1350.72
X$1915 23176 25158 25000 33567 gf180mcu_fd_sc_mcu9t5v0__clkinv_1
* cell instance $1916 m0 *1 1323.28,1320.48
X$1916 16443 12656 23804 23957 24118 24131 gf180mcu_fd_sc_mcu9t5v0__aoi21_1
* cell instance $1917 r0 *1 1322.16,1320.48
X$1917 24253 24131 24232 24118 24422 gf180mcu_fd_sc_mcu9t5v0__nand2_1
* cell instance $1918 m0 *1 1322.16,1330.56
X$1918 24422 12283 20996 24232 24414 24303 gf180mcu_fd_sc_mcu9t5v0__aoi21_1
* cell instance $1919 r0 *1 1372.56,1360.8
X$1919 25332 25596 18277 25430 25268 25445 gf180mcu_fd_sc_mcu9t5v0__mux2_1
* cell instance $1920 r0 *1 1361.92,1340.64
X$1920 18614 22854 22190 24725 24828 24712 24726
+ gf180mcu_fd_sc_mcu9t5v0__oai31_1
* cell instance $1921 r0 *1 1333.36,1340.64
X$1921 23176 24841 24842 13180 24828 24712 gf180mcu_fd_sc_mcu9t5v0__dffrnq_2
* cell instance $1922 m0 *1 1328.88,1340.64
X$1922 24712 24528 gf180mcu_fd_sc_mcu9t5v0__filltie
* cell instance $1923 m0 *1 1328.88,1350.72
X$1923 25000 24828 gf180mcu_fd_sc_mcu9t5v0__filltie
* cell instance $1924 m0 *1 1328.88,1360.8
X$1924 25268 25158 gf180mcu_fd_sc_mcu9t5v0__filltie
* cell instance $1925 r0 *1 1330.56,1370.88
X$1925 25597 25849 25705 25581 25559 gf180mcu_fd_sc_mcu9t5v0__nor2_1
* cell instance $1926 m0 *1 1359.68,1330.56
X$1926 21603 24254 16467 13180 24232 24414 gf180mcu_fd_sc_mcu9t5v0__dffrnq_2
* cell instance $1927 r0 *1 1323.28,1350.72
X$1927 25136 23921 25158 25000 25014 gf180mcu_fd_sc_mcu9t5v0__nand2_1
* cell instance $1928 m0 *1 1316.56,1340.64
X$1928 24600 24599 18277 24528 24712 24724 gf180mcu_fd_sc_mcu9t5v0__mux2_1
* cell instance $1929 m0 *1 1348.48,1360.8
X$1929 25015 25331 20715 25158 25268 25137 gf180mcu_fd_sc_mcu9t5v0__mux2_1
* cell instance $1930 r0 *1 1313.2,1360.8
X$1930 23921 25290 25169 25014 25430 25268 25330
+ gf180mcu_fd_sc_mcu9t5v0__oai31_1
* cell instance $1931 r0 *1 1346.24,1330.56
X$1931 23176 24553 16169 13180 24528 24414 gf180mcu_fd_sc_mcu9t5v0__dffrnq_2
* cell instance $1932 r0 *1 1353.52,1370.88
X$1932 23176 25598 25850 13180 25705 25581 gf180mcu_fd_sc_mcu9t5v0__dffrnq_2
* cell instance $1933 r0 *1 1363.6,1320.48
X$1933 25015 16467 14872 24232 24118 24254 gf180mcu_fd_sc_mcu9t5v0__mux2_1
* cell instance $1934 r0 *1 1338.4,1360.8
X$1934 25331 18277 25430 25268 25597 gf180mcu_fd_sc_mcu9t5v0__nor2_1
* cell instance $1935 r0 *1 1318.8,1360.8
X$1935 23176 25330 25136 13180 25430 25268 gf180mcu_fd_sc_mcu9t5v0__dffrnq_2
* cell instance $1936 m0 *1 1341.2,1320.48
X$1936 21603 23975 24100 13180 23957 24118 gf180mcu_fd_sc_mcu9t5v0__dffrnq_2
* cell instance $1937 m0 *1 1328.88,1320.48
X$1937 24118 23957 gf180mcu_fd_sc_mcu9t5v0__filltie
* cell instance $1938 r0 *1 1345.68,1350.72
X$1938 23176 25137 25015 13180 25158 25000 gf180mcu_fd_sc_mcu9t5v0__dffrnq_2
* cell instance $1939 m0 *1 1356.32,1370.88
X$1939 18614 22854 22468 25560 25430 25581 25598
+ gf180mcu_fd_sc_mcu9t5v0__oai31_1
* cell instance $1940 r0 *1 1314.32,1340.64
X$1940 23176 24724 24600 13180 24828 24712 gf180mcu_fd_sc_mcu9t5v0__dffrnq_2
* cell instance $1941 m0 *1 1328.88,1370.88
X$1941 25581 25430 gf180mcu_fd_sc_mcu9t5v0__filltie
* cell instance $1942 m0 *1 1330,1370.88
X$1942 23176 25559 25331 13180 25430 25581 gf180mcu_fd_sc_mcu9t5v0__dffrnq_2
* cell instance $1943 m0 *1 1286.32,1340.64
X$1943 24595 24098 24528 24712 24596 gf180mcu_fd_sc_mcu9t5v0__nand2_1
* cell instance $1944 m0 *1 1261.12,1360.8
X$1944 25286 23921 25284 25285 25158 25268 25283
+ gf180mcu_fd_sc_mcu9t5v0__aoi22_1
* cell instance $1945 r0 *1 1247.68,1330.56
X$1945 24546 24590 24528 24414 24547 gf180mcu_fd_sc_mcu9t5v0__nand2_1
* cell instance $1946 m0 *1 1294.72,1350.72
X$1946 25135 24828 25000 24974 gf180mcu_fd_sc_mcu9t5v0__clkinv_1
* cell instance $1947 m0 *1 1300.88,1360.8
X$1947 25168 25289 25595 25158 25268 25290 gf180mcu_fd_sc_mcu9t5v0__aoi21_1
* cell instance $1948 m0 *1 1248.24,1340.64
X$1948 24130 24547 24528 24712 24591 gf180mcu_fd_sc_mcu9t5v0__xnor2_1
* cell instance $1949 m0 *1 1272.88,1320.48
X$1949 23176 24097 24098 13180 23957 24118 gf180mcu_fd_sc_mcu9t5v0__dffrnq_2
* cell instance $1950 m0 *1 1305.36,1360.8
X$1950 25595 25168 25289 25158 25268 25169 gf180mcu_fd_sc_mcu9t5v0__and3_1
* cell instance $1951 m0 *1 1289.68,1330.56
X$1951 24550 24300 24232 24414 24301 gf180mcu_fd_sc_mcu9t5v0__nor2_1
* cell instance $1952 r0 *1 1279.6,1340.64
X$1952 24595 24828 24712 24722 gf180mcu_fd_sc_mcu9t5v0__clkinv_1
* cell instance $1953 m0 *1 1294.16,1330.56
X$1953 18277 24421 24232 24414 24302 gf180mcu_fd_sc_mcu9t5v0__nand2_1
* cell instance $1954 r0 *1 1281.84,1340.64
X$1954 24722 24098 24828 24712 24840 gf180mcu_fd_sc_mcu9t5v0__nor2_1
* cell instance $1955 m0 *1 1291.36,1360.8
X$1955 23702 25158 25268 25287 gf180mcu_fd_sc_mcu9t5v0__clkinv_1
* cell instance $1956 r0 *1 1288.56,1360.8
X$1956 25555 25287 25430 25268 25443 gf180mcu_fd_sc_mcu9t5v0__nand2_1
* cell instance $1957 m0 *1 1305.36,1320.48
X$1957 22595 23921 23957 24118 24099 gf180mcu_fd_sc_mcu9t5v0__nand2_1
* cell instance $1958 r0 *1 1247.68,1320.48
X$1958 24130 24250 24249 24232 24118 23922 gf180mcu_fd_sc_mcu9t5v0__nor3_1
* cell instance $1959 m0 *1 1258.88,1320.48
X$1959 18277 24251 23957 24118 23923 gf180mcu_fd_sc_mcu9t5v0__nand2_1
* cell instance $1960 m0 *1 1254.96,1340.64
X$1960 24548 24546 24590 24528 24712 24592 gf180mcu_fd_sc_mcu9t5v0__nand3_1
* cell instance $1961 m0 *1 1267.28,1340.64
X$1961 24594 24298 24592 24528 24712 24971 gf180mcu_fd_sc_mcu9t5v0__and3_1
* cell instance $1962 m0 *1 1281.84,1350.72
X$1962 24840 24971 24974 24828 25000 24973 gf180mcu_fd_sc_mcu9t5v0__oai21_1
* cell instance $1963 m0 *1 1296.96,1330.56
X$1963 24301 24302 24099 24232 24414 24252 gf180mcu_fd_sc_mcu9t5v0__oai21_1
* cell instance $1964 m0 *1 1279.6,1360.8
X$1964 26053 24973 25134 25158 25268 25167 gf180mcu_fd_sc_mcu9t5v0__nand3_1
* cell instance $1965 m0 *1 1278.48,1350.72
X$1965 24840 24971 24828 25000 24972 gf180mcu_fd_sc_mcu9t5v0__nor2_1
* cell instance $1966 r0 *1 1282.4,1350.72
X$1966 25135 24972 25158 25000 25134 gf180mcu_fd_sc_mcu9t5v0__nand2_1
* cell instance $1967 r0 *1 1284.08,1360.8
X$1967 25443 24973 25430 25268 25444 gf180mcu_fd_sc_mcu9t5v0__and2_1
* cell instance $1968 m0 *1 1300.32,1340.64
X$1968 24551 12652 4952 24528 24712 24598 gf180mcu_fd_sc_mcu9t5v0__oai21_1
* cell instance $1969 m0 *1 1304.8,1340.64
X$1969 24551 12652 24598 24528 24712 24597 gf180mcu_fd_sc_mcu9t5v0__aoi21_1
* cell instance $1970 m0 *1 1279.6,1340.64
X$1970 24595 24098 24528 24712 24594 gf180mcu_fd_sc_mcu9t5v0__xnor2_1
* cell instance $1971 r0 *1 1285.2,1330.56
X$1971 24594 24528 24414 24550 gf180mcu_fd_sc_mcu9t5v0__clkinv_1
* cell instance $1972 r0 *1 1264.48,1330.56
X$1972 24549 24528 24414 24299 gf180mcu_fd_sc_mcu9t5v0__clkinv_1
* cell instance $1973 m0 *1 1244.32,1350.72
X$1973 24595 24721 24836 24828 25000 25012 gf180mcu_fd_sc_mcu9t5v0__mux2_1
* cell instance $1974 m0 *1 1258.88,1330.56
X$1974 23333 24232 24414 24297 gf180mcu_fd_sc_mcu9t5v0__clkinv_1
* cell instance $1975 m0 *1 1298.64,1350.72
X$1975 24974 24723 24828 25000 24599 gf180mcu_fd_sc_mcu9t5v0__xnor2_1
* cell instance $1976 r0 *1 1303.68,1350.72
X$1976 25135 24723 25158 25000 25289 gf180mcu_fd_sc_mcu9t5v0__nand2_1
* cell instance $1977 m0 *1 1258.32,1360.8
X$1977 24595 25282 25158 25268 25284 gf180mcu_fd_sc_mcu9t5v0__nand2_1
* cell instance $1978 m0 *1 1262.8,1340.64
X$1978 24298 24592 24594 24528 24712 24593 gf180mcu_fd_sc_mcu9t5v0__aoi21_1
* cell instance $1979 m0 *1 1267.84,1350.72
X$1979 24971 24593 24828 25000 25013 gf180mcu_fd_sc_mcu9t5v0__nor2_1
* cell instance $1980 m0 *1 1266.16,1360.8
X$1980 26053 25013 23921 25158 25268 25285 gf180mcu_fd_sc_mcu9t5v0__aoi21_1
* cell instance $1981 m0 *1 1298.08,1360.8
X$1981 25555 23702 25158 25268 25168 gf180mcu_fd_sc_mcu9t5v0__nand2_1
* cell instance $1982 r0 *1 1296.96,1350.72
X$1982 25555 25158 25000 23702 25135 gf180mcu_fd_sc_mcu9t5v0__xor2_1
* cell instance $1983 m0 *1 1261.12,1330.56
X$1983 24299 23333 24232 24414 24298 gf180mcu_fd_sc_mcu9t5v0__nand2_1
* cell instance $1984 m0 *1 1272.32,1370.88
X$1984 25555 25715 23921 25430 25581 25557 gf180mcu_fd_sc_mcu9t5v0__aoi21_1
* cell instance $1985 r0 *1 1272.88,1370.88
X$1985 25593 23921 25167 25557 25705 25581 26014
+ gf180mcu_fd_sc_mcu9t5v0__aoi22_1
* cell instance $1986 m0 *1 1263.92,1370.88
X$1986 25556 25430 25581 25286 gf180mcu_fd_sc_mcu9t5v0__clkinv_1
* cell instance $1987 r0 *1 1261.68,1330.56
X$1987 24549 24297 24528 24414 24548 gf180mcu_fd_sc_mcu9t5v0__nand2_1
* cell instance $1988 r0 *1 1258.88,1330.56
X$1988 24298 24548 24528 24414 24130 gf180mcu_fd_sc_mcu9t5v0__nand2_1
* cell instance $1989 r0 *1 1295.28,1370.88
X$1989 25595 25705 25581 25594 gf180mcu_fd_sc_mcu9t5v0__clkinv_1
* cell instance $1990 r0 *1 1292.48,1370.88
X$1990 23334 25705 25581 25718 gf180mcu_fd_sc_mcu9t5v0__clkinv_1
* cell instance $1991 r0 *1 1286.88,1370.88
X$1991 25594 25444 25717 25705 25581 25848 gf180mcu_fd_sc_mcu9t5v0__oai21_1
* cell instance $1992 r0 *1 1251.6,1370.88
X$1992 23802 25283 25556 13180 25705 25581 gf180mcu_fd_sc_mcu9t5v0__dffrnq_2
* cell instance $1993 r0 *1 1252.16,1320.48
X$1993 24250 24249 24130 24232 24118 24251 gf180mcu_fd_sc_mcu9t5v0__oai21_1
* cell instance $1994 m0 *1 1263.92,1330.56
X$1994 24299 24297 24251 24232 24414 24300 gf180mcu_fd_sc_mcu9t5v0__oai21_1
* cell instance $1995 r0 *1 1288.56,1330.56
X$1995 24550 24300 24528 24414 24421 gf180mcu_fd_sc_mcu9t5v0__nand2_1
* cell instance $1996 r0 *1 1297.52,1370.88
X$1996 26052 23334 25705 25581 25595 gf180mcu_fd_sc_mcu9t5v0__xnor2_1
* cell instance $1997 m0 *1 1302.56,1370.88
X$1997 26052 23334 25290 25430 25581 25558 gf180mcu_fd_sc_mcu9t5v0__aoi21_1
* cell instance $1998 m0 *1 1293.6,1340.64
X$1998 24596 24421 24528 24712 24723 gf180mcu_fd_sc_mcu9t5v0__nand2_1
* cell instance $1999 m0 *1 1279.04,1290.24
X$1999 18614 22854 22465 23178 23038 23200 23214
+ gf180mcu_fd_sc_mcu9t5v0__oai31_1
* cell instance $2000 r0 *1 1293.6,1300.32
X$2000 18614 23213 22466 23516 23623 23504 23650
+ gf180mcu_fd_sc_mcu9t5v0__oai31_1
* cell instance $2001 m0 *1 1247.68,1310.4
X$2001 23697 23623 23797 23699 17091 gf180mcu_fd_sc_mcu9t5v0__xor2_1
* cell instance $2002 m0 *1 1251.6,1300.32
X$2002 23802 23331 23333 13180 23319 23504 gf180mcu_fd_sc_mcu9t5v0__dffrnq_2
* cell instance $2003 m0 *1 1291.36,1310.4
X$2003 23702 23213 23623 23797 23516 gf180mcu_fd_sc_mcu9t5v0__nand2_1
* cell instance $2004 r0 *1 1303.12,1280.16
X$2004 10982 22898 23038 22885 23052 gf180mcu_fd_sc_mcu9t5v0__xnor2_1
* cell instance $2005 m0 *1 1305.92,1270.08
X$2005 22189 18444 22721 19303 22449 22577 22310
+ gf180mcu_fd_sc_mcu9t5v0__oai211_1
* cell instance $2006 m0 *1 1308.72,1290.24
X$2006 16443 10582 23038 23200 23215 gf180mcu_fd_sc_mcu9t5v0__nand2_1
* cell instance $2007 m0 *1 1307.04,1280.16
X$2007 16443 10982 22700 22885 23021 gf180mcu_fd_sc_mcu9t5v0__nand2_1
* cell instance $2008 m0 *1 1260.56,1310.4
X$2008 23802 23701 21732 13180 23623 23797 gf180mcu_fd_sc_mcu9t5v0__dffrnq_2
* cell instance $2009 r0 *1 1254.96,1270.08
X$2009 22304 18590 22420 4281 22700 22577 22718 gf180mcu_fd_sc_mcu9t5v0__aoi22_1
* cell instance $2010 m0 *1 1261.68,1270.08
X$2010 18614 22854 22186 22719 22449 22577 22593
+ gf180mcu_fd_sc_mcu9t5v0__oai31_1
* cell instance $2011 m0 *1 1289.12,1260
X$2011 22304 18590 22420 5185 22124 22295 22594 gf180mcu_fd_sc_mcu9t5v0__aoi22_1
* cell instance $2012 r0 *1 1270.08,1290.24
X$2012 23176 23214 23177 13180 23319 23200 gf180mcu_fd_sc_mcu9t5v0__dffrnq_2
* cell instance $2013 m0 *1 1248.24,1280.16
X$2013 16443 7095 22700 22885 22902 gf180mcu_fd_sc_mcu9t5v0__nand2_1
* cell instance $2014 m0 *1 1287.44,1290.24
X$2014 23176 23051 23334 13180 23038 23200 gf180mcu_fd_sc_mcu9t5v0__dffrnq_2
* cell instance $2015 r0 *1 1291.36,1270.08
X$2015 22304 18590 22420 4533 22700 22577 22720 gf180mcu_fd_sc_mcu9t5v0__aoi22_1
* cell instance $2016 m0 *1 1245.44,1270.08
X$2016 22591 5171 22449 22577 22592 gf180mcu_fd_sc_mcu9t5v0__nand2_1
* cell instance $2017 r0 *1 1260,1290.24
X$2017 23333 23213 23319 23200 23332 gf180mcu_fd_sc_mcu9t5v0__nand2_1
* cell instance $2018 m0 *1 1245.44,1260
X$2018 20345 22188 22308 13180 22124 22295 gf180mcu_fd_sc_mcu9t5v0__dffrnq_2
* cell instance $2019 r0 *1 1275.12,1260
X$2019 18157 22423 21010 13180 22449 22295 gf180mcu_fd_sc_mcu9t5v0__dffrnq_2
* cell instance $2020 m0 *1 1279.04,1249.92
X$2020 18157 21853 21854 13180 21884 21997 gf180mcu_fd_sc_mcu9t5v0__dffrnq_2
* cell instance $2021 r0 *1 1254.4,1290.24
X$2021 18614 23213 22718 23332 23319 23200 23331
+ gf180mcu_fd_sc_mcu9t5v0__oai31_1
* cell instance $2022 r0 *1 1262.24,1249.92
X$2022 22308 20660 14872 22124 21997 21890 gf180mcu_fd_sc_mcu9t5v0__mux2_1
* cell instance $2023 m0 *1 1245.44,1280.16
X$2023 16443 5913 22700 22885 22853 gf180mcu_fd_sc_mcu9t5v0__nand2_1
* cell instance $2024 r0 *1 1291.36,1290.24
X$2024 23334 23213 23319 23200 23020 gf180mcu_fd_sc_mcu9t5v0__nand2_1
* cell instance $2025 m0 *1 1277.92,1270.08
X$2025 23803 21010 17977 22449 22577 22423 gf180mcu_fd_sc_mcu9t5v0__mux2_1
* cell instance $2026 r0 *1 1244.32,1280.16
X$2026 22853 22852 23038 22885 23174 gf180mcu_fd_sc_mcu9t5v0__nand2_1
* cell instance $2027 m0 *1 1243.76,1290.24
X$2027 7095 23174 20996 23038 23200 23175 gf180mcu_fd_sc_mcu9t5v0__aoi21_1
* cell instance $2028 r0 *1 1289.68,1280.16
X$2028 18614 23213 22720 23020 23038 22885 23051
+ gf180mcu_fd_sc_mcu9t5v0__oai31_1
* cell instance $2029 m0 *1 1267.28,1280.16
X$2029 22855 22854 22700 22885 22719 gf180mcu_fd_sc_mcu9t5v0__nand2_1
* cell instance $2030 m0 *1 1260,1249.92
X$2030 18157 21890 20660 13180 21884 21997 gf180mcu_fd_sc_mcu9t5v0__dffrnq_2
* cell instance $2031 m0 *1 1293.6,1270.08
X$2031 22304 18590 22420 7216 22449 22577 22466 gf180mcu_fd_sc_mcu9t5v0__aoi22_1
* cell instance $2032 m0 *1 1276.24,1290.24
X$2032 23177 22854 23038 23200 23178 gf180mcu_fd_sc_mcu9t5v0__nand2_1
* cell instance $2033 r0 *1 1248.24,1260
X$2033 23973 22308 17977 22449 22295 22188 gf180mcu_fd_sc_mcu9t5v0__mux2_1
* cell instance $2034 r0 *1 1261.12,1270.08
X$2034 20345 22593 22855 13180 22700 22577 gf180mcu_fd_sc_mcu9t5v0__dffrnq_2
* cell instance $2035 m0 *1 1338.96,1280.16
X$2035 18614 22854 22467 22857 22700 22885 23023
+ gf180mcu_fd_sc_mcu9t5v0__oai31_1
* cell instance $2036 m0 *1 1363.04,1290.24
X$2036 23180 22854 23038 23200 22596 gf180mcu_fd_sc_mcu9t5v0__nand2_1
* cell instance $2037 r0 *1 1354.08,1260
X$2037 21725 18590 22420 12032 22449 22295 22469
+ gf180mcu_fd_sc_mcu9t5v0__aoi22_1
* cell instance $2038 r0 *1 1340.64,1260
X$2038 21725 18590 22420 6790 22449 22295 22465 gf180mcu_fd_sc_mcu9t5v0__aoi22_1
* cell instance $2039 r0 *1 1358.56,1270.08
X$2039 18614 22854 22470 22596 22700 22577 23024
+ gf180mcu_fd_sc_mcu9t5v0__oai31_1
* cell instance $2040 m0 *1 1361.36,1310.4
X$2040 23704 22854 23623 23797 23391 gf180mcu_fd_sc_mcu9t5v0__nand2_1
* cell instance $2041 m0 *1 1360.24,1260
X$2041 21725 18590 22420 11200 22124 22295 22312
+ gf180mcu_fd_sc_mcu9t5v0__aoi22_1
* cell instance $2042 m0 *1 1362.48,1300.32
X$2042 18614 22854 22312 23391 23319 23504 23517
+ gf180mcu_fd_sc_mcu9t5v0__oai31_1
* cell instance $2043 r0 *1 1335.04,1280.16
X$2043 21603 23023 22856 13180 23038 22885 gf180mcu_fd_sc_mcu9t5v0__dffrnq_2
* cell instance $2044 m0 *1 1328.88,1260
X$2044 22295 22124 gf180mcu_fd_sc_mcu9t5v0__filltie
* cell instance $2045 m0 *1 1358.56,1270.08
X$2045 21725 18590 22420 12148 22449 22577 22470
+ gf180mcu_fd_sc_mcu9t5v0__aoi22_1
* cell instance $2046 m0 *1 1328.88,1280.16
X$2046 22885 22700 gf180mcu_fd_sc_mcu9t5v0__filltie
* cell instance $2047 r0 *1 1354.08,1280.16
X$2047 21603 23038 22885 33566 gf180mcu_fd_sc_mcu9t5v0__clkinv_1
* cell instance $2048 m0 *1 1352.4,1300.32
X$2048 23388 22854 23319 23504 23389 gf180mcu_fd_sc_mcu9t5v0__nand2_1
* cell instance $2049 m0 *1 1355.2,1300.32
X$2049 18614 22854 22469 23389 23319 23504 23390
+ gf180mcu_fd_sc_mcu9t5v0__oai31_1
* cell instance $2050 m0 *1 1328.88,1270.08
X$2050 22577 22449 gf180mcu_fd_sc_mcu9t5v0__filltie
* cell instance $2051 m0 *1 1333.36,1300.32
X$2051 21603 23336 22018 13180 23319 23504 gf180mcu_fd_sc_mcu9t5v0__dffrnq_2
* cell instance $2052 m0 *1 1336.16,1260
X$2052 21725 18590 22420 9823 22124 22295 22311 gf180mcu_fd_sc_mcu9t5v0__aoi22_1
* cell instance $2053 m0 *1 1317.68,1300.32
X$2053 23386 23335 20996 23319 23504 23385 gf180mcu_fd_sc_mcu9t5v0__aoi21_1
* cell instance $2054 m0 *1 1322.16,1300.32
X$2054 23386 23335 23385 23319 23504 23387 gf180mcu_fd_sc_mcu9t5v0__oai21_1
* cell instance $2055 m0 *1 1328.88,1300.32
X$2055 23504 23319 gf180mcu_fd_sc_mcu9t5v0__filltie
* cell instance $2056 m0 *1 1319.36,1310.4
X$2056 23703 23651 23623 23797 23804 gf180mcu_fd_sc_mcu9t5v0__nand2_1
* cell instance $2057 r0 *1 1359.12,1260
X$2057 21725 18590 22420 11314 22449 22295 22468
+ gf180mcu_fd_sc_mcu9t5v0__aoi22_1
* cell instance $2058 m0 *1 1322.16,1310.4
X$2058 13032 23651 23623 23797 23927 gf180mcu_fd_sc_mcu9t5v0__xnor2_1
* cell instance $2059 m0 *1 1330,1310.4
X$2059 16443 13032 23623 23797 23703 gf180mcu_fd_sc_mcu9t5v0__nand2_1
* cell instance $2060 m0 *1 1355.2,1260
X$2060 21725 18590 22420 15750 22124 22295 22190
+ gf180mcu_fd_sc_mcu9t5v0__aoi22_1
* cell instance $2061 m0 *1 1349.6,1280.16
X$2061 22858 22700 22885 21603 gf180mcu_fd_sc_mcu9t5v0__clkbuf_8
* cell instance $2062 m0 *1 1328.88,1290.24
X$2062 23200 23038 gf180mcu_fd_sc_mcu9t5v0__filltie
* cell instance $2063 m0 *1 1328.88,1249.92
X$2063 21997 21884 gf180mcu_fd_sc_mcu9t5v0__filltie
* cell instance $2064 r0 *1 1356.32,1280.16
X$2064 21603 23024 23180 13180 23038 22885 gf180mcu_fd_sc_mcu9t5v0__dffrnq_2
* cell instance $2065 r0 *1 1354.64,1300.32
X$2065 21603 23390 23388 13180 23623 23504 gf180mcu_fd_sc_mcu9t5v0__dffrnq_2
* cell instance $2066 r0 *1 1337.28,1290.24
X$2066 24600 22018 17977 23319 23200 23336 gf180mcu_fd_sc_mcu9t5v0__mux2_1
* cell instance $2067 r0 *1 1316.56,1270.08
X$2067 22595 22723 17977 22700 22577 22722 gf180mcu_fd_sc_mcu9t5v0__mux2_1
* cell instance $2068 r0 *1 1321.04,1300.32
X$2068 16443 23386 23335 23623 23504 23651 gf180mcu_fd_sc_mcu9t5v0__aoi21_1
* cell instance $2069 r0 *1 1315.44,1290.24
X$2069 23215 23022 23319 23200 23335 gf180mcu_fd_sc_mcu9t5v0__nand2_1
* cell instance $2070 r0 *1 1321.6,1260
X$2070 21603 22424 16200 13180 22449 22295 gf180mcu_fd_sc_mcu9t5v0__dffrnq_2
* cell instance $2071 r0 *1 1345.68,1260
X$2071 21725 18590 22420 11623 22449 22295 22467
+ gf180mcu_fd_sc_mcu9t5v0__aoi22_1
* cell instance $2072 m0 *1 1336.16,1280.16
X$2072 22856 22854 22700 22885 22857 gf180mcu_fd_sc_mcu9t5v0__nand2_1
* cell instance $2073 m0 *1 1343.44,1249.92
X$2073 22018 16532 14872 21884 21997 21855 gf180mcu_fd_sc_mcu9t5v0__mux2_1
* cell instance $2074 m0 *1 1321.6,1260
X$2074 22723 16200 14872 22124 22295 22424 gf180mcu_fd_sc_mcu9t5v0__mux2_1
* cell instance $2075 m0 *1 1328.88,1310.4
X$2075 23797 23623 gf180mcu_fd_sc_mcu9t5v0__filltie
* cell instance $2076 m0 *1 1171.52,1310.4
X$2076 23697 23698 23623 23797 23695 gf180mcu_fd_sc_mcu9t5v0__nand2_1
* cell instance $2077 r0 *1 1173.2,1340.64
X$2077 24582 18590 18614 24828 24712 24834 gf180mcu_fd_sc_mcu9t5v0__aoi21_1
* cell instance $2078 r0 *1 1211.84,1310.4
X$2078 23973 23921 23957 23797 23919 gf180mcu_fd_sc_mcu9t5v0__nand2_1
* cell instance $2079 r0 *1 1204.56,1310.4
X$2079 23917 23918 23919 23957 23797 23972 gf180mcu_fd_sc_mcu9t5v0__oai21_1
* cell instance $2080 m0 *1 1170.96,1330.56
X$2080 23697 23699 24232 24414 24291 gf180mcu_fd_sc_mcu9t5v0__and2_1
* cell instance $2081 r0 *1 1127.28,1310.4
X$2081 23914 23915 23957 23797 23642 gf180mcu_fd_sc_mcu9t5v0__nor2_1
* cell instance $2082 r0 *1 1163.68,1310.4
X$2082 23915 23327 23916 23957 23797 23800 gf180mcu_fd_sc_mcu9t5v0__nor3_1
* cell instance $2083 m0 *1 1170.4,1290.24
X$2083 23328 23173 23049 23038 23200 22135 gf180mcu_fd_sc_mcu9t5v0__oai21_1
* cell instance $2084 r0 *1 1165.92,1350.72
X$2084 24096 25011 25280 13180 25158 25000 gf180mcu_fd_sc_mcu9t5v0__dffrnq_2
* cell instance $2085 m0 *1 1161.44,1370.88
X$2085 24096 25437 25438 13180 25430 25581 gf180mcu_fd_sc_mcu9t5v0__dffrnq_2
* cell instance $2086 r0 *1 1209.04,1310.4
X$2086 23797 23957 gf180mcu_fd_sc_mcu9t5v0__filltie
* cell instance $2087 r0 *1 1209.04,1320.48
X$2087 24118 24232 gf180mcu_fd_sc_mcu9t5v0__filltie
* cell instance $2088 m0 *1 1206.24,1340.64
X$2088 24587 23649 24528 24712 24588 gf180mcu_fd_sc_mcu9t5v0__nor2_1
* cell instance $2089 m0 *1 1224.16,1360.8
X$2089 24295 25282 25158 25268 25441 gf180mcu_fd_sc_mcu9t5v0__nand2_1
* cell instance $2090 m0 *1 1209.6,1340.64
X$2090 24588 25440 24528 24712 24589 gf180mcu_fd_sc_mcu9t5v0__nor2_1
* cell instance $2091 r0 *1 1191.68,1320.48
X$2091 24247 23921 24232 24118 24545 gf180mcu_fd_sc_mcu9t5v0__nand2_1
* cell instance $2092 r0 *1 1184.96,1330.56
X$2092 23921 24544 24545 24528 24414 24292 gf180mcu_fd_sc_mcu9t5v0__oai21_1
* cell instance $2093 r0 *1 1186.08,1320.48
X$2093 24241 18590 4952 23017 24232 24118 24246 gf180mcu_fd_sc_mcu9t5v0__aoi22_1
* cell instance $2094 r0 *1 1211.84,1330.56
X$2094 24719 23649 24528 24414 24420 gf180mcu_fd_sc_mcu9t5v0__nand2_1
* cell instance $2095 r0 *1 1212.96,1340.64
X$2095 24293 24589 24828 24712 24837 gf180mcu_fd_sc_mcu9t5v0__xnor2_1
* cell instance $2096 m0 *1 1216.88,1360.8
X$2096 26053 24837 23921 25158 25268 25281 gf180mcu_fd_sc_mcu9t5v0__aoi21_1
* cell instance $2097 m0 *1 1210.16,1350.72
X$2097 18614 24970 23210 24834 24828 25000 24969
+ gf180mcu_fd_sc_mcu9t5v0__aoi22_1
* cell instance $2098 m0 *1 1219.68,1330.56
X$2098 24293 24420 24248 24232 24414 24294 gf180mcu_fd_sc_mcu9t5v0__and3_1
* cell instance $2099 r0 *1 1209.04,1340.64
X$2099 24712 24828 gf180mcu_fd_sc_mcu9t5v0__filltie
* cell instance $2100 m0 *1 1182.72,1330.56
X$2100 24096 24292 24247 13180 24232 24414 gf180mcu_fd_sc_mcu9t5v0__dffrnq_2
* cell instance $2101 m0 *1 1204,1320.48
X$2101 24096 23972 23973 13180 23957 24118 gf180mcu_fd_sc_mcu9t5v0__dffrnq_2
* cell instance $2102 r0 *1 1200.64,1340.64
X$2102 24719 24828 24712 23649 24720 gf180mcu_fd_sc_mcu9t5v0__xor2_1
* cell instance $2103 m0 *1 1212.96,1340.64
X$2103 24588 25440 24293 24528 24712 24590 gf180mcu_fd_sc_mcu9t5v0__oai21_1
* cell instance $2104 r0 *1 1209.04,1350.72
X$2104 25000 25158 gf180mcu_fd_sc_mcu9t5v0__filltie
* cell instance $2105 r0 *1 1209.04,1330.56
X$2105 24414 24528 gf180mcu_fd_sc_mcu9t5v0__filltie
* cell instance $2106 m0 *1 1179.36,1350.72
X$2106 18614 26347 23801 24834 24828 25000 24968
+ gf180mcu_fd_sc_mcu9t5v0__aoi22_1
* cell instance $2107 m0 *1 1225.28,1330.56
X$2107 24295 23515 24232 24414 24293 gf180mcu_fd_sc_mcu9t5v0__xnor2_1
* cell instance $2108 r0 *1 1221.36,1320.48
X$2108 24420 24248 24293 24232 24118 24249 gf180mcu_fd_sc_mcu9t5v0__aoi21_1
* cell instance $2109 r0 *1 1235.92,1340.64
X$2109 18614 24839 23212 24834 24828 24712 24721
+ gf180mcu_fd_sc_mcu9t5v0__aoi22_1
* cell instance $2110 r0 *1 1204,1320.48
X$2110 18277 24248 24232 24118 23918 gf180mcu_fd_sc_mcu9t5v0__nand2_1
* cell instance $2111 m0 *1 1188.32,1370.88
X$2111 25589 25438 25430 25581 25327 gf180mcu_fd_sc_mcu9t5v0__and2_1
* cell instance $2112 r0 *1 1196.72,1370.88
X$2112 24720 25591 25553 25705 25581 25713 gf180mcu_fd_sc_mcu9t5v0__nand3_1
* cell instance $2113 m0 *1 1223.04,1350.72
X$2113 23802 24838 24295 13180 24828 25000 gf180mcu_fd_sc_mcu9t5v0__dffrnq_2
* cell instance $2114 r0 *1 1229.76,1320.48
X$2114 23921 24249 24294 24129 24232 24118 23920
+ gf180mcu_fd_sc_mcu9t5v0__oai31_1
* cell instance $2115 m0 *1 1237.04,1330.56
X$2115 23515 24232 24414 24296 gf180mcu_fd_sc_mcu9t5v0__clkinv_1
* cell instance $2116 m0 *1 1235.36,1320.48
X$2116 23803 23921 23957 24118 24129 gf180mcu_fd_sc_mcu9t5v0__nand2_1
* cell instance $2117 m0 *1 1204,1370.88
X$2117 25282 25440 25430 25581 25592 gf180mcu_fd_sc_mcu9t5v0__nor2_1
* cell instance $2118 r0 *1 1188.32,1340.64
X$2118 24719 24968 24836 24828 24712 24835 gf180mcu_fd_sc_mcu9t5v0__mux2_1
* cell instance $2119 r0 *1 1204.56,1370.88
X$2119 25713 25592 25705 25581 25714 gf180mcu_fd_sc_mcu9t5v0__nand2_1
* cell instance $2120 r0 *1 1197.84,1360.8
X$2120 25327 25439 24720 25430 25268 24248 gf180mcu_fd_sc_mcu9t5v0__oai21_1
* cell instance $2121 r0 *1 1229.2,1360.8
X$2121 25329 25430 25268 25328 gf180mcu_fd_sc_mcu9t5v0__clkinv_1
* cell instance $2122 r0 *1 1221.36,1360.8
X$2122 25328 23921 25441 25281 25430 25268 25442
+ gf180mcu_fd_sc_mcu9t5v0__aoi22_1
* cell instance $2123 r0 *1 1193.36,1360.8
X$2123 24720 25327 25439 25430 25268 23917 gf180mcu_fd_sc_mcu9t5v0__nor3_1
* cell instance $2124 r0 *1 1209.04,1360.8
X$2124 25268 25430 gf180mcu_fd_sc_mcu9t5v0__filltie
* cell instance $2125 r0 *1 1210.16,1370.88
X$2125 24719 25715 23921 25705 25581 25716 gf180mcu_fd_sc_mcu9t5v0__aoi21_1
* cell instance $2126 m0 *1 1196.16,1370.88
X$2126 25591 25553 24720 25430 25581 25440 gf180mcu_fd_sc_mcu9t5v0__aoi21_1
* cell instance $2127 r0 *1 1222.48,1340.64
X$2127 24295 24969 24836 24828 24712 24838 gf180mcu_fd_sc_mcu9t5v0__mux2_1
* cell instance $2128 r0 *1 1232.56,1370.88
X$2128 23802 25705 25581 gf180mcu_fd_sc_mcu9t5v0__inv_4
* cell instance $2129 r0 *1 1188.32,1370.88
X$2129 25438 25705 25581 25590 gf180mcu_fd_sc_mcu9t5v0__clkinv_1
* cell instance $2130 m0 *1 1218,1370.88
X$2130 23802 25442 25329 13180 25430 25581 gf180mcu_fd_sc_mcu9t5v0__dffrnq_2
* cell instance $2131 r0 *1 1191.12,1370.88
X$2131 25589 25590 25705 25581 25591 gf180mcu_fd_sc_mcu9t5v0__nand2_1
* cell instance $2132 r0 *1 1209.04,1370.88
X$2132 25581 25705 gf180mcu_fd_sc_mcu9t5v0__filltie
* cell instance $2133 m0 *1 1204,1340.64
X$2133 24719 24528 24712 24587 gf180mcu_fd_sc_mcu9t5v0__clkinv_1
* cell instance $2134 m0 *1 1184.4,1350.72
X$2134 23802 24835 24719 13180 24828 25000 gf180mcu_fd_sc_mcu9t5v0__dffrnq_2
* cell instance $2135 m0 *1 1148,1340.64
X$2135 24539 24290 24528 24712 24543 gf180mcu_fd_sc_mcu9t5v0__nand2_1
* cell instance $2136 m0 *1 1126.16,1360.8
X$2136 24096 25278 25279 13331 25158 25268 gf180mcu_fd_sc_mcu9t5v0__dffrnq_2
* cell instance $2137 r0 *1 1149.12,1330.56
X$2137 23915 24289 24528 24414 23696 24543 gf180mcu_fd_sc_mcu9t5v0__xnor3_1
* cell instance $2138 m0 *1 1129.52,1320.48
X$2138 24287 23957 24118 23914 gf180mcu_fd_sc_mcu9t5v0__clkinv_1
* cell instance $2139 m0 *1 1123.36,1320.48
X$2139 23914 23970 23957 24118 23969 gf180mcu_fd_sc_mcu9t5v0__nor2_1
* cell instance $2140 m0 *1 1106.56,1320.48
X$2140 24094 23968 23969 23957 24118 23166 gf180mcu_fd_sc_mcu9t5v0__aoi21_1
* cell instance $2141 m0 *1 1122.24,1350.72
X$2141 25009 24828 25000 24539 gf180mcu_fd_sc_mcu9t5v0__clkinv_1
* cell instance $2142 m0 *1 1138.48,1340.64
X$2142 24287 24528 24712 23379 24542 gf180mcu_fd_sc_mcu9t5v0__xor2_1
* cell instance $2143 r0 *1 1144.08,1330.56
X$2143 24539 24290 24542 24528 24414 23327 gf180mcu_fd_sc_mcu9t5v0__aoi21_1
* cell instance $2144 m0 *1 1145.76,1320.48
X$2144 24127 24095 24289 23957 24118 23644 gf180mcu_fd_sc_mcu9t5v0__oai21_1
* cell instance $2145 m0 *1 1123.36,1340.64
X$2145 24539 23697 24528 24712 24586 gf180mcu_fd_sc_mcu9t5v0__nand2_1
* cell instance $2146 m0 *1 1168.72,1360.8
X$2146 25280 23213 25158 25268 24967 gf180mcu_fd_sc_mcu9t5v0__nand2_1
* cell instance $2147 r0 *1 1165.36,1330.56
X$2147 24127 24528 24414 24290 23699 gf180mcu_fd_sc_mcu9t5v0__xor2_1
* cell instance $2148 r0 *1 1143.52,1350.72
X$2148 24096 25010 21543 13331 25158 25000 gf180mcu_fd_sc_mcu9t5v0__dffrnq_2
* cell instance $2149 r0 *1 1167.6,1320.48
X$2149 24291 23971 24244 24232 24118 23328 gf180mcu_fd_sc_mcu9t5v0__aoi21_1
* cell instance $2150 r0 *1 1153.04,1320.48
X$2150 24127 24095 24289 24232 24118 23916 gf180mcu_fd_sc_mcu9t5v0__nor3_1
* cell instance $2151 m0 *1 1164.24,1320.48
X$2151 23327 23916 24128 23957 24118 23971 gf180mcu_fd_sc_mcu9t5v0__oai21_1
* cell instance $2152 r0 *1 1163.12,1320.48
X$2152 24128 23327 23916 24232 24118 24244 gf180mcu_fd_sc_mcu9t5v0__nor3_1
* cell instance $2153 m0 *1 1126.16,1340.64
X$2153 24586 24540 24528 24712 24541 gf180mcu_fd_sc_mcu9t5v0__xnor2_1
* cell instance $2154 r0 *1 1127.84,1330.56
X$2154 24288 24541 21004 24528 24414 23207 gf180mcu_fd_sc_mcu9t5v0__mux2_1
* cell instance $2155 r0 *1 1140.16,1360.8
X$2155 22858 25430 25268 24096 gf180mcu_fd_sc_mcu9t5v0__clkbuf_8
* cell instance $2156 m0 *1 1166.48,1350.72
X$2156 18614 23213 22716 24967 24828 25000 25011
+ gf180mcu_fd_sc_mcu9t5v0__oai31_1
* cell instance $2157 r0 *1 1161.44,1360.8
X$2157 18614 23213 22460 25326 25430 25268 25437
+ gf180mcu_fd_sc_mcu9t5v0__oai31_1
* cell instance $2158 r0 *1 1132.88,1360.8
X$2158 25279 23213 25430 25268 25325 gf180mcu_fd_sc_mcu9t5v0__nand2_1
* cell instance $2159 r0 *1 1168.16,1360.8
X$2159 25438 23213 25430 25268 25326 gf180mcu_fd_sc_mcu9t5v0__nand2_1
* cell instance $2160 r0 *1 1125.6,1360.8
X$2160 18614 23213 23162 25325 25430 25268 25278
+ gf180mcu_fd_sc_mcu9t5v0__oai31_1
* cell instance $2161 m0 *1 1148.56,1350.72
X$2161 24966 21543 14872 24828 25000 25010 gf180mcu_fd_sc_mcu9t5v0__mux2_1
* cell instance $2162 m0 *1 1164.24,1330.56
X$2162 24291 23696 24232 24414 24288 gf180mcu_fd_sc_mcu9t5v0__xnor2_1
* cell instance $2163 r0 *1 1125.6,1340.64
X$2163 24287 24828 24712 23915 24540 gf180mcu_fd_sc_mcu9t5v0__xor2_1
* cell instance $2164 r0 *1 1123.36,1330.56
X$2164 24539 23697 24540 24528 24414 23694 gf180mcu_fd_sc_mcu9t5v0__aoi21_1
* cell instance $2165 r0 *1 1120,1350.72
X$2165 25009 25158 25000 24127 gf180mcu_fd_sc_mcu9t5v0__buf_8
* cell instance $2166 r0 *1 1142.4,1320.48
X$2166 24095 24128 21004 24232 24118 23970 gf180mcu_fd_sc_mcu9t5v0__mux2_1
* cell instance $2167 m0 *1 1138.48,1330.56
X$2167 24287 23379 24232 24414 24289 gf180mcu_fd_sc_mcu9t5v0__xnor2_1
* cell instance $2168 m0 *1 1116.64,1320.48
X$2168 24287 23970 23957 24118 23968 gf180mcu_fd_sc_mcu9t5v0__xnor2_1
* cell instance $2169 r0 *1 1141.28,1370.88
X$2169 25712 24290 14872 25705 25581 25588 gf180mcu_fd_sc_mcu9t5v0__mux2_1
* cell instance $2170 m0 *1 1141.28,1370.88
X$2170 24096 25588 24290 13331 25430 25581 gf180mcu_fd_sc_mcu9t5v0__dffrnq_2
* cell instance $2171 r0 *1 1123.36,1370.88
X$2171 25887 25712 17977 25705 25581 25711 gf180mcu_fd_sc_mcu9t5v0__mux2_1
* cell instance $2172 m0 *1 1150.24,1330.56
X$2172 24290 24232 24414 24095 gf180mcu_fd_sc_mcu9t5v0__clkinv_1
* cell instance $2173 r0 *1 1149.68,1320.48
X$2173 23915 24232 24118 24128 gf180mcu_fd_sc_mcu9t5v0__clkinv_1
* cell instance $2174 m0 *1 1143.52,1260
X$2174 22417 22181 21598 22124 22295 20999 gf180mcu_fd_sc_mcu9t5v0__aoi21_1
* cell instance $2175 r0 *1 1163.68,1290.24
X$2175 23168 23319 23200 23172 gf180mcu_fd_sc_mcu9t5v0__clkinv_1
* cell instance $2176 m0 *1 1126.72,1310.4
X$2176 23642 23694 23641 23623 23797 23380 gf180mcu_fd_sc_mcu9t5v0__oai21_1
* cell instance $2177 m0 *1 1120.56,1260
X$2177 22174 22175 22124 22295 22176 gf180mcu_fd_sc_mcu9t5v0__nand2_1
* cell instance $2178 m0 *1 1133.44,1260
X$2178 22177 22179 22180 22176 22124 22295 21600
+ gf180mcu_fd_sc_mcu9t5v0__oai31_1
* cell instance $2179 r0 *1 1117.76,1280.16
X$2179 24096 22897 16159 13331 23038 22885 gf180mcu_fd_sc_mcu9t5v0__dffrnq_2
* cell instance $2180 r0 *1 1148,1300.32
X$2180 23645 23644 23643 23623 23504 23048 gf180mcu_fd_sc_mcu9t5v0__nand3_1
* cell instance $2181 r0 *1 1123.36,1300.32
X$2181 23642 23694 23641 23623 23504 23326 gf180mcu_fd_sc_mcu9t5v0__nor3_1
* cell instance $2182 m0 *1 1160.32,1310.4
X$2182 23696 23695 23623 23797 14456 gf180mcu_fd_sc_mcu9t5v0__xnor2_1
* cell instance $2183 m0 *1 1138.48,1310.4
X$2183 23914 23379 23623 23797 23645 gf180mcu_fd_sc_mcu9t5v0__or2_1
* cell instance $2184 m0 *1 1120,1310.4
X$2184 22896 23168 23623 23797 23641 gf180mcu_fd_sc_mcu9t5v0__xnor2_1
* cell instance $2185 r0 *1 1136.8,1300.32
X$2185 22896 23623 23504 22416 23643 gf180mcu_fd_sc_mcu9t5v0__xor2_1
* cell instance $2186 r0 *1 1143.52,1300.32
X$2186 23645 23644 23643 23623 23504 22180 gf180mcu_fd_sc_mcu9t5v0__aoi21_1
* cell instance $2187 m0 *1 1157.52,1290.24
X$2187 23172 23170 23038 23200 23173 23171 gf180mcu_fd_sc_mcu9t5v0__xnor3_1
* cell instance $2188 r0 *1 1165.92,1290.24
X$2188 23328 23173 23319 23200 23208 gf180mcu_fd_sc_mcu9t5v0__xnor2_1
* cell instance $2189 m0 *1 1109.36,1300.32
X$2189 23379 23168 21004 23319 23504 23205 gf180mcu_fd_sc_mcu9t5v0__mux2_1
* cell instance $2190 r0 *1 1169.28,1249.92
X$2190 22135 22136 20346 22124 21997 21852 gf180mcu_fd_sc_mcu9t5v0__oai21_1
* cell instance $2191 r0 *1 1163.68,1280.16
X$2191 23168 23209 23048 23038 22885 23049 gf180mcu_fd_sc_mcu9t5v0__nand3_1
* cell instance $2192 r0 *1 1149.68,1290.24
X$2192 23381 23327 23319 23200 23171 gf180mcu_fd_sc_mcu9t5v0__nor2_1
* cell instance $2193 m0 *1 1131.2,1290.24
X$2193 23169 23168 23380 23038 23200 21730 gf180mcu_fd_sc_mcu9t5v0__oai21_1
* cell instance $2194 m0 *1 1122.24,1280.16
X$2194 16159 23207 13492 22700 22885 22897 gf180mcu_fd_sc_mcu9t5v0__mux2_1
* cell instance $2195 r0 *1 1154.16,1249.92
X$2195 22134 22183 22124 21997 18851 gf180mcu_fd_sc_mcu9t5v0__xnor2_1
* cell instance $2196 m0 *1 1156.96,1280.16
X$2196 23047 22845 22700 22885 19576 gf180mcu_fd_sc_mcu9t5v0__xnor2_1
* cell instance $2197 r0 *1 1143.52,1260
X$2197 22179 22180 22449 22295 22419 gf180mcu_fd_sc_mcu9t5v0__nor2_1
* cell instance $2198 m0 *1 1106,1290.24
X$2198 23166 23167 23206 23038 23200 21847 gf180mcu_fd_sc_mcu9t5v0__oai21_1
* cell instance $2199 r0 *1 1155.84,1260
X$2199 22303 22178 22449 22295 22136 22419 gf180mcu_fd_sc_mcu9t5v0__xnor3_1
* cell instance $2200 r0 *1 1164.8,1249.92
X$2200 22135 22136 22124 21997 21000 gf180mcu_fd_sc_mcu9t5v0__and2_1
* cell instance $2201 r0 *1 1121.68,1290.24
X$2201 21004 23208 23326 23325 23319 23200 22590
+ gf180mcu_fd_sc_mcu9t5v0__oai22_1
* cell instance $2202 m0 *1 1148,1260
X$2202 21598 22178 22124 22295 22134 22419 gf180mcu_fd_sc_mcu9t5v0__xnor3_1
* cell instance $2203 m0 *1 1109.92,1270.08
X$2203 13898 22590 13492 22449 22577 22715 gf180mcu_fd_sc_mcu9t5v0__mux2_1
* cell instance $2204 r0 *1 1159.76,1290.24
X$2204 23172 23209 23048 23319 23200 23016 gf180mcu_fd_sc_mcu9t5v0__nand3_1
* cell instance $2205 r0 *1 1159.2,1280.16
X$2205 23047 22845 23016 23038 22885 22183 gf180mcu_fd_sc_mcu9t5v0__oai21_1
* cell instance $2206 r0 *1 1148.56,1260
X$2206 22417 22181 22303 22449 22295 22182 gf180mcu_fd_sc_mcu9t5v0__aoi21_1
* cell instance $2207 m0 *1 1160.88,1260
X$2207 22134 22183 22182 22124 22295 20832 gf180mcu_fd_sc_mcu9t5v0__aoi21_1
* cell instance $2208 m0 *1 1123.36,1260
X$2208 22174 22175 22124 22295 22177 gf180mcu_fd_sc_mcu9t5v0__nor2_1
* cell instance $2209 m0 *1 1126.72,1260
X$2209 22014 22175 22124 22295 22178 gf180mcu_fd_sc_mcu9t5v0__xnor2_1
* cell instance $2210 r0 *1 1136.8,1260
X$2210 22178 22449 22295 22418 gf180mcu_fd_sc_mcu9t5v0__clkinv_1
* cell instance $2211 r0 *1 1139.04,1260
X$2211 22179 22180 22418 22449 22295 22417 gf180mcu_fd_sc_mcu9t5v0__oai21_1
* cell instance $2212 r0 *1 1112.72,1260
X$2212 22304 18590 22420 7338 22449 22295 22460 gf180mcu_fd_sc_mcu9t5v0__aoi22_1
* cell instance $2213 r0 *1 1136.8,1280.16
X$2213 22896 23038 22885 23169 gf180mcu_fd_sc_mcu9t5v0__clkinv_1
* cell instance $2214 m0 *1 1134,1270.08
X$2214 23169 22416 22449 22577 22179 gf180mcu_fd_sc_mcu9t5v0__nor2_1
* cell instance $2215 m0 *1 1122.8,1300.32
X$2215 21004 23380 23319 23504 23325 gf180mcu_fd_sc_mcu9t5v0__nand2_1
* cell instance $2216 r0 *1 1105.44,1260
X$2216 22416 22303 21004 22449 22295 21849 gf180mcu_fd_sc_mcu9t5v0__mux2_1
* cell instance $2217 m0 *1 1137.36,1290.24
X$2217 22896 22416 23038 23200 23170 gf180mcu_fd_sc_mcu9t5v0__xnor2_1
* cell instance $2218 m0 *1 1167.04,1310.4
X$2218 23696 23695 23800 23623 23797 22845 gf180mcu_fd_sc_mcu9t5v0__aoi21_1
* cell instance $2219 m0 *1 1139.04,1300.32
X$2219 23914 23379 23319 23504 23381 gf180mcu_fd_sc_mcu9t5v0__nor2_1
* cell instance $2220 r0 *1 1145.2,1290.24
X$2220 23381 23327 23170 23319 23200 23209 gf180mcu_fd_sc_mcu9t5v0__oai21_1
* cell instance $2221 r0 *1 1167.6,1270.08
X$2221 22304 18590 22420 4396 22700 22577 22716 gf180mcu_fd_sc_mcu9t5v0__aoi22_1
* cell instance $2222 m0 *1 1123.36,1249.92
X$2222 21250 22175 20346 21884 21997 21850 gf180mcu_fd_sc_mcu9t5v0__mux2_1
* cell instance $2223 m0 *1 1144.64,1290.24
X$2223 23168 23170 23038 23200 23047 23171 gf180mcu_fd_sc_mcu9t5v0__xnor3_1
* cell instance $2224 m0 *1 1139.6,1270.08
X$2224 23169 22416 23209 22178 22449 22577 22181
+ gf180mcu_fd_sc_mcu9t5v0__oai211_1
* cell instance $2225 r0 *1 1133.44,1249.92
X$2225 22303 22124 21997 21598 gf180mcu_fd_sc_mcu9t5v0__clkinv_1
* cell instance $2226 r0 *1 1209.04,1270.08
X$2226 22577 22700 gf180mcu_fd_sc_mcu9t5v0__filltie
* cell instance $2227 m0 *1 1236.48,1290.24
X$2227 4952 23050 23038 23200 23212 gf180mcu_fd_sc_mcu9t5v0__nand2_1
* cell instance $2228 r0 *1 1202.88,1300.32
X$2228 23649 23213 23623 23504 23329 gf180mcu_fd_sc_mcu9t5v0__nand2_1
* cell instance $2229 r0 *1 1179.36,1300.32
X$2229 24096 23646 23648 13180 23623 23504 gf180mcu_fd_sc_mcu9t5v0__dffrnq_2
* cell instance $2230 r0 *1 1209.04,1300.32
X$2230 23504 23623 gf180mcu_fd_sc_mcu9t5v0__filltie
* cell instance $2231 m0 *1 1187.76,1310.4
X$2231 23648 23213 23623 23797 23382 gf180mcu_fd_sc_mcu9t5v0__nand2_1
* cell instance $2232 m0 *1 1175.44,1260
X$2232 22305 10087 20996 22124 22295 22184 gf180mcu_fd_sc_mcu9t5v0__aoi21_1
* cell instance $2233 m0 *1 1179.92,1260
X$2233 22305 10087 22184 22124 22295 22185 gf180mcu_fd_sc_mcu9t5v0__oai21_1
* cell instance $2234 m0 *1 1184.96,1310.4
X$2234 4952 23647 23623 23797 23801 gf180mcu_fd_sc_mcu9t5v0__nand2_1
* cell instance $2235 m0 *1 1200.08,1300.32
X$2235 20345 23330 23649 13180 23319 23504 gf180mcu_fd_sc_mcu9t5v0__dffrnq_2
* cell instance $2236 m0 *1 1227.52,1300.32
X$2236 23515 23213 23319 23504 23383 gf180mcu_fd_sc_mcu9t5v0__nand2_1
* cell instance $2237 m0 *1 1184.96,1300.32
X$2237 18614 23213 22306 23382 23319 23504 23646
+ gf180mcu_fd_sc_mcu9t5v0__oai31_1
* cell instance $2238 m0 *1 1221.92,1300.32
X$2238 18614 23213 22463 23383 23319 23504 23384
+ gf180mcu_fd_sc_mcu9t5v0__oai31_1
* cell instance $2239 r0 *1 1189.44,1280.16
X$2239 20345 22899 22849 13180 23038 22885 gf180mcu_fd_sc_mcu9t5v0__dffrnq_2
* cell instance $2240 r0 *1 1209.04,1290.24
X$2240 23200 23319 gf180mcu_fd_sc_mcu9t5v0__filltie
* cell instance $2241 r0 *1 1221.92,1300.32
X$2241 20345 23384 23515 13180 23623 23504 gf180mcu_fd_sc_mcu9t5v0__dffrnq_2
* cell instance $2242 m0 *1 1178.8,1280.16
X$2242 16443 7346 22846 22587 22700 22885 22898
+ gf180mcu_fd_sc_mcu9t5v0__aoi211_2
* cell instance $2243 m0 *1 1189.44,1260
X$2243 22304 18590 22420 10206 22124 22295 22306
+ gf180mcu_fd_sc_mcu9t5v0__aoi22_1
* cell instance $2244 m0 *1 1216.88,1280.16
X$2244 16443 4917 22700 22885 22851 gf180mcu_fd_sc_mcu9t5v0__nand2_1
* cell instance $2245 m0 *1 1211.28,1280.16
X$2245 16443 4915 22700 22885 22850 gf180mcu_fd_sc_mcu9t5v0__nand2_1
* cell instance $2246 m0 *1 1201.2,1260
X$2246 21725 18590 22420 11989 22124 22295 22186
+ gf180mcu_fd_sc_mcu9t5v0__aoi22_1
* cell instance $2247 m0 *1 1204,1280.16
X$2247 4915 22848 22700 22885 22900 gf180mcu_fd_sc_mcu9t5v0__xnor2_1
* cell instance $2248 m0 *1 1182.16,1310.4
X$2248 23637 22185 23623 23797 23700 gf180mcu_fd_sc_mcu9t5v0__nand2_1
* cell instance $2249 m0 *1 1238.72,1270.08
X$2249 20996 22421 22449 22577 22464 gf180mcu_fd_sc_mcu9t5v0__nor2_1
* cell instance $2250 m0 *1 1209.04,1290.24
X$2250 4952 22900 23038 23200 23210 gf180mcu_fd_sc_mcu9t5v0__nand2_1
* cell instance $2251 m0 *1 1231.44,1310.4
X$2251 24127 23697 23623 23797 18116 gf180mcu_fd_sc_mcu9t5v0__xnor2_1
* cell instance $2252 m0 *1 1202.88,1249.92
X$2252 20345 22015 22016 13180 21884 21997 gf180mcu_fd_sc_mcu9t5v0__dffrnq_2
* cell instance $2253 m0 *1 1175.44,1280.16
X$2253 22846 22587 22700 22885 22847 gf180mcu_fd_sc_mcu9t5v0__nor2_1
* cell instance $2254 r0 *1 1199.52,1260
X$2254 22304 18590 22420 6443 22449 22295 22462 gf180mcu_fd_sc_mcu9t5v0__aoi22_1
* cell instance $2255 r0 *1 1182.16,1280.16
X$2255 7346 22847 23038 22885 23017 gf180mcu_fd_sc_mcu9t5v0__xnor2_1
* cell instance $2256 r0 *1 1209.04,1280.16
X$2256 22885 23038 gf180mcu_fd_sc_mcu9t5v0__filltie
* cell instance $2257 r0 *1 1200.64,1290.24
X$2257 18614 23213 22462 23329 23319 23200 23330
+ gf180mcu_fd_sc_mcu9t5v0__oai31_1
* cell instance $2258 r0 *1 1214.64,1260
X$2258 20345 22307 22187 13180 22449 22295 gf180mcu_fd_sc_mcu9t5v0__dffrnq_2
* cell instance $2259 r0 *1 1188.32,1260
X$2259 6784 22422 16443 22449 22295 22848 gf180mcu_fd_sc_mcu9t5v0__oai21_2
* cell instance $2260 m0 *1 1221.92,1270.08
X$2260 22304 18590 22420 4530 22449 22577 22463 gf180mcu_fd_sc_mcu9t5v0__aoi22_1
* cell instance $2261 m0 *1 1230.88,1249.92
X$2261 22187 20957 14872 21884 21997 22017 gf180mcu_fd_sc_mcu9t5v0__mux2_1
* cell instance $2262 m0 *1 1214.08,1280.16
X$2262 22850 22848 22700 22885 22901 gf180mcu_fd_sc_mcu9t5v0__nand2_1
* cell instance $2263 r0 *1 1201.76,1249.92
X$2263 22849 22016 14872 22124 21997 22015 gf180mcu_fd_sc_mcu9t5v0__mux2_1
* cell instance $2264 r0 *1 1220.8,1280.16
X$2264 4917 22901 23018 23038 22885 23019 gf180mcu_fd_sc_mcu9t5v0__oai21_1
* cell instance $2265 m0 *1 1183.28,1270.08
X$2265 6784 22461 22449 22577 23647 gf180mcu_fd_sc_mcu9t5v0__xnor2_1
* cell instance $2266 r0 *1 1183.28,1260
X$2266 16443 22422 22449 22295 22461 gf180mcu_fd_sc_mcu9t5v0__nand2_1
* cell instance $2267 r0 *1 1209.04,1249.92
X$2267 21997 22124 gf180mcu_fd_sc_mcu9t5v0__filltie
* cell instance $2268 r0 *1 1209.04,1260
X$2268 22295 22449 gf180mcu_fd_sc_mcu9t5v0__filltie
* cell instance $2269 m0 *1 1219.68,1280.16
X$2269 22851 22850 22848 22700 22885 22852 gf180mcu_fd_sc_mcu9t5v0__and3_1
* cell instance $2270 m0 *1 1174.32,1310.4
X$2270 23699 23623 23797 23698 gf180mcu_fd_sc_mcu9t5v0__clkinv_1
* cell instance $2271 r0 *1 1216.32,1280.16
X$2271 4917 22901 20996 23038 22885 23018 gf180mcu_fd_sc_mcu9t5v0__aoi21_1
* cell instance $2272 m0 *1 1218,1260
X$2272 26048 22187 17977 22124 22295 22307 gf180mcu_fd_sc_mcu9t5v0__mux2_1
* cell instance $2273 m0 *1 1195.04,1280.16
X$2273 24247 22849 17977 22700 22885 22899 gf180mcu_fd_sc_mcu9t5v0__mux2_1
* cell instance $2274 r0 *1 1179.36,1260
X$2274 16789 22421 22449 22295 22305 gf180mcu_fd_sc_mcu9t5v0__nor2_1
* cell instance $2275 r0 *1 1192.8,1169.28
X$2275 13729 19729 19605 19741 gf180mcu_fd_sc_mcu9t5v0__clkinv_1
* cell instance $2276 m0 *1 1169.28,1179.36
X$2276 14131 19729 19901 19919 gf180mcu_fd_sc_mcu9t5v0__clkinv_1
* cell instance $2277 m0 *1 1203.44,1179.36
X$2277 19614 19867 19870 19729 19901 19869 gf180mcu_fd_sc_mcu9t5v0__oai21_1
* cell instance $2278 m0 *1 1229.2,1179.36
X$2278 19871 19869 19873 19729 19901 19418 gf180mcu_fd_sc_mcu9t5v0__aoi21_1
* cell instance $2279 m0 *1 1214.64,1179.36
X$2279 19922 19920 19871 19729 19901 19872 gf180mcu_fd_sc_mcu9t5v0__aoi21_1
* cell instance $2280 m0 *1 1210.72,1179.36
X$2280 19922 19920 19871 19729 19901 19615 gf180mcu_fd_sc_mcu9t5v0__nand3_1
* cell instance $2281 r0 *1 1172.64,1219.68
X$2281 20656 21136 21241 21123 21003 20998 gf180mcu_fd_sc_mcu9t5v0__xnor3_1
* cell instance $2282 m0 *1 1189.44,1179.36
X$2282 19741 12632 19921 19868 19729 19901 19580
+ gf180mcu_fd_sc_mcu9t5v0__aoi22_1
* cell instance $2283 m0 *1 1172.64,1199.52
X$2283 19613 19578 20521 20379 20507 19867 gf180mcu_fd_sc_mcu9t5v0__aoi21_1
* cell instance $2284 m0 *1 1173.2,1189.44
X$2284 14685 20089 20028 20217 20090 gf180mcu_fd_sc_mcu9t5v0__nor2_1
* cell instance $2285 m0 *1 1150.24,1179.36
X$2285 20345 19866 14131 13331 19729 19901 gf180mcu_fd_sc_mcu9t5v0__dffrnq_2
* cell instance $2286 m0 *1 1146.32,1179.36
X$2286 8553 12632 19729 19901 19577 gf180mcu_fd_sc_mcu9t5v0__nand2_1
* cell instance $2287 m0 *1 1107.12,1179.36
X$2287 19174 19739 19865 13331 19729 19901 gf180mcu_fd_sc_mcu9t5v0__dffrnq_2
* cell instance $2288 m0 *1 1170.96,1239.84
X$2288 21544 21600 21602 21537 21719 21545 gf180mcu_fd_sc_mcu9t5v0__oai21_1
* cell instance $2289 r0 *1 1209.04,1169.28
X$2289 19605 19729 gf180mcu_fd_sc_mcu9t5v0__filltie
* cell instance $2290 r0 *1 1136.24,1169.28
X$2290 20345 19740 8553 13331 19729 19605 gf180mcu_fd_sc_mcu9t5v0__dffrnq_2
* cell instance $2291 m0 *1 1156.4,1159.2
X$2291 18153 19134 14673 13331 19171 19282 gf180mcu_fd_sc_mcu9t5v0__dffrnq_2
* cell instance $2292 r0 *1 1167.6,1128.96
X$2292 18153 18449 17589 13331 18553 18386 gf180mcu_fd_sc_mcu9t5v0__dffrnq_2
* cell instance $2293 m0 *1 1161.44,1118.88
X$2293 18153 17996 17590 13331 17985 18104 gf180mcu_fd_sc_mcu9t5v0__dffrnq_2
* cell instance $2294 r0 *1 1111.6,1169.28
X$2294 19414 19865 17977 19729 19605 19739 gf180mcu_fd_sc_mcu9t5v0__mux2_1
* cell instance $2295 m0 *1 1167.6,1128.96
X$2295 3816 18268 18386 18153 gf180mcu_fd_sc_mcu9t5v0__clkbuf_8
* cell instance $2296 r0 *1 1177.68,1169.28
X$2296 19614 19867 19729 19605 19416 gf180mcu_fd_sc_mcu9t5v0__nor2_1
* cell instance $2297 r0 *1 1181.04,1169.28
X$2297 19614 19867 19729 19605 19417 gf180mcu_fd_sc_mcu9t5v0__and2_1
* cell instance $2298 r0 *1 1166.48,1169.28
X$2298 19613 19578 14313 19729 19605 19579 gf180mcu_fd_sc_mcu9t5v0__aoi21_1
* cell instance $2299 r0 *1 1167.6,1139.04
X$2299 17589 18607 13214 18841 18731 18449 gf180mcu_fd_sc_mcu9t5v0__mux2_1
* cell instance $2300 r0 *1 1217.44,1169.28
X$2300 14685 19872 19729 19605 19582 gf180mcu_fd_sc_mcu9t5v0__nor2_1
* cell instance $2301 m0 *1 1176,1209.6
X$2301 20703 20655 20637 20822 20521 gf180mcu_fd_sc_mcu9t5v0__nor2_1
* cell instance $2302 r0 *1 1184.4,1199.52
X$2302 20656 20655 20637 20507 20522 gf180mcu_fd_sc_mcu9t5v0__or2_1
* cell instance $2303 m0 *1 1176.56,1219.68
X$2303 21004 21003 12632 20936 21123 20038 gf180mcu_fd_sc_mcu9t5v0__aoi21_1
* cell instance $2304 r0 *1 1205.68,1179.36
X$2304 20043 20042 20028 19901 19870 gf180mcu_fd_sc_mcu9t5v0__nand2_1
* cell instance $2305 m0 *1 1195.04,1219.68
X$2305 20651 20936 21123 20226 21006 gf180mcu_fd_sc_mcu9t5v0__xor2_1
* cell instance $2306 m0 *1 1189.44,1219.68
X$2306 21137 21136 21005 21006 20936 21123 20523
+ gf180mcu_fd_sc_mcu9t5v0__aoi211_1
* cell instance $2307 m0 *1 1219.68,1219.68
X$2307 20223 21008 20936 21123 20955 gf180mcu_fd_sc_mcu9t5v0__nand2_1
* cell instance $2308 m0 *1 1188.32,1199.52
X$2308 20522 20379 20507 20041 gf180mcu_fd_sc_mcu9t5v0__clkinv_1
* cell instance $2309 r0 *1 1210.16,1189.44
X$2309 20225 18614 18612 7091 20379 20217 20347 gf180mcu_fd_sc_mcu9t5v0__aoi22_1
* cell instance $2310 r0 *1 1209.04,1179.36
X$2310 19901 20028 gf180mcu_fd_sc_mcu9t5v0__filltie
* cell instance $2311 r0 *1 1209.04,1189.44
X$2311 20217 20379 gf180mcu_fd_sc_mcu9t5v0__filltie
* cell instance $2312 r0 *1 1221.36,1189.44
X$2312 20227 20348 20346 20379 20217 20349 gf180mcu_fd_sc_mcu9t5v0__aoi21_1
* cell instance $2313 m0 *1 1214.64,1209.6
X$2313 20705 20704 20637 20822 19135 gf180mcu_fd_sc_mcu9t5v0__xnor2_1
* cell instance $2314 r0 *1 1222.48,1209.6
X$2314 20955 20702 20956 20936 20822 20704 gf180mcu_fd_sc_mcu9t5v0__aoi21_1
* cell instance $2315 m0 *1 1212.4,1219.68
X$2315 20955 21007 20936 21123 20954 gf180mcu_fd_sc_mcu9t5v0__nand2_1
* cell instance $2316 r0 *1 1210.16,1209.6
X$2316 20702 20936 20822 20954 18610 gf180mcu_fd_sc_mcu9t5v0__xor2_1
* cell instance $2317 m0 *1 1204,1199.52
X$2317 20651 20043 20523 20379 20507 20227 gf180mcu_fd_sc_mcu9t5v0__aoi21_1
* cell instance $2318 r0 *1 1209.04,1199.52
X$2318 20507 20637 gf180mcu_fd_sc_mcu9t5v0__filltie
* cell instance $2319 r0 *1 1209.04,1209.6
X$2319 20822 20936 gf180mcu_fd_sc_mcu9t5v0__filltie
* cell instance $2320 r0 *1 1209.04,1219.68
X$2320 21123 21241 gf180mcu_fd_sc_mcu9t5v0__filltie
* cell instance $2321 r0 *1 1174.32,1199.52
X$2321 20656 20655 20637 20507 19613 gf180mcu_fd_sc_mcu9t5v0__xnor2_1
* cell instance $2322 r0 *1 1204.56,1189.44
X$2322 20226 20379 20217 20043 gf180mcu_fd_sc_mcu9t5v0__clkinv_1
* cell instance $2323 r0 *1 1230.32,1189.44
X$2323 20223 20044 20379 20217 20228 gf180mcu_fd_sc_mcu9t5v0__nand2_1
* cell instance $2324 m0 *1 1201.76,1229.76
X$2324 20651 21546 21241 21412 20042 21373 gf180mcu_fd_sc_mcu9t5v0__xnor3_1
* cell instance $2325 m0 *1 1202.88,1189.44
X$2325 20043 20042 20028 20217 19614 gf180mcu_fd_sc_mcu9t5v0__xnor2_1
* cell instance $2326 r0 *1 1216.88,1189.44
X$2326 20227 20348 20349 20379 20217 19004 gf180mcu_fd_sc_mcu9t5v0__oai21_1
* cell instance $2327 m0 *1 1183.28,1219.68
X$2327 20656 20998 20936 21123 21137 gf180mcu_fd_sc_mcu9t5v0__nand2_1
* cell instance $2328 r0 *1 1187.76,1179.36
X$2328 20041 20089 19614 20028 19901 19920 gf180mcu_fd_sc_mcu9t5v0__oai21_1
* cell instance $2329 m0 *1 1186.64,1229.76
X$2329 20226 21427 20346 21241 21412 20701 gf180mcu_fd_sc_mcu9t5v0__mux2_1
* cell instance $2330 r0 *1 1234.8,1199.52
X$2330 20706 20092 20637 20507 20350 gf180mcu_fd_sc_mcu9t5v0__nand2_1
* cell instance $2331 r0 *1 1238.16,1179.36
X$2331 20044 20091 20028 19901 19923 gf180mcu_fd_sc_mcu9t5v0__nor2_1
* cell instance $2332 m0 *1 1239.28,1199.52
X$2332 20350 20379 20507 20351 gf180mcu_fd_sc_mcu9t5v0__clkinv_1
* cell instance $2333 m0 *1 1235.92,1189.44
X$2333 20092 20028 20217 20044 gf180mcu_fd_sc_mcu9t5v0__clkinv_1
* cell instance $2334 m0 *1 1215.2,1219.68
X$2334 20223 21008 20936 21123 21007 gf180mcu_fd_sc_mcu9t5v0__or2_1
* cell instance $2335 m0 *1 1184.4,1239.84
X$2335 3816 21537 21719 20345 gf180mcu_fd_sc_mcu9t5v0__clkbuf_8
* cell instance $2336 r0 *1 1209.04,1229.76
X$2336 21412 21537 gf180mcu_fd_sc_mcu9t5v0__filltie
* cell instance $2337 r0 *1 1192.8,1229.76
X$2337 21731 21545 21547 21537 21412 21546 gf180mcu_fd_sc_mcu9t5v0__oai21_1
* cell instance $2338 m0 *1 1207.92,1239.84
X$2338 20651 21373 21537 21719 21548 gf180mcu_fd_sc_mcu9t5v0__nand2_1
* cell instance $2339 r0 *1 1210.16,1229.76
X$2339 21428 21546 21548 21537 21412 20953 gf180mcu_fd_sc_mcu9t5v0__oai21_1
* cell instance $2340 m0 *1 1232.56,1189.44
X$2340 20092 20091 20028 20217 19873 gf180mcu_fd_sc_mcu9t5v0__nor2_1
* cell instance $2341 r0 *1 1233.12,1189.44
X$2341 20228 20350 20379 20217 20348 gf180mcu_fd_sc_mcu9t5v0__nand2_1
* cell instance $2342 r0 *1 1230.88,1179.36
X$2342 20044 20091 20028 19901 19871 gf180mcu_fd_sc_mcu9t5v0__xnor2_1
* cell instance $2343 m0 *1 1233.12,1209.6
X$2343 20223 20637 20822 20706 gf180mcu_fd_sc_mcu9t5v0__clkinv_1
* cell instance $2344 m0 *1 1210.72,1239.84
X$2344 22016 21537 21719 21373 gf180mcu_fd_sc_mcu9t5v0__clkinv_1
* cell instance $2345 r0 *1 1205.68,1229.76
X$2345 20651 21373 21537 21412 21428 gf180mcu_fd_sc_mcu9t5v0__nor2_1
* cell instance $2346 r0 *1 1219.12,1229.76
X$2346 20092 22016 20346 21537 21412 21008 gf180mcu_fd_sc_mcu9t5v0__mux2_1
* cell instance $2347 r0 *1 1179.92,1229.76
X$2347 21426 21545 21537 21412 20655 21427 gf180mcu_fd_sc_mcu9t5v0__xnor3_1
* cell instance $2348 m0 *1 1233.68,1219.68
X$2348 20948 20524 14872 20936 21123 21009 gf180mcu_fd_sc_mcu9t5v0__mux2_1
* cell instance $2349 r0 *1 1230.32,1229.76
X$2349 20347 21550 18272 21537 21412 21549 gf180mcu_fd_sc_mcu9t5v0__mux2_1
* cell instance $2350 r0 *1 1183.28,1179.36
X$2350 20346 19920 20028 19901 20040 gf180mcu_fd_sc_mcu9t5v0__and2_1
* cell instance $2351 m0 *1 1187.2,1189.44
X$2351 20041 20089 19614 20040 20028 20217 19921
+ gf180mcu_fd_sc_mcu9t5v0__oai31_1
* cell instance $2352 m0 *1 1211.84,1189.44
X$2352 20226 20042 20028 20217 19922 gf180mcu_fd_sc_mcu9t5v0__nand2_1
* cell instance $2353 r0 *1 1190.56,1209.6
X$2353 21005 21136 20936 20822 20833 gf180mcu_fd_sc_mcu9t5v0__or2_1
* cell instance $2354 r0 *1 1193.36,1219.68
X$2354 21006 21137 20833 21241 21123 20658 gf180mcu_fd_sc_mcu9t5v0__nand3_1
* cell instance $2355 r0 *1 1196.72,1199.52
X$2355 20346 20523 20637 20507 20657 gf180mcu_fd_sc_mcu9t5v0__nor2_1
* cell instance $2356 r0 *1 1192.24,1199.52
X$2356 20658 20657 12632 20637 20507 19868 gf180mcu_fd_sc_mcu9t5v0__aoi21_1
* cell instance $2357 m0 *1 1221.36,1209.6
X$2357 21007 20637 20822 20956 gf180mcu_fd_sc_mcu9t5v0__clkinv_1
* cell instance $2358 m0 *1 1184.4,1229.76
X$2358 20998 21241 21412 21426 gf180mcu_fd_sc_mcu9t5v0__clkinv_1
* cell instance $2359 r0 *1 1216.88,1209.6
X$2359 20955 20702 20956 20705 20936 20822 20834
+ gf180mcu_fd_sc_mcu9t5v0__aoi211_1
* cell instance $2360 m0 *1 1179.36,1209.6
X$2360 20703 20637 20822 20656 gf180mcu_fd_sc_mcu9t5v0__clkinv_1
* cell instance $2361 m0 *1 1186.08,1219.68
X$2361 20656 20998 20936 21123 21005 gf180mcu_fd_sc_mcu9t5v0__nor2_1
* cell instance $2362 m0 *1 1128.4,1239.84
X$2362 22014 21598 21537 21719 21599 gf180mcu_fd_sc_mcu9t5v0__nand2_1
* cell instance $2363 r0 *1 1109.92,1219.68
X$2363 14015 21596 13492 21241 21123 21370 gf180mcu_fd_sc_mcu9t5v0__mux2_1
* cell instance $2364 r0 *1 1164.24,1209.6
X$2364 21002 21001 20936 20822 20952 gf180mcu_fd_sc_mcu9t5v0__nand2_1
* cell instance $2365 r0 *1 1159.76,1209.6
X$2365 20951 20832 20952 20936 20822 19578 gf180mcu_fd_sc_mcu9t5v0__oai21_1
* cell instance $2366 r0 *1 1142.4,1189.44
X$2366 20345 20224 20088 13331 20379 20217 gf180mcu_fd_sc_mcu9t5v0__dffrnq_2
* cell instance $2367 r0 *1 1121.12,1209.6
X$2367 20998 20698 20936 20822 20949 gf180mcu_fd_sc_mcu9t5v0__nor2_1
* cell instance $2368 m0 *1 1135.12,1209.6
X$2368 20651 20701 20637 20822 20654 gf180mcu_fd_sc_mcu9t5v0__xnor2_1
* cell instance $2369 m0 *1 1127.28,1209.6
X$2369 20700 20699 20949 20654 20637 20822 20831
+ gf180mcu_fd_sc_mcu9t5v0__aoi211_1
* cell instance $2370 m0 *1 1168.72,1189.44
X$2370 20387 20090 20028 20217 20039 gf180mcu_fd_sc_mcu9t5v0__nand2_1
* cell instance $2371 r0 *1 1159.76,1219.68
X$2371 21250 21241 21123 21002 gf180mcu_fd_sc_mcu9t5v0__clkinv_1
* cell instance $2372 r0 *1 1124.48,1209.6
X$2372 20700 20699 20949 20936 20822 20653 gf180mcu_fd_sc_mcu9t5v0__aoi21_1
* cell instance $2373 r0 *1 1127.84,1199.52
X$2373 20654 20653 20637 20507 20037 gf180mcu_fd_sc_mcu9t5v0__xnor2_1
* cell instance $2374 m0 *1 1160.32,1219.68
X$2374 21002 21001 20936 21123 20951 gf180mcu_fd_sc_mcu9t5v0__xnor2_1
* cell instance $2375 r0 *1 1130.64,1179.36
X$2375 14180 20037 13492 20028 19901 20036 gf180mcu_fd_sc_mcu9t5v0__mux2_1
* cell instance $2376 m0 *1 1163.68,1199.52
X$2376 20520 20519 19613 20379 20507 20387 gf180mcu_fd_sc_mcu9t5v0__nand3_1
* cell instance $2377 r0 *1 1166.48,1179.36
X$2377 19919 12632 20039 20038 20028 19901 19866
+ gf180mcu_fd_sc_mcu9t5v0__aoi22_1
* cell instance $2378 m0 *1 1141.84,1209.6
X$2378 20651 20701 20831 20637 20822 20702 gf180mcu_fd_sc_mcu9t5v0__aoi21_1
* cell instance $2379 m0 *1 1129.52,1229.76
X$2379 21250 21241 21412 21597 21372 gf180mcu_fd_sc_mcu9t5v0__xor2_1
* cell instance $2380 m0 *1 1154.16,1219.68
X$2380 20999 21000 20951 20936 21123 20519 gf180mcu_fd_sc_mcu9t5v0__oai21_1
* cell instance $2381 r0 *1 1109.36,1189.44
X$2381 20345 20222 20223 13331 20379 20217 gf180mcu_fd_sc_mcu9t5v0__dffrnq_2
* cell instance $2382 r0 *1 1162,1219.68
X$2382 21002 21597 21249 21241 21123 21136 gf180mcu_fd_sc_mcu9t5v0__aoi21_1
* cell instance $2383 m0 *1 1131.2,1239.84
X$2383 22014 21598 21730 21537 21719 21371 gf180mcu_fd_sc_mcu9t5v0__oai21_1
* cell instance $2384 r0 *1 1132.88,1229.76
X$2384 21599 21371 21372 21537 21412 21249 gf180mcu_fd_sc_mcu9t5v0__aoi21_1
* cell instance $2385 r0 *1 1149.12,1229.76
X$2385 20703 21543 20346 21537 21412 20698 gf180mcu_fd_sc_mcu9t5v0__mux2_1
* cell instance $2386 m0 *1 1155.84,1239.84
X$2386 21543 21537 21719 21601 gf180mcu_fd_sc_mcu9t5v0__clkinv_1
* cell instance $2387 r0 *1 1167.04,1229.76
X$2387 21597 21601 21537 21412 21544 gf180mcu_fd_sc_mcu9t5v0__nor2_1
* cell instance $2388 m0 *1 1158.08,1239.84
X$2388 21597 21600 21537 21719 21001 21601 gf180mcu_fd_sc_mcu9t5v0__xnor3_1
* cell instance $2389 m0 *1 1167.04,1219.68
X$2389 21250 21001 20936 21123 20520 gf180mcu_fd_sc_mcu9t5v0__nand2_1
* cell instance $2390 m0 *1 1127.28,1189.44
X$2390 19174 20036 14180 13331 20028 20217 gf180mcu_fd_sc_mcu9t5v0__dffrnq_2
* cell instance $2391 m0 *1 1123.36,1219.68
X$2391 20998 20698 20936 21123 20700 gf180mcu_fd_sc_mcu9t5v0__nand2_1
* cell instance $2392 m0 *1 1167.6,1199.52
X$2392 20520 20519 19613 20379 20507 20089 gf180mcu_fd_sc_mcu9t5v0__aoi21_1
* cell instance $2393 r0 *1 1162.56,1189.44
X$2393 20088 20379 20217 20225 gf180mcu_fd_sc_mcu9t5v0__clkinv_1
* cell instance $2394 m0 *1 1136.24,1229.76
X$2394 21372 21599 21371 21241 21412 21135 gf180mcu_fd_sc_mcu9t5v0__and3_1
* cell instance $2395 r0 *1 1149.12,1209.6
X$2395 20346 20519 20936 20822 20950 gf180mcu_fd_sc_mcu9t5v0__and2_1
* cell instance $2396 m0 *1 1148.56,1189.44
X$2396 20088 22832 19287 20028 20217 20224 gf180mcu_fd_sc_mcu9t5v0__mux2_1
* cell instance $2397 m0 *1 1115.52,1189.44
X$2397 19865 20223 14872 20028 20217 20222 gf180mcu_fd_sc_mcu9t5v0__mux2_1
* cell instance $2398 m0 *1 1148.56,1219.68
X$2398 20999 21000 20951 20950 20936 21123 21134
+ gf180mcu_fd_sc_mcu9t5v0__oai31_1
* cell instance $2399 r0 *1 1134,1219.68
X$2399 20346 21249 21135 21134 21241 21123 20221
+ gf180mcu_fd_sc_mcu9t5v0__oai31_1
* cell instance $2400 m0 *1 1151.36,1209.6
X$2400 20951 20832 20637 20822 19296 gf180mcu_fd_sc_mcu9t5v0__xnor2_1
* cell instance $2401 m0 *1 1114.4,1209.6
X$2401 20998 20699 20637 20822 18968 20698 gf180mcu_fd_sc_mcu9t5v0__xnor3_1
* cell instance $2402 m0 *1 1115.52,1239.84
X$2402 21729 21595 21537 21719 20699 gf180mcu_fd_sc_mcu9t5v0__and2_1
* cell instance $2403 m0 *1 1136.24,1139.04
X$2403 18153 18742 9090 13331 18553 18731 gf180mcu_fd_sc_mcu9t5v0__dffrnq_2
* cell instance $2404 r0 *1 1137.36,1149.12
X$2404 18153 18969 6956 13331 19171 18996 gf180mcu_fd_sc_mcu9t5v0__dffrnq_2
* cell instance $2405 r0 *1 1120.56,1159.2
X$2405 20345 19415 7790 13331 19448 19282 gf180mcu_fd_sc_mcu9t5v0__dffrnq_2
* cell instance $2406 r0 *1 1159.2,1108.8
X$2406 17590 17846 13214 17985 17837 17996 gf180mcu_fd_sc_mcu9t5v0__mux2_1
* cell instance $2407 r0 *1 1149.12,1128.96
X$2407 9090 12632 18553 18386 18557 gf180mcu_fd_sc_mcu9t5v0__nand2_1
* cell instance $2408 r0 *1 1149.12,1139.04
X$2408 14313 18851 18557 18841 18731 18742 gf180mcu_fd_sc_mcu9t5v0__oai21_1
* cell instance $2409 r0 *1 1118.88,1128.96
X$2409 14181 18603 13475 18553 18386 18606 gf180mcu_fd_sc_mcu9t5v0__mux2_1
* cell instance $2410 m0 *1 1123.92,1128.96
X$2410 18153 18397 18151 13331 18268 18386 gf180mcu_fd_sc_mcu9t5v0__dffrnq_2
* cell instance $2411 m0 *1 1112.16,1128.96
X$2411 18152 14820 18268 18386 17720 gf180mcu_fd_sc_mcu9t5v0__nand2_1
* cell instance $2412 r0 *1 1113.28,1139.04
X$2412 16973 18606 13214 18841 18731 18605 gf180mcu_fd_sc_mcu9t5v0__mux2_1
* cell instance $2413 m0 *1 1145.2,1118.88
X$2413 15869 13475 15744 17985 18104 18115 gf180mcu_fd_sc_mcu9t5v0__aoi21_1
* cell instance $2414 r0 *1 1154.72,1118.88
X$2414 15870 14820 18268 18104 18156 gf180mcu_fd_sc_mcu9t5v0__nand2_1
* cell instance $2415 r0 *1 1116.64,1149.12
X$2415 19174 19003 14179 13331 19171 18996 gf180mcu_fd_sc_mcu9t5v0__dffrnq_2
* cell instance $2416 m0 *1 1164.24,1169.28
X$2416 19613 19578 19579 19448 19605 19575 gf180mcu_fd_sc_mcu9t5v0__oai21_1
* cell instance $2417 m0 *1 1128.4,1169.28
X$2417 19295 19575 19448 19605 19415 gf180mcu_fd_sc_mcu9t5v0__nand2_1
* cell instance $2418 m0 *1 1165.92,1139.04
X$2418 14673 18604 13475 18553 18731 18607 gf180mcu_fd_sc_mcu9t5v0__mux2_1
* cell instance $2419 r0 *1 1163.68,1149.12
X$2419 14673 19135 13492 19171 18996 19134 gf180mcu_fd_sc_mcu9t5v0__mux2_1
* cell instance $2420 m0 *1 1145.76,1169.28
X$2420 14313 19576 19577 19448 19605 19740 gf180mcu_fd_sc_mcu9t5v0__oai21_1
* cell instance $2421 r0 *1 1148,1118.88
X$2421 14820 18115 18156 18268 18104 18155 gf180mcu_fd_sc_mcu9t5v0__oai21_1
* cell instance $2422 m0 *1 1149.12,1159.2
X$2422 6956 12632 19171 19282 18970 gf180mcu_fd_sc_mcu9t5v0__nand2_1
* cell instance $2423 r0 *1 1163.12,1128.96
X$2423 18153 18553 18386 gf180mcu_fd_sc_mcu9t5v0__inv_3
* cell instance $2424 m0 *1 1148,1149.12
X$2424 14313 19296 18970 18841 18996 18969 gf180mcu_fd_sc_mcu9t5v0__oai21_1
* cell instance $2425 r0 *1 1133.44,1118.88
X$2425 18151 14820 18268 18104 18154 gf180mcu_fd_sc_mcu9t5v0__nand2_1
* cell instance $2426 m0 *1 1121.12,1149.12
X$2426 14179 18968 13492 18841 18996 19003 gf180mcu_fd_sc_mcu9t5v0__mux2_1
* cell instance $2427 m0 *1 1105.44,1139.04
X$2427 19174 18605 16973 13331 18553 18731 gf180mcu_fd_sc_mcu9t5v0__dffrnq_2
* cell instance $2428 m0 *1 1128.96,1159.2
X$2428 7790 12632 19171 19282 19295 gf180mcu_fd_sc_mcu9t5v0__nand2_1
* cell instance $2429 r0 *1 1128.96,1118.88
X$2429 14820 16974 18154 18268 18104 18397 gf180mcu_fd_sc_mcu9t5v0__oai21_1
* cell instance $2430 m0 *1 1146.32,1128.96
X$2430 18153 18155 15870 13331 18268 18386 gf180mcu_fd_sc_mcu9t5v0__dffrnq_2
* cell instance $2431 r0 *1 1189.44,1108.8
X$2431 17591 17960 13214 17985 17837 17997 gf180mcu_fd_sc_mcu9t5v0__mux2_1
* cell instance $2432 r0 *1 1210.16,1149.12
X$2432 5284 12632 19171 18996 19297 gf180mcu_fd_sc_mcu9t5v0__nand2_1
* cell instance $2433 m0 *1 1213.52,1139.04
X$2433 18157 18611 13171 13331 18553 18731 gf180mcu_fd_sc_mcu9t5v0__dffrnq_2
* cell instance $2434 r0 *1 1209.04,1108.8
X$2434 17837 17985 gf180mcu_fd_sc_mcu9t5v0__filltie
* cell instance $2435 r0 *1 1209.04,1139.04
X$2435 18731 18841 gf180mcu_fd_sc_mcu9t5v0__filltie
* cell instance $2436 r0 *1 1209.04,1118.88
X$2436 18104 18268 gf180mcu_fd_sc_mcu9t5v0__filltie
* cell instance $2437 r0 *1 1209.04,1128.96
X$2437 18386 18553 gf180mcu_fd_sc_mcu9t5v0__filltie
* cell instance $2438 m0 *1 1215.76,1159.2
X$2438 14313 19581 19298 19297 19171 19282 19177
+ gf180mcu_fd_sc_mcu9t5v0__oai31_1
* cell instance $2439 m0 *1 1200.08,1128.96
X$2439 18153 18399 14181 13331 18268 18386 gf180mcu_fd_sc_mcu9t5v0__dffrnq_2
* cell instance $2440 m0 *1 1192.24,1128.96
X$2440 13895 13697 18268 18386 18398 gf180mcu_fd_sc_mcu9t5v0__nand2_1
* cell instance $2441 r0 *1 1178.24,1149.12
X$2441 10687 12632 19171 18996 19136 gf180mcu_fd_sc_mcu9t5v0__nand2_1
* cell instance $2442 r0 *1 1218,1118.88
X$2442 18157 18158 13695 13331 18268 18104 gf180mcu_fd_sc_mcu9t5v0__dffrnq_2
* cell instance $2443 r0 *1 1178.8,1159.2
X$2443 14313 19416 19417 19136 19448 19282 19176
+ gf180mcu_fd_sc_mcu9t5v0__oai31_1
* cell instance $2444 r0 *1 1196.72,1108.8
X$2444 13060 13729 13475 17985 17837 17960 gf180mcu_fd_sc_mcu9t5v0__mux2_1
* cell instance $2445 r0 *1 1216.88,1149.12
X$2445 13210 12632 19004 19137 19171 18996 18158
+ gf180mcu_fd_sc_mcu9t5v0__aoi22_1
* cell instance $2446 r0 *1 1209.04,1149.12
X$2446 18996 19171 gf180mcu_fd_sc_mcu9t5v0__filltie
* cell instance $2447 m0 *1 1189.44,1139.04
X$2447 15869 18609 13492 18553 18731 18608 gf180mcu_fd_sc_mcu9t5v0__mux2_1
* cell instance $2448 r0 *1 1239.28,1108.8
X$2448 17958 14820 17985 17837 17847 gf180mcu_fd_sc_mcu9t5v0__nand2_1
* cell instance $2449 m0 *1 1175.44,1159.2
X$2449 18153 19176 10687 13331 19171 19282 gf180mcu_fd_sc_mcu9t5v0__dffrnq_2
* cell instance $2450 m0 *1 1237.04,1159.2
X$2450 14313 19299 19300 19005 19171 19282 19138
+ gf180mcu_fd_sc_mcu9t5v0__oai31_1
* cell instance $2451 r0 *1 1237.6,1159.2
X$2451 19419 19418 19448 19282 19299 gf180mcu_fd_sc_mcu9t5v0__nor2_1
* cell instance $2452 m0 *1 1211.84,1169.28
X$2452 19871 19869 19448 19605 19581 gf180mcu_fd_sc_mcu9t5v0__and2_1
* cell instance $2453 m0 *1 1220.8,1169.28
X$2453 19871 19869 19448 19605 19298 gf180mcu_fd_sc_mcu9t5v0__nor2_1
* cell instance $2454 m0 *1 1216.32,1169.28
X$2454 19615 19582 12632 19448 19605 19137 gf180mcu_fd_sc_mcu9t5v0__aoi21_1
* cell instance $2455 m0 *1 1186.64,1169.28
X$2455 18153 19580 13729 13331 19448 19605 gf180mcu_fd_sc_mcu9t5v0__dffrnq_2
* cell instance $2456 r0 *1 1234.8,1108.8
X$2456 14820 17412 17847 17985 17837 17961 gf180mcu_fd_sc_mcu9t5v0__oai21_1
* cell instance $2457 m0 *1 1196.72,1159.2
X$2457 18153 19177 5284 13331 19171 19282 gf180mcu_fd_sc_mcu9t5v0__dffrnq_2
* cell instance $2458 m0 *1 1236.48,1149.12
X$2458 7963 12632 18841 18996 19005 gf180mcu_fd_sc_mcu9t5v0__nand2_1
* cell instance $2459 r0 *1 1192.8,1128.96
X$2459 18398 14135 18439 18553 18386 18558 gf180mcu_fd_sc_mcu9t5v0__aoi21_1
* cell instance $2460 r0 *1 1214.64,1108.8
X$2460 17722 14820 17985 17837 17594 gf180mcu_fd_sc_mcu9t5v0__nand2_1
* cell instance $2461 r0 *1 1182.16,1139.04
X$2461 18153 18608 15869 13331 18841 18731 gf180mcu_fd_sc_mcu9t5v0__dffrnq_2
* cell instance $2462 m0 *1 1205.68,1139.04
X$2462 14181 18610 13492 18553 18731 18399 gf180mcu_fd_sc_mcu9t5v0__mux2_1
* cell instance $2463 m0 *1 1181.6,1118.88
X$2463 18153 17997 17591 13331 17985 18104 gf180mcu_fd_sc_mcu9t5v0__dffrnq_2
* cell instance $2464 r0 *1 1209.04,1159.2
X$2464 19282 19448 gf180mcu_fd_sc_mcu9t5v0__filltie
* cell instance $2465 r0 *1 1221.92,1128.96
X$2465 13171 18450 13492 18553 18386 18611 gf180mcu_fd_sc_mcu9t5v0__mux2_1
* cell instance $2466 m0 *1 1309.84,1239.84
X$2466 21603 21552 21553 13180 21537 21719 gf180mcu_fd_sc_mcu9t5v0__dffrnq_2
* cell instance $2467 r0 *1 1312.08,1229.76
X$2467 21422 21553 17977 21537 21412 21552 gf180mcu_fd_sc_mcu9t5v0__mux2_1
* cell instance $2468 m0 *1 1273.44,1179.36
X$2468 19878 19729 19901 19743 gf180mcu_fd_sc_mcu9t5v0__clkinv_1
* cell instance $2469 m0 *1 1244.88,1179.36
X$2469 19923 19872 19729 19901 19583 gf180mcu_fd_sc_mcu9t5v0__nor2_1
* cell instance $2470 m0 *1 1248.24,1179.36
X$2470 19923 19872 19419 19729 19901 19874 gf180mcu_fd_sc_mcu9t5v0__oai21_1
* cell instance $2471 m0 *1 1288.56,1179.36
X$2471 19179 19618 19729 19901 19878 gf180mcu_fd_sc_mcu9t5v0__xnor2_1
* cell instance $2472 m0 *1 1268.96,1179.36
X$2472 20045 19874 19878 19729 19901 16977 gf180mcu_fd_sc_mcu9t5v0__aoi21_1
* cell instance $2473 m0 *1 1261.68,1179.36
X$2473 19877 20353 19729 19901 19876 gf180mcu_fd_sc_mcu9t5v0__or2_1
* cell instance $2474 m0 *1 1257.2,1179.36
X$2474 19419 19418 19876 19729 19901 19875 gf180mcu_fd_sc_mcu9t5v0__oai21_1
* cell instance $2475 m0 *1 1295.28,1179.36
X$2475 20046 19618 19729 19901 19879 gf180mcu_fd_sc_mcu9t5v0__nor2_1
* cell instance $2476 m0 *1 1284.08,1179.36
X$2476 19878 19875 19879 19729 19901 15154 gf180mcu_fd_sc_mcu9t5v0__aoi21_1
* cell instance $2477 m0 *1 1307.04,1128.96
X$2477 18406 18273 18407 13180 18268 18386 gf180mcu_fd_sc_mcu9t5v0__dffrnq_2
* cell instance $2478 r0 *1 1308.72,1159.2
X$2478 18406 19304 19424 13180 19448 19282 gf180mcu_fd_sc_mcu9t5v0__dffrnq_2
* cell instance $2479 r0 *1 1312.08,1128.96
X$2479 18452 18407 18272 18553 18386 18273 gf180mcu_fd_sc_mcu9t5v0__mux2_1
* cell instance $2480 r0 *1 1307.04,1108.8
X$2480 13699 17848 14310 13180 17985 17837 gf180mcu_fd_sc_mcu9t5v0__dffrnq_2
* cell instance $2481 m0 *1 1310.96,1159.2
X$2481 19301 19424 17977 19171 19282 19304 gf180mcu_fd_sc_mcu9t5v0__mux2_1
* cell instance $2482 m0 *1 1309.84,1149.12
X$2482 18406 18853 16026 13180 18841 18996 gf180mcu_fd_sc_mcu9t5v0__dffrnq_2
* cell instance $2483 m0 *1 1310.4,1139.04
X$2483 18619 18614 18612 7343 18553 18731 18452 gf180mcu_fd_sc_mcu9t5v0__aoi22_1
* cell instance $2484 r0 *1 1275.68,1169.28
X$2484 19878 19875 19729 19605 14466 gf180mcu_fd_sc_mcu9t5v0__xnor2_1
* cell instance $2485 r0 *1 1324.96,1169.28
X$2485 18406 19746 19926 13180 19729 19605 gf180mcu_fd_sc_mcu9t5v0__dffrnq_2
* cell instance $2486 r0 *1 1265.6,1169.28
X$2486 19617 19743 19729 19605 19744 gf180mcu_fd_sc_mcu9t5v0__nor2_1
* cell instance $2487 r0 *1 1268.96,1169.28
X$2487 16977 19744 19729 19605 19584 gf180mcu_fd_sc_mcu9t5v0__nor2_1
* cell instance $2488 r0 *1 1347.92,1169.28
X$2488 19619 22830 19287 19729 19605 19747 gf180mcu_fd_sc_mcu9t5v0__mux2_1
* cell instance $2489 m0 *1 1375.36,1179.36
X$2489 20047 19729 19901 19927 gf180mcu_fd_sc_mcu9t5v0__clkinv_1
* cell instance $2490 r0 *1 1290.24,1169.28
X$2490 19179 19618 19729 19605 17094 gf180mcu_fd_sc_mcu9t5v0__or2_1
* cell instance $2491 m0 *1 1307.04,1179.36
X$2491 19924 18614 18612 4959 19729 19901 19880 gf180mcu_fd_sc_mcu9t5v0__aoi22_1
* cell instance $2492 m0 *1 1313.76,1179.36
X$2492 19880 19881 18272 19729 19901 19925 gf180mcu_fd_sc_mcu9t5v0__mux2_1
* cell instance $2493 m0 *1 1302,1219.68
X$2493 18406 21011 21012 13180 20936 21123 gf180mcu_fd_sc_mcu9t5v0__dffrnq_2
* cell instance $2494 r0 *1 1307.6,1209.6
X$2494 21012 22829 19287 20936 20822 21011 gf180mcu_fd_sc_mcu9t5v0__mux2_1
* cell instance $2495 m0 *1 1300.32,1199.52
X$2495 18406 20389 20354 13180 20379 20507 gf180mcu_fd_sc_mcu9t5v0__dffrnq_2
* cell instance $2496 m0 *1 1344.56,1179.36
X$2496 18406 19747 19619 13180 19729 19901 gf180mcu_fd_sc_mcu9t5v0__dffrnq_2
* cell instance $2497 m0 *1 1330,1179.36
X$2497 19926 19881 18277 19729 19901 19746 gf180mcu_fd_sc_mcu9t5v0__mux2_1
* cell instance $2498 r0 *1 1305.36,1189.44
X$2498 20354 19745 19287 20379 20217 20389 gf180mcu_fd_sc_mcu9t5v0__mux2_1
* cell instance $2499 r0 *1 1311.52,1179.36
X$2499 18406 19925 19881 13180 20028 19901 gf180mcu_fd_sc_mcu9t5v0__dffrnq_2
* cell instance $2500 m0 *1 1328.88,1179.36
X$2500 19901 19729 gf180mcu_fd_sc_mcu9t5v0__filltie
* cell instance $2501 r0 *1 1369.2,1179.36
X$2501 22832 20047 19910 20028 19901 20098 gf180mcu_fd_sc_mcu9t5v0__mux2_1
* cell instance $2502 m0 *1 1345.68,1219.68
X$2502 21375 20936 21123 20958 gf180mcu_fd_sc_mcu9t5v0__clkinv_1
* cell instance $2503 r0 *1 1364.16,1219.68
X$2503 21139 21241 21123 20097 gf180mcu_fd_sc_mcu9t5v0__clkinv_1
* cell instance $2504 m0 *1 1328.88,1239.84
X$2504 21719 21537 gf180mcu_fd_sc_mcu9t5v0__filltie
* cell instance $2505 m0 *1 1330,1239.84
X$2505 21553 21556 14872 21537 21719 21734 gf180mcu_fd_sc_mcu9t5v0__mux2_1
* cell instance $2506 m0 *1 1328.88,1209.6
X$2506 20822 20637 gf180mcu_fd_sc_mcu9t5v0__filltie
* cell instance $2507 r0 *1 1312.64,1189.44
X$2507 20354 20379 20217 19924 gf180mcu_fd_sc_mcu9t5v0__clkinv_1
* cell instance $2508 m0 *1 1368.64,1239.84
X$2508 15415 21604 13492 21537 21719 21735 gf180mcu_fd_sc_mcu9t5v0__mux2_1
* cell instance $2509 r0 *1 1342.88,1209.6
X$2509 20958 18614 18612 9586 20936 20822 20527 gf180mcu_fd_sc_mcu9t5v0__aoi22_1
* cell instance $2510 r0 *1 1359.68,1209.6
X$2510 18000 20836 20714 13180 20936 20822 gf180mcu_fd_sc_mcu9t5v0__dffrnq_2
* cell instance $2511 m0 *1 1349.6,1229.76
X$2511 21603 21253 21139 13180 21241 21412 gf180mcu_fd_sc_mcu9t5v0__dffrnq_2
* cell instance $2512 m0 *1 1328.88,1219.68
X$2512 21123 20936 gf180mcu_fd_sc_mcu9t5v0__filltie
* cell instance $2513 r0 *1 1356.88,1219.68
X$2513 23314 21139 19910 21241 21123 21253 gf180mcu_fd_sc_mcu9t5v0__mux2_1
* cell instance $2514 m0 *1 1363.04,1209.6
X$2514 20714 20664 18277 20637 20822 20836 gf180mcu_fd_sc_mcu9t5v0__mux2_1
* cell instance $2515 r0 *1 1346.24,1199.52
X$2515 20527 20664 18272 20637 20507 20663 gf180mcu_fd_sc_mcu9t5v0__mux2_1
* cell instance $2516 m0 *1 1328.88,1229.76
X$2516 21412 21241 gf180mcu_fd_sc_mcu9t5v0__filltie
* cell instance $2517 m0 *1 1343.44,1189.44
X$2517 20096 22833 19287 20028 20217 20095 gf180mcu_fd_sc_mcu9t5v0__mux2_1
* cell instance $2518 m0 *1 1358,1189.44
X$2518 20097 18614 18412 12791 20028 20217 20232
+ gf180mcu_fd_sc_mcu9t5v0__aoi22_1
* cell instance $2519 m0 *1 1338.4,1229.76
X$2519 21375 23314 19287 21241 21412 21252 gf180mcu_fd_sc_mcu9t5v0__mux2_1
* cell instance $2520 m0 *1 1328.88,1199.52
X$2520 20507 20379 gf180mcu_fd_sc_mcu9t5v0__filltie
* cell instance $2521 m0 *1 1321.6,1209.6
X$2521 20649 20713 17977 20637 20822 20835 gf180mcu_fd_sc_mcu9t5v0__mux2_1
* cell instance $2522 m0 *1 1342.88,1209.6
X$2522 18000 20663 20664 13180 20637 20822 gf180mcu_fd_sc_mcu9t5v0__dffrnq_2
* cell instance $2523 r0 *1 1337.84,1189.44
X$2523 18406 20095 20096 13180 20379 20217 gf180mcu_fd_sc_mcu9t5v0__dffrnq_2
* cell instance $2524 r0 *1 1318.8,1209.6
X$2524 18406 20835 20713 13180 20936 20822 gf180mcu_fd_sc_mcu9t5v0__dffrnq_2
* cell instance $2525 r0 *1 1332.24,1219.68
X$2525 21603 21252 21375 13180 21241 21123 gf180mcu_fd_sc_mcu9t5v0__dffrnq_2
* cell instance $2526 r0 *1 1317.68,1189.44
X$2526 18406 20355 20231 13180 20379 20217 gf180mcu_fd_sc_mcu9t5v0__dffrnq_2
* cell instance $2527 m0 *1 1350.72,1189.44
X$2527 20096 20028 20217 19305 gf180mcu_fd_sc_mcu9t5v0__clkinv_1
* cell instance $2528 m0 *1 1328.88,1189.44
X$2528 20217 20028 gf180mcu_fd_sc_mcu9t5v0__filltie
* cell instance $2529 m0 *1 1321.6,1199.52
X$2529 19917 20231 19910 20379 20507 20355 gf180mcu_fd_sc_mcu9t5v0__mux2_1
* cell instance $2530 r0 *1 1253.28,1229.76
X$2530 21374 21550 18277 21537 21412 21551 gf180mcu_fd_sc_mcu9t5v0__mux2_1
* cell instance $2531 m0 *1 1257.76,1209.6
X$2531 20710 20637 20822 20709 20353 gf180mcu_fd_sc_mcu9t5v0__xor2_1
* cell instance $2532 r0 *1 1291.92,1189.44
X$2532 19140 20379 20217 20094 gf180mcu_fd_sc_mcu9t5v0__clkinv_1
* cell instance $2533 m0 *1 1254.96,1189.44
X$2533 3816 20028 20217 18157 gf180mcu_fd_sc_mcu9t5v0__clkbuf_8
* cell instance $2534 m0 *1 1270.64,1229.76
X$2534 21374 21430 17977 21241 21412 21429 gf180mcu_fd_sc_mcu9t5v0__mux2_1
* cell instance $2535 r0 *1 1276.8,1199.52
X$2535 20660 20637 20507 20525 gf180mcu_fd_sc_mcu9t5v0__clkinv_1
* cell instance $2536 m0 *1 1254.96,1209.6
X$2536 20706 20957 20637 20822 20708 gf180mcu_fd_sc_mcu9t5v0__nand2_1
* cell instance $2537 m0 *1 1264.48,1209.6
X$2537 20524 20660 20637 20822 20710 gf180mcu_fd_sc_mcu9t5v0__xnor2_1
* cell instance $2538 r0 *1 1267.28,1229.76
X$2538 18157 21429 21430 13180 21537 21412 gf180mcu_fd_sc_mcu9t5v0__dffrnq_2
* cell instance $2539 m0 *1 1294.16,1199.52
X$2539 19140 20712 20526 20379 20507 17541 gf180mcu_fd_sc_mcu9t5v0__aoi21_1
* cell instance $2540 m0 *1 1249.92,1239.84
X$2540 18157 21551 21374 13180 21537 21719 gf180mcu_fd_sc_mcu9t5v0__dffrnq_2
* cell instance $2541 r0 *1 1260,1199.52
X$2541 20659 20953 20708 20710 20637 20507 20711
+ gf180mcu_fd_sc_mcu9t5v0__oai211_1
* cell instance $2542 r0 *1 1292.48,1179.36
X$2542 20046 20028 19901 19179 gf180mcu_fd_sc_mcu9t5v0__clkinv_1
* cell instance $2543 m0 *1 1291.36,1219.68
X$2543 21010 20388 14872 20936 21123 21138 gf180mcu_fd_sc_mcu9t5v0__mux2_1
* cell instance $2544 r0 *1 1267.84,1189.44
X$2544 20230 20353 20379 20217 20045 gf180mcu_fd_sc_mcu9t5v0__or2_1
* cell instance $2545 m0 *1 1289.12,1199.52
X$2545 20094 20388 20661 20711 20379 20507 20526
+ gf180mcu_fd_sc_mcu9t5v0__aoi22_1
* cell instance $2546 r0 *1 1260,1179.36
X$2546 19877 20353 20028 19901 19419 gf180mcu_fd_sc_mcu9t5v0__xnor2_1
* cell instance $2547 r0 *1 1279.6,1189.44
X$2547 20046 20660 20346 20379 20217 19007 gf180mcu_fd_sc_mcu9t5v0__mux2_1
* cell instance $2548 r0 *1 1251.6,1209.6
X$2548 19877 20957 20346 20936 20822 20707 gf180mcu_fd_sc_mcu9t5v0__mux2_1
* cell instance $2549 r0 *1 1279.04,1199.52
X$2549 20524 20525 20637 20507 20661 gf180mcu_fd_sc_mcu9t5v0__nand2_1
* cell instance $2550 m0 *1 1252.72,1199.52
X$2550 19877 20379 20507 20524 20352 gf180mcu_fd_sc_mcu9t5v0__xor2_1
* cell instance $2551 m0 *1 1295.28,1239.84
X$2551 21854 17597 14872 21537 21719 21733 gf180mcu_fd_sc_mcu9t5v0__mux2_1
* cell instance $2552 r0 *1 1289.68,1219.68
X$2552 18406 21138 20388 13180 21241 21123 gf180mcu_fd_sc_mcu9t5v0__dffrnq_2
* cell instance $2553 m0 *1 1287.44,1209.6
X$2553 20661 20711 20637 20822 20662 gf180mcu_fd_sc_mcu9t5v0__nand2_1
* cell instance $2554 r0 *1 1267.28,1179.36
X$2554 20045 19874 20028 19901 19617 gf180mcu_fd_sc_mcu9t5v0__nand2_1
* cell instance $2555 r0 *1 1254.96,1189.44
X$2555 18157 20379 20217 gf180mcu_fd_sc_mcu9t5v0__inv_4
* cell instance $2556 m0 *1 1255.52,1219.68
X$2556 20706 20957 20936 21123 20659 gf180mcu_fd_sc_mcu9t5v0__nor2_1
* cell instance $2557 r0 *1 1284.64,1199.52
X$2557 19140 20662 20637 20507 19618 20712 gf180mcu_fd_sc_mcu9t5v0__xnor3_1
* cell instance $2558 r0 *1 1270.64,1219.68
X$2558 18157 21251 19140 13180 21241 21123 gf180mcu_fd_sc_mcu9t5v0__dffrnq_2
* cell instance $2559 r0 *1 1274.56,1189.44
X$2559 20230 20524 20229 20379 20217 19421 gf180mcu_fd_sc_mcu9t5v0__aoi21_1
* cell instance $2560 r0 *1 1247.12,1209.6
X$2560 20524 20707 20834 20936 20822 18971 gf180mcu_fd_sc_mcu9t5v0__aoi21_1
* cell instance $2561 r0 *1 1243.76,1189.44
X$2561 20352 20093 20379 20217 19742 gf180mcu_fd_sc_mcu9t5v0__xnor2_1
* cell instance $2562 m0 *1 1277.36,1219.68
X$2562 21430 19140 14872 20936 21123 21251 gf180mcu_fd_sc_mcu9t5v0__mux2_1
* cell instance $2563 m0 *1 1290.8,1189.44
X$2563 20094 20046 20028 20217 19585 gf180mcu_fd_sc_mcu9t5v0__nand2_1
* cell instance $2564 m0 *1 1292.48,1209.6
X$2564 20388 20637 20822 20712 gf180mcu_fd_sc_mcu9t5v0__clkinv_1
* cell instance $2565 r0 *1 1258.88,1209.6
X$2565 20659 20953 20708 20936 20822 20709 gf180mcu_fd_sc_mcu9t5v0__oai21_1
* cell instance $2566 r0 *1 1290.8,1159.2
X$2566 19423 19421 19448 19282 17998 gf180mcu_fd_sc_mcu9t5v0__and2_1
* cell instance $2567 m0 *1 1271.2,1128.96
X$2567 18404 18405 17977 18268 18386 18159 gf180mcu_fd_sc_mcu9t5v0__mux2_1
* cell instance $2568 r0 *1 1283.52,1128.96
X$2568 18405 17298 14872 18553 18386 18451 gf180mcu_fd_sc_mcu9t5v0__mux2_1
* cell instance $2569 m0 *1 1291.92,1139.04
X$2569 18616 18743 18553 18731 18617 gf180mcu_fd_sc_mcu9t5v0__nor2_1
* cell instance $2570 m0 *1 1244.88,1169.28
X$2570 19583 19419 19448 19605 19616 gf180mcu_fd_sc_mcu9t5v0__xnor2_1
* cell instance $2571 r0 *1 1285.76,1139.04
X$2571 17298 18617 18841 18731 18852 17539 gf180mcu_fd_sc_mcu9t5v0__xor3_1
* cell instance $2572 m0 *1 1280.16,1149.12
X$2572 18616 18841 18996 18973 gf180mcu_fd_sc_mcu9t5v0__clkinv_1
* cell instance $2573 r0 *1 1294.72,1108.8
X$2573 17964 17963 17998 17962 17985 17837 15878
+ gf180mcu_fd_sc_mcu9t5v0__oai31_1
* cell instance $2574 r0 *1 1298.64,1139.04
X$2574 18618 18616 18743 18744 18841 18731 17133
+ gf180mcu_fd_sc_mcu9t5v0__oai31_1
* cell instance $2575 m0 *1 1262.8,1159.2
X$2575 16459 12632 19302 19178 19171 19282 18615
+ gf180mcu_fd_sc_mcu9t5v0__aoi22_1
* cell instance $2576 r0 *1 1248.8,1149.12
X$2576 18157 19139 19006 13331 19171 18996 gf180mcu_fd_sc_mcu9t5v0__dffrnq_2
* cell instance $2577 m0 *1 1260,1128.96
X$2577 18404 18401 18277 18268 18386 18403 gf180mcu_fd_sc_mcu9t5v0__mux2_1
* cell instance $2578 r0 *1 1295.28,1159.2
X$2578 19140 19179 19448 19282 19423 gf180mcu_fd_sc_mcu9t5v0__nand2_1
* cell instance $2579 r0 *1 1266.72,1118.88
X$2579 18157 18159 18405 13180 18268 18104 gf180mcu_fd_sc_mcu9t5v0__dffrnq_2
* cell instance $2580 r0 *1 1288.56,1108.8
X$2580 17298 17095 17985 17837 17962 gf180mcu_fd_sc_mcu9t5v0__nand2_1
* cell instance $2581 r0 *1 1279.6,1149.12
X$2581 19140 19007 19171 18996 18616 gf180mcu_fd_sc_mcu9t5v0__nor2_1
* cell instance $2582 m0 *1 1293.6,1118.88
X$2582 17298 17095 17985 18104 17964 gf180mcu_fd_sc_mcu9t5v0__nor2_1
* cell instance $2583 r0 *1 1251.6,1108.8
X$2583 14677 18615 13172 13331 17985 17837 gf180mcu_fd_sc_mcu9t5v0__dffrnq_2
* cell instance $2584 r0 *1 1284.08,1159.2
X$2584 19421 19420 19422 19448 19282 19302 gf180mcu_fd_sc_mcu9t5v0__oai21_1
* cell instance $2585 m0 *1 1295.84,1139.04
X$2585 17298 18852 18553 18731 18618 gf180mcu_fd_sc_mcu9t5v0__nor2_1
* cell instance $2586 r0 *1 1276.8,1149.12
X$2586 19140 19007 19171 18996 18974 gf180mcu_fd_sc_mcu9t5v0__nand2_1
* cell instance $2587 m0 *1 1248.8,1139.04
X$2587 18613 18614 18612 4674 18553 18731 18402 gf180mcu_fd_sc_mcu9t5v0__aoi22_1
* cell instance $2588 m0 *1 1256.08,1149.12
X$2588 19006 18841 18996 18613 gf180mcu_fd_sc_mcu9t5v0__clkinv_1
* cell instance $2589 m0 *1 1294.72,1149.12
X$2589 17298 18852 18841 18996 18744 gf180mcu_fd_sc_mcu9t5v0__nand2_1
* cell instance $2590 m0 *1 1305.36,1159.2
X$2590 20996 14192 9338 18412 19171 19282 19303 gf180mcu_fd_sc_mcu9t5v0__oai31_1
* cell instance $2591 m0 *1 1275.68,1149.12
X$2591 18974 18971 18841 18996 18743 gf180mcu_fd_sc_mcu9t5v0__and2_1
* cell instance $2592 m0 *1 1247.68,1128.96
X$2592 18402 18401 18272 18268 18386 18400 gf180mcu_fd_sc_mcu9t5v0__mux2_1
* cell instance $2593 r0 *1 1257.2,1128.96
X$2593 18157 18403 18404 13331 18553 18386 gf180mcu_fd_sc_mcu9t5v0__dffrnq_2
* cell instance $2594 m0 *1 1265.6,1169.28
X$2594 20346 19584 12632 19448 19605 19178 gf180mcu_fd_sc_mcu9t5v0__aoi21_1
* cell instance $2595 m0 *1 1291.92,1159.2
X$2595 19140 19179 19171 19282 17963 gf180mcu_fd_sc_mcu9t5v0__nor2_1
* cell instance $2596 r0 *1 1302,1149.12
X$2596 17256 20388 14205 19171 18996 18852 gf180mcu_fd_sc_mcu9t5v0__mux2_1
* cell instance $2597 m0 *1 1291.36,1169.28
X$2597 19423 19585 19448 19605 19420 gf180mcu_fd_sc_mcu9t5v0__nand2_1
* cell instance $2598 m0 *1 1254.4,1159.2
X$2598 19006 22828 19287 19171 19282 19139 gf180mcu_fd_sc_mcu9t5v0__mux2_1
* cell instance $2599 m0 *1 1284.08,1128.96
X$2599 18406 18451 17298 13180 18268 18386 gf180mcu_fd_sc_mcu9t5v0__dffrnq_2
* cell instance $2600 m0 *1 1286.88,1169.28
X$2600 19421 19420 20346 19448 19605 19422 gf180mcu_fd_sc_mcu9t5v0__aoi21_1
* cell instance $2601 m0 *1 1272.88,1149.12
X$2601 18974 18973 18841 18996 18972 gf180mcu_fd_sc_mcu9t5v0__nand2_1
* cell instance $2602 m0 *1 1265.04,1149.12
X$2602 18971 18841 18996 18972 18609 gf180mcu_fd_sc_mcu9t5v0__xor2_1
* cell instance $2603 r0 *1 1291.36,1108.8
X$2603 17963 17998 17985 17837 17723 gf180mcu_fd_sc_mcu9t5v0__nor2_1
* cell instance $2604 m0 *1 1335.04,1118.88
X$2604 18408 17966 17977 17985 18104 17965 gf180mcu_fd_sc_mcu9t5v0__mux2_1
* cell instance $2605 r0 *1 1355.76,1159.2
X$2605 19426 18614 18612 5915 19448 19282 19009 gf180mcu_fd_sc_mcu9t5v0__aoi22_1
* cell instance $2606 m0 *1 1328.88,1169.28
X$2606 19605 19448 gf180mcu_fd_sc_mcu9t5v0__filltie
* cell instance $2607 m0 *1 1358,1169.28
X$2607 19619 19448 19605 19426 gf180mcu_fd_sc_mcu9t5v0__clkinv_1
* cell instance $2608 m0 *1 1330,1169.28
X$2608 3930 19448 19605 18406 gf180mcu_fd_sc_mcu9t5v0__clkbuf_8
* cell instance $2609 m0 *1 1324.4,1169.28
X$2609 18406 19448 19605 33564 gf180mcu_fd_sc_mcu9t5v0__clkinv_1
* cell instance $2610 r0 *1 1341.76,1159.2
X$2610 20231 19448 19282 19425 gf180mcu_fd_sc_mcu9t5v0__clkinv_1
* cell instance $2611 r0 *1 1341.2,1139.04
X$2611 19305 18614 18612 4965 18841 18731 18745 gf180mcu_fd_sc_mcu9t5v0__aoi22_1
* cell instance $2612 m0 *1 1328.88,1149.12
X$2612 18996 18841 gf180mcu_fd_sc_mcu9t5v0__filltie
* cell instance $2613 r0 *1 1329.44,1108.8
X$2613 13699 17965 17966 13180 17985 17837 gf180mcu_fd_sc_mcu9t5v0__dffrnq_2
* cell instance $2614 r0 *1 1353.52,1149.12
X$2614 19009 19180 18272 19171 18996 19142 gf180mcu_fd_sc_mcu9t5v0__mux2_1
* cell instance $2615 m0 *1 1328.88,1128.96
X$2615 18386 18268 gf180mcu_fd_sc_mcu9t5v0__filltie
* cell instance $2616 m0 *1 1328.88,1139.04
X$2616 18731 18553 gf180mcu_fd_sc_mcu9t5v0__filltie
* cell instance $2617 m0 *1 1349.6,1118.88
X$2617 18000 17999 16028 13180 17985 18104 gf180mcu_fd_sc_mcu9t5v0__dffrnq_2
* cell instance $2618 m0 *1 1330,1159.2
X$2618 18406 19141 19008 13180 19171 19282 gf180mcu_fd_sc_mcu9t5v0__dffrnq_2
* cell instance $2619 m0 *1 1330,1128.96
X$2619 18408 18407 18277 18268 18386 18160 gf180mcu_fd_sc_mcu9t5v0__mux2_1
* cell instance $2620 m0 *1 1361.92,1128.96
X$2620 18621 18274 17977 18268 18386 18161 gf180mcu_fd_sc_mcu9t5v0__mux2_1
* cell instance $2621 r0 *1 1357.44,1108.8
X$2621 18274 16028 14872 17985 17837 17999 gf180mcu_fd_sc_mcu9t5v0__mux2_1
* cell instance $2622 r0 *1 1332.24,1149.12
X$2622 19926 19008 17977 19171 18996 19141 gf180mcu_fd_sc_mcu9t5v0__mux2_1
* cell instance $2623 r0 *1 1355.2,1139.04
X$2623 18406 18620 18621 13180 18841 18731 gf180mcu_fd_sc_mcu9t5v0__dffrnq_2
* cell instance $2624 r0 *1 1323.28,1139.04
X$2624 19008 16026 14872 18841 18731 18853 gf180mcu_fd_sc_mcu9t5v0__mux2_1
* cell instance $2625 m0 *1 1338.96,1139.04
X$2625 18406 18559 18409 13180 18553 18731 gf180mcu_fd_sc_mcu9t5v0__dffrnq_2
* cell instance $2626 m0 *1 1360.24,1139.04
X$2626 18621 19180 18277 18553 18731 18620 gf180mcu_fd_sc_mcu9t5v0__mux2_1
* cell instance $2627 r0 *1 1323.28,1118.88
X$2627 18406 18160 18408 13180 18268 18104 gf180mcu_fd_sc_mcu9t5v0__dffrnq_2
* cell instance $2628 r0 *1 1352.96,1118.88
X$2628 18406 18161 18274 13180 18268 18104 gf180mcu_fd_sc_mcu9t5v0__dffrnq_2
* cell instance $2629 m0 *1 1349.04,1159.2
X$2629 18406 19142 19180 13180 19171 19282 gf180mcu_fd_sc_mcu9t5v0__dffrnq_2
* cell instance $2630 r0 *1 1342.88,1128.96
X$2630 18745 18409 18272 18553 18386 18559 gf180mcu_fd_sc_mcu9t5v0__mux2_1
* cell instance $2631 m0 *1 1328.88,1159.2
X$2631 19282 19171 gf180mcu_fd_sc_mcu9t5v0__filltie
* cell instance $2632 m0 *1 1328.88,1118.88
X$2632 18104 17985 gf180mcu_fd_sc_mcu9t5v0__filltie
* cell instance $2633 r0 *1 1313.76,1139.04
X$2633 21012 18841 18731 18619 gf180mcu_fd_sc_mcu9t5v0__clkinv_1
* cell instance $2634 r0 *1 1486.24,1239.84
X$2634 21737 21388 17977 21884 21719 21610 gf180mcu_fd_sc_mcu9t5v0__mux2_1
* cell instance $2635 m0 *1 1504.72,1320.48
X$2635 24310 23977 23932 14696 23957 24118 gf180mcu_fd_sc_mcu9t5v0__dffrnq_2
* cell instance $2636 m0 *1 1517.6,1340.64
X$2636 24605 22862 24528 24712 24729 gf180mcu_fd_sc_mcu9t5v0__nand2_1
* cell instance $2637 r0 *1 1508.64,1340.64
X$2637 24310 24847 24605 14696 24828 24712 gf180mcu_fd_sc_mcu9t5v0__dffrnq_2
* cell instance $2638 r0 *1 1517.04,1310.4
X$2638 22728 23933 23978 14696 23957 23797 gf180mcu_fd_sc_mcu9t5v0__dffrnq_2
* cell instance $2639 m0 *1 1505.28,1360.8
X$2639 24310 25171 25019 14696 25158 25268 gf180mcu_fd_sc_mcu9t5v0__dffrnq_2
* cell instance $2640 m0 *1 1500.8,1249.92
X$2640 19587 21859 21896 14696 21884 21997 gf180mcu_fd_sc_mcu9t5v0__dffrnq_2
* cell instance $2641 r0 *1 1533.84,1239.84
X$2641 21860 21861 21884 21719 21391 gf180mcu_fd_sc_mcu9t5v0__and2_1
* cell instance $2642 r0 *1 1538.32,1239.84
X$2642 21861 21862 21884 21719 20536 gf180mcu_fd_sc_mcu9t5v0__xnor2_1
* cell instance $2643 r0 *1 1550.64,1239.84
X$2643 21864 21860 21863 21738 21884 21719 21865
+ gf180mcu_fd_sc_mcu9t5v0__oai31_1
* cell instance $2644 r0 *1 1508.08,1280.16
X$2644 22728 22904 20397 14696 23038 22885 gf180mcu_fd_sc_mcu9t5v0__dffrnq_2
* cell instance $2645 m0 *1 1512.56,1260
X$2645 19587 22142 22021 14696 22124 22295 gf180mcu_fd_sc_mcu9t5v0__dffrnq_2
* cell instance $2646 r0 *1 1506.96,1239.84
X$2646 21896 17553 20719 21884 21719 21859 gf180mcu_fd_sc_mcu9t5v0__mux2_1
* cell instance $2647 r0 *1 1518.16,1249.92
X$2647 22021 18125 20719 22124 21997 22142 gf180mcu_fd_sc_mcu9t5v0__mux2_1
* cell instance $2648 r0 *1 1589.84,1239.84
X$2648 19752 21867 21868 14696 21884 21719 gf180mcu_fd_sc_mcu9t5v0__dffrnq_2
* cell instance $2649 r0 *1 1557.92,1239.84
X$2649 20398 21864 21884 21719 21738 gf180mcu_fd_sc_mcu9t5v0__nand2_1
* cell instance $2650 r0 *1 1575.84,1239.84
X$2650 21866 21884 21719 21614 gf180mcu_fd_sc_mcu9t5v0__clkinv_1
* cell instance $2651 r0 *1 1578.08,1239.84
X$2651 21438 21560 21884 21719 21611 gf180mcu_fd_sc_mcu9t5v0__nand2_1
* cell instance $2652 r0 *1 1462.72,1239.84
X$2652 21736 21858 21884 21719 21609 gf180mcu_fd_sc_mcu9t5v0__nor2_1
* cell instance $2653 r0 *1 1448.72,1239.84
X$2653 21719 21884 gf180mcu_fd_sc_mcu9t5v0__filltie
* cell instance $2654 r0 *1 1453.76,1239.84
X$2654 21736 21858 21607 21884 21719 21386 gf180mcu_fd_sc_mcu9t5v0__nor3_1
* cell instance $2655 r0 *1 1434.72,1239.84
X$2655 21892 21857 20346 21884 21719 21856 gf180mcu_fd_sc_mcu9t5v0__oai21_1
* cell instance $2656 r0 *1 1458.24,1239.84
X$2656 21736 21858 21607 21884 21719 21013 gf180mcu_fd_sc_mcu9t5v0__oai21_1
* cell instance $2657 r0 *1 1608.88,1239.84
X$2657 19752 21739 21615 14696 21884 21719 gf180mcu_fd_sc_mcu9t5v0__dffrnq_2
* cell instance $2658 m0 *1 1501.36,1169.28
X$2658 19587 19462 19433 14696 19448 19605 gf180mcu_fd_sc_mcu9t5v0__dffrnq_2
* cell instance $2659 r0 *1 1512,1199.52
X$2659 19587 20531 20532 14696 20637 20507 gf180mcu_fd_sc_mcu9t5v0__dffrnq_2
* cell instance $2660 r0 *1 1510.88,1179.36
X$2660 19587 19930 19931 14696 20028 19901 gf180mcu_fd_sc_mcu9t5v0__dffrnq_2
* cell instance $2661 m0 *1 1513.68,1179.36
X$2661 19931 20058 18277 19729 19901 19930 gf180mcu_fd_sc_mcu9t5v0__mux2_1
* cell instance $2662 r0 *1 1505.28,1209.6
X$2662 19587 20838 20718 14696 20936 20822 gf180mcu_fd_sc_mcu9t5v0__dffrnq_2
* cell instance $2663 m0 *1 1518.16,1199.52
X$2663 20532 16689 20719 20379 20507 20531 gf180mcu_fd_sc_mcu9t5v0__mux2_1
* cell instance $2664 m0 *1 1516.48,1159.2
X$2664 19306 19145 19292 19171 19282 19309 gf180mcu_fd_sc_mcu9t5v0__mux2_1
* cell instance $2665 m0 *1 1502.48,1128.96
X$2665 18414 18165 18166 14696 18268 18386 gf180mcu_fd_sc_mcu9t5v0__dffrnq_2
* cell instance $2666 r0 *1 1518.72,1118.88
X$2666 17731 18166 18277 18268 18104 18004 gf180mcu_fd_sc_mcu9t5v0__mux2_1
* cell instance $2667 r0 *1 1513.12,1159.2
X$2667 18414 19309 19145 14696 19448 19282 gf180mcu_fd_sc_mcu9t5v0__dffrnq_2
* cell instance $2668 m0 *1 1515.36,1118.88
X$2668 18414 18004 17731 14696 17985 18104 gf180mcu_fd_sc_mcu9t5v0__dffrnq_2
* cell instance $2669 r0 *1 1517.6,1139.04
X$2669 18414 18628 18629 14696 18841 18731 gf180mcu_fd_sc_mcu9t5v0__dffrnq_2
* cell instance $2670 r0 *1 1513.12,1370.88
X$2670 25603 25600 20719 25705 25581 25854 gf180mcu_fd_sc_mcu9t5v0__mux2_1
* cell instance $2671 r0 *1 1631.84,1239.84
X$2671 19752 21740 21261 14696 21884 21719 gf180mcu_fd_sc_mcu9t5v0__dffrnq_2
* cell instance $2672 r0 *1 1627.92,1239.84
X$2672 21869 21615 21884 21719 21616 gf180mcu_fd_sc_mcu9t5v0__nor2_1
* cell instance $2673 r0 *1 1551.2,1310.4
X$2673 23935 23934 20537 23957 23797 23981 gf180mcu_fd_sc_mcu9t5v0__mux2_1
* cell instance $2674 m0 *1 1588.16,1270.08
X$2674 22728 22433 16485 14696 22449 22577 gf180mcu_fd_sc_mcu9t5v0__dffrnq_2
* cell instance $2675 m0 *1 1572.48,1290.24
X$2675 22728 22906 20112 14696 23038 23200 gf180mcu_fd_sc_mcu9t5v0__dffrnq_2
* cell instance $2676 m0 *1 1585.92,1360.8
X$2676 23521 25298 24981 14696 25158 25268 gf180mcu_fd_sc_mcu9t5v0__dffrnq_2
* cell instance $2677 m0 *1 1586.48,1340.64
X$2677 23521 24609 24427 14696 24528 24712 gf180mcu_fd_sc_mcu9t5v0__dffrnq_2
* cell instance $2678 r0 *1 1591.52,1310.4
X$2678 23521 23937 23982 14696 23957 23797 gf180mcu_fd_sc_mcu9t5v0__dffrnq_2
* cell instance $2679 r0 *1 1576.96,1310.4
X$2679 23982 23935 23936 23957 23797 21560 gf180mcu_fd_sc_mcu9t5v0__aoi21_1
* cell instance $2680 m0 *1 1579.2,1310.4
X$2680 23521 23655 21869 14696 23623 23797 gf180mcu_fd_sc_mcu9t5v0__dffrnq_2
* cell instance $2681 r0 *1 1584.8,1370.88
X$2681 25723 25725 15890 25705 25581 25724 gf180mcu_fd_sc_mcu9t5v0__mux2_1
* cell instance $2682 r0 *1 1624,1310.4
X$2682 23658 23957 23797 23707 23983 gf180mcu_fd_sc_mcu9t5v0__xor2_1
* cell instance $2683 r0 *1 1633.52,1310.4
X$2683 23521 23708 23707 14696 23957 23797 gf180mcu_fd_sc_mcu9t5v0__dffrnq_2
* cell instance $2684 m0 *1 1621.2,1330.56
X$2684 20723 24232 24414 23521 gf180mcu_fd_sc_mcu9t5v0__clkbuf_8
* cell instance $2685 r0 *1 1621.76,1330.56
X$2685 24558 24851 24428 24528 24414 24559 gf180mcu_fd_sc_mcu9t5v0__and3_1
* cell instance $2686 m0 *1 1607.2,1340.64
X$2686 24427 17977 24528 24712 24610 gf180mcu_fd_sc_mcu9t5v0__nand2_1
* cell instance $2687 m0 *1 1616.16,1360.8
X$2687 25145 26022 25158 25268 25299 25144 gf180mcu_fd_sc_mcu9t5v0__xnor3_1
* cell instance $2688 m0 *1 1606.64,1330.56
X$2688 24317 22907 24232 24414 24316 gf180mcu_fd_sc_mcu9t5v0__nand2_1
* cell instance $2689 r0 *1 1596,1330.56
X$2689 23521 24315 24317 14696 24528 24414 gf180mcu_fd_sc_mcu9t5v0__dffrnq_2
* cell instance $2690 m0 *1 1599.36,1330.56
X$2690 16690 22907 24316 24232 24414 24315 gf180mcu_fd_sc_mcu9t5v0__oai21_1
* cell instance $2691 m0 *1 1606.64,1360.8
X$2691 22909 25144 18562 25158 25268 25143 gf180mcu_fd_sc_mcu9t5v0__mux2_1
* cell instance $2692 r0 *1 1618.96,1350.72
X$2692 25145 25144 25158 25000 24851 gf180mcu_fd_sc_mcu9t5v0__nand2_1
* cell instance $2693 r0 *1 1599.36,1350.72
X$2693 23521 25143 25144 14696 25158 25000 gf180mcu_fd_sc_mcu9t5v0__dffrnq_2
* cell instance $2694 m0 *1 1598.24,1320.48
X$2694 23982 24106 15890 23957 24118 23937 gf180mcu_fd_sc_mcu9t5v0__mux2_1
* cell instance $2695 m0 *1 1616.72,1330.56
X$2695 23521 24232 24414 gf180mcu_fd_sc_mcu9t5v0__inv_3
* cell instance $2696 r0 *1 1610.56,1370.88
X$2696 25606 25727 25705 25581 25858 25725 gf180mcu_fd_sc_mcu9t5v0__xor3_1
* cell instance $2697 r0 *1 1621.2,1360.8
X$2697 25145 25144 25430 25268 25146 gf180mcu_fd_sc_mcu9t5v0__nor2_1
* cell instance $2698 r0 *1 1620.08,1320.48
X$2698 24134 24258 24232 24118 24107 gf180mcu_fd_sc_mcu9t5v0__nor2_1
* cell instance $2699 m0 *1 1615.6,1340.64
X$2699 17977 24258 24559 24610 24528 24712 24609
+ gf180mcu_fd_sc_mcu9t5v0__oai31_1
* cell instance $2700 r0 *1 1621.76,1350.72
X$2700 25146 26022 25158 25000 24428 gf180mcu_fd_sc_mcu9t5v0__or2_1
* cell instance $2701 m0 *1 1649.2,1370.88
X$2701 23697 14872 25430 25581 25607 gf180mcu_fd_sc_mcu9t5v0__nand2_1
* cell instance $2702 r0 *1 1630.16,1370.88
X$2702 25600 25858 18562 25705 25581 25728 gf180mcu_fd_sc_mcu9t5v0__mux2_1
* cell instance $2703 m0 *1 1629.6,1360.8
X$2703 25300 25172 25145 14696 25158 25268 gf180mcu_fd_sc_mcu9t5v0__dffrnq_2
* cell instance $2704 r0 *1 1634.08,1350.72
X$2704 16689 25145 22907 25158 25000 25172 gf180mcu_fd_sc_mcu9t5v0__mux2_1
* cell instance $2705 r0 *1 1649.76,1320.48
X$2705 18125 24135 22436 24232 24118 24318 gf180mcu_fd_sc_mcu9t5v0__mux2_1
* cell instance $2706 m0 *1 1627.92,1320.48
X$2706 24134 24258 23983 23957 24118 23185 gf180mcu_fd_sc_mcu9t5v0__oai21_1
* cell instance $2707 m0 *1 1638,1340.64
X$2707 22024 24611 18562 24528 24712 24560 gf180mcu_fd_sc_mcu9t5v0__mux2_1
* cell instance $2708 m0 *1 1647.52,1350.72
X$2708 18125 24982 22434 24828 25000 25147 gf180mcu_fd_sc_mcu9t5v0__mux2_1
* cell instance $2709 r0 *1 1634.08,1330.56
X$2709 23521 24560 24611 14696 24528 24414 gf180mcu_fd_sc_mcu9t5v0__dffrnq_2
* cell instance $2710 r0 *1 1622.32,1340.64
X$2710 24851 24428 24558 24828 24712 24258 gf180mcu_fd_sc_mcu9t5v0__aoi21_1
* cell instance $2711 r0 *1 1598.8,1370.88
X$2711 16688 25606 22907 25705 25581 25726 gf180mcu_fd_sc_mcu9t5v0__mux2_1
* cell instance $2712 r0 *1 1623.44,1320.48
X$2712 24317 24611 24232 24118 24134 gf180mcu_fd_sc_mcu9t5v0__and2_1
* cell instance $2713 m0 *1 1621.2,1320.48
X$2713 24107 23983 23957 24118 24106 gf180mcu_fd_sc_mcu9t5v0__xnor2_1
* cell instance $2714 m0 *1 1621.76,1340.64
X$2714 24317 24611 24528 24712 24558 gf180mcu_fd_sc_mcu9t5v0__xnor2_1
* cell instance $2715 r0 *1 1592.64,1360.8
X$2715 24981 25299 15890 25430 25268 25298 gf180mcu_fd_sc_mcu9t5v0__mux2_1
* cell instance $2716 r0 *1 1572.48,1350.72
X$2716 24981 25141 25158 25000 25142 gf180mcu_fd_sc_mcu9t5v0__xnor2_1
* cell instance $2717 r0 *1 1574.72,1340.64
X$2717 24850 24980 24828 24712 24257 gf180mcu_fd_sc_mcu9t5v0__and2_1
* cell instance $2718 m0 *1 1570.8,1350.72
X$2718 24980 24979 24828 25000 23930 gf180mcu_fd_sc_mcu9t5v0__nand2_1
* cell instance $2719 r0 *1 1574.72,1370.88
X$2719 25723 25722 25705 25581 25447 gf180mcu_fd_sc_mcu9t5v0__or2_1
* cell instance $2720 r0 *1 1552.32,1370.88
X$2720 21864 25604 25902 25605 25705 25581 25857
+ gf180mcu_fd_sc_mcu9t5v0__oai31_1
* cell instance $2721 m0 *1 1568.56,1350.72
X$2721 25000 24828 gf180mcu_fd_sc_mcu9t5v0__filltie
* cell instance $2722 r0 *1 1573.04,1330.56
X$2722 24427 24557 24528 24414 24133 gf180mcu_fd_sc_mcu9t5v0__nand2_1
* cell instance $2723 m0 *1 1573.6,1350.72
X$2723 24981 25141 24828 25000 24850 gf180mcu_fd_sc_mcu9t5v0__nand2_1
* cell instance $2724 r0 *1 1534.4,1340.64
X$2724 24848 24849 24730 24606 24828 24712 24607
+ gf180mcu_fd_sc_mcu9t5v0__aoi211_1
* cell instance $2725 r0 *1 1531.04,1330.56
X$2725 24605 24604 24607 24528 24414 24426 gf180mcu_fd_sc_mcu9t5v0__aoi21_1
* cell instance $2726 m0 *1 1539.44,1320.48
X$2726 23979 24426 23957 24118 23980 gf180mcu_fd_sc_mcu9t5v0__nand2_1
* cell instance $2727 m0 *1 1534.96,1320.48
X$2727 23978 23932 23980 23957 24118 23345 gf180mcu_fd_sc_mcu9t5v0__oai21_1
* cell instance $2728 m0 *1 1548.96,1340.64
X$2728 23521 24556 24557 14696 24528 24712 gf180mcu_fd_sc_mcu9t5v0__dffrnq_2
* cell instance $2729 r0 *1 1532.16,1320.48
X$2729 23978 24426 24232 24118 23934 23932 gf180mcu_fd_sc_mcu9t5v0__xnor3_1
* cell instance $2730 m0 *1 1548.4,1320.48
X$2730 22728 23981 23935 14696 23957 24118 gf180mcu_fd_sc_mcu9t5v0__dffrnq_2
* cell instance $2731 r0 *1 1540,1340.64
X$2731 24848 24849 24730 24828 24712 24608 gf180mcu_fd_sc_mcu9t5v0__aoi21_1
* cell instance $2732 m0 *1 1537.76,1340.64
X$2732 24606 24608 24528 24712 24555 gf180mcu_fd_sc_mcu9t5v0__xnor2_1
* cell instance $2733 r0 *1 1534.96,1350.72
X$2733 25138 24849 25158 25000 25139 25019 gf180mcu_fd_sc_mcu9t5v0__xnor3_1
* cell instance $2734 m0 *1 1528.24,1320.48
X$2734 23978 22862 23957 24118 24103 gf180mcu_fd_sc_mcu9t5v0__nand2_1
* cell instance $2735 m0 *1 1579.2,1320.48
X$2735 23982 23935 23957 24118 24105 gf180mcu_fd_sc_mcu9t5v0__xnor2_1
* cell instance $2736 m0 *1 1568.56,1360.8
X$2736 25268 25158 gf180mcu_fd_sc_mcu9t5v0__filltie
* cell instance $2737 m0 *1 1529.36,1370.88
X$2737 16689 25138 22862 25430 25581 25336 gf180mcu_fd_sc_mcu9t5v0__mux2_1
* cell instance $2738 r0 *1 1540,1370.88
X$2738 25855 25603 25604 25705 25581 24849 gf180mcu_fd_sc_mcu9t5v0__aoi21_1
* cell instance $2739 m0 *1 1568.56,1370.88
X$2739 25581 25430 gf180mcu_fd_sc_mcu9t5v0__filltie
* cell instance $2740 m0 *1 1532.16,1320.48
X$2740 23978 23932 23957 24118 23979 gf180mcu_fd_sc_mcu9t5v0__nand2_1
* cell instance $2741 m0 *1 1523.76,1320.48
X$2741 21026 22862 24103 23957 24118 23933 gf180mcu_fd_sc_mcu9t5v0__oai21_1
* cell instance $2742 r0 *1 1528.8,1350.72
X$2742 25138 25019 25158 25000 24848 gf180mcu_fd_sc_mcu9t5v0__nand2_1
* cell instance $2743 r0 *1 1575.84,1320.48
X$2743 24133 24257 24314 24105 24232 24118 23936
+ gf180mcu_fd_sc_mcu9t5v0__aoi211_1
* cell instance $2744 r0 *1 1559.04,1370.88
X$2744 25722 21864 25705 25581 25605 gf180mcu_fd_sc_mcu9t5v0__nand2_1
* cell instance $2745 r0 *1 1531.6,1350.72
X$2745 25138 25019 25158 25000 24730 gf180mcu_fd_sc_mcu9t5v0__nor2_1
* cell instance $2746 m0 *1 1574.16,1370.88
X$2746 25296 25447 25430 25581 25448 gf180mcu_fd_sc_mcu9t5v0__nand2_1
* cell instance $2747 m0 *1 1528.8,1340.64
X$2747 24605 24604 24528 24712 24606 gf180mcu_fd_sc_mcu9t5v0__xnor2_1
* cell instance $2748 r0 *1 1575.84,1330.56
X$2748 24427 24557 24528 24414 24314 gf180mcu_fd_sc_mcu9t5v0__nor2_1
* cell instance $2749 m0 *1 1540.56,1360.8
X$2749 25335 25268 25158 20723 gf180mcu_fd_sc_mcu9t5v0__clkbuf_16
* cell instance $2750 r0 *1 1571.92,1370.88
X$2750 25723 25722 25705 25581 25296 gf180mcu_fd_sc_mcu9t5v0__nand2_1
* cell instance $2751 r0 *1 1551.76,1330.56
X$2751 24557 24555 20537 24528 24414 24556 gf180mcu_fd_sc_mcu9t5v0__mux2_1
* cell instance $2752 r0 *1 1547.84,1350.72
X$2752 23521 25140 25141 14696 25158 25000 gf180mcu_fd_sc_mcu9t5v0__dffrnq_2
* cell instance $2753 m0 *1 1568.56,1340.64
X$2753 24712 24528 gf180mcu_fd_sc_mcu9t5v0__filltie
* cell instance $2754 m0 *1 1575.28,1330.56
X$2754 24133 24257 24314 24232 24414 24104 gf180mcu_fd_sc_mcu9t5v0__aoi21_1
* cell instance $2755 m0 *1 1572.48,1320.48
X$2755 24105 24104 23957 24118 22429 gf180mcu_fd_sc_mcu9t5v0__xnor2_1
* cell instance $2756 m0 *1 1569.68,1340.64
X$2756 24427 24257 24528 24712 23217 24557 gf180mcu_fd_sc_mcu9t5v0__xnor3_1
* cell instance $2757 r0 *1 1523.2,1360.8
X$2757 25853 25336 25138 14696 25430 25268 gf180mcu_fd_sc_mcu9t5v0__dffrnq_2
* cell instance $2758 m0 *1 1576.96,1370.88
X$2758 25296 25430 25581 25339 gf180mcu_fd_sc_mcu9t5v0__clkinv_1
* cell instance $2759 r0 *1 1577.52,1360.8
X$2759 25339 25337 25447 25297 25430 25268 24980
+ gf180mcu_fd_sc_mcu9t5v0__oai211_1
* cell instance $2760 r0 *1 1550.64,1360.8
X$2760 25141 25139 20537 25430 25268 25140 gf180mcu_fd_sc_mcu9t5v0__mux2_1
* cell instance $2761 r0 *1 1568,1360.8
X$2761 25447 25337 25430 25268 25338 gf180mcu_fd_sc_mcu9t5v0__nand2_1
* cell instance $2762 m0 *1 1578.08,1360.8
X$2762 25142 25158 25268 25297 gf180mcu_fd_sc_mcu9t5v0__clkinv_1
* cell instance $2763 m0 *1 1568.56,1330.56
X$2763 24414 24232 gf180mcu_fd_sc_mcu9t5v0__filltie
* cell instance $2764 r0 *1 1570.8,1360.8
X$2764 25337 25448 25430 25268 24425 gf180mcu_fd_sc_mcu9t5v0__xnor2_1
* cell instance $2765 m0 *1 1574.16,1360.8
X$2765 25142 25296 25338 25158 25268 24979 gf180mcu_fd_sc_mcu9t5v0__nand3_1
* cell instance $2766 m0 *1 1568.56,1320.48
X$2766 24118 23957 gf180mcu_fd_sc_mcu9t5v0__filltie
* cell instance $2767 m0 *1 1524.88,1290.24
X$2767 21618 23183 22862 23038 23200 23218 gf180mcu_fd_sc_mcu9t5v0__mux2_1
* cell instance $2768 r0 *1 1545.04,1290.24
X$2768 23183 23344 23319 23200 23346 gf180mcu_fd_sc_mcu9t5v0__nand2_1
* cell instance $2769 m0 *1 1545.6,1270.08
X$2769 22605 22604 22449 22577 22476 gf180mcu_fd_sc_mcu9t5v0__nand2_1
* cell instance $2770 r0 *1 1540.56,1290.24
X$2770 23184 23345 23346 23319 23200 22729 gf180mcu_fd_sc_mcu9t5v0__oai21_1
* cell instance $2771 m0 *1 1545.6,1290.24
X$2771 22728 22905 22605 14696 23038 23200 gf180mcu_fd_sc_mcu9t5v0__dffrnq_2
* cell instance $2772 r0 *1 1557.92,1300.32
X$2772 22728 23520 23394 14696 23623 23504 gf180mcu_fd_sc_mcu9t5v0__dffrnq_2
* cell instance $2773 m0 *1 1549.52,1249.92
X$2773 22728 21865 20398 14696 21884 21997 gf180mcu_fd_sc_mcu9t5v0__dffrnq_2
* cell instance $2774 r0 *1 1576.96,1249.92
X$2774 21868 22143 22124 21997 21866 gf180mcu_fd_sc_mcu9t5v0__xnor2_1
* cell instance $2775 r0 *1 1578.08,1300.32
X$2775 23055 21869 22907 23623 23504 23655 gf180mcu_fd_sc_mcu9t5v0__mux2_1
* cell instance $2776 m0 *1 1568.56,1280.16
X$2776 22885 22700 gf180mcu_fd_sc_mcu9t5v0__filltie
* cell instance $2777 m0 *1 1568.56,1290.24
X$2777 23200 23038 gf180mcu_fd_sc_mcu9t5v0__filltie
* cell instance $2778 r0 *1 1559.04,1260
X$2778 22728 22477 22143 14696 22449 22295 gf180mcu_fd_sc_mcu9t5v0__dffrnq_2
* cell instance $2779 m0 *1 1568.56,1300.32
X$2779 23504 23319 gf180mcu_fd_sc_mcu9t5v0__filltie
* cell instance $2780 m0 *1 1568.56,1310.4
X$2780 23797 23623 gf180mcu_fd_sc_mcu9t5v0__filltie
* cell instance $2781 r0 *1 1542.24,1270.08
X$2781 22605 22604 22729 22700 22577 22431 gf180mcu_fd_sc_mcu9t5v0__oai21_1
* cell instance $2782 m0 *1 1534.96,1260
X$2782 20397 22021 22124 22295 22430 gf180mcu_fd_sc_mcu9t5v0__xnor2_1
* cell instance $2783 r0 *1 1571.92,1290.24
X$2783 23055 19466 22434 23319 23200 23027 gf180mcu_fd_sc_mcu9t5v0__mux2_1
* cell instance $2784 m0 *1 1583.12,1249.92
X$2784 22023 21884 21997 21612 gf180mcu_fd_sc_mcu9t5v0__clkinv_1
* cell instance $2785 m0 *1 1577.52,1260
X$2785 21868 22143 22022 22124 22295 20539 gf180mcu_fd_sc_mcu9t5v0__aoi21_1
* cell instance $2786 m0 *1 1568.56,1270.08
X$2786 22577 22449 gf180mcu_fd_sc_mcu9t5v0__filltie
* cell instance $2787 r0 *1 1582,1260
X$2787 22432 23394 22449 22295 21438 gf180mcu_fd_sc_mcu9t5v0__nand2_1
* cell instance $2788 r0 *1 1568.56,1280.16
X$2788 22728 23027 19466 14696 23038 22885 gf180mcu_fd_sc_mcu9t5v0__dffrnq_2
* cell instance $2789 m0 *1 1561.28,1270.08
X$2789 22143 22730 20537 22449 22577 22477 gf180mcu_fd_sc_mcu9t5v0__mux2_1
* cell instance $2790 m0 *1 1577.52,1249.92
X$2790 21438 21560 22023 21866 21884 21997 22022
+ gf180mcu_fd_sc_mcu9t5v0__aoi211_1
* cell instance $2791 m0 *1 1568.56,1260
X$2791 22295 22124 gf180mcu_fd_sc_mcu9t5v0__filltie
* cell instance $2792 m0 *1 1568.56,1249.92
X$2792 21997 21884 gf180mcu_fd_sc_mcu9t5v0__filltie
* cell instance $2793 m0 *1 1576.96,1280.16
X$2793 23055 20112 22436 22700 22885 22906 gf180mcu_fd_sc_mcu9t5v0__mux2_1
* cell instance $2794 r0 *1 1578.64,1260
X$2794 22432 23394 22449 22295 22023 gf180mcu_fd_sc_mcu9t5v0__nor2_1
* cell instance $2795 r0 *1 1540.56,1260
X$2795 22476 22431 22430 22449 22295 21860 gf180mcu_fd_sc_mcu9t5v0__aoi21_1
* cell instance $2796 r0 *1 1546.72,1270.08
X$2796 22605 22729 22700 22577 22604 22730 gf180mcu_fd_sc_mcu9t5v0__xor3_1
* cell instance $2797 m0 *1 1539.44,1300.32
X$2797 23183 23345 23319 23504 23393 23344 gf180mcu_fd_sc_mcu9t5v0__xnor3_1
* cell instance $2798 m0 *1 1529.36,1249.92
X$2798 20397 21884 21997 21896 21861 gf180mcu_fd_sc_mcu9t5v0__xor2_1
* cell instance $2799 m0 *1 1560.16,1300.32
X$2799 23394 23393 20537 23319 23504 23520 gf180mcu_fd_sc_mcu9t5v0__mux2_1
* cell instance $2800 m0 *1 1538.32,1290.24
X$2800 23183 23344 23038 23200 23184 gf180mcu_fd_sc_mcu9t5v0__nor2_1
* cell instance $2801 m0 *1 1524.88,1249.92
X$2801 22021 21896 20397 21884 21997 21141 gf180mcu_fd_sc_mcu9t5v0__oai21_1
* cell instance $2802 m0 *1 1536.08,1249.92
X$2802 20397 22021 21860 21884 21997 21862 gf180mcu_fd_sc_mcu9t5v0__aoi21_1
* cell instance $2803 m0 *1 1540.56,1310.4
X$2803 23805 23623 23797 23055 gf180mcu_fd_sc_mcu9t5v0__buf_8
* cell instance $2804 r0 *1 1520.96,1290.24
X$2804 22728 23218 23183 14696 23319 23200 gf180mcu_fd_sc_mcu9t5v0__dffrnq_2
* cell instance $2805 r0 *1 1521.52,1270.08
X$2805 22728 22603 22604 14696 22700 22577 gf180mcu_fd_sc_mcu9t5v0__dffrnq_2
* cell instance $2806 r0 *1 1545.6,1280.16
X$2806 22728 23038 22885 gf180mcu_fd_sc_mcu9t5v0__clkinv_3
* cell instance $2807 r0 *1 1550.08,1280.16
X$2807 20723 23038 22885 22728 gf180mcu_fd_sc_mcu9t5v0__clkbuf_8
* cell instance $2808 r0 *1 1545.04,1260
X$2808 22430 22476 22431 22449 22295 21863 gf180mcu_fd_sc_mcu9t5v0__and3_1
* cell instance $2809 m0 *1 1548.96,1280.16
X$2809 23055 22605 22862 22700 22885 22905 gf180mcu_fd_sc_mcu9t5v0__mux2_1
* cell instance $2810 m0 *1 1526.56,1270.08
X$2810 22604 20111 20719 22449 22577 22603 gf180mcu_fd_sc_mcu9t5v0__mux2_1
* cell instance $2811 m0 *1 1627.36,1300.32
X$2811 23395 23185 23186 23319 23504 23220 gf180mcu_fd_sc_mcu9t5v0__aoi21_1
* cell instance $2812 r0 *1 1615.04,1300.32
X$2812 23658 22907 23623 23504 23657 gf180mcu_fd_sc_mcu9t5v0__nand2_1
* cell instance $2813 r0 *1 1597.12,1260
X$2813 16485 22434 22449 22295 22435 gf180mcu_fd_sc_mcu9t5v0__nand2_1
* cell instance $2814 r0 *1 1617.28,1290.24
X$2814 17977 23220 23348 23219 23319 23200 23347
+ gf180mcu_fd_sc_mcu9t5v0__oai31_1
* cell instance $2815 m0 *1 1604.4,1310.4
X$2815 23521 23656 23658 14696 23623 23797 gf180mcu_fd_sc_mcu9t5v0__dffrnq_2
* cell instance $2816 m0 *1 1637.44,1310.4
X$2816 20543 23707 18562 23623 23797 23708 gf180mcu_fd_sc_mcu9t5v0__mux2_1
* cell instance $2817 r0 *1 1589.84,1260
X$2817 22434 22861 22435 22449 22295 22433 gf180mcu_fd_sc_mcu9t5v0__oai21_1
* cell instance $2818 m0 *1 1607.2,1270.08
X$2818 22728 22478 16215 14696 22449 22577 gf180mcu_fd_sc_mcu9t5v0__dffrnq_2
* cell instance $2819 m0 *1 1626.8,1310.4
X$2819 23658 23707 23623 23797 23395 gf180mcu_fd_sc_mcu9t5v0__nand2_1
* cell instance $2820 r0 *1 1594.88,1290.24
X$2820 23521 23347 22432 14696 23319 23200 gf180mcu_fd_sc_mcu9t5v0__dffrnq_2
* cell instance $2821 r0 *1 1602.16,1260
X$2821 22436 22861 22479 22449 22295 22478 gf180mcu_fd_sc_mcu9t5v0__oai21_1
* cell instance $2822 m0 *1 1613.92,1249.92
X$2822 21869 21617 21884 21997 21897 21615 gf180mcu_fd_sc_mcu9t5v0__xnor3_1
* cell instance $2823 r0 *1 1608.32,1300.32
X$2823 21026 22907 23657 23623 23504 23656 gf180mcu_fd_sc_mcu9t5v0__oai21_1
* cell instance $2824 m0 *1 1596.56,1249.92
X$2824 21868 21897 15890 21884 21997 21867 gf180mcu_fd_sc_mcu9t5v0__mux2_1
* cell instance $2825 m0 *1 1594.88,1290.24
X$2825 22728 23028 18980 14696 23038 23200 gf180mcu_fd_sc_mcu9t5v0__dffrnq_2
* cell instance $2826 r0 *1 1625.12,1280.16
X$2826 23030 22480 23220 23038 22885 21617 gf180mcu_fd_sc_mcu9t5v0__aoi21_1
* cell instance $2827 m0 *1 1641.92,1260
X$2827 22196 18975 14872 22124 22295 22314 gf180mcu_fd_sc_mcu9t5v0__mux2_1
* cell instance $2828 r0 *1 1634.08,1260
X$2828 21024 22314 18975 14696 22449 22295 gf180mcu_fd_sc_mcu9t5v0__dffrnq_2
* cell instance $2829 r0 *1 1622.88,1290.24
X$2829 23521 23349 22473 14696 23319 23200 gf180mcu_fd_sc_mcu9t5v0__dffrnq_2
* cell instance $2830 m0 *1 1626.8,1290.24
X$2830 23395 23185 23186 23038 23200 23348 gf180mcu_fd_sc_mcu9t5v0__and3_1
* cell instance $2831 m0 *1 1626.24,1270.08
X$2831 21395 22480 18562 22449 22577 22437 gf180mcu_fd_sc_mcu9t5v0__mux2_1
* cell instance $2832 r0 *1 1602.72,1280.16
X$2832 18980 22907 23038 22885 23029 gf180mcu_fd_sc_mcu9t5v0__nand2_1
* cell instance $2833 r0 *1 1641.36,1249.92
X$2833 21618 20403 22436 22124 21997 21898 gf180mcu_fd_sc_mcu9t5v0__mux2_1
* cell instance $2834 r0 *1 1629.6,1280.16
X$2834 23030 22480 23038 22885 23186 gf180mcu_fd_sc_mcu9t5v0__xnor2_1
* cell instance $2835 r0 *1 1596.56,1280.16
X$2835 22907 22861 23029 23038 22885 23028 gf180mcu_fd_sc_mcu9t5v0__oai21_1
* cell instance $2836 r0 *1 1641.36,1280.16
X$2836 21618 23030 22907 23038 22885 23056 gf180mcu_fd_sc_mcu9t5v0__mux2_1
* cell instance $2837 r0 *1 1612.24,1260
X$2837 16215 22436 22449 22295 22479 gf180mcu_fd_sc_mcu9t5v0__nand2_1
* cell instance $2838 r0 *1 1615.04,1260
X$2838 22728 22437 22480 14696 22449 22295 gf180mcu_fd_sc_mcu9t5v0__dffrnq_2
* cell instance $2839 m0 *1 1613.92,1290.24
X$2839 22432 17977 23038 23200 23219 gf180mcu_fd_sc_mcu9t5v0__nand2_1
* cell instance $2840 r0 *1 1449.84,1370.88
X$2840 25601 25705 25581 25719 gf180mcu_fd_sc_mcu9t5v0__clkinv_1
* cell instance $2841 r0 *1 1449.84,1280.16
X$2841 23054 22727 23038 22885 22428 22859 gf180mcu_fd_sc_mcu9t5v0__xnor3_1
* cell instance $2842 r0 *1 1449.84,1260
X$2842 22426 22140 22449 22295 22427 gf180mcu_fd_sc_mcu9t5v0__or2_1
* cell instance $2843 m0 *1 1445.92,1270.08
X$2843 23054 21858 22474 22449 22577 21384 gf180mcu_fd_sc_mcu9t5v0__nor3_1
* cell instance $2844 m0 *1 1442.56,1280.16
X$2844 22473 22727 22700 22885 21857 22859 gf180mcu_fd_sc_mcu9t5v0__xnor3_1
* cell instance $2845 r0 *1 1508.08,1310.4
X$2845 23932 20543 20719 23957 23797 23977 gf180mcu_fd_sc_mcu9t5v0__mux2_1
* cell instance $2846 m0 *1 1440.88,1300.32
X$2846 23928 23392 23518 14696 23319 23504 gf180mcu_fd_sc_mcu9t5v0__dffrnq_2
* cell instance $2847 m0 *1 1436.4,1320.48
X$2847 23928 23976 22019 14696 23957 24118 gf180mcu_fd_sc_mcu9t5v0__dffrnq_2
* cell instance $2848 r0 *1 1449.84,1300.32
X$2848 23518 19292 23623 23504 23652 gf180mcu_fd_sc_mcu9t5v0__nand2_1
* cell instance $2849 r0 *1 1448.72,1310.4
X$2849 23797 23957 gf180mcu_fd_sc_mcu9t5v0__filltie
* cell instance $2850 r0 *1 1438.64,1310.4
X$2850 25293 22019 14872 23957 23797 23976 gf180mcu_fd_sc_mcu9t5v0__mux2_1
* cell instance $2851 m0 *1 1444.8,1350.72
X$2851 23928 24845 24727 14696 24828 25000 gf180mcu_fd_sc_mcu9t5v0__dffrnq_2
* cell instance $2852 m0 *1 1435.28,1330.56
X$2852 24310 24311 24424 14696 24232 24414 gf180mcu_fd_sc_mcu9t5v0__dffrnq_2
* cell instance $2853 r0 *1 1406.16,1310.4
X$2853 23928 23706 22472 13180 23957 23797 gf180mcu_fd_sc_mcu9t5v0__dffrnq_2
* cell instance $2854 r0 *1 1387.12,1310.4
X$2854 21603 23806 23807 13180 23957 23797 gf180mcu_fd_sc_mcu9t5v0__dffrnq_2
* cell instance $2855 r0 *1 1492.4,1310.4
X$2855 14872 23930 23931 23957 23797 23929 gf180mcu_fd_sc_mcu9t5v0__oai21_1
* cell instance $2856 r0 *1 1492.4,1370.88
X$2856 24310 25602 14435 14696 25705 25581 gf180mcu_fd_sc_mcu9t5v0__dffrnq_2
* cell instance $2857 m0 *1 1496.88,1340.64
X$2857 24310 24554 24604 14696 24528 24712 gf180mcu_fd_sc_mcu9t5v0__dffrnq_2
* cell instance $2858 r0 *1 1453.2,1320.48
X$2858 24310 24256 13852 14696 24232 24118 gf180mcu_fd_sc_mcu9t5v0__dffrnq_2
* cell instance $2859 m0 *1 1466.08,1330.56
X$2859 24310 24312 24313 14696 24232 24414 gf180mcu_fd_sc_mcu9t5v0__dffrnq_2
* cell instance $2860 m0 *1 1458.8,1330.56
X$2860 24727 13852 14872 24232 24414 24256 gf180mcu_fd_sc_mcu9t5v0__mux2_1
* cell instance $2861 m0 *1 1454.88,1360.8
X$2861 25601 24728 17977 25158 25268 25294 gf180mcu_fd_sc_mcu9t5v0__mux2_1
* cell instance $2862 r0 *1 1464.4,1370.88
X$2862 24310 25721 22303 14696 25705 25581 gf180mcu_fd_sc_mcu9t5v0__dffrnq_2
* cell instance $2863 r0 *1 1470,1330.56
X$2863 24423 24313 17977 24528 24414 24312 gf180mcu_fd_sc_mcu9t5v0__mux2_1
* cell instance $2864 m0 *1 1498,1370.88
X$2864 26484 14435 14872 25430 25581 25602 gf180mcu_fd_sc_mcu9t5v0__mux2_1
* cell instance $2865 m0 *1 1475.6,1360.8
X$2865 26064 25018 17977 25158 25268 25295 gf180mcu_fd_sc_mcu9t5v0__mux2_1
* cell instance $2866 r0 *1 1478.4,1340.64
X$2866 24310 24828 24712 gf180mcu_fd_sc_mcu9t5v0__clkbuf_4
* cell instance $2867 r0 *1 1466.08,1340.64
X$2867 24728 13918 14872 24828 24712 24846 gf180mcu_fd_sc_mcu9t5v0__mux2_1
* cell instance $2868 m0 *1 1451.52,1370.88
X$2868 24310 25294 24728 14696 25430 25581 gf180mcu_fd_sc_mcu9t5v0__dffrnq_2
* cell instance $2869 m0 *1 1463.84,1350.72
X$2869 24310 24846 13918 14696 24828 25000 gf180mcu_fd_sc_mcu9t5v0__dffrnq_2
* cell instance $2870 r0 *1 1450.4,1340.64
X$2870 24727 24844 20715 24828 24712 24845 gf180mcu_fd_sc_mcu9t5v0__mux2_1
* cell instance $2871 m0 *1 1486.24,1360.8
X$2871 24310 25170 14207 14696 25158 25268 gf180mcu_fd_sc_mcu9t5v0__dffrnq_2
* cell instance $2872 r0 *1 1472.24,1360.8
X$2872 24310 25295 25018 14696 25430 25268 gf180mcu_fd_sc_mcu9t5v0__dffrnq_2
* cell instance $2873 r0 *1 1489.04,1350.72
X$2873 25018 14207 14872 25158 25000 25170 gf180mcu_fd_sc_mcu9t5v0__mux2_1
* cell instance $2874 r0 *1 1503.04,1330.56
X$2874 24604 22024 20719 24528 24414 24554 gf180mcu_fd_sc_mcu9t5v0__mux2_1
* cell instance $2875 m0 *1 1511.44,1350.72
X$2875 16690 22862 24729 24828 25000 24847 gf180mcu_fd_sc_mcu9t5v0__oai21_1
* cell instance $2876 r0 *1 1494.08,1320.48
X$2876 20703 14872 24232 24118 23931 gf180mcu_fd_sc_mcu9t5v0__nand2_1
* cell instance $2877 r0 *1 1510.88,1350.72
X$2877 25019 22909 20719 25158 25000 25171 gf180mcu_fd_sc_mcu9t5v0__mux2_1
* cell instance $2878 r0 *1 1450.96,1360.8
X$2878 12129 25430 25268 25335 gf180mcu_fd_sc_mcu9t5v0__clkbuf_8
* cell instance $2879 m0 *1 1477.84,1340.64
X$2879 24310 24603 21250 14696 24528 24712 gf180mcu_fd_sc_mcu9t5v0__dffrnq_2
* cell instance $2880 m0 *1 1485.68,1320.48
X$2880 24310 23929 20703 14696 23957 24118 gf180mcu_fd_sc_mcu9t5v0__dffrnq_2
* cell instance $2881 r0 *1 1486.24,1330.56
X$2881 24425 21250 14872 24528 24414 24603 gf180mcu_fd_sc_mcu9t5v0__mux2_1
* cell instance $2882 m0 *1 1482.88,1350.72
X$2882 20723 24828 25000 24310 gf180mcu_fd_sc_mcu9t5v0__clkbuf_8
* cell instance $2883 r0 *1 1429.68,1360.8
X$2883 23928 25292 25293 14696 25430 25268 gf180mcu_fd_sc_mcu9t5v0__dffrnq_2
* cell instance $2884 r0 *1 1448.72,1370.88
X$2884 25581 25705 gf180mcu_fd_sc_mcu9t5v0__filltie
* cell instance $2885 r0 *1 1421.84,1320.48
X$2885 24255 23339 24232 24118 24102 gf180mcu_fd_sc_mcu9t5v0__nand2_1
* cell instance $2886 r0 *1 1448.72,1330.56
X$2886 24414 24528 gf180mcu_fd_sc_mcu9t5v0__filltie
* cell instance $2887 r0 *1 1448.72,1340.64
X$2887 24712 24828 gf180mcu_fd_sc_mcu9t5v0__filltie
* cell instance $2888 r0 *1 1448.72,1350.72
X$2888 25000 25158 gf180mcu_fd_sc_mcu9t5v0__filltie
* cell instance $2889 r0 *1 1432.48,1320.48
X$2889 24424 24232 24118 24255 gf180mcu_fd_sc_mcu9t5v0__clkinv_1
* cell instance $2890 r0 *1 1437.52,1330.56
X$2890 24978 24424 14872 24528 24414 24311 gf180mcu_fd_sc_mcu9t5v0__mux2_1
* cell instance $2891 r0 *1 1448.72,1360.8
X$2891 25268 25430 gf180mcu_fd_sc_mcu9t5v0__filltie
* cell instance $2892 r0 *1 1448.72,1320.48
X$2892 24118 24232 gf180mcu_fd_sc_mcu9t5v0__filltie
* cell instance $2893 m0 *1 1429.12,1350.72
X$2893 24978 25334 20715 24828 25000 24843 gf180mcu_fd_sc_mcu9t5v0__mux2_1
* cell instance $2894 m0 *1 1435.84,1360.8
X$2894 25288 25293 17977 25158 25268 25292 gf180mcu_fd_sc_mcu9t5v0__mux2_1
* cell instance $2895 m0 *1 1394.96,1350.72
X$2895 25017 24976 17977 24828 25000 25016 gf180mcu_fd_sc_mcu9t5v0__mux2_1
* cell instance $2896 m0 *1 1398.32,1330.56
X$2896 24976 24306 14872 24232 24414 24305 gf180mcu_fd_sc_mcu9t5v0__mux2_1
* cell instance $2897 r0 *1 1441.44,1370.88
X$2897 24844 25705 25581 25720 gf180mcu_fd_sc_mcu9t5v0__clkinv_1
* cell instance $2898 r0 *1 1397.76,1370.88
X$2898 23928 25599 25562 13180 25705 25581 gf180mcu_fd_sc_mcu9t5v0__dffrnq_2
* cell instance $2899 r0 *1 1389.36,1350.72
X$2899 23928 25016 24976 13180 25158 25000 gf180mcu_fd_sc_mcu9t5v0__dffrnq_2
* cell instance $2900 m0 *1 1411.76,1330.56
X$2900 24308 24307 24232 24414 24309 gf180mcu_fd_sc_mcu9t5v0__nand2_1
* cell instance $2901 m0 *1 1408.4,1350.72
X$2901 23928 24977 20668 13180 24828 25000 gf180mcu_fd_sc_mcu9t5v0__dffrnq_2
* cell instance $2902 r0 *1 1410.64,1360.8
X$2902 23928 25446 25334 13180 25430 25268 gf180mcu_fd_sc_mcu9t5v0__dffrnq_2
* cell instance $2903 m0 *1 1401.12,1370.88
X$2903 29984 25562 17977 25430 25581 25599 gf180mcu_fd_sc_mcu9t5v0__mux2_1
* cell instance $2904 m0 *1 1419.04,1330.56
X$2904 24423 23921 24232 24414 24308 gf180mcu_fd_sc_mcu9t5v0__nand2_1
* cell instance $2905 r0 *1 1425.2,1340.64
X$2905 23928 24843 24978 14696 24828 24712 gf180mcu_fd_sc_mcu9t5v0__dffrnq_2
* cell instance $2906 m0 *1 1416.8,1320.48
X$2906 24102 23957 24118 21004 gf180mcu_fd_sc_mcu9t5v0__buf_8
* cell instance $2907 r0 *1 1410.08,1350.72
X$2907 25562 20668 14872 25158 25000 24977 gf180mcu_fd_sc_mcu9t5v0__mux2_1
* cell instance $2908 m0 *1 1387.68,1370.88
X$2908 25017 25561 18277 25430 25581 25333 gf180mcu_fd_sc_mcu9t5v0__mux2_1
* cell instance $2909 m0 *1 1417.36,1360.8
X$2909 23928 25158 25268 gf180mcu_fd_sc_mcu9t5v0__inv_3
* cell instance $2910 r0 *1 1391.6,1330.56
X$2910 23928 24305 24306 13180 24528 24414 gf180mcu_fd_sc_mcu9t5v0__dffrnq_2
* cell instance $2911 m0 *1 1416.8,1370.88
X$2911 25715 25334 23921 25430 25581 25446 gf180mcu_fd_sc_mcu9t5v0__mux2_1
* cell instance $2912 m0 *1 1407.84,1330.56
X$2912 24306 24232 24414 23338 gf180mcu_fd_sc_mcu9t5v0__clkinv_1
* cell instance $2913 r0 *1 1411.2,1330.56
X$2913 23928 24309 24423 13180 24528 24414 gf180mcu_fd_sc_mcu9t5v0__dffrnq_2
* cell instance $2914 r0 *1 1417.36,1350.72
X$2914 20723 25158 25000 23928 gf180mcu_fd_sc_mcu9t5v0__clkbuf_8
* cell instance $2915 r0 *1 1382.64,1360.8
X$2915 23928 25333 25017 13180 25430 25268 gf180mcu_fd_sc_mcu9t5v0__dffrnq_2
* cell instance $2916 m0 *1 1421.84,1260
X$2916 22139 22192 22193 22124 22295 21379 gf180mcu_fd_sc_mcu9t5v0__aoi21_1
* cell instance $2917 r0 *1 1444.8,1280.16
X$2917 22138 22903 23038 22885 22859 gf180mcu_fd_sc_mcu9t5v0__nor2_1
* cell instance $2918 r0 *1 1448.72,1290.24
X$2918 23200 23319 gf180mcu_fd_sc_mcu9t5v0__filltie
* cell instance $2919 r0 *1 1387.12,1290.24
X$2919 21603 23337 23181 13180 23319 23200 gf180mcu_fd_sc_mcu9t5v0__dffrnq_2
* cell instance $2920 m0 *1 1437.52,1249.92
X$2920 21892 21857 21884 21997 21382 gf180mcu_fd_sc_mcu9t5v0__and2_1
* cell instance $2921 m0 *1 1435.28,1290.24
X$2921 22473 23038 23200 23054 gf180mcu_fd_sc_mcu9t5v0__clkinv_1
* cell instance $2922 r0 *1 1417.36,1290.24
X$2922 23340 23339 23319 23200 22471 gf180mcu_fd_sc_mcu9t5v0__and2_1
* cell instance $2923 r0 *1 1429.12,1280.16
X$2923 22472 23038 22885 22903 gf180mcu_fd_sc_mcu9t5v0__clkinv_1
* cell instance $2924 r0 *1 1448.72,1270.08
X$2924 22577 22700 gf180mcu_fd_sc_mcu9t5v0__filltie
* cell instance $2925 r0 *1 1417.92,1249.92
X$2925 22139 22140 22124 21997 21892 gf180mcu_fd_sc_mcu9t5v0__and2_1
* cell instance $2926 r0 *1 1446.48,1260
X$2926 22139 22449 22295 22426 gf180mcu_fd_sc_mcu9t5v0__clkinv_1
* cell instance $2927 r0 *1 1448.72,1249.92
X$2927 21997 22124 gf180mcu_fd_sc_mcu9t5v0__filltie
* cell instance $2928 m0 *1 1433.04,1280.16
X$2928 22726 22700 22885 22020 gf180mcu_fd_sc_mcu9t5v0__clkinv_1
* cell instance $2929 r0 *1 1448.72,1300.32
X$2929 23504 23623 gf180mcu_fd_sc_mcu9t5v0__filltie
* cell instance $2930 m0 *1 1430.24,1249.92
X$2930 20346 21379 21893 21856 21382 21884 21997 21604
+ gf180mcu_fd_sc_mcu9t5v0__oai32_1
* cell instance $2931 r0 *1 1401.68,1260
X$2931 22139 22471 22425 22449 22295 22191 gf180mcu_fd_sc_mcu9t5v0__oai21_1
* cell instance $2932 r0 *1 1448.72,1280.16
X$2932 22885 23038 gf180mcu_fd_sc_mcu9t5v0__filltie
* cell instance $2933 r0 *1 1448.72,1260
X$2933 22295 22449 gf180mcu_fd_sc_mcu9t5v0__filltie
* cell instance $2934 r0 *1 1442,1300.32
X$2934 23378 23652 23623 23504 23392 gf180mcu_fd_sc_mcu9t5v0__nand2_1
* cell instance $2935 m0 *1 1434.16,1270.08
X$2935 22473 22020 22449 22577 21381 gf180mcu_fd_sc_mcu9t5v0__nor2_1
* cell instance $2936 r0 *1 1410.08,1290.24
X$2936 23340 23339 23338 23319 23200 22425 gf180mcu_fd_sc_mcu9t5v0__nand3_1
* cell instance $2937 r0 *1 1402.8,1270.08
X$2937 22139 22471 22425 22138 22700 22577 22725
+ gf180mcu_fd_sc_mcu9t5v0__oai211_1
* cell instance $2938 r0 *1 1421.84,1290.24
X$2938 23340 23339 23054 23319 23200 23182 gf180mcu_fd_sc_mcu9t5v0__aoi21_1
* cell instance $2939 m0 *1 1420.72,1290.24
X$2939 22472 22471 23182 22726 23038 23200 22600
+ gf180mcu_fd_sc_mcu9t5v0__aoi211_1
* cell instance $2940 m0 *1 1403.36,1280.16
X$2940 21606 22725 22600 22700 22885 21605 gf180mcu_fd_sc_mcu9t5v0__nor3_1
* cell instance $2941 m0 *1 1408.4,1310.4
X$2941 23807 22472 14872 23623 23797 23706 gf180mcu_fd_sc_mcu9t5v0__mux2_1
* cell instance $2942 m0 *1 1384.88,1270.08
X$2942 12632 21605 22598 22597 22449 22577 22724
+ gf180mcu_fd_sc_mcu9t5v0__oai31_1
* cell instance $2943 m0 *1 1396.08,1249.92
X$2943 22471 21884 21997 20346 gf180mcu_fd_sc_mcu9t5v0__buf_8
* cell instance $2944 r0 *1 1410.08,1280.16
X$2944 23181 23038 22885 22192 gf180mcu_fd_sc_mcu9t5v0__clkinv_1
* cell instance $2945 r0 *1 1398.88,1249.92
X$2945 22139 22138 22124 21997 16537 gf180mcu_fd_sc_mcu9t5v0__xnor2_1
* cell instance $2946 m0 *1 1412.32,1270.08
X$2946 22138 22449 22577 22472 22140 gf180mcu_fd_sc_mcu9t5v0__xor2_1
* cell instance $2947 m0 *1 1414.56,1249.92
X$2947 21892 21891 21884 21997 16982 gf180mcu_fd_sc_mcu9t5v0__nor2_1
* cell instance $2948 r0 *1 1425.76,1270.08
X$2948 22726 22700 22577 22019 22601 gf180mcu_fd_sc_mcu9t5v0__xor2_1
* cell instance $2949 r0 *1 1426.32,1290.24
X$2949 23340 23339 22473 23319 23200 23026 gf180mcu_fd_sc_mcu9t5v0__aoi21_1
* cell instance $2950 r0 *1 1423.52,1280.16
X$2950 22903 22471 23026 22020 23038 22885 21606
+ gf180mcu_fd_sc_mcu9t5v0__aoi211_1
* cell instance $2951 m0 *1 1426.32,1280.16
X$2951 22192 22472 22601 22700 22885 21858 gf180mcu_fd_sc_mcu9t5v0__aoi21_1
* cell instance $2952 m0 *1 1427.44,1270.08
X$2952 22473 22449 22577 22726 22193 gf180mcu_fd_sc_mcu9t5v0__xor2_1
* cell instance $2953 r0 *1 1424.64,1300.32
X$2953 24255 23623 23504 23340 gf180mcu_fd_sc_mcu9t5v0__buf_8
* cell instance $2954 m0 *1 1388.8,1300.32
X$2954 23025 22138 14872 23319 23504 23337 gf180mcu_fd_sc_mcu9t5v0__mux2_1
* cell instance $2955 m0 *1 1426.32,1260
X$2955 22139 22192 22193 22124 22295 21893 gf180mcu_fd_sc_mcu9t5v0__and3_1
* cell instance $2956 m0 *1 1392.16,1310.4
X$2956 23705 23807 17977 23623 23797 23806 gf180mcu_fd_sc_mcu9t5v0__mux2_1
* cell instance $2957 m0 *1 1400.56,1290.24
X$2957 23181 23038 23200 22138 gf180mcu_fd_sc_mcu9t5v0__buf_8
* cell instance $2958 m0 *1 1397.2,1260
X$2958 22138 22191 22124 22295 18275 gf180mcu_fd_sc_mcu9t5v0__xnor2_1
* cell instance $2959 r0 *1 1414.56,1249.92
X$2959 22139 22140 22124 21997 21891 gf180mcu_fd_sc_mcu9t5v0__nor2_1
* cell instance $2960 m0 *1 1403.36,1270.08
X$2960 21606 22600 22449 22577 22599 gf180mcu_fd_sc_mcu9t5v0__or2_1
* cell instance $2961 m0 *1 1417.92,1249.92
X$2961 21257 22019 22471 21884 21997 21555 gf180mcu_fd_sc_mcu9t5v0__mux2_1
* cell instance $2962 r0 *1 1398.32,1270.08
X$2962 22725 22599 22700 22577 22598 gf180mcu_fd_sc_mcu9t5v0__and2_1
* cell instance $2963 m0 *1 1382.08,1270.08
X$2963 16021 12632 22449 22577 22597 gf180mcu_fd_sc_mcu9t5v0__nand2_1
* cell instance $2964 r0 *1 1450.4,1270.08
X$2964 22138 22903 22727 22700 22577 22474 gf180mcu_fd_sc_mcu9t5v0__nor3_1
* cell instance $2965 m0 *1 1485.68,1260
X$2965 21737 22195 18277 22124 22295 22141 gf180mcu_fd_sc_mcu9t5v0__mux2_1
* cell instance $2966 m0 *1 1456.56,1310.4
X$2966 24310 23653 23519 14696 23623 23797 gf180mcu_fd_sc_mcu9t5v0__dffrnq_2
* cell instance $2967 r0 *1 1471.12,1280.16
X$2967 23342 22726 14872 23038 22885 22860 gf180mcu_fd_sc_mcu9t5v0__mux2_1
* cell instance $2968 r0 *1 1495.76,1270.08
X$2968 20715 22700 22577 15890 gf180mcu_fd_sc_mcu9t5v0__buf_8
* cell instance $2969 m0 *1 1468.32,1300.32
X$2969 23519 23342 17977 23319 23504 23341 gf180mcu_fd_sc_mcu9t5v0__mux2_1
* cell instance $2970 m0 *1 1472.24,1260
X$2970 22194 22310 22124 22295 22313 gf180mcu_fd_sc_mcu9t5v0__nand2_1
* cell instance $2971 m0 *1 1500.24,1300.32
X$2971 22728 23343 23344 14696 23319 23504 gf180mcu_fd_sc_mcu9t5v0__dffrnq_2
* cell instance $2972 r0 *1 1482.88,1249.92
X$2972 19587 22141 21737 14696 22124 21997 gf180mcu_fd_sc_mcu9t5v0__dffrnq_2
* cell instance $2973 m0 *1 1514.8,1280.16
X$2973 20397 22862 22700 22885 22863 gf180mcu_fd_sc_mcu9t5v0__nand2_1
* cell instance $2974 m0 *1 1467.76,1280.16
X$2974 22728 22860 22726 14696 22700 22885 gf180mcu_fd_sc_mcu9t5v0__dffrnq_2
* cell instance $2975 r0 *1 1462.72,1290.24
X$2975 24310 23341 23342 14696 23319 23200 gf180mcu_fd_sc_mcu9t5v0__dffrnq_2
* cell instance $2976 r0 *1 1498.56,1260
X$2976 22429 20092 14872 22449 22295 22475 gf180mcu_fd_sc_mcu9t5v0__mux2_1
* cell instance $2977 m0 *1 1482.32,1290.24
X$2977 22728 23216 20226 14696 23038 23200 gf180mcu_fd_sc_mcu9t5v0__dffrnq_2
* cell instance $2978 r0 *1 1460.48,1300.32
X$2978 23519 23518 18277 23623 23504 23653 gf180mcu_fd_sc_mcu9t5v0__mux2_1
* cell instance $2979 m0 *1 1477.28,1310.4
X$2979 24310 23654 13705 14696 23623 23797 gf180mcu_fd_sc_mcu9t5v0__dffrnq_2
* cell instance $2980 m0 *1 1457.68,1270.08
X$2980 22473 21858 22474 22449 22577 22602 gf180mcu_fd_sc_mcu9t5v0__nor3_1
* cell instance $2981 r0 *1 1480.08,1300.32
X$2981 24313 13705 14872 23623 23504 23654 gf180mcu_fd_sc_mcu9t5v0__mux2_1
* cell instance $2982 r0 *1 1461.04,1260
X$2982 22428 22427 22602 22449 22295 21387 gf180mcu_fd_sc_mcu9t5v0__aoi21_1
* cell instance $2983 m0 *1 1489.6,1270.08
X$2983 19587 22475 20092 14696 22449 22577 gf180mcu_fd_sc_mcu9t5v0__dffrnq_2
* cell instance $2984 r0 *1 1454.32,1260
X$2984 22428 22427 22449 22295 13846 gf180mcu_fd_sc_mcu9t5v0__xnor2_1
* cell instance $2985 r0 *1 1505.84,1290.24
X$2985 23344 21395 20719 23319 23200 23343 gf180mcu_fd_sc_mcu9t5v0__mux2_1
* cell instance $2986 m0 *1 1478.4,1260
X$2986 22195 19292 22124 22295 22194 gf180mcu_fd_sc_mcu9t5v0__nand2_1
* cell instance $2987 r0 *1 1456.56,1249.92
X$2987 22020 22019 22124 21997 21736 gf180mcu_fd_sc_mcu9t5v0__nor2_1
* cell instance $2988 m0 *1 1509.76,1280.16
X$2988 22862 22861 22863 22700 22885 22904 gf180mcu_fd_sc_mcu9t5v0__oai21_1
* cell instance $2989 r0 *1 1489.6,1290.24
X$2989 23217 20226 14872 23319 23200 23216 gf180mcu_fd_sc_mcu9t5v0__mux2_1
* cell instance $2990 r0 *1 1452.08,1249.92
X$2990 22020 22019 22124 21997 21895 gf180mcu_fd_sc_mcu9t5v0__or2_1
* cell instance $2991 m0 *1 1452.08,1290.24
X$2991 22726 22019 23038 23200 22727 gf180mcu_fd_sc_mcu9t5v0__xnor2_1
* cell instance $2992 r0 *1 1470,1260
X$2992 19587 22313 22195 14696 22449 22295 gf180mcu_fd_sc_mcu9t5v0__dffrnq_2
* cell instance $2993 m0 *1 1455.44,1280.16
X$2993 22138 22903 22727 22700 22885 21894 gf180mcu_fd_sc_mcu9t5v0__oai21_1
* cell instance $2994 m0 *1 1460.48,1249.92
X$2994 21607 21884 21997 21608 gf180mcu_fd_sc_mcu9t5v0__clkinv_1
* cell instance $2995 m0 *1 1455.44,1249.92
X$2995 21895 21894 21608 21884 21997 20530 gf180mcu_fd_sc_mcu9t5v0__aoi21_1
* cell instance $2996 m0 *1 1417.36,1179.36
X$2996 19428 19729 19901 19882 20048 gf180mcu_fd_sc_mcu9t5v0__xor2_1
* cell instance $2997 m0 *1 1384.88,1179.36
X$2997 18000 19748 19749 13180 19729 19901 gf180mcu_fd_sc_mcu9t5v0__dffrnq_2
* cell instance $2998 r0 *1 1449.84,1159.2
X$2998 14205 16540 19448 19282 19430 gf180mcu_fd_sc_mcu9t5v0__and2_1
* cell instance $2999 m0 *1 1449.84,1118.88
X$2999 18002 18118 17985 18104 16928 18003 gf180mcu_fd_sc_mcu9t5v0__xnor3_1
* cell instance $3000 r0 *1 1448.72,1169.28
X$3000 19605 19729 gf180mcu_fd_sc_mcu9t5v0__filltie
* cell instance $3001 r0 *1 1465.52,1169.28
X$3001 19587 19621 19431 14696 19729 19605 gf180mcu_fd_sc_mcu9t5v0__dffrnq_2
* cell instance $3002 m0 *1 1424.08,1179.36
X$3002 19750 19929 19729 19901 17724 gf180mcu_fd_sc_mcu9t5v0__and2_1
* cell instance $3003 r0 *1 1391.04,1169.28
X$3003 19745 19749 19910 19729 19605 19748 gf180mcu_fd_sc_mcu9t5v0__mux2_1
* cell instance $3004 r0 *1 1398.32,1169.28
X$3004 19620 18614 18412 12412 19729 19605 19586
+ gf180mcu_fd_sc_mcu9t5v0__aoi22_1
* cell instance $3005 r0 *1 1434.16,1169.28
X$3005 20346 19729 19605 14205 gf180mcu_fd_sc_mcu9t5v0__buf_8
* cell instance $3006 r0 *1 1422.96,1169.28
X$3006 19428 19882 19729 19605 19750 gf180mcu_fd_sc_mcu9t5v0__nand2_1
* cell instance $3007 m0 *1 1454.32,1179.36
X$3007 20054 19883 20055 19729 19901 20101 gf180mcu_fd_sc_mcu9t5v0__and3_1
* cell instance $3008 m0 *1 1447.6,1229.76
X$3008 21384 21382 21385 21241 21412 19883 gf180mcu_fd_sc_mcu9t5v0__oai21_1
* cell instance $3009 m0 *1 1449.28,1189.44
X$3009 14685 20053 20101 20052 20028 20217 13486
+ gf180mcu_fd_sc_mcu9t5v0__oai31_1
* cell instance $3010 r0 *1 1475.6,1229.76
X$3010 19587 21434 13850 14696 21537 21412 gf180mcu_fd_sc_mcu9t5v0__dffrnq_2
* cell instance $3011 r0 *1 1481.2,1189.44
X$3011 19587 20235 14688 14696 20379 20217 gf180mcu_fd_sc_mcu9t5v0__dffrnq_2
* cell instance $3012 m0 *1 1487.92,1219.68
X$3012 20104 20964 20715 20936 21123 20965 gf180mcu_fd_sc_mcu9t5v0__mux2_1
* cell instance $3013 m0 *1 1458.8,1239.84
X$3013 21257 21607 21537 21719 21385 21609 gf180mcu_fd_sc_mcu9t5v0__xnor3_1
* cell instance $3014 m0 *1 1456,1239.84
X$3014 21609 21608 21537 21719 21557 gf180mcu_fd_sc_mcu9t5v0__nand2_1
* cell instance $3015 r0 *1 1500.24,1229.76
X$3015 19587 21435 21389 14696 21537 21412 gf180mcu_fd_sc_mcu9t5v0__dffrnq_2
* cell instance $3016 m0 *1 1495.2,1219.68
X$3016 20723 20936 21123 19587 gf180mcu_fd_sc_mcu9t5v0__clkbuf_8
* cell instance $3017 m0 *1 1496.32,1189.44
X$3017 19587 20057 20058 14696 20028 20217 gf180mcu_fd_sc_mcu9t5v0__dffrnq_2
* cell instance $3018 m0 *1 1477.84,1239.84
X$3018 19587 21610 21388 14696 21537 21719 gf180mcu_fd_sc_mcu9t5v0__dffrnq_2
* cell instance $3019 r0 *1 1495.2,1219.68
X$3019 19587 21241 21123 gf180mcu_fd_sc_mcu9t5v0__clkbuf_4
* cell instance $3020 r0 *1 1486.24,1209.6
X$3020 19587 20965 20104 14696 20936 20822 gf180mcu_fd_sc_mcu9t5v0__dffrnq_2
* cell instance $3021 m0 *1 1489.04,1189.44
X$3021 20104 14688 14872 20028 20217 20235 gf180mcu_fd_sc_mcu9t5v0__mux2_1
* cell instance $3022 r0 *1 1458.8,1229.76
X$3022 21257 21013 21557 21537 21412 20054 gf180mcu_fd_sc_mcu9t5v0__nand3_1
* cell instance $3023 m0 *1 1455.44,1199.52
X$3023 20396 20395 20394 20379 20507 19308 gf180mcu_fd_sc_mcu9t5v0__aoi21_1
* cell instance $3024 r0 *1 1473.36,1189.44
X$3024 20232 20357 19292 20379 20217 20103 gf180mcu_fd_sc_mcu9t5v0__mux2_1
* cell instance $3025 r0 *1 1478.96,1209.6
X$3025 20964 20357 18277 20936 20822 20717 gf180mcu_fd_sc_mcu9t5v0__mux2_1
* cell instance $3026 m0 *1 1462.72,1209.6
X$3026 20961 20637 20822 20716 gf180mcu_fd_sc_mcu9t5v0__clkinv_1
* cell instance $3027 m0 *1 1458.24,1209.6
X$3027 20529 20530 20716 20637 20822 20396 gf180mcu_fd_sc_mcu9t5v0__oai21_1
* cell instance $3028 m0 *1 1454.88,1209.6
X$3028 20529 20530 20637 20822 20670 gf180mcu_fd_sc_mcu9t5v0__nor2_1
* cell instance $3029 m0 *1 1506.4,1209.6
X$3029 20718 16688 20719 20637 20822 20838 gf180mcu_fd_sc_mcu9t5v0__mux2_1
* cell instance $3030 r0 *1 1499.68,1179.36
X$3030 19928 20058 19292 20028 19901 20057 gf180mcu_fd_sc_mcu9t5v0__mux2_1
* cell instance $3031 m0 *1 1506.4,1229.76
X$3031 21389 16935 20719 21241 21412 21435 gf180mcu_fd_sc_mcu9t5v0__mux2_1
* cell instance $3032 r0 *1 1454.88,1199.52
X$3032 20394 20961 20637 20507 20055 20670 gf180mcu_fd_sc_mcu9t5v0__xnor3_1
* cell instance $3033 r0 *1 1450.4,1179.36
X$3033 20054 19883 20055 20028 19901 20053 gf180mcu_fd_sc_mcu9t5v0__aoi21_1
* cell instance $3034 m0 *1 1482.32,1229.76
X$3034 21388 13850 14872 21241 21412 21434 gf180mcu_fd_sc_mcu9t5v0__mux2_1
* cell instance $3035 m0 *1 1457.68,1229.76
X$3035 21257 20530 21386 21385 21387 21241 21412 20056
+ gf180mcu_fd_sc_mcu9t5v0__oai32_1
* cell instance $3036 m0 *1 1459.92,1199.52
X$3036 20396 20395 20391 20379 20507 20102 gf180mcu_fd_sc_mcu9t5v0__aoi21_1
* cell instance $3037 m0 *1 1468.88,1189.44
X$3037 19587 20103 20357 14696 20028 20217 gf180mcu_fd_sc_mcu9t5v0__dffrnq_2
* cell instance $3038 m0 *1 1458.8,1189.44
X$3038 20055 20056 20102 20028 20217 18857 gf180mcu_fd_sc_mcu9t5v0__aoi21_1
* cell instance $3039 m0 *1 1473.92,1209.6
X$3039 19587 20717 20964 14696 20637 20822 gf180mcu_fd_sc_mcu9t5v0__dffrnq_2
* cell instance $3040 r0 *1 1454.88,1179.36
X$3040 20055 20056 20028 19901 14430 gf180mcu_fd_sc_mcu9t5v0__xnor2_1
* cell instance $3041 r0 *1 1458.8,1219.68
X$3041 21385 21387 21241 21123 14686 gf180mcu_fd_sc_mcu9t5v0__xnor2_1
* cell instance $3042 m0 *1 1453.76,1219.68
X$3042 20963 20962 21013 20961 20936 21123 20395
+ gf180mcu_fd_sc_mcu9t5v0__oai211_1
* cell instance $3043 r0 *1 1384.88,1179.36
X$3043 22858 20028 19901 18000 gf180mcu_fd_sc_mcu9t5v0__clkbuf_8
* cell instance $3044 r0 *1 1442.56,1229.76
X$3044 21384 21382 21537 21412 21383 gf180mcu_fd_sc_mcu9t5v0__nor2_1
* cell instance $3045 r0 *1 1426.88,1219.68
X$3045 14685 21256 21380 21255 21241 21123 18163
+ gf180mcu_fd_sc_mcu9t5v0__oai22_1
* cell instance $3046 m0 *1 1423.52,1209.6
X$3046 20391 20962 20346 20637 20822 20390 gf180mcu_fd_sc_mcu9t5v0__mux2_1
* cell instance $3047 r0 *1 1415.68,1229.76
X$3047 21556 21555 21537 21412 21377 gf180mcu_fd_sc_mcu9t5v0__nand2_1
* cell instance $3048 m0 *1 1425.76,1199.52
X$3048 20391 20234 20379 20507 20392 gf180mcu_fd_sc_mcu9t5v0__nand2_1
* cell instance $3049 m0 *1 1427.44,1229.76
X$3049 21381 21379 21378 21241 21412 21254 gf180mcu_fd_sc_mcu9t5v0__oai21_1
* cell instance $3050 r0 *1 1418.48,1229.76
X$3050 21556 21537 21412 20963 gf180mcu_fd_sc_mcu9t5v0__clkinv_1
* cell instance $3051 m0 *1 1385.44,1229.76
X$3051 22168 21432 19910 21241 21412 21431 gf180mcu_fd_sc_mcu9t5v0__mux2_1
* cell instance $3052 m0 *1 1412.88,1189.44
X$3052 20049 20099 20100 20028 20217 20050 gf180mcu_fd_sc_mcu9t5v0__oai21_1
* cell instance $3053 r0 *1 1408.96,1229.76
X$3053 20963 21555 21537 21412 21433 gf180mcu_fd_sc_mcu9t5v0__xnor2_1
* cell instance $3054 m0 *1 1405.04,1239.84
X$3054 21606 21605 21433 21537 21719 21376 gf180mcu_fd_sc_mcu9t5v0__oai21_1
* cell instance $3055 r0 *1 1417.36,1209.6
X$3055 20667 20668 20936 20822 20961 gf180mcu_fd_sc_mcu9t5v0__xnor2_1
* cell instance $3056 m0 *1 1428.56,1199.52
X$3056 20356 20393 20392 20379 20507 19429 gf180mcu_fd_sc_mcu9t5v0__oai21_1
* cell instance $3057 r0 *1 1428.56,1179.36
X$3057 18975 20668 20346 20028 19901 19882 gf180mcu_fd_sc_mcu9t5v0__mux2_1
* cell instance $3058 r0 *1 1435.28,1199.52
X$3058 20234 20668 20637 20507 20669 gf180mcu_fd_sc_mcu9t5v0__nor2_1
* cell instance $3059 r0 *1 1445.36,1209.6
X$3059 20963 20962 20936 20822 20529 gf180mcu_fd_sc_mcu9t5v0__nor2_1
* cell instance $3060 r0 *1 1431.36,1189.44
X$3060 20391 20234 20379 20217 20356 gf180mcu_fd_sc_mcu9t5v0__nor2_1
* cell instance $3061 r0 *1 1439.2,1199.52
X$3061 20391 20637 20507 20394 gf180mcu_fd_sc_mcu9t5v0__clkinv_1
* cell instance $3062 m0 *1 1433.04,1199.52
X$3062 20394 20393 20379 20507 20051 20234 gf180mcu_fd_sc_mcu9t5v0__xnor3_1
* cell instance $3063 r0 *1 1385.44,1189.44
X$3063 18000 20233 19458 13180 20379 20217 gf180mcu_fd_sc_mcu9t5v0__dffrnq_2
* cell instance $3064 r0 *1 1432.48,1199.52
X$3064 20234 20668 20637 20507 20528 gf180mcu_fd_sc_mcu9t5v0__nand2_1
* cell instance $3065 r0 *1 1441.44,1199.52
X$3065 20669 20529 20530 20528 20637 20507 18456
+ gf180mcu_fd_sc_mcu9t5v0__oai31_1
* cell instance $3066 m0 *1 1433.6,1239.84
X$3066 21556 20962 21537 21719 21607 gf180mcu_fd_sc_mcu9t5v0__xnor2_1
* cell instance $3067 r0 *1 1448.72,1199.52
X$3067 20507 20637 gf180mcu_fd_sc_mcu9t5v0__filltie
* cell instance $3068 r0 *1 1423.52,1229.76
X$3068 21556 21257 21537 21412 21378 gf180mcu_fd_sc_mcu9t5v0__xnor2_1
* cell instance $3069 r0 *1 1397.76,1209.6
X$3069 18000 20837 20667 13180 20936 20822 gf180mcu_fd_sc_mcu9t5v0__dffrnq_2
* cell instance $3070 r0 *1 1411.2,1179.36
X$3070 20048 20050 20028 19901 15036 gf180mcu_fd_sc_mcu9t5v0__xnor2_1
* cell instance $3071 r0 *1 1448.72,1209.6
X$3071 20822 20936 gf180mcu_fd_sc_mcu9t5v0__filltie
* cell instance $3072 r0 *1 1448.72,1219.68
X$3072 21123 21241 gf180mcu_fd_sc_mcu9t5v0__filltie
* cell instance $3073 r0 *1 1445.36,1179.36
X$3073 14685 20051 20028 19901 20052 gf180mcu_fd_sc_mcu9t5v0__nand2_1
* cell instance $3074 m0 *1 1409.52,1229.76
X$3074 21377 21376 21241 21412 20099 gf180mcu_fd_sc_mcu9t5v0__nand2_1
* cell instance $3075 m0 *1 1440.88,1229.76
X$3075 21383 21241 21412 21385 21256 gf180mcu_fd_sc_mcu9t5v0__xor2_1
* cell instance $3076 r0 *1 1448.72,1179.36
X$3076 19901 20028 gf180mcu_fd_sc_mcu9t5v0__filltie
* cell instance $3077 r0 *1 1448.72,1189.44
X$3077 20217 20379 gf180mcu_fd_sc_mcu9t5v0__filltie
* cell instance $3078 r0 *1 1416.8,1199.52
X$3078 20667 20637 20507 20234 gf180mcu_fd_sc_mcu9t5v0__clkinv_1
* cell instance $3079 r0 *1 1412.88,1189.44
X$3079 20667 20390 20379 20217 20100 gf180mcu_fd_sc_mcu9t5v0__or2_1
* cell instance $3080 m0 *1 1381.52,1219.68
X$3080 18000 20959 20960 13180 20936 21123 gf180mcu_fd_sc_mcu9t5v0__dffrnq_2
* cell instance $3081 r0 *1 1412.32,1199.52
X$3081 20667 20390 20637 20507 20049 gf180mcu_fd_sc_mcu9t5v0__and2_1
* cell instance $3082 r0 *1 1432.48,1219.68
X$3082 20963 21257 21254 21241 21123 20393 gf180mcu_fd_sc_mcu9t5v0__oai21_1
* cell instance $3083 r0 *1 1417.92,1179.36
X$3083 20049 20099 20100 20048 20028 19901 19929
+ gf180mcu_fd_sc_mcu9t5v0__oai211_1
* cell instance $3084 m0 *1 1408.4,1199.52
X$3084 20234 20099 20379 20507 15417 20390 gf180mcu_fd_sc_mcu9t5v0__xnor3_1
* cell instance $3085 m0 *1 1401.12,1209.6
X$3085 20713 20667 14872 20637 20822 20837 gf180mcu_fd_sc_mcu9t5v0__mux2_1
* cell instance $3086 r0 *1 1448.72,1229.76
X$3086 21412 21537 gf180mcu_fd_sc_mcu9t5v0__filltie
* cell instance $3087 m0 *1 1401.68,1239.84
X$3087 21606 21605 21537 21719 21554 gf180mcu_fd_sc_mcu9t5v0__nor2_1
* cell instance $3088 r0 *1 1424.08,1219.68
X$3088 14685 21254 21241 21123 21255 gf180mcu_fd_sc_mcu9t5v0__nand2_1
* cell instance $3089 r0 *1 1402.24,1229.76
X$3089 21554 21537 21412 21433 17260 gf180mcu_fd_sc_mcu9t5v0__xor2_1
* cell instance $3090 m0 *1 1393.28,1229.76
X$3090 21432 21241 21412 19427 gf180mcu_fd_sc_mcu9t5v0__clkinv_1
* cell instance $3091 r0 *1 1388.24,1209.6
X$3091 22829 20960 19910 20936 20822 20959 gf180mcu_fd_sc_mcu9t5v0__mux2_1
* cell instance $3092 m0 *1 1391.04,1189.44
X$3092 22830 19458 19910 20028 20217 20233 gf180mcu_fd_sc_mcu9t5v0__mux2_1
* cell instance $3093 m0 *1 1422.96,1229.76
X$3093 21381 21379 21378 21241 21412 21380 gf180mcu_fd_sc_mcu9t5v0__nor3_1
* cell instance $3094 r0 *1 1395.52,1209.6
X$3094 20960 20936 20822 19620 gf180mcu_fd_sc_mcu9t5v0__clkinv_1
* cell instance $3095 m0 *1 1435.28,1118.88
X$3095 17968 17969 17985 18104 17972 gf180mcu_fd_sc_mcu9t5v0__nor2_1
* cell instance $3096 r0 *1 1408.96,1159.2
X$3096 19424 19428 14872 19448 19282 19459 gf180mcu_fd_sc_mcu9t5v0__mux2_1
* cell instance $3097 r0 *1 1448.72,1108.8
X$3097 17837 17985 gf180mcu_fd_sc_mcu9t5v0__filltie
* cell instance $3098 m0 *1 1430.8,1159.2
X$3098 19144 12632 19307 19182 19171 19282 19143
+ gf180mcu_fd_sc_mcu9t5v0__aoi22_1
* cell instance $3099 r0 *1 1435.84,1108.8
X$3099 17970 17724 17972 17725 17985 17837 17973
+ gf180mcu_fd_sc_mcu9t5v0__aoi211_1
* cell instance $3100 r0 *1 1448.72,1128.96
X$3100 18386 18553 gf180mcu_fd_sc_mcu9t5v0__filltie
* cell instance $3101 r0 *1 1434.72,1159.2
X$3101 19460 19429 19448 19282 19184 gf180mcu_fd_sc_mcu9t5v0__nand2_1
* cell instance $3102 r0 *1 1441.44,1139.04
X$3102 19428 18454 18841 18731 18746 gf180mcu_fd_sc_mcu9t5v0__nand2_1
* cell instance $3103 r0 *1 1444.24,1128.96
X$3103 18455 18456 18746 18553 18386 18118 gf180mcu_fd_sc_mcu9t5v0__oai21_1
* cell instance $3104 r0 *1 1448.72,1159.2
X$3104 19282 19448 gf180mcu_fd_sc_mcu9t5v0__filltie
* cell instance $3105 r0 *1 1433.04,1149.12
X$3105 13888 19171 18996 19144 gf180mcu_fd_sc_mcu9t5v0__clkinv_1
* cell instance $3106 m0 *1 1445.36,1149.12
X$3106 18975 18841 18996 18856 gf180mcu_fd_sc_mcu9t5v0__clkinv_1
* cell instance $3107 m0 *1 1436.4,1139.04
X$3107 19428 18456 18553 18731 18625 18164 gf180mcu_fd_sc_mcu9t5v0__xnor3_1
* cell instance $3108 r0 *1 1444.24,1139.04
X$3108 18856 18625 18841 18731 16682 gf180mcu_fd_sc_mcu9t5v0__or2_1
* cell instance $3109 r0 *1 1448.72,1139.04
X$3109 18731 18841 gf180mcu_fd_sc_mcu9t5v0__filltie
* cell instance $3110 r0 *1 1438.64,1118.88
X$3110 17262 18164 14205 18268 18104 17969 gf180mcu_fd_sc_mcu9t5v0__mux2_1
* cell instance $3111 r0 *1 1448.72,1118.88
X$3111 18104 18268 gf180mcu_fd_sc_mcu9t5v0__filltie
* cell instance $3112 m0 *1 1396.64,1139.04
X$3112 18623 18614 18412 12913 18553 18731 18624
+ gf180mcu_fd_sc_mcu9t5v0__aoi22_1
* cell instance $3113 r0 *1 1417.92,1128.96
X$3113 18855 18453 17977 18553 18386 18561 gf180mcu_fd_sc_mcu9t5v0__mux2_1
* cell instance $3114 m0 *1 1399.44,1149.12
X$3114 18000 18854 18855 13180 18841 18996 gf180mcu_fd_sc_mcu9t5v0__dffrnq_2
* cell instance $3115 r0 *1 1396.64,1128.96
X$3115 18560 18614 18412 13332 18553 18386 18162
+ gf180mcu_fd_sc_mcu9t5v0__aoi22_1
* cell instance $3116 m0 *1 1388.8,1159.2
X$3116 19457 19171 19282 18622 gf180mcu_fd_sc_mcu9t5v0__clkinv_1
* cell instance $3117 r0 *1 1392.16,1159.2
X$3117 19427 18614 18412 11467 19448 19282 19306
+ gf180mcu_fd_sc_mcu9t5v0__aoi22_1
* cell instance $3118 m0 *1 1391.04,1159.2
X$3118 19425 18614 18412 7100 19171 19282 19181 gf180mcu_fd_sc_mcu9t5v0__aoi22_1
* cell instance $3119 r0 *1 1417.92,1118.88
X$3119 13698 18163 13492 18268 18104 18117 gf180mcu_fd_sc_mcu9t5v0__mux2_1
* cell instance $3120 r0 *1 1401.68,1139.04
X$3120 18855 18741 18277 18841 18731 18854 gf180mcu_fd_sc_mcu9t5v0__mux2_1
* cell instance $3121 m0 *1 1393.28,1128.96
X$3121 18622 18614 18412 11736 18268 18386 18276
+ gf180mcu_fd_sc_mcu9t5v0__aoi22_1
* cell instance $3122 r0 *1 1397.2,1108.8
X$3122 14427 17967 17968 13180 17985 17837 gf180mcu_fd_sc_mcu9t5v0__dffrnq_2
* cell instance $3123 m0 *1 1397.2,1149.12
X$3123 19458 18841 18996 18623 gf180mcu_fd_sc_mcu9t5v0__clkinv_1
* cell instance $3124 r0 *1 1431.36,1108.8
X$3124 17970 17724 17972 17985 17837 17971 gf180mcu_fd_sc_mcu9t5v0__aoi21_1
* cell instance $3125 r0 *1 1428.56,1108.8
X$3125 17968 17969 17985 17837 17970 gf180mcu_fd_sc_mcu9t5v0__nand2_1
* cell instance $3126 r0 *1 1448.72,1149.12
X$3126 18996 19171 gf180mcu_fd_sc_mcu9t5v0__filltie
* cell instance $3127 m0 *1 1440.32,1159.2
X$3127 14205 19185 19171 19282 19183 gf180mcu_fd_sc_mcu9t5v0__nor2_1
* cell instance $3128 m0 *1 1400,1118.88
X$3128 18600 17968 14872 17985 18104 17967 gf180mcu_fd_sc_mcu9t5v0__mux2_1
* cell instance $3129 r0 *1 1438.64,1128.96
X$3129 18164 18553 18386 18454 gf180mcu_fd_sc_mcu9t5v0__clkinv_1
* cell instance $3130 r0 *1 1440.88,1128.96
X$3130 19428 18454 18553 18386 18455 gf180mcu_fd_sc_mcu9t5v0__nor2_1
* cell instance $3131 r0 *1 1437.52,1159.2
X$3131 19460 19429 19448 19282 19185 gf180mcu_fd_sc_mcu9t5v0__nor2_1
* cell instance $3132 m0 *1 1440.88,1149.12
X$3132 19428 18856 19185 18841 18996 17420 gf180mcu_fd_sc_mcu9t5v0__aoi21_1
* cell instance $3133 m0 *1 1435.84,1159.2
X$3133 19184 19183 12632 19171 19282 19182 gf180mcu_fd_sc_mcu9t5v0__aoi21_1
* cell instance $3134 m0 *1 1406.16,1169.28
X$3134 18000 19459 19428 13180 19448 19605 gf180mcu_fd_sc_mcu9t5v0__dffrnq_2
* cell instance $3135 m0 *1 1415.12,1139.04
X$3135 18000 18561 18453 13180 18553 18731 gf180mcu_fd_sc_mcu9t5v0__dffrnq_2
* cell instance $3136 m0 *1 1398.32,1169.28
X$3136 19749 19448 19605 18560 gf180mcu_fd_sc_mcu9t5v0__clkinv_1
* cell instance $3137 m0 *1 1435.28,1169.28
X$3137 19428 19448 19605 18975 19460 gf180mcu_fd_sc_mcu9t5v0__xor2_1
* cell instance $3138 m0 *1 1410.08,1118.88
X$3138 18000 18117 13698 13180 17985 18104 gf180mcu_fd_sc_mcu9t5v0__dffrnq_2
* cell instance $3139 r0 *1 1414,1149.12
X$3139 18000 19143 13888 13180 19171 18996 gf180mcu_fd_sc_mcu9t5v0__dffrnq_2
* cell instance $3140 r0 *1 1506.4,1118.88
X$3140 18162 18166 19292 18268 18104 18165 gf180mcu_fd_sc_mcu9t5v0__mux2_1
* cell instance $3141 m0 *1 1467.2,1118.88
X$3141 17266 18003 14205 17985 18104 17976 gf180mcu_fd_sc_mcu9t5v0__mux2_1
* cell instance $3142 m0 *1 1500.24,1149.12
X$3142 18414 18977 13707 14696 18841 18996 gf180mcu_fd_sc_mcu9t5v0__dffrnq_2
* cell instance $3143 m0 *1 1465.52,1128.96
X$3143 18453 17421 14872 18268 18386 18413 gf180mcu_fd_sc_mcu9t5v0__mux2_1
* cell instance $3144 r0 *1 1462.72,1128.96
X$3144 18414 18413 17421 14696 18553 18386 gf180mcu_fd_sc_mcu9t5v0__dffrnq_2
* cell instance $3145 m0 *1 1457.68,1139.04
X$3145 18975 18625 18553 18731 18626 gf180mcu_fd_sc_mcu9t5v0__or2_1
* cell instance $3146 m0 *1 1469.44,1149.12
X$3146 19181 19012 19292 18841 18996 19011 gf180mcu_fd_sc_mcu9t5v0__mux2_1
* cell instance $3147 m0 *1 1462.72,1118.88
X$3147 18002 18003 17985 18104 17975 gf180mcu_fd_sc_mcu9t5v0__nand2_1
* cell instance $3148 r0 *1 1456.56,1108.8
X$3148 17974 18118 17975 17985 17837 17726 gf180mcu_fd_sc_mcu9t5v0__oai21_1
* cell instance $3149 r0 *1 1463.28,1139.04
X$3149 18747 18857 18626 18841 18731 15714 gf180mcu_fd_sc_mcu9t5v0__oai21_1
* cell instance $3150 m0 *1 1482.32,1169.28
X$3150 19587 19461 19432 14696 19448 19605 gf180mcu_fd_sc_mcu9t5v0__dffrnq_2
* cell instance $3151 r0 *1 1456.56,1139.04
X$3151 18747 18857 18841 18731 13220 gf180mcu_fd_sc_mcu9t5v0__xnor2_1
* cell instance $3152 r0 *1 1454.32,1159.2
X$3152 19308 20053 18747 19430 19448 19282 19307
+ gf180mcu_fd_sc_mcu9t5v0__oai31_1
* cell instance $3153 m0 *1 1456,1149.12
X$3153 18975 18625 18841 18996 18747 gf180mcu_fd_sc_mcu9t5v0__xnor2_1
* cell instance $3154 r0 *1 1451.52,1108.8
X$3154 17968 17985 17837 18002 gf180mcu_fd_sc_mcu9t5v0__clkinv_1
* cell instance $3155 m0 *1 1468.88,1169.28
X$3155 19586 19431 19292 19448 19605 19621 gf180mcu_fd_sc_mcu9t5v0__mux2_1
* cell instance $3156 r0 *1 1465.52,1149.12
X$3156 18414 19011 19012 14696 19171 18996 gf180mcu_fd_sc_mcu9t5v0__dffrnq_2
* cell instance $3157 r0 *1 1464.4,1108.8
X$3157 17421 17976 17985 17837 17725 gf180mcu_fd_sc_mcu9t5v0__xnor2_1
* cell instance $3158 m0 *1 1454.88,1159.2
X$3158 19308 20053 18747 19171 19282 16540 gf180mcu_fd_sc_mcu9t5v0__oai21_1
* cell instance $3159 r0 *1 1483.44,1118.88
X$3159 18414 18119 17268 14696 18268 18104 gf180mcu_fd_sc_mcu9t5v0__dffrnq_2
* cell instance $3160 m0 *1 1489.04,1139.04
X$3160 19013 18457 17977 18553 18731 18627 gf180mcu_fd_sc_mcu9t5v0__mux2_1
* cell instance $3161 m0 *1 1480.08,1149.12
X$3161 18414 18976 19013 14696 18841 18996 gf180mcu_fd_sc_mcu9t5v0__dffrnq_2
* cell instance $3162 m0 *1 1489.04,1118.88
X$3162 18457 17268 14872 17985 18104 18119 gf180mcu_fd_sc_mcu9t5v0__mux2_1
* cell instance $3163 r0 *1 1481.76,1128.96
X$3163 18414 18627 18457 14696 18553 18386 gf180mcu_fd_sc_mcu9t5v0__dffrnq_2
* cell instance $3164 r0 *1 1484.56,1149.12
X$3164 19013 19012 18277 19171 18996 18976 gf180mcu_fd_sc_mcu9t5v0__mux2_1
* cell instance $3165 r0 *1 1471.12,1108.8
X$3165 17421 17976 17973 17985 17837 17727 gf180mcu_fd_sc_mcu9t5v0__aoi21_1
* cell instance $3166 r0 *1 1500.8,1159.2
X$3166 19432 19433 17977 19448 19282 19462 gf180mcu_fd_sc_mcu9t5v0__mux2_1
* cell instance $3167 r0 *1 1504.72,1139.04
X$3167 19433 13707 14872 18841 18731 18977 gf180mcu_fd_sc_mcu9t5v0__mux2_1
* cell instance $3168 r0 *1 1485.12,1159.2
X$3168 19432 19431 18277 19448 19282 19461 gf180mcu_fd_sc_mcu9t5v0__mux2_1
* cell instance $3169 r0 *1 1455.44,1118.88
X$3169 18002 18003 18268 18104 17974 gf180mcu_fd_sc_mcu9t5v0__nor2_1
* cell instance $3170 r0 *1 1612.24,1169.28
X$3170 19589 19753 19729 19605 19152 gf180mcu_fd_sc_mcu9t5v0__xnor2_1
* cell instance $3171 r0 *1 1541.12,1169.28
X$3171 18414 19623 15908 14696 19729 19605 gf180mcu_fd_sc_mcu9t5v0__dffrnq_2
* cell instance $3172 r0 *1 1570.24,1169.28
X$3172 19752 19624 19625 14696 19729 19605 gf180mcu_fd_sc_mcu9t5v0__dffrnq_2
* cell instance $3173 r0 *1 1528.24,1169.28
X$3173 19931 19622 17977 19729 19605 19751 gf180mcu_fd_sc_mcu9t5v0__mux2_1
* cell instance $3174 r0 *1 1597.68,1169.28
X$3174 16688 19885 18562 19729 19605 19884 gf180mcu_fd_sc_mcu9t5v0__mux2_1
* cell instance $3175 m0 *1 1588.16,1149.12
X$3175 19016 18841 18996 19017 gf180mcu_fd_sc_mcu9t5v0__clkinv_1
* cell instance $3176 r0 *1 1577.52,1118.88
X$3176 18414 18122 18123 14696 18268 18104 gf180mcu_fd_sc_mcu9t5v0__dffrnq_2
* cell instance $3177 r0 *1 1583.68,1149.12
X$3177 19149 18979 19015 19017 19171 18996 18631
+ gf180mcu_fd_sc_mcu9t5v0__oai211_1
* cell instance $3178 m0 *1 1587.6,1159.2
X$3178 19150 19151 19171 19282 19016 gf180mcu_fd_sc_mcu9t5v0__xnor2_1
* cell instance $3179 m0 *1 1581.44,1118.88
X$3179 18460 18123 17977 17985 18104 18122 gf180mcu_fd_sc_mcu9t5v0__mux2_1
* cell instance $3180 m0 *1 1586.48,1139.04
X$3180 18631 19148 18553 18731 16545 gf180mcu_fd_sc_mcu9t5v0__nand2_1
* cell instance $3181 r0 *1 1618.96,1169.28
X$3181 19590 19729 19605 19626 19588 gf180mcu_fd_sc_mcu9t5v0__xor2_1
* cell instance $3182 m0 *1 1568.56,1179.36
X$3182 19901 19729 gf180mcu_fd_sc_mcu9t5v0__filltie
* cell instance $3183 m0 *1 1591.52,1179.36
X$3183 19752 19884 19885 14696 19729 19901 gf180mcu_fd_sc_mcu9t5v0__dffrnq_2
* cell instance $3184 m0 *1 1617.28,1179.36
X$3184 18980 19885 19729 19901 19932 gf180mcu_fd_sc_mcu9t5v0__nand2_1
* cell instance $3185 r0 *1 1572.48,1219.68
X$3185 19752 21144 19877 14696 21241 21123 gf180mcu_fd_sc_mcu9t5v0__dffrnq_2
* cell instance $3186 m0 *1 1610.56,1179.36
X$3186 18980 19885 19729 19901 19589 gf180mcu_fd_sc_mcu9t5v0__xnor2_1
* cell instance $3187 m0 *1 1524.32,1179.36
X$3187 18414 19751 19622 14696 19729 19901 gf180mcu_fd_sc_mcu9t5v0__dffrnq_2
* cell instance $3188 r0 *1 1630.16,1169.28
X$3188 18980 19465 19729 19605 19754 gf180mcu_fd_sc_mcu9t5v0__nand2_1
* cell instance $3189 r0 *1 1625.68,1169.28
X$3189 19590 19626 19754 19729 19605 19753 gf180mcu_fd_sc_mcu9t5v0__oai21_1
* cell instance $3190 m0 *1 1624,1179.36
X$3190 19886 19591 19933 19729 19901 18982 gf180mcu_fd_sc_mcu9t5v0__aoi21_1
* cell instance $3191 m0 *1 1635.2,1239.84
X$3191 21618 21261 22434 21537 21719 21740 gf180mcu_fd_sc_mcu9t5v0__mux2_1
* cell instance $3192 m0 *1 1621.2,1239.84
X$3192 21617 21616 21561 21537 21719 21021 gf180mcu_fd_sc_mcu9t5v0__oai21_1
* cell instance $3193 r0 *1 1618.4,1209.6
X$3193 20538 17977 20936 20822 20966 gf180mcu_fd_sc_mcu9t5v0__nand2_1
* cell instance $3194 r0 *1 1622.32,1219.68
X$3194 21021 20840 21241 21123 21022 gf180mcu_fd_sc_mcu9t5v0__nor2_1
* cell instance $3195 r0 *1 1621.2,1209.6
X$3195 15890 20540 20936 20822 20967 gf180mcu_fd_sc_mcu9t5v0__nand2_1
* cell instance $3196 r0 *1 1622.32,1199.52
X$3196 20540 20401 20637 20507 19886 gf180mcu_fd_sc_mcu9t5v0__nor2_1
* cell instance $3197 r0 *1 1589.28,1199.52
X$3197 19752 20672 18632 14696 20637 20507 gf180mcu_fd_sc_mcu9t5v0__dffrnq_2
* cell instance $3198 r0 *1 1591.52,1219.68
X$3198 19752 21145 18416 14696 21241 21123 gf180mcu_fd_sc_mcu9t5v0__dffrnq_2
* cell instance $3199 r0 *1 1619.52,1199.52
X$3199 20541 20540 20637 20507 20400 gf180mcu_fd_sc_mcu9t5v0__nand2_1
* cell instance $3200 m0 *1 1592.08,1209.6
X$3200 18632 20535 20537 20637 20822 20672 gf180mcu_fd_sc_mcu9t5v0__mux2_1
* cell instance $3201 r0 *1 1602.72,1189.44
X$3201 20360 20361 15890 20379 20217 20399 gf180mcu_fd_sc_mcu9t5v0__mux2_1
* cell instance $3202 m0 *1 1592.64,1219.68
X$3202 18416 21018 20537 20936 21123 21145 gf180mcu_fd_sc_mcu9t5v0__mux2_1
* cell instance $3203 m0 *1 1604.96,1209.6
X$3203 20723 20637 20822 19752 gf180mcu_fd_sc_mcu9t5v0__clkbuf_8
* cell instance $3204 m0 *1 1604.4,1219.68
X$3204 19752 21020 20538 14696 20936 21123 gf180mcu_fd_sc_mcu9t5v0__dffrnq_2
* cell instance $3205 m0 *1 1600.48,1209.6
X$3205 19752 20637 20822 gf180mcu_fd_sc_mcu9t5v0__inv_3
* cell instance $3206 m0 *1 1594.32,1199.52
X$3206 19752 20399 20360 14696 20379 20507 gf180mcu_fd_sc_mcu9t5v0__dffrnq_2
* cell instance $3207 r0 *1 1619.52,1229.76
X$3207 21869 21615 21537 21412 21561 gf180mcu_fd_sc_mcu9t5v0__nand2_1
* cell instance $3208 m0 *1 1612.8,1239.84
X$3208 20111 21615 18562 21537 21719 21739 gf180mcu_fd_sc_mcu9t5v0__mux2_1
* cell instance $3209 r0 *1 1621.76,1189.44
X$3209 18980 20110 20362 19886 20379 20217 19626
+ gf180mcu_fd_sc_mcu9t5v0__aoi211_1
* cell instance $3210 r0 *1 1636.32,1189.44
X$3210 18172 20236 20110 14696 20379 20217 gf180mcu_fd_sc_mcu9t5v0__dffrnq_2
* cell instance $3211 m0 *1 1627.92,1219.68
X$3211 21021 20840 20936 21123 20540 gf180mcu_fd_sc_mcu9t5v0__nand2_1
* cell instance $3212 m0 *1 1640.24,1189.44
X$3212 17553 20110 18562 20028 20217 20236 gf180mcu_fd_sc_mcu9t5v0__mux2_1
* cell instance $3213 m0 *1 1624,1199.52
X$3213 18980 20110 20379 20507 20401 gf180mcu_fd_sc_mcu9t5v0__xnor2_1
* cell instance $3214 m0 *1 1623.44,1219.68
X$3214 21022 20967 20966 20936 21123 21020 gf180mcu_fd_sc_mcu9t5v0__oai21_1
* cell instance $3215 m0 *1 1646.96,1199.52
X$3215 17266 20379 20507 17107 gf180mcu_fd_sc_mcu9t5v0__clkinv_1
* cell instance $3216 r0 *1 1645.28,1219.68
X$3216 17107 14872 21147 21260 21241 21123 21146
+ gf180mcu_fd_sc_mcu9t5v0__aoi22_1
* cell instance $3217 r0 *1 1624,1209.6
X$3217 20362 20968 20936 20822 20840 gf180mcu_fd_sc_mcu9t5v0__nor2_1
* cell instance $3218 r0 *1 1635.76,1199.52
X$3218 18125 20542 18562 20637 20507 20673 gf180mcu_fd_sc_mcu9t5v0__mux2_1
* cell instance $3219 m0 *1 1625.68,1189.44
X$3219 18980 20110 20028 20217 20061 gf180mcu_fd_sc_mcu9t5v0__nand2_1
* cell instance $3220 r0 *1 1625.68,1199.52
X$3220 18980 20542 20637 20507 20541 gf180mcu_fd_sc_mcu9t5v0__nand2_1
* cell instance $3221 m0 *1 1630.72,1199.52
X$3221 20541 20379 20507 20362 gf180mcu_fd_sc_mcu9t5v0__clkinv_1
* cell instance $3222 m0 *1 1617.28,1199.52
X$3222 20401 20400 20379 20507 20361 gf180mcu_fd_sc_mcu9t5v0__xnor2_1
* cell instance $3223 r0 *1 1627.36,1209.6
X$3223 18980 20542 20936 20822 20968 gf180mcu_fd_sc_mcu9t5v0__nor2_1
* cell instance $3224 r0 *1 1622.88,1179.36
X$3224 20541 20061 19754 19932 20028 19901 19933
+ gf180mcu_fd_sc_mcu9t5v0__nand4_1
* cell instance $3225 m0 *1 1631.84,1209.6
X$3225 19752 20673 20542 14696 20637 20822 gf180mcu_fd_sc_mcu9t5v0__dffrnq_2
* cell instance $3226 r0 *1 1650.32,1219.68
X$3226 21262 21394 21241 21123 21147 gf180mcu_fd_sc_mcu9t5v0__or2_1
* cell instance $3227 m0 *1 1648.64,1229.76
X$3227 21262 21394 14872 21241 21412 21260 gf180mcu_fd_sc_mcu9t5v0__aoi21_1
* cell instance $3228 m0 *1 1574.72,1219.68
X$3228 20230 14872 21143 21019 20936 21123 21144
+ gf180mcu_fd_sc_mcu9t5v0__aoi22_1
* cell instance $3229 m0 *1 1568.56,1219.68
X$3229 21123 20936 gf180mcu_fd_sc_mcu9t5v0__filltie
* cell instance $3230 m0 *1 1537.2,1219.68
X$3230 21014 20936 21123 21015 20722 gf180mcu_fd_sc_mcu9t5v0__xor2_1
* cell instance $3231 m0 *1 1568.56,1229.76
X$3231 21412 21241 gf180mcu_fd_sc_mcu9t5v0__filltie
* cell instance $3232 r0 *1 1579.76,1179.36
X$3232 20108 20109 20028 19901 20060 gf180mcu_fd_sc_mcu9t5v0__nor2_1
* cell instance $3233 m0 *1 1533.28,1199.52
X$3233 20397 20720 20533 20379 20507 20534 gf180mcu_fd_sc_mcu9t5v0__and3_1
* cell instance $3234 m0 *1 1546.72,1229.76
X$3234 20537 21259 21241 21412 21437 gf180mcu_fd_sc_mcu9t5v0__nand2_1
* cell instance $3235 m0 *1 1533.84,1209.6
X$3235 20397 20720 20533 20637 20822 20721 gf180mcu_fd_sc_mcu9t5v0__nor3_1
* cell instance $3236 r0 *1 1557.36,1179.36
X$3236 20059 20046 14872 20028 19901 20105 gf180mcu_fd_sc_mcu9t5v0__mux2_1
* cell instance $3237 r0 *1 1550.64,1209.6
X$3237 19587 20839 19151 14696 20936 20822 gf180mcu_fd_sc_mcu9t5v0__dffrnq_2
* cell instance $3238 r0 *1 1522.08,1229.76
X$3238 20397 21537 21412 21389 21390 gf180mcu_fd_sc_mcu9t5v0__xor2_1
* cell instance $3239 m0 *1 1531.04,1229.76
X$3239 21391 21014 21390 21241 21412 21142 gf180mcu_fd_sc_mcu9t5v0__nand3_1
* cell instance $3240 m0 *1 1580.32,1239.84
X$3240 21438 21612 21560 21537 21719 21393 gf180mcu_fd_sc_mcu9t5v0__aoi21_1
* cell instance $3241 r0 *1 1527.12,1219.68
X$3241 21258 21140 21142 21141 21241 21123 20533 gf180mcu_fd_sc_mcu9t5v0__and4_1
* cell instance $3242 m0 *1 1580.32,1189.44
X$3242 20107 20060 20028 20217 17605 gf180mcu_fd_sc_mcu9t5v0__xnor2_1
* cell instance $3243 m0 *1 1573.6,1239.84
X$3243 21614 21613 21537 21719 20059 gf180mcu_fd_sc_mcu9t5v0__xnor2_1
* cell instance $3244 r0 *1 1533.28,1229.76
X$3244 21141 21537 21412 21558 gf180mcu_fd_sc_mcu9t5v0__clkinv_1
* cell instance $3245 m0 *1 1548.4,1199.52
X$3245 20359 20536 20537 20379 20507 20358 gf180mcu_fd_sc_mcu9t5v0__mux2_1
* cell instance $3246 m0 *1 1538.32,1209.6
X$3246 20534 20721 20637 20822 21016 gf180mcu_fd_sc_mcu9t5v0__nor2_1
* cell instance $3247 m0 *1 1543.92,1219.68
X$3247 21017 21016 20936 21123 21018 gf180mcu_fd_sc_mcu9t5v0__xnor2_1
* cell instance $3248 r0 *1 1568.56,1199.52
X$3248 20538 20539 20637 20507 19434 20398 gf180mcu_fd_sc_mcu9t5v0__xnor3_1
* cell instance $3249 m0 *1 1568.56,1189.44
X$3249 20217 20028 gf180mcu_fd_sc_mcu9t5v0__filltie
* cell instance $3250 r0 *1 1531.04,1199.52
X$3250 20397 20533 20637 20507 20535 20532 gf180mcu_fd_sc_mcu9t5v0__xnor3_1
* cell instance $3251 r0 *1 1581.44,1199.52
X$3251 20671 20539 20637 20507 20109 gf180mcu_fd_sc_mcu9t5v0__and2_1
* cell instance $3252 r0 *1 1574.16,1189.44
X$3252 20360 20359 20379 20217 20106 gf180mcu_fd_sc_mcu9t5v0__nand2_1
* cell instance $3253 m0 *1 1574.72,1189.44
X$3253 20107 20108 20109 20106 20028 20217 18979
+ gf180mcu_fd_sc_mcu9t5v0__oai31_1
* cell instance $3254 r0 *1 1537.2,1229.76
X$3254 21391 21390 21558 21537 21412 21436 gf180mcu_fd_sc_mcu9t5v0__nor3_1
* cell instance $3255 m0 *1 1568.56,1239.84
X$3255 21719 21537 gf180mcu_fd_sc_mcu9t5v0__filltie
* cell instance $3256 m0 *1 1570.8,1239.84
X$3256 21612 21611 21537 21719 21613 gf180mcu_fd_sc_mcu9t5v0__nand2_1
* cell instance $3257 r0 *1 1576.96,1189.44
X$3257 20360 20359 20379 20217 20107 gf180mcu_fd_sc_mcu9t5v0__xnor2_1
* cell instance $3258 r0 *1 1546.16,1189.44
X$3258 19752 20358 20359 14696 20379 20217 gf180mcu_fd_sc_mcu9t5v0__dffrnq_2
* cell instance $3259 m0 *1 1547.84,1189.44
X$3259 19752 20105 20046 14696 20028 20217 gf180mcu_fd_sc_mcu9t5v0__dffrnq_2
* cell instance $3260 r0 *1 1558.48,1229.76
X$3260 21864 19435 21537 21412 21559 gf180mcu_fd_sc_mcu9t5v0__nand2_1
* cell instance $3261 m0 *1 1549.52,1229.76
X$3261 22728 21392 19435 14696 21241 21412 gf180mcu_fd_sc_mcu9t5v0__dffrnq_2
* cell instance $3262 m0 *1 1554,1209.6
X$3262 19151 20722 20537 20637 20822 20839 gf180mcu_fd_sc_mcu9t5v0__mux2_1
* cell instance $3263 m0 *1 1536.08,1229.76
X$3263 21391 21558 21390 21241 21412 21259 gf180mcu_fd_sc_mcu9t5v0__oai21_1
* cell instance $3264 m0 *1 1576.4,1199.52
X$3264 20538 20398 20379 20507 20108 gf180mcu_fd_sc_mcu9t5v0__nor2_1
* cell instance $3265 m0 *1 1572.48,1219.68
X$3265 19877 20936 21123 20230 gf180mcu_fd_sc_mcu9t5v0__clkinv_1
* cell instance $3266 m0 *1 1574.72,1209.6
X$3266 20538 20398 20637 20822 20671 gf180mcu_fd_sc_mcu9t5v0__nand2_1
* cell instance $3267 m0 *1 1568.56,1199.52
X$3267 20507 20379 gf180mcu_fd_sc_mcu9t5v0__filltie
* cell instance $3268 m0 *1 1568.56,1209.6
X$3268 20822 20637 gf180mcu_fd_sc_mcu9t5v0__filltie
* cell instance $3269 r0 *1 1536.08,1219.68
X$3269 21140 21259 21241 21123 21015 gf180mcu_fd_sc_mcu9t5v0__nand2_1
* cell instance $3270 m0 *1 1576.4,1229.76
X$3270 14872 21393 21241 21412 21019 gf180mcu_fd_sc_mcu9t5v0__nor2_1
* cell instance $3271 r0 *1 1522.08,1219.68
X$3271 20397 20718 21241 21123 21258 gf180mcu_fd_sc_mcu9t5v0__nand2_1
* cell instance $3272 m0 *1 1523.76,1229.76
X$3272 20397 21389 21241 21412 21140 gf180mcu_fd_sc_mcu9t5v0__nand2_1
* cell instance $3273 m0 *1 1531.6,1209.6
X$3273 20532 20637 20822 20720 gf180mcu_fd_sc_mcu9t5v0__clkinv_1
* cell instance $3274 r0 *1 1551.2,1229.76
X$3274 21436 21437 21559 21537 21412 21392 gf180mcu_fd_sc_mcu9t5v0__oai21_1
* cell instance $3275 m0 *1 1521.52,1219.68
X$3275 20397 20936 21123 20718 21014 gf180mcu_fd_sc_mcu9t5v0__xor2_1
* cell instance $3276 r0 *1 1576.96,1229.76
X$3276 21438 21612 21560 21537 21412 21143 gf180mcu_fd_sc_mcu9t5v0__nand3_1
* cell instance $3277 r0 *1 1579.2,1159.2
X$3277 19625 19435 19448 19282 19015 gf180mcu_fd_sc_mcu9t5v0__or2_1
* cell instance $3278 r0 *1 1562.4,1159.2
X$3278 19434 17256 14872 19448 19282 19463 gf180mcu_fd_sc_mcu9t5v0__mux2_1
* cell instance $3279 m0 *1 1531.6,1128.96
X$3279 18276 18458 19292 18268 18386 18415 gf180mcu_fd_sc_mcu9t5v0__mux2_1
* cell instance $3280 r0 *1 1583.68,1159.2
X$3280 19625 19435 19448 19282 19147 gf180mcu_fd_sc_mcu9t5v0__nand2_1
* cell instance $3281 r0 *1 1565.76,1128.96
X$3281 18414 18459 18460 14696 18553 18386 gf180mcu_fd_sc_mcu9t5v0__dffrnq_2
* cell instance $3282 m0 *1 1527.68,1139.04
X$3282 20723 18553 18731 18414 gf180mcu_fd_sc_mcu9t5v0__clkbuf_8
* cell instance $3283 r0 *1 1558.48,1128.96
X$3283 18460 18629 18277 18553 18386 18459 gf180mcu_fd_sc_mcu9t5v0__mux2_1
* cell instance $3284 m0 *1 1568.56,1118.88
X$3284 18104 17985 gf180mcu_fd_sc_mcu9t5v0__filltie
* cell instance $3285 m0 *1 1568.56,1149.12
X$3285 18996 18841 gf180mcu_fd_sc_mcu9t5v0__filltie
* cell instance $3286 r0 *1 1576.96,1149.12
X$3286 19147 19015 19171 18996 18978 gf180mcu_fd_sc_mcu9t5v0__nand2_1
* cell instance $3287 m0 *1 1568.56,1128.96
X$3287 18386 18268 gf180mcu_fd_sc_mcu9t5v0__filltie
* cell instance $3288 r0 *1 1579.76,1149.12
X$3288 19016 19147 19186 19171 18996 19148 gf180mcu_fd_sc_mcu9t5v0__nand3_1
* cell instance $3289 m0 *1 1581.44,1149.12
X$3289 18979 18978 18841 18996 16986 gf180mcu_fd_sc_mcu9t5v0__xnor2_1
* cell instance $3290 r0 *1 1561.84,1108.8
X$3290 14695 18005 17978 14696 17985 17837 gf180mcu_fd_sc_mcu9t5v0__dffrnq_2
* cell instance $3291 m0 *1 1519.84,1139.04
X$3291 18624 18629 19292 18553 18731 18628 gf180mcu_fd_sc_mcu9t5v0__mux2_1
* cell instance $3292 r0 *1 1547.28,1139.04
X$3292 19014 18859 17977 18841 18731 18858 gf180mcu_fd_sc_mcu9t5v0__mux2_1
* cell instance $3293 r0 *1 1533.84,1149.12
X$3293 19014 19145 18277 19171 18996 19146 gf180mcu_fd_sc_mcu9t5v0__mux2_1
* cell instance $3294 r0 *1 1532.16,1128.96
X$3294 18414 18415 18458 14696 18553 18386 gf180mcu_fd_sc_mcu9t5v0__dffrnq_2
* cell instance $3295 r0 *1 1555.12,1139.04
X$3295 18414 18630 16815 14696 18841 18731 gf180mcu_fd_sc_mcu9t5v0__dffrnq_2
* cell instance $3296 m0 *1 1550.64,1118.88
X$3296 18121 18458 18277 17985 18104 18120 gf180mcu_fd_sc_mcu9t5v0__mux2_1
* cell instance $3297 r0 *1 1546.72,1118.88
X$3297 18414 18120 18121 14696 18268 18104 gf180mcu_fd_sc_mcu9t5v0__dffrnq_2
* cell instance $3298 m0 *1 1542.8,1149.12
X$3298 18414 18858 18859 14696 18841 18996 gf180mcu_fd_sc_mcu9t5v0__dffrnq_2
* cell instance $3299 m0 *1 1578.64,1169.28
X$3299 19625 19588 15890 19448 19605 19624 gf180mcu_fd_sc_mcu9t5v0__mux2_1
* cell instance $3300 m0 *1 1549.52,1169.28
X$3300 19752 19463 17256 14696 19448 19605 gf180mcu_fd_sc_mcu9t5v0__dffrnq_2
* cell instance $3301 r0 *1 1532.16,1108.8
X$3301 14695 17851 17732 14696 17985 17837 gf180mcu_fd_sc_mcu9t5v0__dffrnq_2
* cell instance $3302 m0 *1 1538.32,1169.28
X$3302 19622 15908 14872 19448 19605 19623 gf180mcu_fd_sc_mcu9t5v0__mux2_1
* cell instance $3303 m0 *1 1555.12,1139.04
X$3303 18859 16815 14872 18553 18731 18630 gf180mcu_fd_sc_mcu9t5v0__mux2_1
* cell instance $3304 m0 *1 1561.28,1118.88
X$3304 18121 17978 17977 17985 18104 18005 gf180mcu_fd_sc_mcu9t5v0__mux2_1
* cell instance $3305 m0 *1 1568.56,1169.28
X$3305 19605 19448 gf180mcu_fd_sc_mcu9t5v0__filltie
* cell instance $3306 m0 *1 1530.48,1159.2
X$3306 18414 19146 19014 14696 19171 19282 gf180mcu_fd_sc_mcu9t5v0__dffrnq_2
* cell instance $3307 m0 *1 1527.68,1149.12
X$3307 18414 18841 18996 33563 gf180mcu_fd_sc_mcu9t5v0__clkinv_1
* cell instance $3308 m0 *1 1582.56,1159.2
X$3308 19015 18979 19171 19282 19186 gf180mcu_fd_sc_mcu9t5v0__nand2_1
* cell instance $3309 m0 *1 1568.56,1139.04
X$3309 18731 18553 gf180mcu_fd_sc_mcu9t5v0__filltie
* cell instance $3310 m0 *1 1568.56,1159.2
X$3310 19282 19171 gf180mcu_fd_sc_mcu9t5v0__filltie
* cell instance $3311 r0 *1 1606.08,1149.12
X$3311 19150 19152 15890 19171 18996 19187 gf180mcu_fd_sc_mcu9t5v0__mux2_1
* cell instance $3312 m0 *1 1597.68,1139.04
X$3312 18633 18632 18553 18731 18462 gf180mcu_fd_sc_mcu9t5v0__xnor2_1
* cell instance $3313 m0 *1 1598.24,1159.2
X$3313 19752 19187 19150 14696 19171 19282 gf180mcu_fd_sc_mcu9t5v0__dffrnq_2
* cell instance $3314 m0 *1 1611.12,1139.04
X$3314 18633 18635 15890 18553 18731 18634 gf180mcu_fd_sc_mcu9t5v0__mux2_1
* cell instance $3315 r0 *1 1612.24,1118.88
X$3315 18167 18169 15890 18268 18104 18168 gf180mcu_fd_sc_mcu9t5v0__mux2_1
* cell instance $3316 m0 *1 1593.2,1128.96
X$3316 18461 18631 18462 18268 18386 18278 gf180mcu_fd_sc_mcu9t5v0__aoi21_1
* cell instance $3317 m0 *1 1636.88,1169.28
X$3317 18172 19464 19465 14696 19448 19605 gf180mcu_fd_sc_mcu9t5v0__dffrnq_2
* cell instance $3318 r0 *1 1601.6,1128.96
X$3318 18633 18632 18278 18553 18386 18463 gf180mcu_fd_sc_mcu9t5v0__aoi21_1
* cell instance $3319 m0 *1 1628.48,1169.28
X$3319 18980 19465 19448 19605 19590 gf180mcu_fd_sc_mcu9t5v0__xnor2_1
* cell instance $3320 r0 *1 1592.64,1128.96
X$3320 18461 18631 18462 18553 18386 17734 gf180mcu_fd_sc_mcu9t5v0__and3_1
* cell instance $3321 r0 *1 1599.36,1118.88
X$3321 18167 18463 18268 18104 17276 18416 gf180mcu_fd_sc_mcu9t5v0__xnor3_1
* cell instance $3322 m0 *1 1620.64,1149.12
X$3322 18980 18982 18841 18996 18635 18981 gf180mcu_fd_sc_mcu9t5v0__xnor3_1
* cell instance $3323 r0 *1 1627.36,1149.12
X$3323 18980 19153 18982 19171 18996 19018 gf180mcu_fd_sc_mcu9t5v0__and3_1
* cell instance $3324 r0 *1 1603.28,1139.04
X$3324 19752 18634 18633 14696 18841 18731 gf180mcu_fd_sc_mcu9t5v0__dffrnq_2
* cell instance $3325 m0 *1 1639.12,1118.88
X$3325 18125 17608 16818 17985 18104 18124 gf180mcu_fd_sc_mcu9t5v0__mux2_1
* cell instance $3326 m0 *1 1648.64,1139.04
X$3326 16485 17608 18553 18731 18636 gf180mcu_fd_sc_mcu9t5v0__xnor2_1
* cell instance $3327 r0 *1 1632.96,1149.12
X$3327 18981 19171 18996 19153 gf180mcu_fd_sc_mcu9t5v0__clkinv_1
* cell instance $3328 r0 *1 1640.8,1139.04
X$3328 16689 18981 18562 18841 18731 18860 gf180mcu_fd_sc_mcu9t5v0__mux2_1
* cell instance $3329 m0 *1 1619.52,1169.28
X$3329 19590 19589 19448 19605 19591 gf180mcu_fd_sc_mcu9t5v0__nor2_1
* cell instance $3330 r0 *1 1635.76,1118.88
X$3330 18172 18124 17608 14696 18268 18104 gf180mcu_fd_sc_mcu9t5v0__dffrnq_2
* cell instance $3331 m0 *1 1602.72,1118.88
X$3331 18414 18168 18167 14696 17985 18104 gf180mcu_fd_sc_mcu9t5v0__dffrnq_2
* cell instance $3332 m0 *1 1637.44,1149.12
X$3332 18172 18860 18981 14696 18841 18996 gf180mcu_fd_sc_mcu9t5v0__dffrnq_2
* cell instance $3333 m0 *1 1620.08,1128.96
X$3333 18414 18417 18170 14696 18268 18386 gf180mcu_fd_sc_mcu9t5v0__dffrnq_2
* cell instance $3334 m0 *1 1633.52,1149.12
X$3334 19018 18983 18841 18996 18171 gf180mcu_fd_sc_mcu9t5v0__nor2_1
* cell instance $3335 m0 *1 1627.92,1159.2
X$3335 18980 19153 18982 19171 19282 18983 gf180mcu_fd_sc_mcu9t5v0__nor3_1
* cell instance $3336 r0 *1 1626.8,1118.88
X$3336 18170 18171 18268 18104 18169 gf180mcu_fd_sc_mcu9t5v0__xnor2_1
* cell instance $3337 r0 *1 1628.48,1128.96
X$3337 18170 18562 18553 18386 18464 gf180mcu_fd_sc_mcu9t5v0__nand2_1
* cell instance $3338 r0 *1 1591.52,1149.12
X$3338 19150 19151 19171 18996 18461 gf180mcu_fd_sc_mcu9t5v0__nand2_1
* cell instance $3339 r0 *1 1640.24,1159.2
X$3339 16935 19465 18562 19448 19282 19464 gf180mcu_fd_sc_mcu9t5v0__mux2_1
* cell instance $3340 r0 *1 1589.28,1149.12
X$3340 19147 19171 18996 19149 gf180mcu_fd_sc_mcu9t5v0__clkinv_1
* cell instance $3341 r0 *1 1624,1128.96
X$3341 16690 18562 18464 18553 18386 18417 gf180mcu_fd_sc_mcu9t5v0__oai21_1
* cell instance $3342 r0 *1 1689.52,1380.96
X$3342 25300 25905 25148 14696 25997 25870 gf180mcu_fd_sc_mcu9t5v0__dffrnq_2
* cell instance $3343 r0 *1 1688.4,1380.96
X$3343 25870 25997 gf180mcu_fd_sc_mcu9t5v0__filltie
* cell instance $3344 r0 *1 1738.8,1380.96
X$3344 25304 26658 16821 25997 25870 25860 gf180mcu_fd_sc_mcu9t5v0__mux2_1
* cell instance $3345 m0 *1 1808.24,1380.96
X$3345 25870 25705 gf180mcu_fd_sc_mcu9t5v0__filltie
* cell instance $3346 r0 *1 1761.2,1380.96
X$3346 20723 25997 25870 24854 gf180mcu_fd_sc_mcu9t5v0__clkbuf_8
* cell instance $3347 r180 *1 1864.8,1380.96
X$3347 25870 25705 gf180mcu_fd_sc_mcu9t5v0__endcap
* cell instance $3348 m90 *1 1864.8,1380.96
X$3348 25870 25997 gf180mcu_fd_sc_mcu9t5v0__endcap
* cell instance $3349 r0 *1 1775.76,1380.96
X$3349 25600 25906 22436 25997 25870 26025 gf180mcu_fd_sc_mcu9t5v0__mux2_1
* cell instance $3350 m0 *1 1736.56,1380.96
X$3350 24854 25860 25304 14696 25705 25870 gf180mcu_fd_sc_mcu9t5v0__dffrnq_2
* cell instance $3351 r0 *1 1673.84,1380.96
X$3351 20723 25997 25870 25300 gf180mcu_fd_sc_mcu9t5v0__clkbuf_8
* cell instance $3352 r0 *1 1666.56,1380.96
X$3352 25730 26024 16818 25997 25870 26023 gf180mcu_fd_sc_mcu9t5v0__mux2_1
* cell instance $3353 r90 *1 2210,1105
X$3353 18862 33658 33657 33656 33655 33654 33653 33652 33651 33650 33649 33648
+ 33647 33646 33645 33644 33643 33642 33641 33640 33639 33638 33637 33636 33635
+ 33634 33633 33632 33631 33630 33629 33628 33627 33626 33625 33624 33623 33622
+ 33621 33620 33619 33618 33617 33616 33615 33614 33613 18007 33612 33611 33610
+ 33609 33608 33607 33606 33605 33604 33603 33602 33601 33600 33599 33598 33597
+ 33596 33595 33594 33593 33592 33591 33590 33589 33588 33587 33586 33585 33584
+ 17979 33583 33582 33581 18007 17979 17979 17979 17979 19726 18007
+ gf180mcu_fd_io__bi_t
* cell instance $3354 m0 *1 1710.8,1380.96
X$3354 25300 25729 25151 14696 25705 25870 gf180mcu_fd_sc_mcu9t5v0__dffrnq_2
* cell instance $3355 m0 *1 1690.64,1380.96
X$3355 26658 25148 16818 25705 25870 25905 gf180mcu_fd_sc_mcu9t5v0__mux2_1
* cell instance $3356 m0 *1 1793.12,1391.04
X$3356 26194 25906 15890 25997 26166 26193 gf180mcu_fd_sc_mcu9t5v0__mux2_1
* cell instance $3357 m0 *1 1793.12,1411.2
X$3357 26540 26980 15890 26632 26757 26787 gf180mcu_fd_sc_mcu9t5v0__mux2_1
* cell instance $3358 r0 *1 1790.88,1411.2
X$3358 24854 26787 26540 14696 26942 26757 gf180mcu_fd_sc_mcu9t5v0__dffrnq_2
* cell instance $3359 r0 *1 1789.76,1391.04
X$3359 24854 26193 26194 14696 26331 26166 gf180mcu_fd_sc_mcu9t5v0__dffrnq_2
* cell instance $3360 r0 *1 1792.56,1431.36
X$3360 27237 27398 27399 14696 27517 27367 gf180mcu_fd_sc_mcu9t5v0__dffrnq_2
* cell instance $3361 m0 *1 1788.64,1451.52
X$3361 27237 27851 27796 14696 27807 27945 gf180mcu_fd_sc_mcu9t5v0__dffrnq_2
* cell instance $3362 r0 *1 1792,1441.44
X$3362 27796 27795 15890 27807 27666 27851 gf180mcu_fd_sc_mcu9t5v0__mux2_1
* cell instance $3363 m0 *1 1794.8,1431.36
X$3363 27399 27397 15890 27213 27367 27398 gf180mcu_fd_sc_mcu9t5v0__mux2_1
* cell instance $3364 r0 *1 1794.24,1401.12
X$3364 26500 26540 26662 26499 26632 26456 26539
+ gf180mcu_fd_sc_mcu9t5v0__aoi22_1
* cell instance $3365 m0 *1 1755.04,1411.2
X$3365 25730 26786 22436 26632 26757 26785 gf180mcu_fd_sc_mcu9t5v0__mux2_1
* cell instance $3366 m0 *1 1772.96,1421.28
X$3366 24854 26979 26980 14696 26942 27078 gf180mcu_fd_sc_mcu9t5v0__dffrnq_2
* cell instance $3367 m0 *1 1774.08,1391.04
X$3367 24854 26025 25906 14696 25997 26166 gf180mcu_fd_sc_mcu9t5v0__dffrnq_2
* cell instance $3368 r0 *1 1688.4,1411.2
X$3368 26757 26942 gf180mcu_fd_sc_mcu9t5v0__filltie
* cell instance $3369 r0 *1 1701.28,1421.28
X$3369 26535 27240 27213 27078 27239 gf180mcu_fd_sc_mcu9t5v0__nor2_1
* cell instance $3370 r0 *1 1773.52,1431.36
X$3370 27237 27396 27397 14696 27517 27367 gf180mcu_fd_sc_mcu9t5v0__dffrnq_2
* cell instance $3371 m0 *1 1771.84,1411.2
X$3371 26662 26786 15890 26632 26757 26538 gf180mcu_fd_sc_mcu9t5v0__mux2_1
* cell instance $3372 m0 *1 1758.4,1471.68
X$3372 28223 28527 28528 14696 28378 28530 gf180mcu_fd_sc_mcu9t5v0__dffrnq_2
* cell instance $3373 r0 *1 1688.4,1421.28
X$3373 27078 27213 gf180mcu_fd_sc_mcu9t5v0__filltie
* cell instance $3374 m0 *1 1755.04,1431.36
X$3374 27394 27681 15890 27213 27367 27395 gf180mcu_fd_sc_mcu9t5v0__mux2_1
* cell instance $3375 r0 *1 1753.92,1441.44
X$3375 25600 27681 22907 27807 27666 27653 gf180mcu_fd_sc_mcu9t5v0__mux2_1
* cell instance $3376 r0 *1 1761.76,1471.68
X$3376 26658 28528 22907 28635 28530 28527 gf180mcu_fd_sc_mcu9t5v0__mux2_1
* cell instance $3377 m0 *1 1769.6,1461.6
X$3377 27849 28528 15890 28103 28239 28254 gf180mcu_fd_sc_mcu9t5v0__mux2_1
* cell instance $3378 r0 *1 1774.64,1441.44
X$3378 25600 27795 22434 27807 27666 27850 gf180mcu_fd_sc_mcu9t5v0__mux2_1
* cell instance $3379 m0 *1 1776.88,1431.36
X$3379 26658 27397 22434 27213 27367 27396 gf180mcu_fd_sc_mcu9t5v0__mux2_1
* cell instance $3380 r0 *1 1688.4,1401.12
X$3380 26456 26632 gf180mcu_fd_sc_mcu9t5v0__filltie
* cell instance $3381 r0 *1 1689.52,1411.2
X$3381 22024 26925 22862 26942 26757 26976 gf180mcu_fd_sc_mcu9t5v0__mux2_1
* cell instance $3382 r0 *1 1766.24,1461.6
X$3382 28223 28254 27849 14696 28378 28239 gf180mcu_fd_sc_mcu9t5v0__dffrnq_2
* cell instance $3383 m0 *1 1694.56,1401.12
X$3383 26535 26496 15890 26331 26456 26497 gf180mcu_fd_sc_mcu9t5v0__mux2_1
* cell instance $3384 m0 *1 1706.88,1391.04
X$3384 22909 26191 22862 25997 26166 26190 gf180mcu_fd_sc_mcu9t5v0__mux2_1
* cell instance $3385 r0 *1 1735.44,1411.2
X$3385 26926 26661 15890 26942 26757 26978 gf180mcu_fd_sc_mcu9t5v0__mux2_1
* cell instance $3386 m0 *1 1769.6,1451.52
X$3386 28223 27850 27795 14696 27807 27945 gf180mcu_fd_sc_mcu9t5v0__dffrnq_2
* cell instance $3387 r0 *1 1769.6,1401.12
X$3387 24854 26538 26662 14696 26632 26456 gf180mcu_fd_sc_mcu9t5v0__dffrnq_2
* cell instance $3388 r0 *1 1776.88,1411.2
X$3388 26658 26980 22436 26942 26757 26979 gf180mcu_fd_sc_mcu9t5v0__mux2_1
* cell instance $3389 r0 *1 1761.2,1391.04
X$3389 26192 26361 15890 26331 26166 26066 gf180mcu_fd_sc_mcu9t5v0__mux2_1
* cell instance $3390 m0 *1 1755.04,1391.04
X$3390 24854 26066 26192 14696 25997 26166 gf180mcu_fd_sc_mcu9t5v0__dffrnq_2
* cell instance $3391 m0 *1 1778.56,1401.12
X$3391 26192 26331 26456 26499 gf180mcu_fd_sc_mcu9t5v0__clkinv_1
* cell instance $3392 m0 *1 1674.4,1401.12
X$3392 25300 26495 26496 14696 26331 26456 gf180mcu_fd_sc_mcu9t5v0__dffrnq_2
* cell instance $3393 r0 *1 1681.12,1461.6
X$3393 20543 28230 22907 28378 28239 28229 gf180mcu_fd_sc_mcu9t5v0__mux2_1
* cell instance $3394 r0 *1 1681.12,1401.12
X$3394 22024 26496 22907 26632 26456 26495 gf180mcu_fd_sc_mcu9t5v0__mux2_1
* cell instance $3395 m0 *1 1718.08,1431.36
X$3395 27392 27390 20537 27213 27367 27391 gf180mcu_fd_sc_mcu9t5v0__mux2_1
* cell instance $3396 m0 *1 1677.76,1461.6
X$3396 27237 28229 28230 14696 28103 28239 gf180mcu_fd_sc_mcu9t5v0__dffrnq_2
* cell instance $3397 m0 *1 1679.44,1421.28
X$3397 25300 26976 26925 14696 26942 27078 gf180mcu_fd_sc_mcu9t5v0__dffrnq_2
* cell instance $3398 m0 *1 1685.6,1451.52
X$3398 27679 28230 15890 27807 27945 27652 gf180mcu_fd_sc_mcu9t5v0__mux2_1
* cell instance $3399 m0 *1 1719.76,1471.68
X$3399 27237 28401 28369 14696 28378 28530 gf180mcu_fd_sc_mcu9t5v0__dffrnq_2
* cell instance $3400 r0 *1 1717.52,1451.52
X$3400 27237 27846 27847 14696 28103 27945 gf180mcu_fd_sc_mcu9t5v0__dffrnq_2
* cell instance $3401 r0 *1 1716.4,1431.36
X$3401 27237 27391 27392 14696 27517 27367 gf180mcu_fd_sc_mcu9t5v0__dffrnq_2
* cell instance $3402 m0 *1 1688.4,1481.76
X$3402 28661 28635 gf180mcu_fd_sc_mcu9t5v0__filltie
* cell instance $3403 r0 *1 1709.68,1441.44
X$3403 27237 27807 27666 gf180mcu_fd_sc_mcu9t5v0__clkbuf_4
* cell instance $3404 r0 *1 1688.4,1471.68
X$3404 28530 28635 gf180mcu_fd_sc_mcu9t5v0__filltie
* cell instance $3405 m0 *1 1709.68,1451.52
X$3405 20723 27807 27945 27237 gf180mcu_fd_sc_mcu9t5v0__clkbuf_8
* cell instance $3406 m0 *1 1733.2,1441.44
X$3406 27394 27392 27517 27666 27680 gf180mcu_fd_sc_mcu9t5v0__nand2_1
* cell instance $3407 m0 *1 1736,1451.52
X$3407 27849 27847 27807 27945 27848 gf180mcu_fd_sc_mcu9t5v0__nand2_1
* cell instance $3408 r0 *1 1736.56,1451.52
X$3408 27849 27847 28015 28369 28103 27945 27794
+ gf180mcu_fd_sc_mcu9t5v0__oai211_1
* cell instance $3409 r0 *1 1744.4,1461.6
X$3409 25730 28370 22907 28378 28239 28402 gf180mcu_fd_sc_mcu9t5v0__mux2_1
* cell instance $3410 r0 *1 1703.52,1431.36
X$3410 25600 27390 22862 27517 27367 27532 gf180mcu_fd_sc_mcu9t5v0__mux2_1
* cell instance $3411 m0 *1 1702.4,1451.52
X$3411 26658 27845 22862 27807 27945 27975 gf180mcu_fd_sc_mcu9t5v0__mux2_1
* cell instance $3412 m0 *1 1704.64,1471.68
X$3412 25730 28368 22862 28378 28530 28548 gf180mcu_fd_sc_mcu9t5v0__mux2_1
* cell instance $3413 r0 *1 1734.32,1441.44
X$3413 27680 27848 27794 27807 27666 27393 gf180mcu_fd_sc_mcu9t5v0__and3_1
* cell instance $3414 r0 *1 1719.2,1441.44
X$3414 27847 27845 20537 27807 27666 27846 gf180mcu_fd_sc_mcu9t5v0__mux2_1
* cell instance $3415 r0 *1 1688.4,1431.36
X$3415 27367 27517 gf180mcu_fd_sc_mcu9t5v0__filltie
* cell instance $3416 r0 *1 1720.88,1461.6
X$3416 28369 28368 20537 28378 28239 28401 gf180mcu_fd_sc_mcu9t5v0__mux2_1
* cell instance $3417 r0 *1 1688.4,1441.44
X$3417 27666 27807 gf180mcu_fd_sc_mcu9t5v0__filltie
* cell instance $3418 r0 *1 1699.04,1471.68
X$3418 27237 28548 28368 14696 28635 28530 gf180mcu_fd_sc_mcu9t5v0__dffrnq_2
* cell instance $3419 r0 *1 1698.48,1451.52
X$3419 27237 27975 27845 14696 28103 27945 gf180mcu_fd_sc_mcu9t5v0__dffrnq_2
* cell instance $3420 m0 *1 1699.6,1441.44
X$3420 27237 27532 27390 14696 27517 27666 gf180mcu_fd_sc_mcu9t5v0__dffrnq_2
* cell instance $3421 r0 *1 1688.4,1451.52
X$3421 27945 28103 gf180mcu_fd_sc_mcu9t5v0__filltie
* cell instance $3422 r0 *1 1688.4,1461.6
X$3422 28239 28378 gf180mcu_fd_sc_mcu9t5v0__filltie
* cell instance $3423 m0 *1 1664.32,1461.6
X$3423 27651 28228 20537 28103 28239 28253 gf180mcu_fd_sc_mcu9t5v0__mux2_1
* cell instance $3424 m0 *1 1671.04,1441.44
X$3424 27650 27649 27679 27651 27517 27666 27511
+ gf180mcu_fd_sc_mcu9t5v0__aoi22_1
* cell instance $3425 r0 *1 1677.2,1431.36
X$3425 27511 27517 27367 27389 gf180mcu_fd_sc_mcu9t5v0__clkinv_1
* cell instance $3426 m0 *1 1659.28,1441.44
X$3426 27650 28014 15890 27517 27666 27678 gf180mcu_fd_sc_mcu9t5v0__mux2_1
* cell instance $3427 m0 *1 1666.56,1441.44
X$3427 27650 27649 27517 27666 26923 gf180mcu_fd_sc_mcu9t5v0__nor2_1
* cell instance $3428 r0 *1 1661.52,1461.6
X$3428 27237 28253 27651 14696 28378 28239 gf180mcu_fd_sc_mcu9t5v0__dffrnq_2
* cell instance $3429 m0 *1 1677.2,1441.44
X$3429 27679 27651 27517 27666 27531 gf180mcu_fd_sc_mcu9t5v0__nor2_1
* cell instance $3430 r0 *1 1720.32,1421.28
X$3430 26926 26536 26535 27240 27213 27078 27241
+ gf180mcu_fd_sc_mcu9t5v0__aoi22_1
* cell instance $3431 r0 *1 1748.32,1451.52
X$3431 28015 28370 15890 28103 27945 28231 gf180mcu_fd_sc_mcu9t5v0__mux2_1
* cell instance $3432 m0 *1 1738.8,1471.68
X$3432 27237 28402 28370 14696 28378 28530 gf180mcu_fd_sc_mcu9t5v0__dffrnq_2
* cell instance $3433 m0 *1 1749.44,1401.12
X$3433 25730 26361 22434 26331 26456 26326 gf180mcu_fd_sc_mcu9t5v0__mux2_1
* cell instance $3434 m0 *1 1744.4,1461.6
X$3434 27237 28231 28015 14696 28103 28239 gf180mcu_fd_sc_mcu9t5v0__dffrnq_2
* cell instance $3435 r0 *1 1749.44,1431.36
X$3435 27237 27395 27394 14696 27517 27367 gf180mcu_fd_sc_mcu9t5v0__dffrnq_2
* cell instance $3436 r0 *1 1674.4,1391.04
X$3436 25300 26331 26166 33573 gf180mcu_fd_sc_mcu9t5v0__clkinv_1
* cell instance $3437 r0 *1 1667.12,1421.28
X$3437 26923 26924 27213 27078 26975 gf180mcu_fd_sc_mcu9t5v0__nor2_1
* cell instance $3438 r0 *1 1662.08,1421.28
X$3438 26494 26920 27213 27078 26922 gf180mcu_fd_sc_mcu9t5v0__nor2_1
* cell instance $3439 m0 *1 1658.72,1421.28
X$3439 26494 26975 26942 27078 26660 26920 gf180mcu_fd_sc_mcu9t5v0__xnor3_1
* cell instance $3440 r0 *1 1742.16,1391.04
X$3440 24854 26326 26361 14696 26331 26166 gf180mcu_fd_sc_mcu9t5v0__dffrnq_2
* cell instance $3441 m0 *1 1665.44,1391.04
X$3441 25300 26023 26024 14696 25997 26166 gf180mcu_fd_sc_mcu9t5v0__dffrnq_2
* cell instance $3442 m0 *1 1746.64,1441.44
X$3442 27237 27653 27681 14696 27517 27666 gf180mcu_fd_sc_mcu9t5v0__dffrnq_2
* cell instance $3443 r0 *1 1751.68,1411.2
X$3443 24854 26785 26786 14696 26942 26757 gf180mcu_fd_sc_mcu9t5v0__dffrnq_2
* cell instance $3444 r0 *1 1660.4,1411.2
X$3444 26494 26920 26942 26757 26921 gf180mcu_fd_sc_mcu9t5v0__nand2_1
* cell instance $3445 r0 *1 1663.2,1411.2
X$3445 26922 26923 26924 26921 26942 26757 26919
+ gf180mcu_fd_sc_mcu9t5v0__oai31_1
* cell instance $3446 m0 *1 1733.76,1411.2
X$3446 22909 26661 22907 26632 26757 26537 gf180mcu_fd_sc_mcu9t5v0__mux2_1
* cell instance $3447 m0 *1 1729.84,1431.36
X$3447 26926 26536 27394 27392 27213 27367 27273
+ gf180mcu_fd_sc_mcu9t5v0__oai22_1
* cell instance $3448 m0 *1 1725.36,1431.36
X$3448 27393 27273 27241 27213 27367 27272 gf180mcu_fd_sc_mcu9t5v0__oai21_1
* cell instance $3449 m0 *1 1682.8,1431.36
X$3449 27531 27239 27213 27367 27271 gf180mcu_fd_sc_mcu9t5v0__nor2_1
* cell instance $3450 m0 *1 1678.32,1431.36
X$3450 27272 27271 27389 27213 27367 26924 gf180mcu_fd_sc_mcu9t5v0__aoi21_1
* cell instance $3451 m0 *1 1729.84,1421.28
X$3451 24854 26978 26926 14696 26942 27078 gf180mcu_fd_sc_mcu9t5v0__dffrnq_2
* cell instance $3452 r0 *1 1695.12,1401.12
X$3452 25300 26497 26535 14696 26632 26456 gf180mcu_fd_sc_mcu9t5v0__dffrnq_2
* cell instance $3453 m0 *1 1680.56,1441.44
X$3453 27237 27652 27679 14696 27517 27666 gf180mcu_fd_sc_mcu9t5v0__dffrnq_2
* cell instance $3454 r0 *1 1700.16,1411.2
X$3454 27240 26925 20537 26942 26757 26977 gf180mcu_fd_sc_mcu9t5v0__mux2_1
* cell instance $3455 m0 *1 1717.52,1401.12
X$3455 24854 26498 26536 14696 26331 26456 gf180mcu_fd_sc_mcu9t5v0__dffrnq_2
* cell instance $3456 r0 *1 1725.92,1401.12
X$3456 24854 26537 26661 14696 26632 26456 gf180mcu_fd_sc_mcu9t5v0__dffrnq_2
* cell instance $3457 m0 *1 1700.72,1421.28
X$3457 25300 26977 27240 14696 26942 27078 gf180mcu_fd_sc_mcu9t5v0__dffrnq_2
* cell instance $3458 r0 *1 1701.84,1391.04
X$3458 25300 26190 26191 14696 26331 26166 gf180mcu_fd_sc_mcu9t5v0__dffrnq_2
* cell instance $3459 r0 *1 1688.4,1391.04
X$3459 26166 26331 gf180mcu_fd_sc_mcu9t5v0__filltie
* cell instance $3460 r0 *1 1718.64,1401.12
X$3460 26536 26191 20537 26632 26456 26498 gf180mcu_fd_sc_mcu9t5v0__mux2_1
* cell instance $3461 m0 *1 1808.24,1481.76
X$3461 28661 28635 gf180mcu_fd_sc_mcu9t5v0__filltie
* cell instance $3462 r0 *1 1802.64,1441.44
X$3462 27796 27807 27666 26067 gf180mcu_fd_sc_mcu9t5v0__clkinv_1
* cell instance $3463 m0 *1 1800.96,1401.12
X$3463 26067 26194 26540 26500 26331 26456 26501
+ gf180mcu_fd_sc_mcu9t5v0__oai22_1
* cell instance $3464 m0 *1 1803.2,1391.04
X$3464 25568 25567 26194 26067 25997 26166 26068
+ gf180mcu_fd_sc_mcu9t5v0__aoi22_1
* cell instance $3465 r0 *1 1808.8,1391.04
X$3465 26539 26501 26068 26331 26166 24430 gf180mcu_fd_sc_mcu9t5v0__oai21_1
* cell instance $3466 r180 *1 1864.8,1451.52
X$3466 27945 27807 gf180mcu_fd_sc_mcu9t5v0__endcap
* cell instance $3467 m90 *1 1864.8,1451.52
X$3467 27945 28103 gf180mcu_fd_sc_mcu9t5v0__endcap
* cell instance $3468 m0 *1 1808.24,1431.36
X$3468 27367 27213 gf180mcu_fd_sc_mcu9t5v0__filltie
* cell instance $3469 r180 *1 1864.8,1461.6
X$3469 28239 28103 gf180mcu_fd_sc_mcu9t5v0__endcap
* cell instance $3470 m0 *1 1808.24,1411.2
X$3470 26757 26632 gf180mcu_fd_sc_mcu9t5v0__filltie
* cell instance $3471 m90 *1 1864.8,1471.68
X$3471 28530 28635 gf180mcu_fd_sc_mcu9t5v0__endcap
* cell instance $3472 m0 *1 1808.24,1461.6
X$3472 28239 28103 gf180mcu_fd_sc_mcu9t5v0__filltie
* cell instance $3473 m0 *1 1808.24,1441.44
X$3473 27666 27517 gf180mcu_fd_sc_mcu9t5v0__filltie
* cell instance $3474 r180 *1 1864.8,1471.68
X$3474 28530 28378 gf180mcu_fd_sc_mcu9t5v0__endcap
* cell instance $3475 m0 *1 1808.24,1401.12
X$3475 26456 26331 gf180mcu_fd_sc_mcu9t5v0__filltie
* cell instance $3476 r180 *1 1864.8,1481.76
X$3476 28661 28635 gf180mcu_fd_sc_mcu9t5v0__endcap
* cell instance $3477 m0 *1 1808.24,1471.68
X$3477 28530 28378 gf180mcu_fd_sc_mcu9t5v0__filltie
* cell instance $3478 m90 *1 1864.8,1461.6
X$3478 28239 28378 gf180mcu_fd_sc_mcu9t5v0__endcap
* cell instance $3479 m0 *1 1808.24,1421.28
X$3479 27078 26942 gf180mcu_fd_sc_mcu9t5v0__filltie
* cell instance $3480 r180 *1 1864.8,1401.12
X$3480 26456 26331 gf180mcu_fd_sc_mcu9t5v0__endcap
* cell instance $3481 m90 *1 1864.8,1401.12
X$3481 26456 26632 gf180mcu_fd_sc_mcu9t5v0__endcap
* cell instance $3482 r180 *1 1864.8,1411.2
X$3482 26757 26632 gf180mcu_fd_sc_mcu9t5v0__endcap
* cell instance $3483 m90 *1 1864.8,1411.2
X$3483 26757 26942 gf180mcu_fd_sc_mcu9t5v0__endcap
* cell instance $3484 r180 *1 1864.8,1421.28
X$3484 27078 26942 gf180mcu_fd_sc_mcu9t5v0__endcap
* cell instance $3485 m0 *1 1802.08,1431.36
X$3485 27399 27213 27367 26500 gf180mcu_fd_sc_mcu9t5v0__clkinv_1
* cell instance $3486 m90 *1 1864.8,1421.28
X$3486 27078 27213 gf180mcu_fd_sc_mcu9t5v0__endcap
* cell instance $3487 r180 *1 1864.8,1431.36
X$3487 27367 27213 gf180mcu_fd_sc_mcu9t5v0__endcap
* cell instance $3488 m90 *1 1864.8,1431.36
X$3488 27367 27517 gf180mcu_fd_sc_mcu9t5v0__endcap
* cell instance $3489 r180 *1 1864.8,1441.44
X$3489 27666 27517 gf180mcu_fd_sc_mcu9t5v0__endcap
* cell instance $3490 m90 *1 1864.8,1441.44
X$3490 27666 27807 gf180mcu_fd_sc_mcu9t5v0__endcap
* cell instance $3491 m0 *1 1808.24,1451.52
X$3491 27945 27807 gf180mcu_fd_sc_mcu9t5v0__filltie
* cell instance $3492 r180 *1 1864.8,1391.04
X$3492 26166 25997 gf180mcu_fd_sc_mcu9t5v0__endcap
* cell instance $3493 m0 *1 1808.24,1391.04
X$3493 26166 25997 gf180mcu_fd_sc_mcu9t5v0__filltie
* cell instance $3494 m90 *1 1864.8,1391.04
X$3494 26166 26331 gf180mcu_fd_sc_mcu9t5v0__endcap
* cell instance $3495 r0 *1 1790.88,1320.48
X$3495 23031 24268 24139 14696 24232 24118 gf180mcu_fd_sc_mcu9t5v0__dffrnq_2
* cell instance $3496 r0 *1 1794.24,1340.64
X$3496 23031 24856 24616 14696 24828 24712 gf180mcu_fd_sc_mcu9t5v0__dffrnq_2
* cell instance $3497 r0 *1 1788.08,1249.92
X$3497 18172 22156 22199 14696 22124 21997 gf180mcu_fd_sc_mcu9t5v0__dffrnq_2
* cell instance $3498 r0 *1 1790.88,1300.32
X$3498 23031 23665 23411 14696 23623 23504 gf180mcu_fd_sc_mcu9t5v0__dffrnq_2
* cell instance $3499 r0 *1 1756.16,1239.84
X$3499 21742 22024 16821 21884 21719 21873 gf180mcu_fd_sc_mcu9t5v0__mux2_1
* cell instance $3500 m0 *1 1792,1310.4
X$3500 23411 23664 15890 23623 23797 23665 gf180mcu_fd_sc_mcu9t5v0__mux2_1
* cell instance $3501 m0 *1 1792,1260
X$3501 22199 22155 15890 22124 22295 22156 gf180mcu_fd_sc_mcu9t5v0__mux2_1
* cell instance $3502 m0 *1 1795.36,1350.72
X$3502 24616 25154 15890 24828 25000 24856 gf180mcu_fd_sc_mcu9t5v0__mux2_1
* cell instance $3503 m0 *1 1792,1360.8
X$3503 25308 25306 15890 25158 25268 25307 gf180mcu_fd_sc_mcu9t5v0__mux2_1
* cell instance $3504 r0 *1 1779.68,1280.16
X$3504 23031 22912 22872 14696 23038 22885 gf180mcu_fd_sc_mcu9t5v0__dffrnq_2
* cell instance $3505 m90 *1 1864.8,1239.84
X$3505 21719 21884 gf180mcu_fd_sc_mcu9t5v0__endcap
* cell instance $3506 m0 *1 1793.12,1330.56
X$3506 24139 24267 15890 24232 24414 24268 gf180mcu_fd_sc_mcu9t5v0__mux2_1
* cell instance $3507 r0 *1 1795.36,1370.88
X$3507 24854 25566 25567 14696 25705 25581 gf180mcu_fd_sc_mcu9t5v0__dffrnq_2
* cell instance $3508 r0 *1 1792,1360.8
X$3508 24854 25307 25308 14696 25430 25268 gf180mcu_fd_sc_mcu9t5v0__dffrnq_2
* cell instance $3509 r0 *1 1749.44,1239.84
X$3509 21263 21742 21884 21719 21872 gf180mcu_fd_sc_mcu9t5v0__xnor2_1
* cell instance $3510 r0 *1 1667.12,1239.84
X$3510 23057 20391 14872 21884 21719 21870 gf180mcu_fd_sc_mcu9t5v0__mux2_1
* cell instance $3511 r0 *1 1692.32,1239.84
X$3511 17977 22025 21741 21440 21884 21719 21619
+ gf180mcu_fd_sc_mcu9t5v0__oai31_1
* cell instance $3512 r0 *1 1688.4,1239.84
X$3512 21719 21884 gf180mcu_fd_sc_mcu9t5v0__filltie
* cell instance $3513 r0 *1 1725.36,1239.84
X$3513 21563 17977 21884 21719 21443 gf180mcu_fd_sc_mcu9t5v0__nand2_1
* cell instance $3514 m0 *1 1808.24,1260
X$3514 22295 22124 gf180mcu_fd_sc_mcu9t5v0__filltie
* cell instance $3515 m0 *1 1808.24,1300.32
X$3515 23504 23319 gf180mcu_fd_sc_mcu9t5v0__filltie
* cell instance $3516 m90 *1 1864.8,1260
X$3516 22295 22449 gf180mcu_fd_sc_mcu9t5v0__endcap
* cell instance $3517 m90 *1 1864.8,1270.08
X$3517 22577 22700 gf180mcu_fd_sc_mcu9t5v0__endcap
* cell instance $3518 m0 *1 1808.24,1249.92
X$3518 21997 21884 gf180mcu_fd_sc_mcu9t5v0__filltie
* cell instance $3519 m0 *1 1808.24,1310.4
X$3519 23797 23623 gf180mcu_fd_sc_mcu9t5v0__filltie
* cell instance $3520 m90 *1 1864.8,1290.24
X$3520 23200 23319 gf180mcu_fd_sc_mcu9t5v0__endcap
* cell instance $3521 m0 *1 1808.24,1330.56
X$3521 24414 24232 gf180mcu_fd_sc_mcu9t5v0__filltie
* cell instance $3522 r180 *1 1864.8,1280.16
X$3522 22885 22700 gf180mcu_fd_sc_mcu9t5v0__endcap
* cell instance $3523 m90 *1 1864.8,1280.16
X$3523 22885 23038 gf180mcu_fd_sc_mcu9t5v0__endcap
* cell instance $3524 r180 *1 1864.8,1290.24
X$3524 23200 23038 gf180mcu_fd_sc_mcu9t5v0__endcap
* cell instance $3525 m0 *1 1802.64,1300.32
X$3525 23411 23188 23319 23504 23525 gf180mcu_fd_sc_mcu9t5v0__nand2_1
* cell instance $3526 m90 *1 1864.8,1370.88
X$3526 25581 25705 gf180mcu_fd_sc_mcu9t5v0__endcap
* cell instance $3527 m0 *1 1808.24,1370.88
X$3527 25581 25430 gf180mcu_fd_sc_mcu9t5v0__filltie
* cell instance $3528 m0 *1 1796.48,1280.16
X$3528 22873 22872 15890 22700 22885 22913 gf180mcu_fd_sc_mcu9t5v0__mux2_1
* cell instance $3529 m0 *1 1806,1370.88
X$3529 25308 25430 25581 25568 gf180mcu_fd_sc_mcu9t5v0__clkinv_1
* cell instance $3530 r180 *1 1864.8,1370.88
X$3530 25581 25430 gf180mcu_fd_sc_mcu9t5v0__endcap
* cell instance $3531 m0 *1 1795.92,1370.88
X$3531 25567 25565 15890 25430 25581 25566 gf180mcu_fd_sc_mcu9t5v0__mux2_1
* cell instance $3532 m90 *1 1864.8,1249.92
X$3532 21997 22124 gf180mcu_fd_sc_mcu9t5v0__endcap
* cell instance $3533 r180 *1 1864.8,1260
X$3533 22295 22124 gf180mcu_fd_sc_mcu9t5v0__endcap
* cell instance $3534 m0 *1 1801.52,1310.4
X$3534 23711 24139 23525 23623 23797 23410 gf180mcu_fd_sc_mcu9t5v0__oai21_1
* cell instance $3535 m90 *1 1864.8,1330.56
X$3535 24414 24528 gf180mcu_fd_sc_mcu9t5v0__endcap
* cell instance $3536 m0 *1 1795.92,1300.32
X$3536 23411 23188 23354 23410 23409 23319 23504 23399
+ gf180mcu_fd_sc_mcu9t5v0__oai221_1
* cell instance $3537 m90 *1 1864.8,1360.8
X$3537 25268 25430 gf180mcu_fd_sc_mcu9t5v0__endcap
* cell instance $3538 m90 *1 1864.8,1310.4
X$3538 23797 23957 gf180mcu_fd_sc_mcu9t5v0__endcap
* cell instance $3539 r180 *1 1864.8,1320.48
X$3539 24118 23957 gf180mcu_fd_sc_mcu9t5v0__endcap
* cell instance $3540 m90 *1 1864.8,1320.48
X$3540 24118 24232 gf180mcu_fd_sc_mcu9t5v0__endcap
* cell instance $3541 r180 *1 1864.8,1330.56
X$3541 24414 24232 gf180mcu_fd_sc_mcu9t5v0__endcap
* cell instance $3542 r180 *1 1864.8,1340.64
X$3542 24712 24528 gf180mcu_fd_sc_mcu9t5v0__endcap
* cell instance $3543 r180 *1 1864.8,1300.32
X$3543 23504 23319 gf180mcu_fd_sc_mcu9t5v0__endcap
* cell instance $3544 r180 *1 1864.8,1270.08
X$3544 22577 22449 gf180mcu_fd_sc_mcu9t5v0__endcap
* cell instance $3545 m0 *1 1808.24,1270.08
X$3545 22577 22449 gf180mcu_fd_sc_mcu9t5v0__filltie
* cell instance $3546 m90 *1 1864.8,1350.72
X$3546 25000 25158 gf180mcu_fd_sc_mcu9t5v0__endcap
* cell instance $3547 m0 *1 1808.24,1340.64
X$3547 24712 24528 gf180mcu_fd_sc_mcu9t5v0__filltie
* cell instance $3548 m0 *1 1803.76,1290.24
X$3548 22873 23038 23200 23188 gf180mcu_fd_sc_mcu9t5v0__clkinv_1
* cell instance $3549 m0 *1 1802.64,1270.08
X$3549 22199 22449 22577 23711 gf180mcu_fd_sc_mcu9t5v0__clkinv_1
* cell instance $3550 r180 *1 1864.8,1350.72
X$3550 25000 24828 gf180mcu_fd_sc_mcu9t5v0__endcap
* cell instance $3551 m90 *1 1864.8,1300.32
X$3551 23504 23623 gf180mcu_fd_sc_mcu9t5v0__endcap
* cell instance $3552 r180 *1 1864.8,1310.4
X$3552 23797 23623 gf180mcu_fd_sc_mcu9t5v0__endcap
* cell instance $3553 m0 *1 1808.24,1290.24
X$3553 23200 23038 gf180mcu_fd_sc_mcu9t5v0__filltie
* cell instance $3554 m0 *1 1808.24,1350.72
X$3554 25000 24828 gf180mcu_fd_sc_mcu9t5v0__filltie
* cell instance $3555 m90 *1 1864.8,1340.64
X$3555 24712 24828 gf180mcu_fd_sc_mcu9t5v0__endcap
* cell instance $3556 m0 *1 1808.24,1280.16
X$3556 22885 22700 gf180mcu_fd_sc_mcu9t5v0__filltie
* cell instance $3557 r0 *1 1798.72,1280.16
X$3557 23031 22913 22873 14696 23038 22885 gf180mcu_fd_sc_mcu9t5v0__dffrnq_2
* cell instance $3558 r0 *1 1797.6,1290.24
X$3558 23411 23188 23354 23410 23319 23200 23353
+ gf180mcu_fd_sc_mcu9t5v0__oai22_1
* cell instance $3559 m0 *1 1804.32,1360.8
X$3559 25567 25158 25268 25022 gf180mcu_fd_sc_mcu9t5v0__clkinv_1
* cell instance $3560 r180 *1 1864.8,1360.8
X$3560 25268 25158 gf180mcu_fd_sc_mcu9t5v0__endcap
* cell instance $3561 m0 *1 1802.64,1350.72
X$3561 24616 24987 25022 25308 24828 25000 24429
+ gf180mcu_fd_sc_mcu9t5v0__aoi22_1
* cell instance $3562 m0 *1 1808.24,1360.8
X$3562 25268 25158 gf180mcu_fd_sc_mcu9t5v0__filltie
* cell instance $3563 m0 *1 1803.2,1340.64
X$3563 24616 24987 24528 24712 24431 gf180mcu_fd_sc_mcu9t5v0__nor2_1
* cell instance $3564 r0 *1 1800.96,1330.56
X$3564 23711 24139 24430 24429 24431 24528 24414 23354
+ gf180mcu_fd_sc_mcu9t5v0__aoi221_1
* cell instance $3565 m0 *1 1808.24,1320.48
X$3565 24118 23957 gf180mcu_fd_sc_mcu9t5v0__filltie
* cell instance $3566 r180 *1 1864.8,1249.92
X$3566 21997 21884 gf180mcu_fd_sc_mcu9t5v0__endcap
* cell instance $3567 r0 *1 1688.4,1310.4
X$3567 23797 23957 gf180mcu_fd_sc_mcu9t5v0__filltie
* cell instance $3568 r0 *1 1727.04,1310.4
X$3568 23945 23957 23797 23944 gf180mcu_fd_sc_mcu9t5v0__clkinv_1
* cell instance $3569 r0 *1 1720.32,1310.4
X$3569 23945 23957 23797 23943 23402 gf180mcu_fd_sc_mcu9t5v0__xor2_1
* cell instance $3570 r0 *1 1696.24,1310.4
X$3570 23941 23940 23942 23957 23797 22733 gf180mcu_fd_sc_mcu9t5v0__aoi21_1
* cell instance $3571 m0 *1 1723.68,1330.56
X$3571 23031 24262 24137 14696 24232 24414 gf180mcu_fd_sc_mcu9t5v0__dffrnq_2
* cell instance $3572 r0 *1 1717.52,1310.4
X$3572 23944 23943 23957 23797 23403 gf180mcu_fd_sc_mcu9t5v0__nand2_1
* cell instance $3573 r0 *1 1720.88,1350.72
X$3573 25150 25158 25000 25151 24852 gf180mcu_fd_sc_mcu9t5v0__xor2_1
* cell instance $3574 m0 *1 1710.8,1360.8
X$3574 25300 25173 25150 14696 25158 25268 gf180mcu_fd_sc_mcu9t5v0__dffrnq_2
* cell instance $3575 r0 *1 1669.36,1310.4
X$3575 24612 23957 23797 23938 gf180mcu_fd_sc_mcu9t5v0__clkinv_1
* cell instance $3576 r0 *1 1671.6,1310.4
X$3576 23522 23938 23957 23797 23939 gf180mcu_fd_sc_mcu9t5v0__nor2_1
* cell instance $3577 r0 *1 1751.68,1310.4
X$3577 20111 23524 22434 23957 23797 23406 gf180mcu_fd_sc_mcu9t5v0__mux2_1
* cell instance $3578 r0 *1 1720.88,1280.16
X$3578 22867 22868 23038 22885 22871 gf180mcu_fd_sc_mcu9t5v0__xnor2_1
* cell instance $3579 r0 *1 1724.8,1249.92
X$3579 16689 22026 22436 22124 21997 22151 gf180mcu_fd_sc_mcu9t5v0__mux2_1
* cell instance $3580 m0 *1 1723.12,1260
X$3580 21024 22151 22026 14696 22124 22295 gf180mcu_fd_sc_mcu9t5v0__dffrnq_2
* cell instance $3581 r0 *1 1727.04,1340.64
X$3581 24854 24855 23945 14696 24828 24712 gf180mcu_fd_sc_mcu9t5v0__dffrnq_2
* cell instance $3582 r0 *1 1727.04,1320.48
X$3582 16688 24137 22436 24232 24118 24262 gf180mcu_fd_sc_mcu9t5v0__mux2_1
* cell instance $3583 m0 *1 1729.84,1360.8
X$3583 25150 25151 25158 25268 25021 gf180mcu_fd_sc_mcu9t5v0__nand2_1
* cell instance $3584 m0 *1 1747.76,1360.8
X$3584 25303 25304 25158 25268 25152 gf180mcu_fd_sc_mcu9t5v0__nor2_1
* cell instance $3585 m0 *1 1767.36,1370.88
X$3585 22909 25565 22436 25430 25581 25731 gf180mcu_fd_sc_mcu9t5v0__mux2_1
* cell instance $3586 r0 *1 1737.68,1320.48
X$3586 24137 24264 24232 24118 24138 23710 gf180mcu_fd_sc_mcu9t5v0__xor3_1
* cell instance $3587 m0 *1 1734.88,1360.8
X$3587 25303 25021 25158 25268 24986 25304 gf180mcu_fd_sc_mcu9t5v0__xnor3_1
* cell instance $3588 m0 *1 1732.08,1370.88
X$3588 16935 25303 22436 25430 25581 25608 gf180mcu_fd_sc_mcu9t5v0__mux2_1
* cell instance $3589 m0 *1 1752.8,1360.8
X$3589 24854 25174 25154 14696 25158 25268 gf180mcu_fd_sc_mcu9t5v0__dffrnq_2
* cell instance $3590 r0 *1 1757.28,1370.88
X$3590 24854 25731 25565 14696 25705 25581 gf180mcu_fd_sc_mcu9t5v0__dffrnq_2
* cell instance $3591 r0 *1 1729.84,1370.88
X$3591 25300 25608 25303 14696 25705 25581 gf180mcu_fd_sc_mcu9t5v0__dffrnq_2
* cell instance $3592 m0 *1 1734.88,1350.72
X$3592 23945 24986 15890 24828 25000 24855 gf180mcu_fd_sc_mcu9t5v0__mux2_1
* cell instance $3593 r0 *1 1750.56,1320.48
X$3593 24264 24263 24320 24232 24118 22315 gf180mcu_fd_sc_mcu9t5v0__aoi21_1
* cell instance $3594 r0 *1 1743.28,1350.72
X$3594 25021 25152 25153 25158 25000 24264 gf180mcu_fd_sc_mcu9t5v0__oai21_1
* cell instance $3595 m0 *1 1741.6,1320.48
X$3595 24137 24138 23957 24118 24263 gf180mcu_fd_sc_mcu9t5v0__or2_1
* cell instance $3596 m0 *1 1743.28,1330.56
X$3596 24137 24138 24232 24414 24320 gf180mcu_fd_sc_mcu9t5v0__and2_1
* cell instance $3597 m0 *1 1773.52,1330.56
X$3597 24854 24266 24267 14696 24232 24414 gf180mcu_fd_sc_mcu9t5v0__dffrnq_2
* cell instance $3598 m0 *1 1775.2,1360.8
X$3598 22909 25306 22434 25158 25268 25305 gf180mcu_fd_sc_mcu9t5v0__mux2_1
* cell instance $3599 r0 *1 1771.84,1360.8
X$3599 24854 25305 25306 14696 25430 25268 gf180mcu_fd_sc_mcu9t5v0__dffrnq_2
* cell instance $3600 r0 *1 1744.4,1360.8
X$3600 25303 25304 25430 25268 25153 gf180mcu_fd_sc_mcu9t5v0__nand2_1
* cell instance $3601 r0 *1 1777.44,1320.48
X$3601 20543 24267 22436 24232 24118 24266 gf180mcu_fd_sc_mcu9t5v0__mux2_1
* cell instance $3602 m0 *1 1758.4,1340.64
X$3602 22024 24614 22436 24528 24712 24732 gf180mcu_fd_sc_mcu9t5v0__mux2_1
* cell instance $3603 r0 *1 1757.28,1320.48
X$3603 24138 25600 16821 24232 24118 24265 gf180mcu_fd_sc_mcu9t5v0__mux2_1
* cell instance $3604 m0 *1 1754.48,1330.56
X$3604 24854 24265 24138 14696 24232 24414 gf180mcu_fd_sc_mcu9t5v0__dffrnq_2
* cell instance $3605 m0 *1 1775.76,1340.64
X$3605 24615 24614 15890 24528 24712 24733 gf180mcu_fd_sc_mcu9t5v0__mux2_1
* cell instance $3606 m0 *1 1793.12,1350.72
X$3606 24615 24828 25000 24987 gf180mcu_fd_sc_mcu9t5v0__clkinv_1
* cell instance $3607 r0 *1 1757.84,1350.72
X$3607 22024 25154 22434 25158 25000 25174 gf180mcu_fd_sc_mcu9t5v0__mux2_1
* cell instance $3608 r0 *1 1753.92,1340.64
X$3608 24854 24732 24614 14696 24828 24712 gf180mcu_fd_sc_mcu9t5v0__dffrnq_2
* cell instance $3609 r0 *1 1772.96,1340.64
X$3609 24854 24733 24615 14696 24828 24712 gf180mcu_fd_sc_mcu9t5v0__dffrnq_2
* cell instance $3610 m0 *1 1664.88,1360.8
X$3610 25302 25301 15890 25158 25268 25340 gf180mcu_fd_sc_mcu9t5v0__mux2_1
* cell instance $3611 m0 *1 1669.92,1330.56
X$3611 24260 24259 24232 24414 24108 gf180mcu_fd_sc_mcu9t5v0__nand2_1
* cell instance $3612 m0 *1 1673.28,1320.48
X$3612 24109 23939 23351 24108 23957 24118 23400
+ gf180mcu_fd_sc_mcu9t5v0__oai31_1
* cell instance $3613 r0 *1 1692.88,1320.48
X$3613 23401 23941 24232 24118 24110 24261 gf180mcu_fd_sc_mcu9t5v0__xor3_1
* cell instance $3614 m0 *1 1701.28,1360.8
X$3614 25149 25148 25158 25268 24985 gf180mcu_fd_sc_mcu9t5v0__nand2_1
* cell instance $3615 m0 *1 1709.12,1320.48
X$3615 23660 24261 15890 23957 24118 24136 gf180mcu_fd_sc_mcu9t5v0__mux2_1
* cell instance $3616 r0 *1 1688.4,1370.88
X$3616 25581 25705 gf180mcu_fd_sc_mcu9t5v0__filltie
* cell instance $3617 r0 *1 1657.6,1340.64
X$3617 23521 24731 24612 14696 24828 24712 gf180mcu_fd_sc_mcu9t5v0__dffrnq_2
* cell instance $3618 r0 *1 1715.28,1370.88
X$3618 25151 25730 16821 25705 25581 25729 gf180mcu_fd_sc_mcu9t5v0__mux2_1
* cell instance $3619 r0 *1 1696.8,1350.72
X$3619 25149 25020 25158 25000 24853 25148 gf180mcu_fd_sc_mcu9t5v0__xnor3_1
* cell instance $3620 r0 *1 1667.68,1320.48
X$3620 24260 23984 24232 24118 22197 24259 gf180mcu_fd_sc_mcu9t5v0__xnor3_1
* cell instance $3621 m0 *1 1698.48,1350.72
X$3621 25020 24984 24985 24828 25000 23941 gf180mcu_fd_sc_mcu9t5v0__oai21_1
* cell instance $3622 r0 *1 1671.04,1330.56
X$3622 25302 24528 24414 24260 gf180mcu_fd_sc_mcu9t5v0__clkinv_1
* cell instance $3623 r0 *1 1709.12,1340.64
X$3623 23943 24853 15890 24828 24712 24613 gf180mcu_fd_sc_mcu9t5v0__mux2_1
* cell instance $3624 m0 *1 1693.44,1320.48
X$3624 23401 24110 23957 24118 23940 gf180mcu_fd_sc_mcu9t5v0__or2_1
* cell instance $3625 m0 *1 1697.92,1320.48
X$3625 23401 24110 23957 24118 23942 gf180mcu_fd_sc_mcu9t5v0__and2_1
* cell instance $3626 m0 *1 1697.92,1360.8
X$3626 25149 25148 25158 25268 24984 gf180mcu_fd_sc_mcu9t5v0__nor2_1
* cell instance $3627 r0 *1 1713.6,1350.72
X$3627 17553 25150 22436 25158 25000 25173 gf180mcu_fd_sc_mcu9t5v0__mux2_1
* cell instance $3628 r0 *1 1688.4,1340.64
X$3628 24712 24828 gf180mcu_fd_sc_mcu9t5v0__filltie
* cell instance $3629 r0 *1 1688.4,1330.56
X$3629 24414 24528 gf180mcu_fd_sc_mcu9t5v0__filltie
* cell instance $3630 r0 *1 1694,1360.8
X$3630 16935 25149 22434 25430 25268 25449 gf180mcu_fd_sc_mcu9t5v0__mux2_1
* cell instance $3631 r0 *1 1682.8,1360.8
X$3631 25563 26024 25430 25268 25020 gf180mcu_fd_sc_mcu9t5v0__nand2_1
* cell instance $3632 r0 *1 1688.4,1360.8
X$3632 25268 25430 gf180mcu_fd_sc_mcu9t5v0__filltie
* cell instance $3633 m0 *1 1705.2,1340.64
X$3633 23031 24613 23943 14696 24528 24712 gf180mcu_fd_sc_mcu9t5v0__dffrnq_2
* cell instance $3634 r0 *1 1688.4,1320.48
X$3634 24118 24232 gf180mcu_fd_sc_mcu9t5v0__filltie
* cell instance $3635 m0 *1 1688.4,1370.88
X$3635 25300 25449 25149 14696 25430 25581 gf180mcu_fd_sc_mcu9t5v0__dffrnq_2
* cell instance $3636 m0 *1 1672.72,1330.56
X$3636 24260 24259 24232 24414 24109 gf180mcu_fd_sc_mcu9t5v0__nor2_1
* cell instance $3637 m0 *1 1669.92,1320.48
X$3637 23939 23351 23957 24118 23984 gf180mcu_fd_sc_mcu9t5v0__nor2_1
* cell instance $3638 r0 *1 1705.76,1320.48
X$3638 23031 24136 23660 14696 24232 24118 gf180mcu_fd_sc_mcu9t5v0__dffrnq_2
* cell instance $3639 r0 *1 1688.4,1350.72
X$3639 25000 25158 gf180mcu_fd_sc_mcu9t5v0__filltie
* cell instance $3640 m0 *1 1660.96,1340.64
X$3640 24612 24982 15890 24528 24712 24731 gf180mcu_fd_sc_mcu9t5v0__mux2_1
* cell instance $3641 r0 *1 1689.52,1330.56
X$3641 25600 24110 16818 24528 24414 24319 gf180mcu_fd_sc_mcu9t5v0__mux2_1
* cell instance $3642 m0 *1 1673.28,1350.72
X$3642 23521 24983 24259 14696 24828 25000 gf180mcu_fd_sc_mcu9t5v0__dffrnq_2
* cell instance $3643 r0 *1 1681.12,1340.64
X$3643 24259 24852 15890 24828 24712 24983 gf180mcu_fd_sc_mcu9t5v0__mux2_1
* cell instance $3644 m0 *1 1681.68,1330.56
X$3644 23521 24319 24110 14696 24232 24414 gf180mcu_fd_sc_mcu9t5v0__dffrnq_2
* cell instance $3645 m0 *1 1672.72,1370.88
X$3645 17553 25563 22434 25430 25581 25564 gf180mcu_fd_sc_mcu9t5v0__mux2_1
* cell instance $3646 r0 *1 1667.68,1370.88
X$3646 25300 25564 25563 14696 25705 25581 gf180mcu_fd_sc_mcu9t5v0__dffrnq_2
* cell instance $3647 m0 *1 1666,1370.88
X$3647 25563 25430 25581 26024 25301 gf180mcu_fd_sc_mcu9t5v0__xor2_1
* cell instance $3648 r0 *1 1688.4,1300.32
X$3648 23504 23623 gf180mcu_fd_sc_mcu9t5v0__filltie
* cell instance $3649 m0 *1 1698.48,1260
X$3649 22148 22198 22147 22124 22295 21741 gf180mcu_fd_sc_mcu9t5v0__and3_1
* cell instance $3650 m0 *1 1719.2,1280.16
X$3650 22871 23187 22870 22700 22885 21397 gf180mcu_fd_sc_mcu9t5v0__and3_1
* cell instance $3651 m0 *1 1669.36,1310.4
X$3651 23522 23623 23797 24612 23398 gf180mcu_fd_sc_mcu9t5v0__xor2_1
* cell instance $3652 r0 *1 1688.4,1290.24
X$3652 23200 23319 gf180mcu_fd_sc_mcu9t5v0__filltie
* cell instance $3653 r0 *1 1690.64,1270.08
X$3653 22864 22865 22700 22577 22198 gf180mcu_fd_sc_mcu9t5v0__nand2_1
* cell instance $3654 m0 *1 1690.64,1280.16
X$3654 22864 22733 22700 22885 22866 22865 gf180mcu_fd_sc_mcu9t5v0__xnor3_1
* cell instance $3655 r0 *1 1701.84,1280.16
X$3655 23031 22910 22867 14696 23038 22885 gf180mcu_fd_sc_mcu9t5v0__dffrnq_2
* cell instance $3656 m0 *1 1704.64,1280.16
X$3656 22867 22866 15890 22700 22885 22910 gf180mcu_fd_sc_mcu9t5v0__mux2_1
* cell instance $3657 r0 *1 1693.44,1270.08
X$3657 22732 22733 22700 22577 22147 gf180mcu_fd_sc_mcu9t5v0__or2_1
* cell instance $3658 m0 *1 1691.76,1260
X$3658 22146 22145 22124 22295 22148 gf180mcu_fd_sc_mcu9t5v0__xnor2_1
* cell instance $3659 r0 *1 1694.56,1249.92
X$3659 22198 22147 22148 22124 21997 22025 gf180mcu_fd_sc_mcu9t5v0__aoi21_1
* cell instance $3660 r0 *1 1689.52,1300.32
X$3660 23031 23523 23401 14696 23623 23504 gf180mcu_fd_sc_mcu9t5v0__dffrnq_2
* cell instance $3661 m0 *1 1704.08,1260
X$3661 21024 22149 22146 14696 22124 22295 gf180mcu_fd_sc_mcu9t5v0__dffrnq_2
* cell instance $3662 m0 *1 1718.64,1290.24
X$3662 23187 22870 22871 23038 23200 21150 gf180mcu_fd_sc_mcu9t5v0__aoi21_1
* cell instance $3663 m0 *1 1717.52,1310.4
X$3663 23402 23400 23403 23623 23797 23709 gf180mcu_fd_sc_mcu9t5v0__oai21_1
* cell instance $3664 r0 *1 1711.36,1300.32
X$3664 23660 23623 23504 23404 gf180mcu_fd_sc_mcu9t5v0__clkinv_1
* cell instance $3665 m0 *1 1666,1280.16
X$3665 21024 22731 22864 14696 22700 22885 gf180mcu_fd_sc_mcu9t5v0__dffrnq_2
* cell instance $3666 m0 *1 1660.4,1249.92
X$3666 21024 21870 20391 14696 21884 21997 gf180mcu_fd_sc_mcu9t5v0__dffrnq_2
* cell instance $3667 r0 *1 1671.04,1270.08
X$3667 16689 22864 22434 22700 22577 22731 gf180mcu_fd_sc_mcu9t5v0__mux2_1
* cell instance $3668 m0 *1 1663.2,1260
X$3668 22197 21257 14872 22124 22295 22438 gf180mcu_fd_sc_mcu9t5v0__mux2_1
* cell instance $3669 r0 *1 1658.72,1290.24
X$3669 22473 14872 23319 23200 23350 gf180mcu_fd_sc_mcu9t5v0__nand2_1
* cell instance $3670 r0 *1 1665.44,1290.24
X$3670 14872 23351 23396 23350 23319 23200 23349
+ gf180mcu_fd_sc_mcu9t5v0__oai31_1
* cell instance $3671 m0 *1 1713.6,1280.16
X$3671 22867 22700 22885 22869 gf180mcu_fd_sc_mcu9t5v0__clkinv_1
* cell instance $3672 r0 *1 1688.4,1280.16
X$3672 22885 23038 gf180mcu_fd_sc_mcu9t5v0__filltie
* cell instance $3673 m0 *1 1715.84,1280.16
X$3673 22869 22868 22700 22885 21564 gf180mcu_fd_sc_mcu9t5v0__nor2_1
* cell instance $3674 r0 *1 1690.08,1249.92
X$3674 22146 22145 22025 22124 21997 20725 gf180mcu_fd_sc_mcu9t5v0__aoi21_1
* cell instance $3675 r0 *1 1708.56,1249.92
X$3675 20723 22124 21997 21024 gf180mcu_fd_sc_mcu9t5v0__clkbuf_8
* cell instance $3676 r0 *1 1713.6,1300.32
X$3676 23405 23709 23623 23504 22196 23660 gf180mcu_fd_sc_mcu9t5v0__xnor3_1
* cell instance $3677 r0 *1 1688.4,1260
X$3677 22295 22449 gf180mcu_fd_sc_mcu9t5v0__filltie
* cell instance $3678 r0 *1 1710.8,1260
X$3678 22146 22434 22449 22295 22150 gf180mcu_fd_sc_mcu9t5v0__nand2_1
* cell instance $3679 r0 *1 1688.4,1270.08
X$3679 22577 22700 gf180mcu_fd_sc_mcu9t5v0__filltie
* cell instance $3680 r0 *1 1704.08,1249.92
X$3680 22434 16690 22150 22124 21997 22149 gf180mcu_fd_sc_mcu9t5v0__oai21_1
* cell instance $3681 m0 *1 1672.72,1300.32
X$3681 23397 23399 23398 23319 23504 23396 gf180mcu_fd_sc_mcu9t5v0__and3_1
* cell instance $3682 r0 *1 1688.4,1249.92
X$3682 21997 22124 gf180mcu_fd_sc_mcu9t5v0__filltie
* cell instance $3683 m0 *1 1699.6,1300.32
X$3683 23402 23319 23504 23400 23057 gf180mcu_fd_sc_mcu9t5v0__xor2_1
* cell instance $3684 m0 *1 1708.56,1249.92
X$3684 21024 21884 21997 gf180mcu_fd_sc_mcu9t5v0__clkinv_3
* cell instance $3685 m0 *1 1687.28,1280.16
X$3685 22864 22865 22700 22885 22732 gf180mcu_fd_sc_mcu9t5v0__nor2_1
* cell instance $3686 r0 *1 1680.56,1249.92
X$3686 22024 22145 16818 22124 21997 22144 gf180mcu_fd_sc_mcu9t5v0__mux2_1
* cell instance $3687 r0 *1 1681.12,1280.16
X$3687 22909 22865 16818 23038 22885 23058 gf180mcu_fd_sc_mcu9t5v0__mux2_1
* cell instance $3688 m0 *1 1692.32,1300.32
X$3688 16688 23401 22434 23319 23504 23523 gf180mcu_fd_sc_mcu9t5v0__mux2_1
* cell instance $3689 m0 *1 1715.84,1300.32
X$3689 23405 23404 23402 23400 23403 23319 23504 22870
+ gf180mcu_fd_sc_mcu9t5v0__oai221_1
* cell instance $3690 m0 *1 1722.56,1300.32
X$3690 23405 23404 23319 23504 23187 gf180mcu_fd_sc_mcu9t5v0__nand2_1
* cell instance $3691 m0 *1 1677.76,1290.24
X$3691 23031 23058 22865 14696 23038 23200 gf180mcu_fd_sc_mcu9t5v0__dffrnq_2
* cell instance $3692 m0 *1 1672.72,1260
X$3692 21024 22144 22145 14696 22124 22295 gf180mcu_fd_sc_mcu9t5v0__dffrnq_2
* cell instance $3693 m0 *1 1678.32,1300.32
X$3693 23397 23399 23398 23319 23504 23351 gf180mcu_fd_sc_mcu9t5v0__aoi21_1
* cell instance $3694 r0 *1 1760.64,1280.16
X$3694 23031 23032 23352 14696 23038 22885 gf180mcu_fd_sc_mcu9t5v0__dffrnq_2
* cell instance $3695 m0 *1 1761.76,1310.4
X$3695 23407 23524 15890 23623 23797 23662 gf180mcu_fd_sc_mcu9t5v0__mux2_1
* cell instance $3696 m0 *1 1747.2,1310.4
X$3696 20723 23623 23797 23031 gf180mcu_fd_sc_mcu9t5v0__clkbuf_8
* cell instance $3697 m0 *1 1747.76,1280.16
X$3697 23031 22734 22735 14696 22700 22885 gf180mcu_fd_sc_mcu9t5v0__dffrnq_2
* cell instance $3698 m0 *1 1737.68,1310.4
X$3698 23405 23710 15890 23623 23797 23661 gf180mcu_fd_sc_mcu9t5v0__mux2_1
* cell instance $3699 m0 *1 1769.6,1300.32
X$3699 23352 23319 23504 23408 gf180mcu_fd_sc_mcu9t5v0__clkinv_1
* cell instance $3700 m0 *1 1766.8,1300.32
X$3700 23407 23408 23319 23504 23397 gf180mcu_fd_sc_mcu9t5v0__nand2_1
* cell instance $3701 r0 *1 1777.44,1249.92
X$3701 20543 22155 22434 22124 21997 22154 gf180mcu_fd_sc_mcu9t5v0__mux2_1
* cell instance $3702 r0 *1 1730.96,1280.16
X$3702 23031 22911 22868 14696 23038 22885 gf180mcu_fd_sc_mcu9t5v0__dffrnq_2
* cell instance $3703 r0 *1 1752.24,1260
X$3703 21024 22316 22152 14696 22449 22295 gf180mcu_fd_sc_mcu9t5v0__dffrnq_2
* cell instance $3704 m0 *1 1752.8,1249.92
X$3704 21024 21873 21742 14696 21884 21997 gf180mcu_fd_sc_mcu9t5v0__dffrnq_2
* cell instance $3705 m0 *1 1763.44,1290.24
X$3705 23352 22735 15890 23038 23200 23032 gf180mcu_fd_sc_mcu9t5v0__mux2_1
* cell instance $3706 m0 *1 1780.24,1280.16
X$3706 21395 22872 22436 22700 22885 22912 gf180mcu_fd_sc_mcu9t5v0__mux2_1
* cell instance $3707 m0 *1 1742.16,1260
X$3707 22153 22315 22124 22295 21900 gf180mcu_fd_sc_mcu9t5v0__or2_1
* cell instance $3708 r0 *1 1784.72,1290.24
X$3708 23409 23353 23319 23200 23221 gf180mcu_fd_sc_mcu9t5v0__xnor2_1
* cell instance $3709 m0 *1 1772.96,1260
X$3709 21024 22154 22155 14696 22124 22295 gf180mcu_fd_sc_mcu9t5v0__dffrnq_2
* cell instance $3710 m0 *1 1744.4,1300.32
X$3710 23031 23406 23524 14696 23319 23504 gf180mcu_fd_sc_mcu9t5v0__dffrnq_2
* cell instance $3711 r0 *1 1737.68,1260
X$3711 22026 22152 22449 22295 21899 gf180mcu_fd_sc_mcu9t5v0__nand2_1
* cell instance $3712 m0 *1 1742.72,1249.92
X$3712 21899 21900 21872 21884 21997 21871 gf180mcu_fd_sc_mcu9t5v0__aoi21_1
* cell instance $3713 m0 *1 1771.84,1310.4
X$3713 23031 23663 23664 14696 23623 23797 gf180mcu_fd_sc_mcu9t5v0__dffrnq_2
* cell instance $3714 r0 *1 1737.68,1249.92
X$3714 22026 22152 22124 21997 22153 gf180mcu_fd_sc_mcu9t5v0__nor2_1
* cell instance $3715 r0 *1 1749.44,1300.32
X$3715 23031 23623 23504 gf180mcu_fd_sc_mcu9t5v0__inv_3
* cell instance $3716 m0 *1 1774.64,1300.32
X$3716 23407 23352 23319 23504 23409 gf180mcu_fd_sc_mcu9t5v0__xnor2_1
* cell instance $3717 r0 *1 1730.4,1300.32
X$3717 23031 23661 23405 14696 23623 23504 gf180mcu_fd_sc_mcu9t5v0__dffrnq_2
* cell instance $3718 r0 *1 1755.6,1300.32
X$3718 23031 23662 23407 14696 23623 23504 gf180mcu_fd_sc_mcu9t5v0__dffrnq_2
* cell instance $3719 m0 *1 1737.12,1249.92
X$3719 21872 21899 21900 21884 21997 21621 gf180mcu_fd_sc_mcu9t5v0__and3_1
* cell instance $3720 m0 *1 1755.6,1260
X$3720 22152 22909 16821 22124 22295 22316 gf180mcu_fd_sc_mcu9t5v0__mux2_1
* cell instance $3721 m0 *1 1733.76,1270.08
X$3721 22026 22315 22449 22577 22481 22152 gf180mcu_fd_sc_mcu9t5v0__xnor3_1
* cell instance $3722 m0 *1 1737.12,1280.16
X$3722 22868 22481 15890 22700 22885 22911 gf180mcu_fd_sc_mcu9t5v0__mux2_1
* cell instance $3723 r0 *1 1752.8,1270.08
X$3723 20111 22735 22436 22700 22577 22734 gf180mcu_fd_sc_mcu9t5v0__mux2_1
* cell instance $3724 r0 *1 1776.88,1300.32
X$3724 21395 23664 22434 23623 23504 23663 gf180mcu_fd_sc_mcu9t5v0__mux2_1
* cell instance $3725 m0 *1 1720.32,1189.44
X$3725 18172 20116 20065 14696 20028 20217 gf180mcu_fd_sc_mcu9t5v0__dffrnq_2
* cell instance $3726 m0 *1 1714.72,1179.36
X$3726 18172 19756 19628 14696 19729 19901 gf180mcu_fd_sc_mcu9t5v0__dffrnq_2
* cell instance $3727 m0 *1 1720.32,1239.84
X$3727 21024 21620 21563 14696 21537 21719 gf180mcu_fd_sc_mcu9t5v0__dffrnq_2
* cell instance $3728 r0 *1 1745.52,1169.28
X$3728 19441 19757 15890 19729 19605 19593 gf180mcu_fd_sc_mcu9t5v0__mux2_1
* cell instance $3729 r0 *1 1688.4,1169.28
X$3729 19605 19729 gf180mcu_fd_sc_mcu9t5v0__filltie
* cell instance $3730 r0 *1 1691.76,1169.28
X$3730 18172 19467 19439 14696 19729 19605 gf180mcu_fd_sc_mcu9t5v0__dffrnq_2
* cell instance $3731 r0 *1 1669.36,1169.28
X$3731 18172 19627 19019 14696 19729 19605 gf180mcu_fd_sc_mcu9t5v0__dffrnq_2
* cell instance $3732 r0 *1 1689.52,1169.28
X$3732 18172 19729 19605 33570 gf180mcu_fd_sc_mcu9t5v0__clkinv_1
* cell instance $3733 r0 *1 1716.4,1169.28
X$3733 19628 19755 15890 19729 19605 19756 gf180mcu_fd_sc_mcu9t5v0__mux2_1
* cell instance $3734 r0 *1 1721.44,1189.44
X$3734 20065 20404 15890 20379 20217 20116 gf180mcu_fd_sc_mcu9t5v0__mux2_1
* cell instance $3735 r0 *1 1708.56,1209.6
X$3735 21024 20973 20724 14696 20936 20822 gf180mcu_fd_sc_mcu9t5v0__dffrnq_2
* cell instance $3736 r0 *1 1724.8,1159.2
X$3736 19628 19448 19282 19441 19162 gf180mcu_fd_sc_mcu9t5v0__xor2_1
* cell instance $3737 r0 *1 1712.48,1128.96
X$3737 18172 18466 16983 14696 18553 18386 gf180mcu_fd_sc_mcu9t5v0__dffrnq_2
* cell instance $3738 r0 *1 1726.48,1149.12
X$3738 19188 19022 19171 18996 19164 gf180mcu_fd_sc_mcu9t5v0__nand2_1
* cell instance $3739 m0 *1 1789.76,1179.36
X$3739 19729 19901 18007 gf180mcu_fd_sc_mcu9t5v0__tieh
* cell instance $3740 m0 *1 1780.24,1179.36
X$3740 19729 19901 17979 gf180mcu_fd_sc_mcu9t5v0__tiel
* cell instance $3741 m0 *1 1744.4,1199.52
X$3741 20406 20544 20379 20507 20407 gf180mcu_fd_sc_mcu9t5v0__nand2_1
* cell instance $3742 r0 *1 1729.84,1219.68
X$3742 21024 21027 20406 14696 21241 21123 gf180mcu_fd_sc_mcu9t5v0__dffrnq_2
* cell instance $3743 m0 *1 1728.16,1209.6
X$3743 21024 20676 20544 14696 20637 20822 gf180mcu_fd_sc_mcu9t5v0__dffrnq_2
* cell instance $3744 m0 *1 1736.56,1219.68
X$3744 20406 22436 20936 21123 21028 gf180mcu_fd_sc_mcu9t5v0__nand2_1
* cell instance $3745 m0 *1 1743.84,1229.76
X$3745 16690 22436 21399 21241 21412 21398 gf180mcu_fd_sc_mcu9t5v0__oai21_1
* cell instance $3746 m0 *1 1739.92,1199.52
X$3746 20406 20544 20405 20379 20507 20113 gf180mcu_fd_sc_mcu9t5v0__oai21_1
* cell instance $3747 m0 *1 1747.2,1199.52
X$3747 20407 20545 20379 20507 20405 gf180mcu_fd_sc_mcu9t5v0__nand2_1
* cell instance $3748 r0 *1 1741.04,1199.52
X$3748 20406 20545 20637 20507 19757 20544 gf180mcu_fd_sc_mcu9t5v0__xnor3_1
* cell instance $3749 r0 *1 1727.6,1229.76
X$3749 17977 21871 21621 21443 21537 21412 21620
+ gf180mcu_fd_sc_mcu9t5v0__oai31_1
* cell instance $3750 m0 *1 1748.32,1229.76
X$3750 21024 21398 21263 14696 21241 21412 gf180mcu_fd_sc_mcu9t5v0__dffrnq_2
* cell instance $3751 m0 *1 1751.12,1239.84
X$3751 21263 21742 21871 21537 21719 20545 gf180mcu_fd_sc_mcu9t5v0__aoi21_1
* cell instance $3752 r0 *1 1733.2,1199.52
X$3752 20544 20543 16821 20637 20507 20676 gf180mcu_fd_sc_mcu9t5v0__mux2_1
* cell instance $3753 r0 *1 1753.36,1219.68
X$3753 21263 22436 21241 21123 21399 gf180mcu_fd_sc_mcu9t5v0__nand2_1
* cell instance $3754 m0 *1 1730.96,1219.68
X$3754 21026 22436 21028 20936 21123 21027 gf180mcu_fd_sc_mcu9t5v0__oai21_1
* cell instance $3755 m0 *1 1665.44,1189.44
X$3755 20063 20111 16821 20028 20217 20237 gf180mcu_fd_sc_mcu9t5v0__mux2_1
* cell instance $3756 r0 *1 1688.4,1219.68
X$3756 21123 21241 gf180mcu_fd_sc_mcu9t5v0__filltie
* cell instance $3757 r0 *1 1659.28,1189.44
X$3757 18172 20237 20063 14696 20379 20217 gf180mcu_fd_sc_mcu9t5v0__dffrnq_2
* cell instance $3758 m0 *1 1709.68,1239.84
X$3758 21563 21396 21537 21719 21442 gf180mcu_fd_sc_mcu9t5v0__nand2_1
* cell instance $3759 r0 *1 1681.12,1209.6
X$3759 20724 20675 20970 20936 20822 20969 gf180mcu_fd_sc_mcu9t5v0__oai21_1
* cell instance $3760 m0 *1 1659.28,1209.6
X$3760 18172 20674 20675 14696 20637 20822 gf180mcu_fd_sc_mcu9t5v0__dffrnq_2
* cell instance $3761 r0 *1 1663.76,1219.68
X$3761 21261 21148 21241 21123 21149 gf180mcu_fd_sc_mcu9t5v0__nand2_1
* cell instance $3762 m0 *1 1668.24,1219.68
X$3762 21023 20969 21149 20936 21123 19437 gf180mcu_fd_sc_mcu9t5v0__oai21_1
* cell instance $3763 r0 *1 1669.92,1219.68
X$3763 21261 20969 21241 21123 19438 21148 gf180mcu_fd_sc_mcu9t5v0__xnor3_1
* cell instance $3764 m0 *1 1682.8,1239.84
X$3764 21024 21619 21562 14696 21537 21719 gf180mcu_fd_sc_mcu9t5v0__dffrnq_2
* cell instance $3765 r0 *1 1711.92,1229.76
X$3765 21441 21564 21397 21442 21537 21412 19163
+ gf180mcu_fd_sc_mcu9t5v0__oai31_1
* cell instance $3766 r0 *1 1666.56,1219.68
X$3766 21261 21148 21241 21123 21023 gf180mcu_fd_sc_mcu9t5v0__nor2_1
* cell instance $3767 r0 *1 1688.4,1229.76
X$3767 21412 21537 gf180mcu_fd_sc_mcu9t5v0__filltie
* cell instance $3768 r0 *1 1688.4,1189.44
X$3768 20217 20379 gf180mcu_fd_sc_mcu9t5v0__filltie
* cell instance $3769 r0 *1 1689.52,1189.44
X$3769 18172 20363 20402 14696 20379 20217 gf180mcu_fd_sc_mcu9t5v0__dffrnq_2
* cell instance $3770 r0 *1 1689.52,1209.6
X$3770 20971 20725 20936 20822 20970 gf180mcu_fd_sc_mcu9t5v0__nand2_1
* cell instance $3771 m0 *1 1690.64,1219.68
X$3771 21024 21025 17262 14696 20936 21123 gf180mcu_fd_sc_mcu9t5v0__dffrnq_2
* cell instance $3772 m0 *1 1662.64,1229.76
X$3772 21395 21148 16818 21241 21412 21439 gf180mcu_fd_sc_mcu9t5v0__mux2_1
* cell instance $3773 r0 *1 1683.92,1189.44
X$3773 20112 20063 20379 20217 18279 gf180mcu_fd_sc_mcu9t5v0__nand2_1
* cell instance $3774 r0 *1 1688.4,1209.6
X$3774 20822 20936 gf180mcu_fd_sc_mcu9t5v0__filltie
* cell instance $3775 r0 *1 1708.56,1189.44
X$3775 20403 20113 20379 20217 20404 20402 gf180mcu_fd_sc_mcu9t5v0__xnor3_1
* cell instance $3776 m0 *1 1693.44,1199.52
X$3776 20402 21395 16821 20379 20507 20363 gf180mcu_fd_sc_mcu9t5v0__mux2_1
* cell instance $3777 r0 *1 1688.4,1199.52
X$3777 20507 20637 gf180mcu_fd_sc_mcu9t5v0__filltie
* cell instance $3778 m0 *1 1710.24,1229.76
X$3778 21563 21396 21241 21412 21441 gf180mcu_fd_sc_mcu9t5v0__nor2_1
* cell instance $3779 r0 *1 1705.76,1209.6
X$3779 17262 14872 20936 20822 20972 gf180mcu_fd_sc_mcu9t5v0__nand2_1
* cell instance $3780 r0 *1 1693.44,1229.76
X$3780 21562 17977 21537 21412 21440 gf180mcu_fd_sc_mcu9t5v0__nand2_1
* cell instance $3781 r0 *1 1683.92,1179.36
X$3781 20112 20063 20064 20028 19901 18418 gf180mcu_fd_sc_mcu9t5v0__oai21_1
* cell instance $3782 m0 *1 1678.32,1189.44
X$3782 20112 20064 20028 20217 20063 19592 gf180mcu_fd_sc_mcu9t5v0__xor3_1
* cell instance $3783 m0 *1 1681.68,1209.6
X$3783 20724 20725 20637 20822 19755 20675 gf180mcu_fd_sc_mcu9t5v0__xnor3_1
* cell instance $3784 r0 *1 1685.6,1209.6
X$3784 20724 20675 20936 20822 20971 gf180mcu_fd_sc_mcu9t5v0__nand2_1
* cell instance $3785 m0 *1 1704.64,1199.52
X$3785 20403 20402 20379 20507 20114 gf180mcu_fd_sc_mcu9t5v0__nor2_1
* cell instance $3786 r0 *1 1718.64,1179.36
X$3786 20065 20028 19901 19468 gf180mcu_fd_sc_mcu9t5v0__clkinv_1
* cell instance $3787 m0 *1 1714.72,1209.6
X$3787 20724 22434 20637 20822 20726 gf180mcu_fd_sc_mcu9t5v0__nand2_1
* cell instance $3788 m0 *1 1708,1199.52
X$3788 20403 20402 20379 20507 20115 gf180mcu_fd_sc_mcu9t5v0__nand2_1
* cell instance $3789 m0 *1 1704.64,1189.44
X$3789 20114 20113 20115 20028 20217 20064 gf180mcu_fd_sc_mcu9t5v0__oai21_1
* cell instance $3790 r0 *1 1688.4,1179.36
X$3790 19901 20028 gf180mcu_fd_sc_mcu9t5v0__filltie
* cell instance $3791 m0 *1 1711.92,1219.68
X$3791 22434 21026 20726 20936 21123 20973 gf180mcu_fd_sc_mcu9t5v0__oai21_1
* cell instance $3792 r0 *1 1709.68,1219.68
X$3792 14872 21397 21150 20972 21241 21123 21025
+ gf180mcu_fd_sc_mcu9t5v0__oai31_1
* cell instance $3793 r0 *1 1707.44,1229.76
X$3793 21564 21397 21537 21412 21262 gf180mcu_fd_sc_mcu9t5v0__or2_1
* cell instance $3794 r0 *1 1696.24,1229.76
X$3794 21563 21537 21412 21562 21394 gf180mcu_fd_sc_mcu9t5v0__xor2_1
* cell instance $3795 m0 *1 1705.2,1239.84
X$3795 21562 21537 21719 21396 gf180mcu_fd_sc_mcu9t5v0__clkinv_1
* cell instance $3796 r0 *1 1666.56,1199.52
X$3796 20543 20675 16818 20637 20507 20674 gf180mcu_fd_sc_mcu9t5v0__mux2_1
* cell instance $3797 r0 *1 1673.28,1128.96
X$3797 18465 18553 18386 18006 gf180mcu_fd_sc_mcu9t5v0__clkinv_1
* cell instance $3798 m0 *1 1672.16,1118.88
X$3798 18006 18127 17985 18104 17852 gf180mcu_fd_sc_mcu9t5v0__or2_1
* cell instance $3799 r0 *1 1668.8,1128.96
X$3799 18465 17977 18553 18386 18637 gf180mcu_fd_sc_mcu9t5v0__nand2_1
* cell instance $3800 r0 *1 1668.8,1149.12
X$3800 19156 19155 15890 19171 18996 19154 gf180mcu_fd_sc_mcu9t5v0__mux2_1
* cell instance $3801 m0 *1 1669.92,1118.88
X$3801 18126 17985 18104 17853 gf180mcu_fd_sc_mcu9t5v0__clkinv_1
* cell instance $3802 m0 *1 1686.72,1159.2
X$3802 19156 19019 19171 19282 19158 gf180mcu_fd_sc_mcu9t5v0__xnor2_1
* cell instance $3803 m0 *1 1683.92,1128.96
X$3803 18279 18418 18280 18268 18386 17738 gf180mcu_fd_sc_mcu9t5v0__aoi21_1
* cell instance $3804 m0 *1 1676.64,1118.88
X$3804 18006 18127 17985 18104 18126 gf180mcu_fd_sc_mcu9t5v0__nand2_1
* cell instance $3805 r0 *1 1681.12,1149.12
X$3805 19019 19171 18996 19157 gf180mcu_fd_sc_mcu9t5v0__clkinv_1
* cell instance $3806 m0 *1 1685.6,1169.28
X$3806 20723 19448 19605 18172 gf180mcu_fd_sc_mcu9t5v0__clkbuf_8
* cell instance $3807 m0 *1 1664.88,1159.2
X$3807 18172 19154 19156 14696 19171 19282 gf180mcu_fd_sc_mcu9t5v0__dffrnq_2
* cell instance $3808 r0 *1 1706.88,1108.8
X$3808 15043 17854 17613 14696 17985 17837 gf180mcu_fd_sc_mcu9t5v0__dffrnq_2
* cell instance $3809 r0 *1 1722,1159.2
X$3809 19628 19440 19448 19282 19188 gf180mcu_fd_sc_mcu9t5v0__nand2_1
* cell instance $3810 r0 *1 1715.28,1149.12
X$3810 19162 19163 19171 18996 19022 gf180mcu_fd_sc_mcu9t5v0__or2_1
* cell instance $3811 m0 *1 1716.4,1139.04
X$3811 14872 18641 18563 18553 18731 18466 gf180mcu_fd_sc_mcu9t5v0__oai21_1
* cell instance $3812 r0 *1 1709.12,1159.2
X$3812 19468 19439 19448 19282 19159 gf180mcu_fd_sc_mcu9t5v0__or2_1
* cell instance $3813 m0 *1 1688.4,1128.96
X$3813 18280 18279 18418 18268 18386 18281 gf180mcu_fd_sc_mcu9t5v0__and3_1
* cell instance $3814 m0 *1 1694.56,1118.88
X$3814 18127 17977 17985 18104 18128 gf180mcu_fd_sc_mcu9t5v0__nand2_1
* cell instance $3815 r0 *1 1696.24,1118.88
X$3815 17977 17738 18281 18128 18268 18104 18174
+ gf180mcu_fd_sc_mcu9t5v0__oai31_1
* cell instance $3816 r0 *1 1712.48,1149.12
X$3816 19160 19159 19171 18996 19161 gf180mcu_fd_sc_mcu9t5v0__nand2_1
* cell instance $3817 m0 *1 1697.36,1159.2
X$3817 19159 19021 19158 19171 19282 18986 gf180mcu_fd_sc_mcu9t5v0__aoi21_1
* cell instance $3818 m0 *1 1697.92,1128.96
X$3818 18172 18174 18127 14696 18268 18386 gf180mcu_fd_sc_mcu9t5v0__dffrnq_2
* cell instance $3819 r0 *1 1713.6,1159.2
X$3819 19468 19439 19448 19282 19160 gf180mcu_fd_sc_mcu9t5v0__nand2_1
* cell instance $3820 m0 *1 1721.44,1149.12
X$3820 19022 18987 18841 18996 18641 gf180mcu_fd_sc_mcu9t5v0__nand2_1
* cell instance $3821 m0 *1 1717.52,1128.96
X$3821 16983 14872 18268 18386 18563 gf180mcu_fd_sc_mcu9t5v0__nand2_1
* cell instance $3822 r0 *1 1688.4,1159.2
X$3822 19282 19448 gf180mcu_fd_sc_mcu9t5v0__filltie
* cell instance $3823 r0 *1 1688.4,1149.12
X$3823 18996 19171 gf180mcu_fd_sc_mcu9t5v0__filltie
* cell instance $3824 m0 *1 1718.64,1149.12
X$3824 19162 19163 18841 18996 18987 gf180mcu_fd_sc_mcu9t5v0__nand2_1
* cell instance $3825 m0 *1 1716.4,1159.2
X$3825 19162 19163 19160 19188 19171 19282 19021
+ gf180mcu_fd_sc_mcu9t5v0__oai211_1
* cell instance $3826 m0 *1 1692.88,1139.04
X$3826 16175 14872 18553 18731 18640 gf180mcu_fd_sc_mcu9t5v0__nand2_1
* cell instance $3827 r0 *1 1695.12,1159.2
X$3827 19439 19438 15890 19448 19282 19467 gf180mcu_fd_sc_mcu9t5v0__mux2_1
* cell instance $3828 m0 *1 1692.88,1149.12
X$3828 14872 19020 18986 18640 18841 18996 18985
+ gf180mcu_fd_sc_mcu9t5v0__oai31_1
* cell instance $3829 r0 *1 1688.4,1118.88
X$3829 18104 18268 gf180mcu_fd_sc_mcu9t5v0__filltie
* cell instance $3830 r0 *1 1688.4,1139.04
X$3830 18731 18841 gf180mcu_fd_sc_mcu9t5v0__filltie
* cell instance $3831 r0 *1 1688.4,1108.8
X$3831 17837 17985 gf180mcu_fd_sc_mcu9t5v0__filltie
* cell instance $3832 m0 *1 1661.52,1139.04
X$3832 18172 18639 18465 14696 18553 18731 gf180mcu_fd_sc_mcu9t5v0__dffrnq_2
* cell instance $3833 r0 *1 1688.4,1128.96
X$3833 18386 18553 gf180mcu_fd_sc_mcu9t5v0__filltie
* cell instance $3834 r0 *1 1683.36,1149.12
X$3834 19156 19157 19020 19171 18996 17735 gf180mcu_fd_sc_mcu9t5v0__aoi21_1
* cell instance $3835 r0 *1 1696.8,1149.12
X$3835 19158 19159 19021 19171 18996 19020 gf180mcu_fd_sc_mcu9t5v0__and3_1
* cell instance $3836 r0 *1 1719.76,1149.12
X$3836 19164 19161 19171 18996 17614 gf180mcu_fd_sc_mcu9t5v0__xnor2_1
* cell instance $3837 r0 *1 1669.36,1118.88
X$3837 18006 17735 18268 18104 15760 18127 gf180mcu_fd_sc_mcu9t5v0__xnor3_1
* cell instance $3838 r0 *1 1689.52,1118.88
X$3838 16215 17736 18268 18104 18280 gf180mcu_fd_sc_mcu9t5v0__xnor2_1
* cell instance $3839 r0 *1 1689.52,1139.04
X$3839 18172 18985 16175 14696 18841 18731 gf180mcu_fd_sc_mcu9t5v0__dffrnq_2
* cell instance $3840 m0 *1 1678.32,1169.28
X$3840 19019 19592 15890 19448 19605 19627 gf180mcu_fd_sc_mcu9t5v0__mux2_1
* cell instance $3841 r0 *1 1658.16,1159.2
X$3841 19466 19436 19437 19448 19282 18984 gf180mcu_fd_sc_mcu9t5v0__oai21_1
* cell instance $3842 m0 *1 1657.6,1169.28
X$3842 19466 19437 19448 19605 19436 19155 gf180mcu_fd_sc_mcu9t5v0__xor3_1
* cell instance $3843 m0 *1 1728.72,1169.28
X$3843 19441 19448 19605 19440 gf180mcu_fd_sc_mcu9t5v0__clkinv_1
* cell instance $3844 m0 *1 1739.36,1169.28
X$3844 18172 19593 19441 14696 19448 19605 gf180mcu_fd_sc_mcu9t5v0__dffrnq_2
* cell instance $3845 m0 *1 1808.24,1229.76
X$3845 21412 21241 gf180mcu_fd_sc_mcu9t5v0__filltie
* cell instance $3846 r180 *1 1864.8,1179.36
X$3846 33924 33852 gf180mcu_fd_sc_mcu9t5v0__endcap
* cell instance $3847 m90 *1 1864.8,1199.52
X$3847 20507 20637 gf180mcu_fd_sc_mcu9t5v0__endcap
* cell instance $3848 m0 *1 1808.24,1159.2
X$3848 19282 19171 gf180mcu_fd_sc_mcu9t5v0__filltie
* cell instance $3849 m90 *1 1864.8,1139.04
X$3849 33915 33850 gf180mcu_fd_sc_mcu9t5v0__endcap
* cell instance $3850 m90 *1 1864.8,1108.8
X$3850 33914 33846 gf180mcu_fd_sc_mcu9t5v0__endcap
* cell instance $3851 r180 *1 1864.8,1118.88
X$3851 33925 33846 gf180mcu_fd_sc_mcu9t5v0__endcap
* cell instance $3852 m90 *1 1864.8,1118.88
X$3852 33925 33853 gf180mcu_fd_sc_mcu9t5v0__endcap
* cell instance $3853 m90 *1 1864.8,1179.36
X$3853 33924 20028 gf180mcu_fd_sc_mcu9t5v0__endcap
* cell instance $3854 r180 *1 1864.8,1128.96
X$3854 33912 33853 gf180mcu_fd_sc_mcu9t5v0__endcap
* cell instance $3855 m90 *1 1864.8,1128.96
X$3855 33912 33844 gf180mcu_fd_sc_mcu9t5v0__endcap
* cell instance $3856 m0 *1 1808.24,1209.6
X$3856 20822 20637 gf180mcu_fd_sc_mcu9t5v0__filltie
* cell instance $3857 r180 *1 1864.8,1189.44
X$3857 20217 20028 gf180mcu_fd_sc_mcu9t5v0__endcap
* cell instance $3858 m90 *1 1864.8,1189.44
X$3858 20217 20379 gf180mcu_fd_sc_mcu9t5v0__endcap
* cell instance $3859 r180 *1 1864.8,1199.52
X$3859 20507 20379 gf180mcu_fd_sc_mcu9t5v0__endcap
* cell instance $3860 r180 *1 1864.8,1159.2
X$3860 33916 33845 gf180mcu_fd_sc_mcu9t5v0__endcap
* cell instance $3861 m0 *1 1808.24,1199.52
X$3861 20507 20379 gf180mcu_fd_sc_mcu9t5v0__filltie
* cell instance $3862 m90 *1 1864.8,1149.12
X$3862 33913 33845 gf180mcu_fd_sc_mcu9t5v0__endcap
* cell instance $3863 r180 *1 1864.8,1209.6
X$3863 20822 20637 gf180mcu_fd_sc_mcu9t5v0__endcap
* cell instance $3864 m90 *1 1864.8,1209.6
X$3864 20822 20936 gf180mcu_fd_sc_mcu9t5v0__endcap
* cell instance $3865 m0 *1 1808.24,1189.44
X$3865 20217 20028 gf180mcu_fd_sc_mcu9t5v0__filltie
* cell instance $3866 r180 *1 1864.8,1219.68
X$3866 21123 20936 gf180mcu_fd_sc_mcu9t5v0__endcap
* cell instance $3867 m0 *1 1808.24,1219.68
X$3867 21123 20936 gf180mcu_fd_sc_mcu9t5v0__filltie
* cell instance $3868 m90 *1 1864.8,1219.68
X$3868 21123 21241 gf180mcu_fd_sc_mcu9t5v0__endcap
* cell instance $3869 m0 *1 1808.24,1139.04
X$3869 18731 18553 gf180mcu_fd_sc_mcu9t5v0__filltie
* cell instance $3870 r180 *1 1864.8,1229.76
X$3870 21412 21241 gf180mcu_fd_sc_mcu9t5v0__endcap
* cell instance $3871 m0 *1 1808.24,1239.84
X$3871 21719 21537 gf180mcu_fd_sc_mcu9t5v0__filltie
* cell instance $3872 m0 *1 1808.24,1169.28
X$3872 19605 19448 gf180mcu_fd_sc_mcu9t5v0__filltie
* cell instance $3873 m0 *1 1808.24,1118.88
X$3873 18104 17985 gf180mcu_fd_sc_mcu9t5v0__filltie
* cell instance $3874 m90 *1 1864.8,1229.76
X$3874 21412 21537 gf180mcu_fd_sc_mcu9t5v0__endcap
* cell instance $3875 m90 *1 1864.8,1159.2
X$3875 33916 33847 gf180mcu_fd_sc_mcu9t5v0__endcap
* cell instance $3876 m0 *1 1808.24,1179.36
X$3876 19901 19729 gf180mcu_fd_sc_mcu9t5v0__filltie
* cell instance $3877 r180 *1 1864.8,1239.84
X$3877 21719 21537 gf180mcu_fd_sc_mcu9t5v0__endcap
* cell instance $3878 r180 *1 1864.8,1169.28
X$3878 33922 33847 gf180mcu_fd_sc_mcu9t5v0__endcap
* cell instance $3879 r180 *1 1864.8,1139.04
X$3879 33915 33844 gf180mcu_fd_sc_mcu9t5v0__endcap
* cell instance $3880 m90 *1 1864.8,1169.28
X$3880 33922 33852 gf180mcu_fd_sc_mcu9t5v0__endcap
* cell instance $3881 m0 *1 1808.24,1128.96
X$3881 18386 18268 gf180mcu_fd_sc_mcu9t5v0__filltie
* cell instance $3882 r180 *1 1864.8,1149.12
X$3882 33913 33850 gf180mcu_fd_sc_mcu9t5v0__endcap
* cell instance $3883 m0 *1 1808.24,1149.12
X$3883 18996 18841 gf180mcu_fd_sc_mcu9t5v0__filltie
* cell instance $3884 r0 *1 390,1504.12
X$3884 3 17113 29059 22441 22572 16941 29059 29059 19113 21726 20826 29059
+ 15731 29144 29060 29164 29165 33520 29166 29059 28373 28374 28633 28375 25265
+ 16952 29059 20030 33518 23615 19569 29059 29059 17835 22443 33519 19917 29059
+ 15856 33526 33525 33524 33523 33522 33536 33529 33541 33521 33546 33538 33531
+ 33527 33543 33539 33533 33532 33530 33528 33545 33544 33542 33540 33537 3
+ 33535 33534 33547 1 gf180mcu_fd_ip_sram__sram256x8m8wm1
* cell instance $3885 r0 *1 842.24,1653.12
X$3885 31118 31125 gf180mcu_fd_sc_mcu9t5v0__endcap
* cell instance $3886 r0 *1 891.52,1653.12
X$3886 31257 31102 31124 31125 31118 31665 gf180mcu_fd_sc_mcu9t5v0__aoi21_1
* cell instance $3887 r0 *1 848.96,1653.12
X$3887 31123 31315 31125 31118 30908 30816 gf180mcu_fd_sc_mcu9t5v0__xnor3_1
* cell instance $3888 r0 *1 931.84,1653.12
X$3888 31128 31127 31126 31125 31118 30646 gf180mcu_fd_sc_mcu9t5v0__nor3_1
* cell instance $3889 r0 *1 962.08,1653.12
X$3889 31118 31125 gf180mcu_fd_sc_mcu9t5v0__filltie
* cell instance $3890 r0 *1 1036.56,1653.12
X$3890 30495 31125 31118 31057 gf180mcu_fd_sc_mcu9t5v0__inv_1
* cell instance $3891 r0 *1 1010.8,1653.12
X$3891 30494 31107 30438 18834 31125 31118 gf180mcu_fd_sc_mcu9t5v0__dffrnq_2
* cell instance $3892 r0 *1 1055.6,1653.12
X$3892 31131 30495 31125 31118 31129 gf180mcu_fd_sc_mcu9t5v0__nand2_1
* cell instance $3893 r0 *1 1050,1653.12
X$3893 30495 31119 31130 31129 31125 31118 31041
+ gf180mcu_fd_sc_mcu9t5v0__oai31_1
* cell instance $3894 r0 *1 548.8,1360.8
X$3894 25314 25313 21531 25430 25268 22287 gf180mcu_fd_sc_mcu9t5v0__aoi21_1
* cell instance $3895 m0 *1 549.36,1431.36
X$3895 27205 27243 27364 18834 27213 27367 gf180mcu_fd_sc_mcu9t5v0__dffrnq_2
* cell instance $3896 r0 *1 546,1441.44
X$3896 19917 27799 25693 27807 27666 27800 gf180mcu_fd_sc_mcu9t5v0__mux2_1
* cell instance $3897 m0 *1 543.76,1451.52
X$3897 27205 27800 27799 18834 27807 27945 gf180mcu_fd_sc_mcu9t5v0__dffrnq_2
* cell instance $3898 r0 *1 549.92,1461.6
X$3898 27205 28344 28491 18834 28378 28239 gf180mcu_fd_sc_mcu9t5v0__dffrnq_2
* cell instance $3899 m0 *1 544.88,1370.88
X$3899 25817 25535 25315 18834 25430 25581 gf180mcu_fd_sc_mcu9t5v0__dffrnq_2
* cell instance $3900 r0 *1 540.4,1421.28
X$3900 27205 27067 27068 18834 27213 27078 gf180mcu_fd_sc_mcu9t5v0__dffrnq_2
* cell instance $3901 r0 *1 551.6,1370.88
X$3901 25570 25315 24819 25705 25581 25535 gf180mcu_fd_sc_mcu9t5v0__mux2_1
* cell instance $3902 r0 *1 535.36,1401.12
X$3902 25817 26448 26160 18834 26632 26456 gf180mcu_fd_sc_mcu9t5v0__dffrnq_2
* cell instance $3903 m0 *1 551.04,1300.32
X$3903 22168 22830 22829 22828 23319 23504 23311 gf180mcu_fd_sc_mcu9t5v0__nor4_1
* cell instance $3904 m0 *1 547.12,1350.72
X$3904 25817 24824 24707 18834 24828 25000 gf180mcu_fd_sc_mcu9t5v0__dffrnq_2
* cell instance $3905 r0 *1 535.36,1320.48
X$3905 23036 24074 24227 18834 24232 24118 gf180mcu_fd_sc_mcu9t5v0__dffrnq_2
* cell instance $3906 r0 *1 533.68,1300.32
X$3906 23036 23358 23499 18834 23623 23504 gf180mcu_fd_sc_mcu9t5v0__dffrnq_2
* cell instance $3907 r0 *1 551.04,1260
X$3907 22288 22449 22295 21992 gf180mcu_fd_sc_mcu9t5v0__clkinv_1
* cell instance $3908 m0 *1 549.36,1280.16
X$3908 22168 22830 22829 22828 22700 22885 22831
+ gf180mcu_fd_sc_mcu9t5v0__nand4_1
* cell instance $3909 m0 *1 538.72,1260
X$3909 22820 22116 22288 11958 22124 22295 gf180mcu_fd_sc_mcu9t5v0__dffrnq_2
* cell instance $3910 m0 *1 549.36,1290.24
X$3910 21531 18430 21353 23038 23200 23004 gf180mcu_fd_sc_mcu9t5v0__nor3_1
* cell instance $3911 r0 *1 551.6,1249.92
X$3911 22288 21531 21714 22287 22124 21997 20980
+ gf180mcu_fd_sc_mcu9t5v0__aoi211_1
* cell instance $3912 m0 *1 551.6,1249.92
X$3912 20326 20814 22694 11958 21884 21997 gf180mcu_fd_sc_mcu9t5v0__dffrnq_2
* cell instance $3913 r0 *1 552.16,1169.28
X$3913 19558 19729 19605 15529 gf180mcu_fd_sc_mcu9t5v0__buf_8
* cell instance $3914 m0 *1 550.48,1169.28
X$3914 18421 20022 2137 19448 19605 19558 gf180mcu_fd_sc_mcu9t5v0__oai21_1
* cell instance $3915 r0 *1 551.04,1179.36
X$3915 19891 20022 19847 20028 19901 19849 gf180mcu_fd_sc_mcu9t5v0__nand3_1
* cell instance $3916 r0 *1 540.4,1189.44
X$3916 20326 20329 20365 11958 20379 20217 gf180mcu_fd_sc_mcu9t5v0__dffrnq_2
* cell instance $3917 m0 *1 540.4,1229.76
X$3917 20326 21353 18430 11958 21241 21412 gf180mcu_fd_sc_mcu9t5v0__dffrnq_2
* cell instance $3918 r0 *1 548.8,1108.8
X$3918 17941 17231 17228 17985 17837 18429 gf180mcu_fd_sc_mcu9t5v0__and3_1
* cell instance $3919 r0 *1 549.92,1128.96
X$3919 18432 18428 18434 18433 18553 18386 18435 gf180mcu_fd_sc_mcu9t5v0__or4_1
* cell instance $3920 r0 *1 552.16,1149.12
X$3920 18955 19171 18996 18989 gf180mcu_fd_sc_mcu9t5v0__clkinv_1
* cell instance $3921 m0 *1 551.04,1139.04
X$3921 18432 18428 18434 18433 18553 18731 18570 gf180mcu_fd_sc_mcu9t5v0__nor4_1
* cell instance $3922 m0 *1 552.16,1149.12
X$3922 18430 18570 18841 18996 18955 gf180mcu_fd_sc_mcu9t5v0__nand2_1
* cell instance $3923 m0 *1 537.04,1118.88
X$3923 18093 18095 17941 11958 17985 18104 gf180mcu_fd_sc_mcu9t5v0__dffrnq_2
* cell instance $3924 m0 *1 955,2210
X$3924 33487 33814 33812 33810 33808 33806 33804 33802 33800 33798 33796 33794
+ 33792 33790 33788 33786 33784 33782 33780 33778 33776 33774 33772 33770 33768
+ 33766 33764 33762 33760 33758 33756 33754 33752 33750 33748 33746 33744 33742
+ 33740 33738 33736 33734 33732 33730 33728 33726 33724 33722 33720 33718 33716
+ 33714 33712 33710 33708 33706 33704 33702 33700 33698 33696 33694 33692 33690
+ 33688 33686 33684 33682 33680 33678 33676 33674 33672 21987 33670 33668 33666
+ 33664 33662 33660 21987 33326 gf180mcu_fd_io__in_c
* cell instance $3925 m0 *1 1030,2210
X$3925 33814 33812 33810 33808 33804 33806 33802 33798 33800 33796 33792 33794
+ 33790 33786 33788 33784 33780 33782 33778 33774 33776 33772 33770 33768 33764
+ 33766 33762 33760 33758 33756 33754 33750 33752 33748 33744 33746 33742 33738
+ 33740 33736 33732 33734 33730 33726 33728 33724 33720 33722 33718 33714 33716
+ 33712 33710 33708 33706 33702 33704 33700 33698 33696 33694 33692 33690 33688
+ 33684 33686 33682 33680 33678 33670 33676 33672 33666 33668 33674 33664 33660
+ 33662 gf180mcu_fd_io__dvdd
* cell instance $3926 m0 *1 880,2210
X$3926 33486 33814 33812 33810 33808 33806 33804 33802 33800 33798 33796 33794
+ 33792 33790 33788 33786 33784 33782 33780 33778 33776 33774 33772 33770 33768
+ 33766 33764 33762 33760 33758 33756 33754 33752 33750 33748 33746 33744 33742
+ 33740 33738 33736 33734 33732 33730 33728 33726 33724 33722 33720 33718 33716
+ 33714 33712 33710 33708 33706 33704 33702 33700 33698 33696 33694 33692 33690
+ 33688 33686 33684 33682 33680 33678 33676 33674 33672 19859 33670 33668 33666
+ 33664 33662 33660 19859 33325 gf180mcu_fd_io__in_c
* cell instance $3927 r0 *1 729.68,1854.72
X$3927 33242 33323 gf180mcu_fd_sc_mcu9t5v0__filltie
* cell instance $3928 r0 *1 609.84,1854.72
X$3928 33242 33323 gf180mcu_fd_sc_mcu9t5v0__filltie
* cell instance $3929 r0 *1 963.2,1713.6
X$3929 31984 32037 31972 31128 gf180mcu_fd_sc_mcu9t5v0__buf_8
* cell instance $3930 r0 *1 962.08,1794.24
X$3930 32804 32842 gf180mcu_fd_sc_mcu9t5v0__filltie
* cell instance $3931 m0 *1 945.28,1794.24
X$3931 32805 32804 32753 32092 gf180mcu_fd_sc_mcu9t5v0__clkbuf_16
* cell instance $3932 m0 *1 964.32,1713.6
X$3932 31984 31894 31972 31607 31338 gf180mcu_fd_sc_mcu9t5v0__xor2_1
* cell instance $3933 m0 *1 964.88,1693.44
X$3933 31391 31607 31604 31710 31686 gf180mcu_fd_sc_mcu9t5v0__and2_1
* cell instance $3934 m0 *1 951.44,1723.68
X$3934 30348 31983 31984 18834 32037 32105 gf180mcu_fd_sc_mcu9t5v0__dffrnq_2
* cell instance $3935 r0 *1 842.24,1794.24
X$3935 32804 32842 gf180mcu_fd_sc_mcu9t5v0__endcap
* cell instance $3936 r0 *1 1089.2,1854.72
X$3936 33242 33816 gf180mcu_fd_sc_mcu9t5v0__filltie
* cell instance $3937 r0 *1 1000.16,1854.72
X$3937 33326 33579 33242 33327 gf180mcu_fd_sc_mcu9t5v0__buf_1
* cell instance $3938 r0 *1 1025.36,1854.72
X$3938 33327 33580 33242 12383 gf180mcu_fd_sc_mcu9t5v0__buf_20
* cell instance $3939 r0 *1 969.36,1854.72
X$3939 33242 33815 gf180mcu_fd_sc_mcu9t5v0__filltie
* cell instance $3940 m0 *1 1081.92,1824.48
X$3940 33081 33002 gf180mcu_fd_sc_mcu9t5v0__filltie
* cell instance $3941 m0 *1 1081.92,1804.32
X$3941 32921 32842 gf180mcu_fd_sc_mcu9t5v0__filltie
* cell instance $3942 m0 *1 1081.92,1834.56
X$3942 33161 33082 gf180mcu_fd_sc_mcu9t5v0__filltie
* cell instance $3943 m0 *1 1081.92,1844.64
X$3943 33241 33162 gf180mcu_fd_sc_mcu9t5v0__filltie
* cell instance $3944 m0 *1 1081.92,1854.72
X$3944 33242 33244 gf180mcu_fd_sc_mcu9t5v0__filltie
* cell instance $3945 m0 *1 1081.92,1814.4
X$3945 33001 32922 gf180mcu_fd_sc_mcu9t5v0__filltie
* cell instance $3946 r0 *1 962.08,1844.64
X$3946 33241 33244 gf180mcu_fd_sc_mcu9t5v0__filltie
* cell instance $3947 r0 *1 962.08,1814.4
X$3947 33001 33002 gf180mcu_fd_sc_mcu9t5v0__filltie
* cell instance $3948 r0 *1 849.52,1854.72
X$3948 33242 33323 gf180mcu_fd_sc_mcu9t5v0__filltie
* cell instance $3949 r0 *1 900.48,1854.72
X$3949 33325 33578 33242 32805 gf180mcu_fd_sc_mcu9t5v0__clkbuf_1
* cell instance $3950 r0 *1 962.08,1824.48
X$3950 33081 33082 gf180mcu_fd_sc_mcu9t5v0__filltie
* cell instance $3951 m0 *1 842.24,1824.48
X$3951 33081 33002 gf180mcu_fd_sc_mcu9t5v0__endcap
* cell instance $3952 m0 *1 842.24,1814.4
X$3952 33001 32922 gf180mcu_fd_sc_mcu9t5v0__endcap
* cell instance $3953 r0 *1 962.08,1834.56
X$3953 33161 33162 gf180mcu_fd_sc_mcu9t5v0__filltie
* cell instance $3954 r0 *1 842.24,1844.64
X$3954 33241 33244 gf180mcu_fd_sc_mcu9t5v0__endcap
* cell instance $3955 m0 *1 842.24,1854.72
X$3955 33242 33244 gf180mcu_fd_sc_mcu9t5v0__endcap
* cell instance $3956 m0 *1 842.24,1864.8
X$3956 33324 33323 gf180mcu_fd_sc_mcu9t5v0__endcap
* cell instance $3957 r0 *1 842.24,1804.32
X$3957 32921 32922 gf180mcu_fd_sc_mcu9t5v0__endcap
* cell instance $3958 r0 *1 842.24,1814.4
X$3958 33001 33002 gf180mcu_fd_sc_mcu9t5v0__endcap
* cell instance $3959 r0 *1 962.08,1804.32
X$3959 32921 32922 gf180mcu_fd_sc_mcu9t5v0__filltie
* cell instance $3960 r0 *1 842.24,1824.48
X$3960 33081 33082 gf180mcu_fd_sc_mcu9t5v0__endcap
* cell instance $3961 m0 *1 842.24,1804.32
X$3961 32921 32842 gf180mcu_fd_sc_mcu9t5v0__endcap
* cell instance $3962 m0 *1 842.24,1834.56
X$3962 33161 33082 gf180mcu_fd_sc_mcu9t5v0__endcap
* cell instance $3963 r0 *1 842.24,1834.56
X$3963 33161 33162 gf180mcu_fd_sc_mcu9t5v0__endcap
* cell instance $3964 m0 *1 842.24,1844.64
X$3964 33241 33162 gf180mcu_fd_sc_mcu9t5v0__endcap
* cell instance $3965 r0 *1 894.88,1683.36
X$3965 31318 31037 31604 31529 31518 gf180mcu_fd_sc_mcu9t5v0__xnor2_1
* cell instance $3966 r0 *1 907.76,1723.68
X$3966 31053 32090 31515 32169 32105 32112 gf180mcu_fd_sc_mcu9t5v0__oai21_1
* cell instance $3967 r0 *1 962.08,1723.68
X$3967 32105 32169 gf180mcu_fd_sc_mcu9t5v0__filltie
* cell instance $3968 r0 *1 921.2,1723.68
X$3968 30348 32113 30820 18834 32169 32105 gf180mcu_fd_sc_mcu9t5v0__dffrnq_2
* cell instance $3969 r0 *1 904.4,1723.68
X$3969 32089 32112 32169 32105 32168 gf180mcu_fd_sc_mcu9t5v0__nor2_1
* cell instance $3970 r0 *1 887.6,1703.52
X$3970 30348 31767 31759 18834 31894 31827 gf180mcu_fd_sc_mcu9t5v0__dffrnq_2
* cell instance $3971 m0 *1 880.88,1693.44
X$3971 30348 31530 31318 18834 31604 31710 gf180mcu_fd_sc_mcu9t5v0__dffrnq_2
* cell instance $3972 r0 *1 882.56,1723.68
X$3972 30348 32111 31256 18834 32169 32105 gf180mcu_fd_sc_mcu9t5v0__dffrnq_2
* cell instance $3973 m0 *1 896.56,1683.36
X$3973 31518 31464 31529 31462 31517 gf180mcu_fd_sc_mcu9t5v0__xor2_1
* cell instance $3974 m0 *1 887.04,1663.2
X$3974 31318 31102 31125 31239 30970 31256 gf180mcu_fd_sc_mcu9t5v0__xnor3_1
* cell instance $3975 r0 *1 842.24,1723.68
X$3975 32105 32169 gf180mcu_fd_sc_mcu9t5v0__endcap
* cell instance $3976 r0 *1 962.08,1733.76
X$3976 32228 32299 gf180mcu_fd_sc_mcu9t5v0__filltie
* cell instance $3977 m0 *1 904.96,1733.76
X$3977 30348 32168 31053 18834 32169 32228 gf180mcu_fd_sc_mcu9t5v0__dffrnq_2
* cell instance $3978 r0 *1 962.08,1753.92
X$3978 32453 32459 gf180mcu_fd_sc_mcu9t5v0__filltie
* cell instance $3979 r0 *1 962.08,1764
X$3979 32560 32561 gf180mcu_fd_sc_mcu9t5v0__filltie
* cell instance $3980 r0 *1 962.08,1774.08
X$3980 32661 32663 gf180mcu_fd_sc_mcu9t5v0__filltie
* cell instance $3981 r0 *1 962.08,1784.16
X$3981 32709 32753 gf180mcu_fd_sc_mcu9t5v0__filltie
* cell instance $3982 r0 *1 962.08,1743.84
X$3982 32351 32352 gf180mcu_fd_sc_mcu9t5v0__filltie
* cell instance $3983 m0 *1 842.24,1743.84
X$3983 32351 32299 gf180mcu_fd_sc_mcu9t5v0__endcap
* cell instance $3984 r0 *1 842.24,1743.84
X$3984 32351 32352 gf180mcu_fd_sc_mcu9t5v0__endcap
* cell instance $3985 m0 *1 842.24,1753.92
X$3985 32453 32352 gf180mcu_fd_sc_mcu9t5v0__endcap
* cell instance $3986 r0 *1 842.24,1753.92
X$3986 32453 32459 gf180mcu_fd_sc_mcu9t5v0__endcap
* cell instance $3987 m0 *1 842.24,1764
X$3987 32560 32459 gf180mcu_fd_sc_mcu9t5v0__endcap
* cell instance $3988 r0 *1 842.24,1764
X$3988 32560 32561 gf180mcu_fd_sc_mcu9t5v0__endcap
* cell instance $3989 m0 *1 842.24,1774.08
X$3989 32661 32561 gf180mcu_fd_sc_mcu9t5v0__endcap
* cell instance $3990 r0 *1 842.24,1774.08
X$3990 32661 32663 gf180mcu_fd_sc_mcu9t5v0__endcap
* cell instance $3991 m0 *1 842.24,1784.16
X$3991 32709 32663 gf180mcu_fd_sc_mcu9t5v0__endcap
* cell instance $3992 r0 *1 842.24,1784.16
X$3992 32709 32753 gf180mcu_fd_sc_mcu9t5v0__endcap
* cell instance $3993 m0 *1 842.24,1794.24
X$3993 32804 32753 gf180mcu_fd_sc_mcu9t5v0__endcap
* cell instance $3994 m0 *1 887.6,1733.76
X$3994 31256 32089 32101 32169 32228 32111 gf180mcu_fd_sc_mcu9t5v0__aoi21_1
* cell instance $3995 m0 *1 842.24,1733.76
X$3995 32228 32169 gf180mcu_fd_sc_mcu9t5v0__endcap
* cell instance $3996 r0 *1 842.24,1733.76
X$3996 32228 32299 gf180mcu_fd_sc_mcu9t5v0__endcap
* cell instance $3997 r0 *1 868,1693.44
X$3997 31709 31128 31760 31769 31710 31681 gf180mcu_fd_sc_mcu9t5v0__nand3_1
* cell instance $3998 m0 *1 870.24,1673.28
X$3998 31128 31185 31321 31388 31315 gf180mcu_fd_sc_mcu9t5v0__nand2_1
* cell instance $3999 r0 *1 887.04,1663.2
X$3999 31318 31256 31321 31239 31257 gf180mcu_fd_sc_mcu9t5v0__or2_1
* cell instance $4000 m0 *1 857.36,1663.2
X$4000 30816 31252 31125 31239 31251 gf180mcu_fd_sc_mcu9t5v0__nor2_1
* cell instance $4001 m0 *1 883.68,1683.36
X$4001 31318 31515 31464 31529 31516 gf180mcu_fd_sc_mcu9t5v0__nand2_1
* cell instance $4002 r0 *1 852.88,1663.2
X$4002 30816 31252 31321 31239 31314 gf180mcu_fd_sc_mcu9t5v0__nand2_1
* cell instance $4003 r0 *1 850.64,1673.28
X$4003 31316 31464 31388 31461 30889 gf180mcu_fd_sc_mcu9t5v0__xor2_1
* cell instance $4004 r0 *1 848.4,1663.2
X$4004 31123 31251 31314 31321 31239 31184 gf180mcu_fd_sc_mcu9t5v0__oai21_1
* cell instance $4005 m0 *1 886.48,1683.36
X$4005 31515 31052 31517 31516 31464 31529 31530
+ gf180mcu_fd_sc_mcu9t5v0__oai31_1
* cell instance $4006 r0 *1 890.4,1683.36
X$4006 31318 31037 31538 31604 31529 31603 gf180mcu_fd_sc_mcu9t5v0__aoi21_1
* cell instance $4007 r0 *1 891.52,1663.2
X$4007 31318 31256 31321 31239 31124 gf180mcu_fd_sc_mcu9t5v0__and2_1
* cell instance $4008 r0 *1 869.12,1673.28
X$4008 31254 31450 31464 31388 31449 gf180mcu_fd_sc_mcu9t5v0__nor2_1
* cell instance $4009 m0 *1 871.92,1683.36
X$4009 31316 31515 31464 31529 31514 gf180mcu_fd_sc_mcu9t5v0__nand2_1
* cell instance $4010 m0 *1 867.44,1683.36
X$4010 30347 31449 31514 31464 31529 31513 gf180mcu_fd_sc_mcu9t5v0__oai21_1
* cell instance $4011 r0 *1 871.92,1693.44
X$4011 31128 31760 31709 31769 31710 31682 gf180mcu_fd_sc_mcu9t5v0__aoi21_1
* cell instance $4012 m0 *1 869.68,1663.2
X$4012 31128 31185 31125 31239 31252 gf180mcu_fd_sc_mcu9t5v0__and2_1
* cell instance $4013 m0 *1 870.8,1693.44
X$4013 31681 31603 31682 31604 31710 31450 gf180mcu_fd_sc_mcu9t5v0__aoi21_1
* cell instance $4014 r0 *1 884.24,1663.2
X$4014 31128 31255 31321 31239 30086 gf180mcu_fd_sc_mcu9t5v0__nand2_1
* cell instance $4015 r0 *1 863.52,1663.2
X$4015 31316 31252 31321 31239 31253 gf180mcu_fd_sc_mcu9t5v0__nand2_1
* cell instance $4016 r0 *1 866.32,1663.2
X$4016 31316 31315 31321 31239 31254 gf180mcu_fd_sc_mcu9t5v0__xnor2_1
* cell instance $4017 m0 *1 846.72,1683.36
X$4017 28500 31513 31316 18834 31464 31529 gf180mcu_fd_sc_mcu9t5v0__dffrnq_2
* cell instance $4018 r0 *1 877.52,1663.2
X$4018 30086 31253 31321 31239 31317 gf180mcu_fd_sc_mcu9t5v0__nand2_1
* cell instance $4019 r0 *1 873.04,1663.2
X$4019 31254 31450 31317 31321 31239 30281 gf180mcu_fd_sc_mcu9t5v0__aoi21_1
* cell instance $4020 r0 *1 889.84,1713.6
X$4020 31256 32089 32037 31972 31919 gf180mcu_fd_sc_mcu9t5v0__nand2_1
* cell instance $4021 m0 *1 887.6,1713.6
X$4021 31759 31894 31972 31919 31815 gf180mcu_fd_sc_mcu9t5v0__xor2_1
* cell instance $4022 m0 *1 890.4,1703.52
X$4022 30297 31815 31769 31827 31767 gf180mcu_fd_sc_mcu9t5v0__nor2_1
* cell instance $4023 m0 *1 850.64,1703.52
X$4023 31709 31759 31769 31827 31679 gf180mcu_fd_sc_mcu9t5v0__nor2_1
* cell instance $4024 m0 *1 854,1703.52
X$4024 31709 31759 31769 31827 31680 gf180mcu_fd_sc_mcu9t5v0__nand2_1
* cell instance $4025 r0 *1 846.72,1693.44
X$4025 31709 31665 31769 31710 30816 31759 gf180mcu_fd_sc_mcu9t5v0__xnor3_1
* cell instance $4026 m0 *1 851.2,1693.44
X$4026 31665 31679 31680 31604 31710 31461 gf180mcu_fd_sc_mcu9t5v0__oai21_1
* cell instance $4027 r0 *1 869.68,1703.52
X$4027 31880 30347 31881 31894 31827 31893 gf180mcu_fd_sc_mcu9t5v0__oai21_1
* cell instance $4028 m0 *1 862.96,1713.6
X$4028 30348 31893 31709 18834 31894 31972 gf180mcu_fd_sc_mcu9t5v0__dffrnq_2
* cell instance $4029 m0 *1 863.52,1703.52
X$4029 31709 31603 31769 31827 31880 31035 gf180mcu_fd_sc_mcu9t5v0__xnor3_1
* cell instance $4030 r0 *1 871.92,1713.6
X$4030 31709 31515 32037 31972 31881 gf180mcu_fd_sc_mcu9t5v0__nand2_1
* cell instance $4031 r0 *1 842.24,1683.36
X$4031 31529 31604 gf180mcu_fd_sc_mcu9t5v0__endcap
* cell instance $4032 m0 *1 842.24,1663.2
X$4032 31239 31125 gf180mcu_fd_sc_mcu9t5v0__endcap
* cell instance $4033 r0 *1 842.24,1663.2
X$4033 31239 31321 gf180mcu_fd_sc_mcu9t5v0__endcap
* cell instance $4034 m0 *1 842.24,1673.28
X$4034 31388 31321 gf180mcu_fd_sc_mcu9t5v0__endcap
* cell instance $4035 m0 *1 842.24,1693.44
X$4035 31710 31604 gf180mcu_fd_sc_mcu9t5v0__endcap
* cell instance $4036 r0 *1 842.24,1673.28
X$4036 31388 31464 gf180mcu_fd_sc_mcu9t5v0__endcap
* cell instance $4037 r0 *1 842.24,1693.44
X$4037 31710 31769 gf180mcu_fd_sc_mcu9t5v0__endcap
* cell instance $4038 m0 *1 842.24,1703.52
X$4038 31827 31769 gf180mcu_fd_sc_mcu9t5v0__endcap
* cell instance $4039 r0 *1 842.24,1703.52
X$4039 31827 31894 gf180mcu_fd_sc_mcu9t5v0__endcap
* cell instance $4040 m0 *1 842.24,1713.6
X$4040 31972 31894 gf180mcu_fd_sc_mcu9t5v0__endcap
* cell instance $4041 r0 *1 842.24,1713.6
X$4041 31972 32037 gf180mcu_fd_sc_mcu9t5v0__endcap
* cell instance $4042 m0 *1 842.24,1723.68
X$4042 32105 32037 gf180mcu_fd_sc_mcu9t5v0__endcap
* cell instance $4043 m0 *1 842.24,1683.36
X$4043 31529 31464 gf180mcu_fd_sc_mcu9t5v0__endcap
* cell instance $4044 m0 *1 844.48,1663.2
X$4044 31238 30889 31125 31239 30969 31184 gf180mcu_fd_sc_mcu9t5v0__xnor3_1
* cell instance $4045 r0 *1 865.2,1693.44
X$4045 31128 31760 31769 31710 31035 gf180mcu_fd_sc_mcu9t5v0__nand2_1
* cell instance $4046 m0 *1 889.84,1723.68
X$4046 31256 32089 31515 32037 32105 32101 gf180mcu_fd_sc_mcu9t5v0__oai21_1
* cell instance $4047 r0 *1 962.08,1703.52
X$4047 31827 31894 gf180mcu_fd_sc_mcu9t5v0__filltie
* cell instance $4048 m0 *1 935.76,1693.44
X$4048 31770 31606 31604 31710 31390 gf180mcu_fd_sc_mcu9t5v0__nor2_1
* cell instance $4049 m0 *1 957.04,1673.28
X$4049 31392 31539 31321 31388 31255 gf180mcu_fd_sc_mcu9t5v0__nor2_1
* cell instance $4050 m0 *1 929.6,1683.36
X$4050 30104 31464 31529 30487 31531 gf180mcu_fd_sc_mcu9t5v0__xor2_1
* cell instance $4051 m0 *1 926.24,1673.28
X$4051 19402 31321 31388 30348 gf180mcu_fd_sc_mcu9t5v0__clkbuf_8
* cell instance $4052 m0 *1 954.24,1673.28
X$4052 31392 31126 31321 31388 31391 gf180mcu_fd_sc_mcu9t5v0__nand2_1
* cell instance $4053 r0 *1 952,1673.28
X$4053 31128 31391 31464 31388 30487 gf180mcu_fd_sc_mcu9t5v0__nor2_1
* cell instance $4054 r0 *1 913.92,1673.28
X$4054 31463 30821 31464 31388 31451 gf180mcu_fd_sc_mcu9t5v0__or2_1
* cell instance $4055 m0 *1 960.4,1673.28
X$4055 31128 31392 31539 31321 31388 30910 gf180mcu_fd_sc_mcu9t5v0__nor3_1
* cell instance $4056 r0 *1 962.08,1673.28
X$4056 31388 31464 gf180mcu_fd_sc_mcu9t5v0__filltie
* cell instance $4057 m0 *1 931.28,1663.2
X$4057 31127 31126 31125 31239 31185 gf180mcu_fd_sc_mcu9t5v0__nor2_1
* cell instance $4058 r0 *1 962.08,1663.2
X$4058 31239 31321 gf180mcu_fd_sc_mcu9t5v0__filltie
* cell instance $4059 r0 *1 935.2,1663.2
X$4059 31256 31255 31185 31053 31321 31239 31322
+ gf180mcu_fd_sc_mcu9t5v0__aoi22_1
* cell instance $4060 r0 *1 918.96,1663.2
X$4060 31028 31515 31321 31239 31320 gf180mcu_fd_sc_mcu9t5v0__nand2_1
* cell instance $4061 r0 *1 959.84,1673.28
X$4061 31127 31464 31388 31392 gf180mcu_fd_sc_mcu9t5v0__clkinv_1
* cell instance $4062 r0 *1 946.96,1663.2
X$4062 30820 31338 31321 31239 31240 gf180mcu_fd_sc_mcu9t5v0__nand2_1
* cell instance $4063 m0 *1 941.36,1663.2
X$4063 31240 31187 31390 31125 31239 30158 gf180mcu_fd_sc_mcu9t5v0__nand3_1
* cell instance $4064 r0 *1 926.24,1663.2
X$4064 30348 31321 31239 gf180mcu_fd_sc_mcu9t5v0__clkbuf_4
* cell instance $4065 r0 *1 910.56,1673.28
X$4065 31028 30910 31464 31388 31463 gf180mcu_fd_sc_mcu9t5v0__nor2_1
* cell instance $4066 m0 *1 934.64,1663.2
X$4066 31128 31053 31125 31239 31187 gf180mcu_fd_sc_mcu9t5v0__xnor2_1
* cell instance $4067 m0 *1 952,1683.36
X$4067 31053 30820 31539 31464 31529 31465 gf180mcu_fd_sc_mcu9t5v0__mux2_1
* cell instance $4068 m0 *1 941.36,1713.6
X$4068 31539 31105 31894 31972 31920 gf180mcu_fd_sc_mcu9t5v0__nand2_1
* cell instance $4069 r0 *1 940.24,1663.2
X$4069 31128 31127 31126 31321 31239 31323 gf180mcu_fd_sc_mcu9t5v0__aoi21_1
* cell instance $4070 m0 *1 940.8,1673.28
X$4070 31759 31126 31323 31256 31321 31388 31324
+ gf180mcu_fd_sc_mcu9t5v0__aoi22_1
* cell instance $4071 r0 *1 914.48,1663.2
X$4071 30347 31319 31320 31321 31239 31186 gf180mcu_fd_sc_mcu9t5v0__oai21_1
* cell instance $4072 r0 *1 957.6,1663.2
X$4072 31128 31255 31321 31239 31238 gf180mcu_fd_sc_mcu9t5v0__and2_1
* cell instance $4073 m0 *1 946.96,1673.28
X$4073 31539 31321 31388 31126 gf180mcu_fd_sc_mcu9t5v0__clkinv_1
* cell instance $4074 m0 *1 936.88,1713.6
X$4074 31539 30916 31920 31894 31972 31973 gf180mcu_fd_sc_mcu9t5v0__oai21_1
* cell instance $4075 m0 *1 952.56,1703.52
X$4075 30820 30517 31539 31769 31827 31817 gf180mcu_fd_sc_mcu9t5v0__mux2_1
* cell instance $4076 r0 *1 962.08,1713.6
X$4076 31972 32037 gf180mcu_fd_sc_mcu9t5v0__filltie
* cell instance $4077 m0 *1 931.28,1703.52
X$4077 31128 31127 31769 31827 31683 gf180mcu_fd_sc_mcu9t5v0__nor2_1
* cell instance $4078 r0 *1 934.64,1713.6
X$4078 30348 31973 31539 18834 32037 31972 gf180mcu_fd_sc_mcu9t5v0__dffrnq_2
* cell instance $4079 r0 *1 935.2,1693.44
X$4079 31256 31769 31710 31685 31761 gf180mcu_fd_sc_mcu9t5v0__xor2_1
* cell instance $4080 m0 *1 927.92,1693.44
X$4080 31128 31127 31604 31710 31666 gf180mcu_fd_sc_mcu9t5v0__nand2_1
* cell instance $4081 m0 *1 930.72,1693.44
X$4081 31759 31666 31683 30517 31604 31710 31684
+ gf180mcu_fd_sc_mcu9t5v0__aoi22_1
* cell instance $4082 m0 *1 904.96,1703.52
X$4082 30297 31816 31768 31769 31827 31828 gf180mcu_fd_sc_mcu9t5v0__nor3_1
* cell instance $4083 r0 *1 929.6,1693.44
X$4083 30517 31683 31761 31684 31769 31710 31770
+ gf180mcu_fd_sc_mcu9t5v0__oai211_1
* cell instance $4084 m0 *1 959.28,1693.44
X$4084 31391 31607 31604 31710 31258 gf180mcu_fd_sc_mcu9t5v0__nand2_1
* cell instance $4085 m0 *1 952.56,1693.44
X$4085 31127 31539 31604 31710 31607 gf180mcu_fd_sc_mcu9t5v0__nand2_1
* cell instance $4086 m0 *1 948.64,1713.6
X$4086 31128 31105 31894 31972 31974 gf180mcu_fd_sc_mcu9t5v0__nand2_1
* cell instance $4087 m0 *1 962.08,1693.44
X$4087 31128 31391 31604 31710 31685 gf180mcu_fd_sc_mcu9t5v0__nand2_1
* cell instance $4088 r0 *1 938.56,1683.36
X$4088 31127 31539 31128 31604 31529 31605 gf180mcu_fd_sc_mcu9t5v0__aoi21_1
* cell instance $4089 r0 *1 931.84,1683.36
X$4089 30820 31605 31666 31759 31531 31604 31529 31606
+ gf180mcu_fd_sc_mcu9t5v0__oai221_1
* cell instance $4090 m0 *1 915.04,1723.68
X$4090 30820 31816 31515 32037 32105 32091 gf180mcu_fd_sc_mcu9t5v0__oai21_1
* cell instance $4091 m0 *1 955.36,1693.44
X$4091 31127 31539 31604 31710 31760 gf180mcu_fd_sc_mcu9t5v0__nor2_1
* cell instance $4092 m0 *1 906.08,1723.68
X$4092 31053 32090 32037 32105 32089 gf180mcu_fd_sc_mcu9t5v0__and2_1
* cell instance $4093 r0 *1 962.08,1693.44
X$4093 31710 31769 gf180mcu_fd_sc_mcu9t5v0__filltie
* cell instance $4094 m0 *1 903.28,1683.36
X$4094 31389 31451 31518 31464 31529 31538 gf180mcu_fd_sc_mcu9t5v0__aoi21_1
* cell instance $4095 m0 *1 919.52,1723.68
X$4095 32090 32091 32037 32105 32113 gf180mcu_fd_sc_mcu9t5v0__nor2_1
* cell instance $4096 r0 *1 953.12,1693.44
X$4096 30517 30104 31539 31769 31710 31762 gf180mcu_fd_sc_mcu9t5v0__mux2_1
* cell instance $4097 r0 *1 900.48,1673.28
X$4097 31389 31451 31464 31388 31462 gf180mcu_fd_sc_mcu9t5v0__nand2_1
* cell instance $4098 r0 *1 962.08,1683.36
X$4098 31529 31604 gf180mcu_fd_sc_mcu9t5v0__filltie
* cell instance $4099 m0 *1 909.44,1673.28
X$4099 31028 30821 31321 31388 30910 31319 gf180mcu_fd_sc_mcu9t5v0__xor3_1
* cell instance $4100 r0 *1 953.68,1713.6
X$4100 31338 30916 31974 32037 31972 31983 gf180mcu_fd_sc_mcu9t5v0__oai21_1
* cell instance $4101 m0 *1 909.44,1703.52
X$4101 30517 30104 29693 31769 31827 31816 gf180mcu_fd_sc_mcu9t5v0__and3_1
* cell instance $4102 r0 *1 903.28,1673.28
X$4102 31028 30910 31464 31388 31389 gf180mcu_fd_sc_mcu9t5v0__nand2_1
* cell instance $4103 m0 *1 910.56,1723.68
X$4103 30820 31816 32037 32105 32090 gf180mcu_fd_sc_mcu9t5v0__and2_1
* cell instance $4104 r0 *1 909.44,1703.52
X$4104 30348 31828 30517 18834 31894 31827 gf180mcu_fd_sc_mcu9t5v0__dffrnq_2
* cell instance $4105 r0 *1 915.6,1683.36
X$4105 31128 31607 31604 31529 31037 gf180mcu_fd_sc_mcu9t5v0__nor2_1
* cell instance $4106 m0 *1 910.56,1663.2
X$4106 30348 31186 31028 18834 31125 31239 gf180mcu_fd_sc_mcu9t5v0__dffrnq_2
* cell instance $4107 r0 *1 908.32,1693.44
X$4107 30104 29693 30517 31769 31710 31768 gf180mcu_fd_sc_mcu9t5v0__aoi21_1
* cell instance $4108 r0 *1 1053.92,1723.68
X$4108 32041 31819 32115 31519 32169 32105 32040
+ gf180mcu_fd_sc_mcu9t5v0__aoi22_1
* cell instance $4109 r0 *1 1098.16,1723.68
X$4109 31108 32118 31119 32119 32169 32105 32102
+ gf180mcu_fd_sc_mcu9t5v0__aoi211_1
* cell instance $4110 r0 *1 1084.72,1723.68
X$4110 31393 32042 32116 31108 32169 32105 32117
+ gf180mcu_fd_sc_mcu9t5v0__aoi211_1
* cell instance $4111 m0 *1 1032.64,1713.6
X$4111 31667 31467 31455 31976 31261 31894 31972 32093
+ gf180mcu_fd_sc_mcu9t5v0__aoi221_1
* cell instance $4112 r0 *1 1033.76,1703.52
X$4112 31667 31882 31894 31827 31831 gf180mcu_fd_sc_mcu9t5v0__nand2_1
* cell instance $4113 r0 *1 1012.48,1723.68
X$4113 31393 32114 31975 31108 32169 32105 32106
+ gf180mcu_fd_sc_mcu9t5v0__oai211_1
* cell instance $4114 m0 *1 1033.2,1683.36
X$4114 31520 31519 31464 31529 31453 gf180mcu_fd_sc_mcu9t5v0__nand2_1
* cell instance $4115 r0 *1 1034.88,1663.2
X$4115 31329 31327 31108 31321 31239 31263 gf180mcu_fd_sc_mcu9t5v0__oai21_1
* cell instance $4116 r0 *1 1032.08,1673.28
X$4116 31453 31454 31455 31464 31388 31328 gf180mcu_fd_sc_mcu9t5v0__oai21_1
* cell instance $4117 r0 *1 1033.76,1683.36
X$4117 31667 31454 31541 31985 31604 31529 31542
+ gf180mcu_fd_sc_mcu9t5v0__aoi22_1
* cell instance $4118 r0 *1 1048.88,1743.84
X$4118 31393 32353 32352 32351 32345 gf180mcu_fd_sc_mcu9t5v0__nand2_1
* cell instance $4119 m0 *1 1051.12,1743.84
X$4119 32240 32343 32345 32299 32351 32344 gf180mcu_fd_sc_mcu9t5v0__aoi21_1
* cell instance $4120 m0 *1 1089.2,1743.84
X$4120 32302 32344 32299 32351 32220 gf180mcu_fd_sc_mcu9t5v0__nor2_1
* cell instance $4121 m0 *1 1094.24,1733.76
X$4121 32118 32220 31108 32169 32228 30826 gf180mcu_fd_sc_mcu9t5v0__mux2_1
* cell instance $4122 m0 *1 1043.84,1743.84
X$4122 32300 32343 32342 31923 31393 32299 32351 32094
+ gf180mcu_fd_sc_mcu9t5v0__aoi221_1
* cell instance $4123 m0 *1 1070.16,1743.84
X$4123 31923 31819 32343 32299 32351 32301 gf180mcu_fd_sc_mcu9t5v0__aoi21_1
* cell instance $4124 r0 *1 1081.92,1733.76
X$4124 31393 32301 32299 32228 32116 gf180mcu_fd_sc_mcu9t5v0__nor2_1
* cell instance $4125 m0 *1 1101.52,1733.76
X$4125 31108 32220 32169 32228 32119 gf180mcu_fd_sc_mcu9t5v0__nor2_1
* cell instance $4126 m0 *1 1064,1743.84
X$4126 31519 31925 32299 32351 32343 gf180mcu_fd_sc_mcu9t5v0__and2_1
* cell instance $4127 r0 *1 1048.32,1733.76
X$4127 32039 31925 32299 32228 32342 gf180mcu_fd_sc_mcu9t5v0__nand2_1
* cell instance $4128 m0 *1 1081.92,1733.76
X$4128 32228 32169 gf180mcu_fd_sc_mcu9t5v0__filltie
* cell instance $4129 m0 *1 1081.92,1743.84
X$4129 32351 32299 gf180mcu_fd_sc_mcu9t5v0__filltie
* cell instance $4130 m0 *1 1050.56,1733.76
X$4130 32240 31831 32169 32228 32115 gf180mcu_fd_sc_mcu9t5v0__nand2_1
* cell instance $4131 r0 *1 1042.72,1733.76
X$4131 31985 31883 32300 31519 32299 32228 32246
+ gf180mcu_fd_sc_mcu9t5v0__oai211_1
* cell instance $4132 r0 *1 1061.76,1733.76
X$4132 32229 31925 32299 32228 32247 gf180mcu_fd_sc_mcu9t5v0__nand2_1
* cell instance $4133 r0 *1 1064.56,1733.76
X$4133 31261 32246 32247 32299 32228 32248 gf180mcu_fd_sc_mcu9t5v0__nand3_1
* cell instance $4134 m0 *1 1081.92,1794.24
X$4134 32804 32753 gf180mcu_fd_sc_mcu9t5v0__filltie
* cell instance $4135 r0 *1 1072.96,1733.76
X$4135 31261 31713 31610 32248 32299 32228 32250
+ gf180mcu_fd_sc_mcu9t5v0__oai31_1
* cell instance $4136 r0 *1 1092.56,1733.76
X$4136 32250 32299 32228 32118 gf180mcu_fd_sc_mcu9t5v0__clkinv_1
* cell instance $4137 m0 *1 1081.92,1764
X$4137 32560 32459 gf180mcu_fd_sc_mcu9t5v0__filltie
* cell instance $4138 r0 *1 1068.48,1733.76
X$4138 31341 31819 31884 32299 32228 32249 gf180mcu_fd_sc_mcu9t5v0__oai21_1
* cell instance $4139 m0 *1 1081.92,1774.08
X$4139 32661 32561 gf180mcu_fd_sc_mcu9t5v0__filltie
* cell instance $4140 m0 *1 1081.92,1784.16
X$4140 32709 32663 gf180mcu_fd_sc_mcu9t5v0__filltie
* cell instance $4141 m0 *1 1081.92,1753.92
X$4141 32453 32352 gf180mcu_fd_sc_mcu9t5v0__filltie
* cell instance $4142 m0 *1 1038.24,1743.84
X$4142 31985 31883 32300 31923 32299 32351 32353
+ gf180mcu_fd_sc_mcu9t5v0__oai211_1
* cell instance $4143 r0 *1 1085.28,1733.76
X$4143 31393 32249 32299 32228 32302 gf180mcu_fd_sc_mcu9t5v0__nor2_1
* cell instance $4144 r0 *1 1014.16,1733.76
X$4144 31519 32241 32299 32228 32242 gf180mcu_fd_sc_mcu9t5v0__nand2_1
* cell instance $4145 r0 *1 1030.4,1733.76
X$4145 31923 32300 31819 32299 32228 32243 gf180mcu_fd_sc_mcu9t5v0__nand3_1
* cell instance $4146 r0 *1 1018.08,1733.76
X$4146 32242 32243 32299 32228 32244 gf180mcu_fd_sc_mcu9t5v0__nand2_1
* cell instance $4147 m0 *1 1028.16,1743.84
X$4147 31341 31985 32299 32351 32300 gf180mcu_fd_sc_mcu9t5v0__nand2_1
* cell instance $4148 r0 *1 990.08,1733.76
X$4148 32038 32299 32228 31519 gf180mcu_fd_sc_mcu9t5v0__buf_8
* cell instance $4149 m0 *1 1006.88,1743.84
X$4149 32240 32239 32299 32351 32230 gf180mcu_fd_sc_mcu9t5v0__nand2_1
* cell instance $4150 r0 *1 1025.36,1733.76
X$4150 32170 32245 32244 31393 32299 32228 31241
+ gf180mcu_fd_sc_mcu9t5v0__aoi22_1
* cell instance $4151 m0 *1 990.64,1733.76
X$4151 31712 31985 32038 32169 32228 32229 gf180mcu_fd_sc_mcu9t5v0__aoi21_1
* cell instance $4152 m0 *1 996.24,1733.76
X$4152 31712 31985 32169 32228 32240 gf180mcu_fd_sc_mcu9t5v0__nand2_1
* cell instance $4153 m0 *1 1007.44,1733.76
X$4153 32039 32229 32230 31519 32169 32228 32114
+ gf180mcu_fd_sc_mcu9t5v0__aoi22_1
* cell instance $4154 r0 *1 1011.36,1733.76
X$4154 31923 32240 32299 32228 31713 gf180mcu_fd_sc_mcu9t5v0__nand2_1
* cell instance $4155 m0 *1 1030.96,1733.76
X$4155 31923 32039 32300 32169 32228 31455 gf180mcu_fd_sc_mcu9t5v0__nand3_1
* cell instance $4156 m0 *1 1027.04,1733.76
X$4156 31519 32039 31831 32169 32228 32170 gf180mcu_fd_sc_mcu9t5v0__nand3_1
* cell instance $4157 r0 *1 1020.88,1733.76
X$4157 31923 31610 31393 32299 32228 32245 gf180mcu_fd_sc_mcu9t5v0__aoi21_1
* cell instance $4158 r0 *1 1006.88,1733.76
X$4158 31341 32039 32239 32299 32228 32241 gf180mcu_fd_sc_mcu9t5v0__oai21_1
* cell instance $4159 r0 *1 1016.4,1703.52
X$4159 31922 31985 31532 31894 31827 31763 gf180mcu_fd_sc_mcu9t5v0__aoi21_1
* cell instance $4160 m0 *1 1008,1693.44
X$4160 31609 31610 31519 31604 31710 31668 gf180mcu_fd_sc_mcu9t5v0__oai21_1
* cell instance $4161 r0 *1 1010.8,1693.44
X$4161 31261 31713 31668 31769 31710 31772 gf180mcu_fd_sc_mcu9t5v0__nand3_1
* cell instance $4162 m0 *1 1022.56,1703.52
X$4162 31922 31819 31689 31769 31827 31688 gf180mcu_fd_sc_mcu9t5v0__oai21_1
* cell instance $4163 m0 *1 994.56,1713.6
X$4163 31830 31894 31972 31923 gf180mcu_fd_sc_mcu9t5v0__buf_8
* cell instance $4164 m0 *1 990.64,1713.6
X$4164 31338 31341 31894 31972 31922 gf180mcu_fd_sc_mcu9t5v0__nor2_1
* cell instance $4165 r0 *1 980,1713.6
X$4165 31921 32037 31972 31985 gf180mcu_fd_sc_mcu9t5v0__buf_8
* cell instance $4166 m0 *1 1013.6,1693.44
X$4166 31341 31608 31688 31393 31604 31710 31669
+ gf180mcu_fd_sc_mcu9t5v0__oai211_1
* cell instance $4167 m0 *1 1019.2,1693.44
X$4167 31772 31669 31108 31604 31710 31670 gf180mcu_fd_sc_mcu9t5v0__aoi21_1
* cell instance $4168 m0 *1 1014.16,1713.6
X$4168 31923 31763 31541 31713 31393 31894 31972 31975
+ gf180mcu_fd_sc_mcu9t5v0__oai221_1
* cell instance $4169 m0 *1 1029.28,1713.6
X$4169 31519 31924 31894 31972 31689 gf180mcu_fd_sc_mcu9t5v0__nor2_1
* cell instance $4170 m0 *1 1025.92,1713.6
X$4170 31609 31922 31894 31972 31883 gf180mcu_fd_sc_mcu9t5v0__nand2_1
* cell instance $4171 r0 *1 979.44,1693.44
X$4171 31686 31762 31769 31710 31712 gf180mcu_fd_sc_mcu9t5v0__and2_1
* cell instance $4172 m0 *1 993.44,1693.44
X$4172 31687 31712 31604 31710 31667 gf180mcu_fd_sc_mcu9t5v0__nand2_1
* cell instance $4173 m0 *1 1009.12,1713.6
X$4173 31922 31985 31894 31972 31610 gf180mcu_fd_sc_mcu9t5v0__nor2_1
* cell instance $4174 m0 *1 981.12,1713.6
X$4174 31338 31829 31894 31972 31882 gf180mcu_fd_sc_mcu9t5v0__or2_1
* cell instance $4175 m0 *1 977.76,1693.44
X$4175 31685 31762 31604 31710 31711 gf180mcu_fd_sc_mcu9t5v0__nand2_1
* cell instance $4176 r0 *1 986.16,1693.44
X$4176 31258 31711 31769 31710 31818 gf180mcu_fd_sc_mcu9t5v0__nand2_1
* cell instance $4177 r0 *1 1002.96,1713.6
X$4177 31609 31667 32037 31972 32239 gf180mcu_fd_sc_mcu9t5v0__nand2_1
* cell instance $4178 m0 *1 984.48,1673.28
X$4178 31338 31341 31259 31340 31321 31388 31326
+ gf180mcu_fd_sc_mcu9t5v0__aoi22_1
* cell instance $4179 r0 *1 1018.08,1673.28
X$4179 31393 31452 31466 31464 31388 31342 gf180mcu_fd_sc_mcu9t5v0__nand3_1
* cell instance $4180 r0 *1 994,1693.44
X$4180 31608 31769 31710 31771 gf180mcu_fd_sc_mcu9t5v0__clkinv_1
* cell instance $4181 m0 *1 992.88,1703.52
X$4181 31818 31771 31769 31827 31830 gf180mcu_fd_sc_mcu9t5v0__nand2_1
* cell instance $4182 r0 *1 976.64,1693.44
X$4182 31686 31762 31769 31710 31341 gf180mcu_fd_sc_mcu9t5v0__nand2_1
* cell instance $4183 m0 *1 980,1673.28
X$4183 31260 31325 31321 31388 31393 gf180mcu_fd_sc_mcu9t5v0__or2_1
* cell instance $4184 m0 *1 997.36,1663.2
X$4184 31188 31125 31239 31261 gf180mcu_fd_sc_mcu9t5v0__buf_8
* cell instance $4185 r0 *1 1028.72,1713.6
X$4185 31609 31985 32037 31972 31924 gf180mcu_fd_sc_mcu9t5v0__nor2_1
* cell instance $4186 r0 *1 999.04,1663.2
X$4186 31326 31321 31239 31108 gf180mcu_fd_sc_mcu9t5v0__buf_8
* cell instance $4187 r0 *1 983.36,1663.2
X$4187 31260 31325 31321 31239 31188 gf180mcu_fd_sc_mcu9t5v0__nor2_1
* cell instance $4188 m0 *1 1000.72,1683.36
X$4188 31667 31465 31464 31529 31452 gf180mcu_fd_sc_mcu9t5v0__or2_1
* cell instance $4189 r0 *1 1025.36,1673.28
X$4189 31453 31454 31452 31467 31464 31388 31262
+ gf180mcu_fd_sc_mcu9t5v0__oai22_1
* cell instance $4190 r0 *1 1027.6,1663.2
X$4190 31261 31262 31321 31239 31327 gf180mcu_fd_sc_mcu9t5v0__and2_1
* cell instance $4191 m0 *1 989.52,1723.68
X$4191 32092 32105 32037 31106 gf180mcu_fd_sc_mcu9t5v0__clkbuf_16
* cell instance $4192 m0 *1 997.36,1683.36
X$4192 30104 31238 31464 31529 31532 gf180mcu_fd_sc_mcu9t5v0__nand2_1
* cell instance $4193 r0 *1 982.8,1673.28
X$4193 31258 31465 31338 31464 31388 31340 gf180mcu_fd_sc_mcu9t5v0__aoi21_1
* cell instance $4194 r0 *1 988.96,1693.44
X$4194 31258 31711 31608 31769 31710 32038 gf180mcu_fd_sc_mcu9t5v0__aoi21_1
* cell instance $4195 r0 *1 1025.36,1703.52
X$4195 31609 31882 31894 31827 31467 gf180mcu_fd_sc_mcu9t5v0__nor2_1
* cell instance $4196 m0 *1 969.36,1693.44
X$4196 31128 31607 31604 31710 31687 gf180mcu_fd_sc_mcu9t5v0__xnor2_1
* cell instance $4197 m0 *1 974.4,1673.28
X$4197 30104 30910 31321 31388 31260 gf180mcu_fd_sc_mcu9t5v0__and2_1
* cell instance $4198 m0 *1 969.92,1673.28
X$4198 31339 31322 31338 31321 31388 31325 gf180mcu_fd_sc_mcu9t5v0__aoi21_1
* cell instance $4199 m0 *1 971.04,1703.52
X$4199 30104 31760 31686 31817 31769 31827 31829
+ gf180mcu_fd_sc_mcu9t5v0__aoi22_1
* cell instance $4200 r0 *1 975.52,1663.2
X$4200 31258 31324 31321 31239 31259 gf180mcu_fd_sc_mcu9t5v0__or2_1
* cell instance $4201 m0 *1 977.76,1713.6
X$4201 31338 31829 31894 31972 31921 gf180mcu_fd_sc_mcu9t5v0__nor2_1
* cell instance $4202 r0 *1 971.6,1693.44
X$4202 31685 31258 31817 31769 31710 31339 gf180mcu_fd_sc_mcu9t5v0__nand3_1
* cell instance $4203 r0 *1 1005.76,1713.6
X$4203 31532 31985 32037 31972 32039 gf180mcu_fd_sc_mcu9t5v0__nand2_1
* cell instance $4204 r0 *1 1023.68,1683.36
X$4204 31985 31453 31763 31519 31393 31604 31529 31540
+ gf180mcu_fd_sc_mcu9t5v0__oai221_1
* cell instance $4205 r0 *1 1013.04,1683.36
X$4205 31532 31519 31610 31604 31529 31466 gf180mcu_fd_sc_mcu9t5v0__nand3_1
* cell instance $4206 r0 *1 1022,1713.6
X$4206 31609 31985 32037 31972 31819 gf180mcu_fd_sc_mcu9t5v0__nand2_1
* cell instance $4207 r0 *1 988.96,1683.36
X$4207 31258 31465 31687 31604 31529 31608 gf180mcu_fd_sc_mcu9t5v0__oai21_1
* cell instance $4208 r0 *1 996.8,1683.36
X$4208 30104 31238 31604 31529 31609 gf180mcu_fd_sc_mcu9t5v0__and2_1
* cell instance $4209 r0 *1 1030.4,1683.36
X$4209 31532 31985 31604 31529 31454 gf180mcu_fd_sc_mcu9t5v0__nor2_1
* cell instance $4210 r0 *1 1089.2,1703.52
X$4210 31885 31894 31827 31898 gf180mcu_fd_sc_mcu9t5v0__clkinv_1
* cell instance $4211 r0 *1 1076.32,1693.44
X$4211 31393 31713 31769 31710 31331 gf180mcu_fd_sc_mcu9t5v0__nand2_1
* cell instance $4212 m0 *1 1076.32,1703.52
X$4212 31393 31764 31331 31884 31769 31827 31820
+ gf180mcu_fd_sc_mcu9t5v0__oai22_1
* cell instance $4213 m0 *1 1081.92,1703.52
X$4213 31827 31769 gf180mcu_fd_sc_mcu9t5v0__filltie
* cell instance $4214 m0 *1 1074.64,1723.68
X$4214 31923 31610 31924 32037 32105 31884 gf180mcu_fd_sc_mcu9t5v0__nor3_1
* cell instance $4215 r0 *1 1071.28,1713.6
X$4215 31831 32041 32037 31972 31976 gf180mcu_fd_sc_mcu9t5v0__nand2_1
* cell instance $4216 r0 *1 1043.84,1703.52
X$4216 31541 31831 31393 31923 31894 31827 31895
+ gf180mcu_fd_sc_mcu9t5v0__aoi211_1
* cell instance $4217 m0 *1 1056.72,1723.68
X$4217 32243 32037 32105 32095 gf180mcu_fd_sc_mcu9t5v0__clkinv_1
* cell instance $4218 r0 *1 1058.96,1713.6
X$4218 32041 31819 32095 31925 31261 32037 31972 31896
+ gf180mcu_fd_sc_mcu9t5v0__aoi221_1
* cell instance $4219 r0 *1 1060.08,1693.44
X$4219 31341 31608 31819 31769 31710 31764 gf180mcu_fd_sc_mcu9t5v0__nor3_1
* cell instance $4220 m0 *1 1042.16,1693.44
X$4220 31612 31689 31764 31261 31604 31710 31329
+ gf180mcu_fd_sc_mcu9t5v0__aoi211_1
* cell instance $4221 r0 *1 1037.12,1703.52
X$4221 31520 31883 31894 31827 31541 gf180mcu_fd_sc_mcu9t5v0__nand2_1
* cell instance $4222 r0 *1 1098.72,1673.28
X$4222 30040 31242 31464 31388 31469 gf180mcu_fd_sc_mcu9t5v0__nand2_1
* cell instance $4223 m0 *1 1053.36,1673.28
X$4223 31342 31394 31321 31388 31265 gf180mcu_fd_sc_mcu9t5v0__nand2_1
* cell instance $4224 m0 *1 1040.48,1663.2
X$4224 31108 31241 31263 31125 31239 31242 gf180mcu_fd_sc_mcu9t5v0__oai21_1
* cell instance $4225 m0 *1 1091.44,1673.28
X$4225 31615 31242 31547 31330 31321 31388 30897 gf180mcu_fd_sc_mcu9t5v0__nor4_1
* cell instance $4226 m0 *1 1081.92,1663.2
X$4226 31239 31125 gf180mcu_fd_sc_mcu9t5v0__filltie
* cell instance $4227 m0 *1 1070.16,1683.36
X$4227 31520 31521 31976 31261 31464 31529 31396
+ gf180mcu_fd_sc_mcu9t5v0__oai211_1
* cell instance $4228 r0 *1 1044.96,1663.2
X$4228 31108 31241 31119 31264 31321 31239 31243
+ gf180mcu_fd_sc_mcu9t5v0__aoi211_1
* cell instance $4229 r0 *1 1094.8,1663.2
X$4229 30040 30840 31333 31321 31239 31266 gf180mcu_fd_sc_mcu9t5v0__mux2_1
* cell instance $4230 m0 *1 1066.8,1683.36
X$4230 31520 31521 31464 31529 31395 gf180mcu_fd_sc_mcu9t5v0__nor2_1
* cell instance $4231 m0 *1 1067.36,1673.28
X$4231 31261 31395 31321 31388 31109 gf180mcu_fd_sc_mcu9t5v0__nand2_1
* cell instance $4232 m0 *1 1076.88,1673.28
X$4232 31108 31396 31321 31388 31332 gf180mcu_fd_sc_mcu9t5v0__nand2_1
* cell instance $4233 r0 *1 1071.84,1663.2
X$4233 31108 31331 31332 31321 31239 31121 gf180mcu_fd_sc_mcu9t5v0__oai21_1
* cell instance $4234 m0 *1 1061.2,1663.2
X$4234 31108 31189 31125 31239 31244 gf180mcu_fd_sc_mcu9t5v0__nand2_1
* cell instance $4235 m0 *1 1098.16,1683.36
X$4235 31615 31464 31529 31469 31533 gf180mcu_fd_sc_mcu9t5v0__xor2_1
* cell instance $4236 r0 *1 1076.32,1663.2
X$4236 31396 31331 31108 31321 31239 31110 gf180mcu_fd_sc_mcu9t5v0__mux2_1
* cell instance $4237 m0 *1 1081.92,1673.28
X$4237 31388 31321 gf180mcu_fd_sc_mcu9t5v0__filltie
* cell instance $4238 m0 *1 1093.68,1663.2
X$4238 30840 30040 31330 31125 31239 31190 gf180mcu_fd_sc_mcu9t5v0__mux2_1
* cell instance $4239 r0 *1 1055.6,1663.2
X$4239 31189 31265 31108 31321 31239 31130 gf180mcu_fd_sc_mcu9t5v0__mux2_1
* cell instance $4240 m0 *1 1089.76,1723.68
X$4240 31108 32096 32106 32037 32105 31615 gf180mcu_fd_sc_mcu9t5v0__oai21_1
* cell instance $4241 r0 *1 1094.24,1673.28
X$4241 31615 31242 30040 31464 31388 31468 gf180mcu_fd_sc_mcu9t5v0__oai21_1
* cell instance $4242 m0 *1 1081.92,1683.36
X$4242 31529 31464 gf180mcu_fd_sc_mcu9t5v0__filltie
* cell instance $4243 r0 *1 1062.88,1663.2
X$4243 31108 31265 31244 31321 31239 31330 gf180mcu_fd_sc_mcu9t5v0__oai21_1
* cell instance $4244 m0 *1 1036.56,1693.44
X$4244 31532 31667 31604 31710 31520 gf180mcu_fd_sc_mcu9t5v0__nand2_1
* cell instance $4245 m0 *1 1089.76,1693.44
X$4245 31108 31544 31119 31670 31604 31710 31616
+ gf180mcu_fd_sc_mcu9t5v0__aoi211_1
* cell instance $4246 r0 *1 1056.72,1703.52
X$4246 31895 31896 31894 31827 31189 gf180mcu_fd_sc_mcu9t5v0__or2_1
* cell instance $4247 m0 *1 1081.92,1713.6
X$4247 31972 31894 gf180mcu_fd_sc_mcu9t5v0__filltie
* cell instance $4248 r0 *1 1061.2,1703.52
X$4248 31882 31923 31894 31827 31521 gf180mcu_fd_sc_mcu9t5v0__nand2_1
* cell instance $4249 m0 *1 1069.6,1723.68
X$4249 31532 31519 31831 32095 32037 32105 32042
+ gf180mcu_fd_sc_mcu9t5v0__aoi22_1
* cell instance $4250 m0 *1 1051.12,1723.68
X$4250 31924 32243 32040 31261 32037 32105 31394
+ gf180mcu_fd_sc_mcu9t5v0__oai211_1
* cell instance $4251 m0 *1 1055.04,1713.6
X$4251 31519 32039 31925 31894 31972 31773 gf180mcu_fd_sc_mcu9t5v0__nand3_1
* cell instance $4252 r0 *1 1075.2,1683.36
X$4252 31393 31671 31614 31604 31529 31545 gf180mcu_fd_sc_mcu9t5v0__oai21_1
* cell instance $4253 r0 *1 1086.4,1683.36
X$4253 31108 31545 31604 31529 31546 gf180mcu_fd_sc_mcu9t5v0__nand2_1
* cell instance $4254 r0 *1 1089.2,1683.36
X$4254 31108 31544 31546 31604 31529 31547 gf180mcu_fd_sc_mcu9t5v0__oai21_1
* cell instance $4255 r0 *1 1041.6,1683.36
X$4255 31985 31541 31604 31529 31612 gf180mcu_fd_sc_mcu9t5v0__nand2_1
* cell instance $4256 r0 *1 1039.36,1663.2
X$4256 31261 31328 31329 31108 31321 31239 31264
+ gf180mcu_fd_sc_mcu9t5v0__aoi211_1
* cell instance $4257 r0 *1 1094.8,1683.36
X$4257 31547 31604 31529 31468 31548 gf180mcu_fd_sc_mcu9t5v0__xor2_1
* cell instance $4258 r0 *1 1047.2,1683.36
X$4258 31519 31542 31604 31529 31543 gf180mcu_fd_sc_mcu9t5v0__nand2_1
* cell instance $4259 m0 *1 1039.36,1693.44
X$4259 31541 31689 31604 31710 31611 gf180mcu_fd_sc_mcu9t5v0__nand2_1
* cell instance $4260 r0 *1 1050,1683.36
X$4260 31261 31543 31611 31604 31529 31613 gf180mcu_fd_sc_mcu9t5v0__nand3_1
* cell instance $4261 r0 *1 1053.92,1683.36
X$4261 31613 31540 31604 31529 31544 gf180mcu_fd_sc_mcu9t5v0__nand2_1
* cell instance $4262 m0 *1 1081.92,1723.68
X$4262 32105 32037 gf180mcu_fd_sc_mcu9t5v0__filltie
* cell instance $4263 m0 *1 1068.48,1693.44
X$4263 31520 31519 31521 31773 31604 31710 31671
+ gf180mcu_fd_sc_mcu9t5v0__oai211_1
* cell instance $4264 m0 *1 1094.24,1723.68
X$4264 31108 32096 31119 32117 32037 32105 32097
+ gf180mcu_fd_sc_mcu9t5v0__aoi211_1
* cell instance $4265 r0 *1 1091.44,1703.52
X$4265 31898 31820 31108 31894 31827 31333 gf180mcu_fd_sc_mcu9t5v0__mux2_1
* cell instance $4266 m0 *1 1043.84,1723.68
X$4266 32093 32094 32037 32105 32096 gf180mcu_fd_sc_mcu9t5v0__or2_1
* cell instance $4267 r0 *1 1069.6,1703.52
X$4267 31520 31521 32229 31884 31261 31894 31827 31897
+ gf180mcu_fd_sc_mcu9t5v0__oai221_1
* cell instance $4268 r0 *1 1076.32,1703.52
X$4268 31261 31519 31831 31897 31894 31827 31885
+ gf180mcu_fd_sc_mcu9t5v0__oai31_1
* cell instance $4269 r0 *1 1058.4,1683.36
X$4269 31341 31608 31519 31542 31393 31604 31529 31614
+ gf180mcu_fd_sc_mcu9t5v0__oai221_1
* cell instance $4270 m0 *1 1094.24,1703.52
X$4270 31108 31820 31769 31827 31832 gf180mcu_fd_sc_mcu9t5v0__nor2_1
* cell instance $4271 r0 *1 1098.72,1703.52
X$4271 31108 31898 31119 31832 31894 31827 31833
+ gf180mcu_fd_sc_mcu9t5v0__aoi211_1
* cell instance $4272 m0 *1 1081.92,1693.44
X$4272 31710 31604 gf180mcu_fd_sc_mcu9t5v0__filltie
* cell instance $4273 r0 *1 1067.92,1713.6
X$4273 31923 31924 32037 31972 32041 gf180mcu_fd_sc_mcu9t5v0__nor2_1
* cell instance $4274 m0 *1 1044.4,1713.6
X$4274 31520 31882 31883 31894 31972 31925 gf180mcu_fd_sc_mcu9t5v0__nand3_1
* cell instance $4275 m0 *1 0,2210
X$4275 gf180mcu_fd_io__cor
* cell instance $4276 r0 *1 490,1854.72
X$4276 33242 33323 gf180mcu_fd_sc_mcu9t5v0__filltie
* cell instance $4277 r0 *1 370.16,1854.72
X$4277 33242 33323 gf180mcu_fd_sc_mcu9t5v0__endcap
* cell instance $4278 m0 *1 415.52,1380.96
X$4278 23306 25816 25309 18834 25705 25870 gf180mcu_fd_sc_mcu9t5v0__dffrnq_2
* cell instance $4279 m0 *1 370.16,1380.96
X$4279 25870 25705 gf180mcu_fd_sc_mcu9t5v0__endcap
* cell instance $4280 r0 *1 370.16,1380.96
X$4280 25870 25997 gf180mcu_fd_sc_mcu9t5v0__endcap
* cell instance $4281 r0 *1 492.24,1380.96
X$4281 20826 25819 25693 25997 25870 25818 gf180mcu_fd_sc_mcu9t5v0__mux2_1
* cell instance $4282 m0 *1 472.08,1380.96
X$4282 25817 25818 25819 18834 25705 25870 gf180mcu_fd_sc_mcu9t5v0__dffrnq_2
* cell instance $4283 r0 *1 459.2,1380.96
X$4283 25817 25861 25862 18834 25997 25870 gf180mcu_fd_sc_mcu9t5v0__dffrnq_2
* cell instance $4284 m0 *1 491.12,1380.96
X$4284 25817 25696 25697 18834 25705 25870 gf180mcu_fd_sc_mcu9t5v0__dffrnq_2
* cell instance $4285 r0 *1 490,1380.96
X$4285 25870 25997 gf180mcu_fd_sc_mcu9t5v0__filltie
* cell instance $4286 r0 *1 512.4,1380.96
X$4286 25863 25992 24819 25997 25870 25991 gf180mcu_fd_sc_mcu9t5v0__mux2_1
* cell instance $4287 m0 *1 464.8,1380.96
X$4287 20030 25862 25693 25705 25870 25861 gf180mcu_fd_sc_mcu9t5v0__mux2_1
* cell instance $4288 m45 *1 0,1105
X$4288 18832 33813 33811 33809 33807 33805 33803 33801 33799 33797 33795 33793
+ 33791 33789 33787 33785 33783 33781 33779 33777 33775 33773 33771 33769 33767
+ 33765 33763 33761 33759 33757 33755 33753 33751 33749 33747 33745 33743 33741
+ 33739 33737 33735 33733 33731 33729 33727 33725 33723 33721 33719 33717 33715
+ 33713 33711 33709 33707 33705 33703 33701 33699 33697 33695 33693 33691 33689
+ 33687 33685 33683 33681 33679 33677 33675 33673 33671 17699 33669 33667 33665
+ 33663 33661 33659 17699 18833 gf180mcu_fd_io__in_c
* cell instance $4289 m0 *1 528.64,1380.96
X$4289 25817 25820 25312 18834 25705 25870 gf180mcu_fd_sc_mcu9t5v0__dffrnq_2
* cell instance $4290 r0 *1 523.04,1380.96
X$4290 25992 25260 25997 25870 25534 gf180mcu_fd_sc_mcu9t5v0__or2_1
* cell instance $4291 m45 *1 0,1180
X$4291 20974 33813 33811 33809 33807 33805 33803 33801 33799 33797 33795 33793
+ 33791 33789 33785 33787 33783 33779 33781 33777 33775 33773 33771 33769 33767
+ 33763 33765 33761 33759 33757 33755 33753 33751 33749 33747 33745 33743 33741
+ 33737 33739 33735 33733 33731 33729 33727 33725 33723 20066 33721 33719 33717
+ 33713 33715 33711 33709 33707 33705 33701 33703 33693 33699 33695 33689 33691
+ 33697 33687 33683 33685 33681 33679 33677 33669 33675 33673 33671 33665 33667
+ 20018 33663 33659 33661 20066 20018 20018 20018 20018 19848 20066
+ gf180mcu_fd_io__bi_t
* cell instance $4292 m0 *1 443.52,1380.96
X$4292 23306 25694 25695 18834 25705 25870 gf180mcu_fd_sc_mcu9t5v0__dffrnq_2
* cell instance $4293 r0 *1 370.16,1421.28
X$4293 27078 27213 gf180mcu_fd_sc_mcu9t5v0__endcap
* cell instance $4294 r0 *1 370.16,1391.04
X$4294 26166 26331 gf180mcu_fd_sc_mcu9t5v0__endcap
* cell instance $4295 m0 *1 370.16,1391.04
X$4295 26166 25997 gf180mcu_fd_sc_mcu9t5v0__endcap
* cell instance $4296 r0 *1 370.16,1461.6
X$4296 28239 28378 gf180mcu_fd_sc_mcu9t5v0__endcap
* cell instance $4297 m0 *1 370.16,1471.68
X$4297 28530 28378 gf180mcu_fd_sc_mcu9t5v0__endcap
* cell instance $4298 r0 *1 370.16,1471.68
X$4298 28530 28635 gf180mcu_fd_sc_mcu9t5v0__endcap
* cell instance $4299 m0 *1 370.16,1481.76
X$4299 28661 28635 gf180mcu_fd_sc_mcu9t5v0__endcap
* cell instance $4300 r0 *1 370.16,1431.36
X$4300 27367 27517 gf180mcu_fd_sc_mcu9t5v0__endcap
* cell instance $4301 m0 *1 370.16,1401.12
X$4301 26456 26331 gf180mcu_fd_sc_mcu9t5v0__endcap
* cell instance $4302 m0 *1 370.16,1431.36
X$4302 27367 27213 gf180mcu_fd_sc_mcu9t5v0__endcap
* cell instance $4303 m0 *1 370.16,1441.44
X$4303 27666 27517 gf180mcu_fd_sc_mcu9t5v0__endcap
* cell instance $4304 r0 *1 370.16,1401.12
X$4304 26456 26632 gf180mcu_fd_sc_mcu9t5v0__endcap
* cell instance $4305 r0 *1 370.16,1441.44
X$4305 27666 27807 gf180mcu_fd_sc_mcu9t5v0__endcap
* cell instance $4306 m0 *1 370.16,1451.52
X$4306 27945 27807 gf180mcu_fd_sc_mcu9t5v0__endcap
* cell instance $4307 r0 *1 370.16,1451.52
X$4307 27945 28103 gf180mcu_fd_sc_mcu9t5v0__endcap
* cell instance $4308 m0 *1 370.16,1411.2
X$4308 26757 26632 gf180mcu_fd_sc_mcu9t5v0__endcap
* cell instance $4309 r0 *1 370.16,1411.2
X$4309 26757 26942 gf180mcu_fd_sc_mcu9t5v0__endcap
* cell instance $4310 m0 *1 370.16,1461.6
X$4310 28239 28103 gf180mcu_fd_sc_mcu9t5v0__endcap
* cell instance $4311 m0 *1 370.16,1421.28
X$4311 27078 26942 gf180mcu_fd_sc_mcu9t5v0__endcap
* cell instance $4312 r0 *1 514.08,1471.68
X$4312 27205 28490 28234 18834 28635 28530 gf180mcu_fd_sc_mcu9t5v0__dffrnq_2
* cell instance $4313 r0 *1 507.92,1391.04
X$4313 25817 25991 25992 18834 26331 26166 gf180mcu_fd_sc_mcu9t5v0__dffrnq_2
* cell instance $4314 r0 *1 515.2,1441.44
X$4314 27205 27766 27798 18834 27807 27666 gf180mcu_fd_sc_mcu9t5v0__dffrnq_2
* cell instance $4315 m0 *1 526.4,1451.52
X$4315 27940 27798 24819 27807 27945 27766 gf180mcu_fd_sc_mcu9t5v0__mux2_1
* cell instance $4316 r0 *1 526.4,1451.52
X$4316 27205 27977 27940 18834 28103 27945 gf180mcu_fd_sc_mcu9t5v0__dffrnq_2
* cell instance $4317 m0 *1 523.04,1471.68
X$4317 28343 28234 24702 28378 28530 28490 gf180mcu_fd_sc_mcu9t5v0__mux2_1
* cell instance $4318 r0 *1 525.84,1431.36
X$4318 27205 27362 27363 18834 27517 27367 gf180mcu_fd_sc_mcu9t5v0__dffrnq_2
* cell instance $4319 m0 *1 533.12,1471.68
X$4319 27205 28372 28343 18834 28378 28530 gf180mcu_fd_sc_mcu9t5v0__dffrnq_2
* cell instance $4320 r0 *1 542.08,1461.6
X$4320 22830 28343 25693 28378 28239 28372 gf180mcu_fd_sc_mcu9t5v0__mux2_1
* cell instance $4321 m0 *1 535.36,1451.52
X$4321 27799 27940 24702 27807 27945 27977 gf180mcu_fd_sc_mcu9t5v0__mux2_1
* cell instance $4322 m0 *1 511.84,1461.6
X$4322 28234 27797 24819 28103 28239 28233 gf180mcu_fd_sc_mcu9t5v0__mux2_1
* cell instance $4323 r0 *1 490,1451.52
X$4323 27945 28103 gf180mcu_fd_sc_mcu9t5v0__filltie
* cell instance $4324 r0 *1 470.96,1461.6
X$4324 27484 28341 27939 18834 28378 28239 gf180mcu_fd_sc_mcu9t5v0__dffrnq_2
* cell instance $4325 r0 *1 490,1431.36
X$4325 27367 27517 gf180mcu_fd_sc_mcu9t5v0__filltie
* cell instance $4326 r0 *1 490,1461.6
X$4326 28239 28378 gf180mcu_fd_sc_mcu9t5v0__filltie
* cell instance $4327 r0 *1 490,1471.68
X$4327 28530 28635 gf180mcu_fd_sc_mcu9t5v0__filltie
* cell instance $4328 r0 *1 468.72,1471.68
X$4328 19745 28340 25693 28635 28530 28488 gf180mcu_fd_sc_mcu9t5v0__mux2_1
* cell instance $4329 m0 *1 465.92,1441.44
X$4329 27200 27938 27937 27361 27517 27666 27201 gf180mcu_fd_sc_mcu9t5v0__nor4_1
* cell instance $4330 m0 *1 463.12,1451.52
X$4330 28232 27938 24819 27807 27945 27976 gf180mcu_fd_sc_mcu9t5v0__mux2_1
* cell instance $4331 m0 *1 508.48,1451.52
X$4331 27798 27797 27619 27620 27807 27945 26874 gf180mcu_fd_sc_mcu9t5v0__nor4_1
* cell instance $4332 r0 *1 465.92,1441.44
X$4332 27200 27938 27937 27361 27807 27666 27654
+ gf180mcu_fd_sc_mcu9t5v0__nand4_1
* cell instance $4333 r0 *1 510.16,1441.44
X$4333 27798 27797 27619 27620 27807 27666 27656
+ gf180mcu_fd_sc_mcu9t5v0__nand4_1
* cell instance $4334 m0 *1 511.28,1441.44
X$4334 27654 27656 27517 27666 25993 gf180mcu_fd_sc_mcu9t5v0__or2_1
* cell instance $4335 m0 *1 504,1441.44
X$4335 27204 27620 24819 27517 27666 27655 gf180mcu_fd_sc_mcu9t5v0__mux2_1
* cell instance $4336 m0 *1 487.2,1471.68
X$4336 27484 28489 28342 18834 28378 28530 gf180mcu_fd_sc_mcu9t5v0__dffrnq_2
* cell instance $4337 m0 *1 490,1481.76
X$4337 28661 28635 gf180mcu_fd_sc_mcu9t5v0__filltie
* cell instance $4338 m0 *1 460.32,1471.68
X$4338 27484 28488 28340 18834 28378 28530 gf180mcu_fd_sc_mcu9t5v0__dffrnq_2
* cell instance $4339 r0 *1 496.72,1471.68
X$4339 22168 28342 25693 28635 28530 28489 gf180mcu_fd_sc_mcu9t5v0__mux2_1
* cell instance $4340 m0 *1 477.12,1441.44
X$4340 27484 27618 27619 18834 27517 27666 gf180mcu_fd_sc_mcu9t5v0__dffrnq_2
* cell instance $4341 r0 *1 502.32,1461.6
X$4341 27205 28233 27797 18834 28378 28239 gf180mcu_fd_sc_mcu9t5v0__dffrnq_2
* cell instance $4342 r0 *1 491.12,1441.44
X$4342 27205 27655 27620 18834 27807 27666 gf180mcu_fd_sc_mcu9t5v0__dffrnq_2
* cell instance $4343 r0 *1 491.12,1461.6
X$4343 28342 27939 24702 28378 28239 28341 gf180mcu_fd_sc_mcu9t5v0__mux2_1
* cell instance $4344 r0 *1 490,1441.44
X$4344 27666 27807 gf180mcu_fd_sc_mcu9t5v0__filltie
* cell instance $4345 m0 *1 483.84,1451.52
X$4345 27939 27619 24819 27807 27945 27618 gf180mcu_fd_sc_mcu9t5v0__mux2_1
* cell instance $4346 r0 *1 482.72,1401.12
X$4346 26158 26327 24819 26632 26456 26446 gf180mcu_fd_sc_mcu9t5v0__mux2_1
* cell instance $4347 r0 *1 514.08,1411.2
X$4347 27201 26874 25698 26942 26757 25260 gf180mcu_fd_sc_mcu9t5v0__aoi21_1
* cell instance $4348 m0 *1 461.44,1421.28
X$4348 25817 26928 27065 18834 26942 27078 gf180mcu_fd_sc_mcu9t5v0__dffrnq_2
* cell instance $4349 r0 *1 503.44,1421.28
X$4349 27205 27203 27204 18834 27213 27078 gf180mcu_fd_sc_mcu9t5v0__dffrnq_2
* cell instance $4350 r0 *1 501.76,1411.2
X$4350 23615 26873 25693 26942 26757 26929 gf180mcu_fd_sc_mcu9t5v0__mux2_1
* cell instance $4351 m0 *1 514.08,1421.28
X$4351 26750 27204 24702 26942 27078 27203 gf180mcu_fd_sc_mcu9t5v0__mux2_1
* cell instance $4352 r0 *1 422.24,1471.68
X$4352 28199 28487 28339 18834 28635 28530 gf180mcu_fd_sc_mcu9t5v0__dffrnq_2
* cell instance $4353 r0 *1 490,1391.04
X$4353 26166 26331 gf180mcu_fd_sc_mcu9t5v0__filltie
* cell instance $4354 r0 *1 466.48,1421.28
X$4354 27065 27200 24819 27213 27078 27242 gf180mcu_fd_sc_mcu9t5v0__mux2_1
* cell instance $4355 m0 *1 491.12,1421.28
X$4355 25817 26929 26873 18834 26942 27078 gf180mcu_fd_sc_mcu9t5v0__dffrnq_2
* cell instance $4356 r0 *1 473.76,1421.28
X$4356 27066 27065 24702 27213 27078 26928 gf180mcu_fd_sc_mcu9t5v0__mux2_1
* cell instance $4357 r0 *1 482.72,1421.28
X$4357 22829 27066 25693 27213 27078 27202 gf180mcu_fd_sc_mcu9t5v0__mux2_1
* cell instance $4358 m0 *1 478.24,1401.12
X$4358 25817 26446 26327 18834 26331 26456 gf180mcu_fd_sc_mcu9t5v0__dffrnq_2
* cell instance $4359 r0 *1 437.92,1391.04
X$4359 23306 26155 26156 18834 26331 26166 gf180mcu_fd_sc_mcu9t5v0__dffrnq_2
* cell instance $4360 r0 *1 490,1421.28
X$4360 27078 27213 gf180mcu_fd_sc_mcu9t5v0__filltie
* cell instance $4361 r0 *1 500.08,1391.04
X$4361 25817 26331 26166 gf180mcu_fd_sc_mcu9t5v0__clkbuf_4
* cell instance $4362 r0 *1 436.24,1411.2
X$4362 23306 26872 26748 18834 26942 26757 gf180mcu_fd_sc_mcu9t5v0__dffrnq_2
* cell instance $4363 r0 *1 416.64,1431.36
X$4363 27484 27358 27359 18834 27517 27367 gf180mcu_fd_sc_mcu9t5v0__dffrnq_2
* cell instance $4364 r0 *1 490,1411.2
X$4364 26757 26942 gf180mcu_fd_sc_mcu9t5v0__filltie
* cell instance $4365 m0 *1 422.8,1461.6
X$4365 28199 28200 28201 18834 28103 28239 gf180mcu_fd_sc_mcu9t5v0__dffrnq_2
* cell instance $4366 r0 *1 418.88,1391.04
X$4366 23306 26153 26154 18834 26331 26166 gf180mcu_fd_sc_mcu9t5v0__dffrnq_2
* cell instance $4367 r0 *1 490,1401.12
X$4367 26456 26632 gf180mcu_fd_sc_mcu9t5v0__filltie
* cell instance $4368 m0 *1 506.8,1391.04
X$4368 19567 25997 26166 25817 gf180mcu_fd_sc_mcu9t5v0__clkbuf_8
* cell instance $4369 m0 *1 433.44,1471.68
X$4369 22828 28339 25693 28378 28530 28487 gf180mcu_fd_sc_mcu9t5v0__mux2_1
* cell instance $4370 r0 *1 467.04,1391.04
X$4370 25817 26157 26158 18834 26331 26166 gf180mcu_fd_sc_mcu9t5v0__dffrnq_2
* cell instance $4371 m0 *1 497.28,1401.12
X$4371 25817 26447 25863 18834 26331 26456 gf180mcu_fd_sc_mcu9t5v0__dffrnq_2
* cell instance $4372 r0 *1 503.44,1401.12
X$4372 26873 25863 24702 26632 26456 26447 gf180mcu_fd_sc_mcu9t5v0__mux2_1
* cell instance $4373 m0 *1 471.52,1391.04
X$4373 25862 26158 24702 25997 26166 26157 gf180mcu_fd_sc_mcu9t5v0__mux2_1
* cell instance $4374 m0 *1 542.08,1421.28
X$4374 27363 27068 24819 26942 27078 27067 gf180mcu_fd_sc_mcu9t5v0__mux2_1
* cell instance $4375 r0 *1 531.44,1391.04
X$4375 25817 26159 25569 18834 26331 26166 gf180mcu_fd_sc_mcu9t5v0__dffrnq_2
* cell instance $4376 m0 *1 434,1441.44
X$4376 22832 27512 25693 27517 27666 27617 gf180mcu_fd_sc_mcu9t5v0__mux2_1
* cell instance $4377 m0 *1 544.88,1401.12
X$4377 22443 26160 25693 26331 26456 26448 gf180mcu_fd_sc_mcu9t5v0__mux2_1
* cell instance $4378 m0 *1 526.96,1411.2
X$4378 22833 26750 25693 26632 26757 26749 gf180mcu_fd_sc_mcu9t5v0__mux2_1
* cell instance $4379 m0 *1 439.04,1421.28
X$4379 21726 26747 25693 26942 27078 26927 gf180mcu_fd_sc_mcu9t5v0__mux2_1
* cell instance $4380 m0 *1 430.08,1391.04
X$4380 22572 26154 25693 25997 26166 26153 gf180mcu_fd_sc_mcu9t5v0__mux2_1
* cell instance $4381 m0 *1 541.52,1391.04
X$4381 26160 25569 24702 25997 26166 26159 gf180mcu_fd_sc_mcu9t5v0__mux2_1
* cell instance $4382 m0 *1 526.4,1401.12
X$4382 26502 25260 26331 26456 25111 gf180mcu_fd_sc_mcu9t5v0__or2_1
* cell instance $4383 r0 *1 431.2,1461.6
X$4383 28339 28201 24702 28378 28239 28200 gf180mcu_fd_sc_mcu9t5v0__mux2_1
* cell instance $4384 m0 *1 428.4,1431.36
X$4384 27512 27359 24702 27213 27367 27358 gf180mcu_fd_sc_mcu9t5v0__mux2_1
* cell instance $4385 r0 *1 455.28,1401.12
X$4385 26748 26502 24819 26632 26456 26625 gf180mcu_fd_sc_mcu9t5v0__mux2_1
* cell instance $4386 m0 *1 448.56,1461.6
X$4386 27484 28103 28239 gf180mcu_fd_sc_mcu9t5v0__clkinv_8
* cell instance $4387 r0 *1 457.52,1461.6
X$4387 28340 28232 24702 28378 28239 28371 gf180mcu_fd_sc_mcu9t5v0__mux2_1
* cell instance $4388 m0 *1 448.56,1451.52
X$4388 19567 27807 27945 27484 gf180mcu_fd_sc_mcu9t5v0__clkbuf_8
* cell instance $4389 m0 *1 441.28,1471.68
X$4389 28199 28371 28232 18834 28378 28530 gf180mcu_fd_sc_mcu9t5v0__dffrnq_2
* cell instance $4390 m0 *1 452.48,1411.2
X$4390 25817 26625 26502 18834 26632 26757 gf180mcu_fd_sc_mcu9t5v0__dffrnq_2
* cell instance $4391 r0 *1 440.72,1431.36
X$4391 27484 27360 27361 18834 27517 27367 gf180mcu_fd_sc_mcu9t5v0__dffrnq_2
* cell instance $4392 r0 *1 455.84,1451.52
X$4392 27484 27976 27938 18834 28103 27945 gf180mcu_fd_sc_mcu9t5v0__dffrnq_2
* cell instance $4393 m0 *1 454.16,1431.36
X$4393 27484 27242 27200 18834 27213 27367 gf180mcu_fd_sc_mcu9t5v0__dffrnq_2
* cell instance $4394 m0 *1 440.72,1451.52
X$4394 28201 27937 24819 27807 27945 27936 gf180mcu_fd_sc_mcu9t5v0__mux2_1
* cell instance $4395 m0 *1 441.28,1391.04
X$4395 26154 26156 24702 25997 26166 26155 gf180mcu_fd_sc_mcu9t5v0__mux2_1
* cell instance $4396 r0 *1 436.8,1451.52
X$4396 28199 27936 27937 18834 28103 27945 gf180mcu_fd_sc_mcu9t5v0__dffrnq_2
* cell instance $4397 m0 *1 426.16,1411.2
X$4397 23306 26927 26747 18834 26632 26757 gf180mcu_fd_sc_mcu9t5v0__dffrnq_2
* cell instance $4398 m0 *1 414.96,1441.44
X$4398 27484 27617 27512 18834 27517 27666 gf180mcu_fd_sc_mcu9t5v0__dffrnq_2
* cell instance $4399 m0 *1 444.08,1431.36
X$4399 27359 27361 24819 27213 27367 27360 gf180mcu_fd_sc_mcu9t5v0__mux2_1
* cell instance $4400 m0 *1 445.2,1411.2
X$4400 26747 26748 24702 26632 26757 26872 gf180mcu_fd_sc_mcu9t5v0__mux2_1
* cell instance $4401 m0 *1 532.56,1431.36
X$4401 19745 27363 24702 27213 27367 27362 gf180mcu_fd_sc_mcu9t5v0__mux2_1
* cell instance $4402 m0 *1 477.12,1431.36
X$4402 27205 27202 27066 18834 27213 27367 gf180mcu_fd_sc_mcu9t5v0__dffrnq_2
* cell instance $4403 r0 *1 519.12,1411.2
X$4403 25817 26749 26750 18834 26942 26757 gf180mcu_fd_sc_mcu9t5v0__dffrnq_2
* cell instance $4404 r0 *1 456.96,1239.84
X$4404 21530 21708 21709 21711 21884 21719 21988 gf180mcu_fd_sc_mcu9t5v0__nor4_1
* cell instance $4405 r0 *1 496.72,1239.84
X$4405 21348 21712 21567 11958 21719 21884 gf180mcu_fd_sc_mcu9t5v0__dffsnq_2
* cell instance $4406 r0 *1 490,1239.84
X$4406 21719 21884 gf180mcu_fd_sc_mcu9t5v0__filltie
* cell instance $4407 r0 *1 483.84,1239.84
X$4407 21529 21833 21884 21719 21566 gf180mcu_fd_sc_mcu9t5v0__nor2_1
* cell instance $4408 r0 *1 477.12,1239.84
X$4408 21832 21876 21884 21719 21833 gf180mcu_fd_sc_mcu9t5v0__xnor2_1
* cell instance $4409 r0 *1 421.12,1239.84
X$4409 21829 21707 21884 21719 21706 gf180mcu_fd_sc_mcu9t5v0__nor2_1
* cell instance $4410 r0 *1 411.04,1249.92
X$4410 21986 21706 22124 21997 22112 gf180mcu_fd_sc_mcu9t5v0__xnor2_1
* cell instance $4411 m0 *1 397.04,1260
X$4411 21348 22111 21986 18834 22124 22295 gf180mcu_fd_sc_mcu9t5v0__dffrnq_2
* cell instance $4412 r0 *1 398.16,1239.84
X$4412 21348 21827 21828 18834 21884 21719 gf180mcu_fd_sc_mcu9t5v0__dffrnq_2
* cell instance $4413 m0 *1 397.04,1320.48
X$4413 23306 24111 23894 18834 23957 24118 gf180mcu_fd_sc_mcu9t5v0__dffrnq_2
* cell instance $4414 m0 *1 413.84,1310.4
X$4414 23306 23611 23666 18834 23623 23797 gf180mcu_fd_sc_mcu9t5v0__dffrnq_2
* cell instance $4415 r0 *1 397.6,1290.24
X$4415 23306 23189 23144 18834 23319 23200 gf180mcu_fd_sc_mcu9t5v0__dffrnq_2
* cell instance $4416 m0 *1 399.84,1280.16
X$4416 22820 22566 22998 18834 22700 22885 gf180mcu_fd_sc_mcu9t5v0__dffrnq_2
* cell instance $4417 r0 *1 451.36,1239.84
X$4417 21530 21709 21710 21708 21884 21719 21830
+ gf180mcu_fd_sc_mcu9t5v0__oai31_1
* cell instance $4418 r0 *1 440.72,1239.84
X$4418 22158 21707 21830 21884 21719 21831 gf180mcu_fd_sc_mcu9t5v0__nand3_1
* cell instance $4419 r0 *1 370.16,1239.84
X$4419 21719 21884 gf180mcu_fd_sc_mcu9t5v0__endcap
* cell instance $4420 r0 *1 409.92,1280.16
X$4420 22998 22999 23038 22885 22874 gf180mcu_fd_sc_mcu9t5v0__xnor2_1
* cell instance $4421 m0 *1 408.8,1290.24
X$4421 23144 23038 23200 23145 23143 gf180mcu_fd_sc_mcu9t5v0__xor2_1
* cell instance $4422 r0 *1 406,1149.12
X$4422 18093 18947 18951 18834 19171 18996 gf180mcu_fd_sc_mcu9t5v0__dffrnq_2
* cell instance $4423 m0 *1 412.72,1139.04
X$4423 18093 18564 18419 18834 18553 18731 gf180mcu_fd_sc_mcu9t5v0__dffrnq_2
* cell instance $4424 r0 *1 403.76,1169.28
X$4424 18093 19713 19554 18834 19729 19605 gf180mcu_fd_sc_mcu9t5v0__dffrnq_2
* cell instance $4425 r0 *1 538.72,1310.4
X$4425 21726 22405 23957 23797 23949 gf180mcu_fd_sc_mcu9t5v0__nand2_1
* cell instance $4426 m0 *1 481.6,1330.56
X$4426 22820 24269 24517 18834 24232 24414 gf180mcu_fd_sc_mcu9t5v0__dffrnq_2
* cell instance $4427 m0 *1 467.04,1360.8
X$4427 23306 25155 24988 18834 25158 25268 gf180mcu_fd_sc_mcu9t5v0__dffrnq_2
* cell instance $4428 r0 *1 491.12,1310.4
X$4428 22820 23670 23612 18834 23957 23797 gf180mcu_fd_sc_mcu9t5v0__dffrnq_2
* cell instance $4429 r0 *1 478.8,1340.64
X$4429 22441 24703 24702 24828 24712 24564 gf180mcu_fd_sc_mcu9t5v0__mux2_1
* cell instance $4430 r0 *1 472.64,1310.4
X$4430 23667 21876 22876 23957 23797 23896 gf180mcu_fd_sc_mcu9t5v0__oai21_1
* cell instance $4431 r0 *1 468.72,1310.4
X$4431 23896 23957 23797 23947 gf180mcu_fd_sc_mcu9t5v0__clkinv_1
* cell instance $4432 r0 *1 490,1310.4
X$4432 23797 23957 gf180mcu_fd_sc_mcu9t5v0__filltie
* cell instance $4433 m0 *1 471.52,1340.64
X$4433 23306 24564 24703 18834 24528 24712 gf180mcu_fd_sc_mcu9t5v0__dffrnq_2
* cell instance $4434 r0 *1 482.72,1330.56
X$4434 24703 24517 24819 24528 24414 24269 gf180mcu_fd_sc_mcu9t5v0__mux2_1
* cell instance $4435 m0 *1 472.08,1290.24
X$4435 22820 23001 22823 18834 23038 23200 gf180mcu_fd_sc_mcu9t5v0__dffrnq_2
* cell instance $4436 m0 *1 467.04,1270.08
X$4436 21348 22439 21878 18834 22449 22577 gf180mcu_fd_sc_mcu9t5v0__dffrnq_2
* cell instance $4437 r0 *1 478.24,1249.92
X$4437 21832 22124 21997 21878 22159 gf180mcu_fd_sc_mcu9t5v0__xor2_1
* cell instance $4438 m0 *1 480.48,1260
X$4438 21529 22159 23147 22124 22295 22286 gf180mcu_fd_sc_mcu9t5v0__oai21_1
* cell instance $4439 r0 *1 428.4,1310.4
X$4439 24226 23894 23895 23666 23957 23797 23796 gf180mcu_fd_sc_mcu9t5v0__or4_1
* cell instance $4440 r0 *1 442.4,1310.4
X$4440 23895 23496 22163 23957 23797 24070 gf180mcu_fd_sc_mcu9t5v0__or3_1
* cell instance $4441 r0 *1 448.56,1310.4
X$4441 23496 22163 23895 22158 23957 23797 23946
+ gf180mcu_fd_sc_mcu9t5v0__oai211_1
* cell instance $4442 r0 *1 520.8,1310.4
X$4442 23898 22163 22162 23897 23957 23797 23948
+ gf180mcu_fd_sc_mcu9t5v0__aoi22_1
* cell instance $4443 m0 *1 540.4,1320.48
X$4443 24272 22163 22162 23949 23957 24118 24074
+ gf180mcu_fd_sc_mcu9t5v0__aoi22_1
* cell instance $4444 r0 *1 495.6,1370.88
X$4444 25819 25697 24702 25705 25581 25696 gf180mcu_fd_sc_mcu9t5v0__mux2_1
* cell instance $4445 m0 *1 504,1330.56
X$4445 24821 24271 24819 24232 24414 24270 gf180mcu_fd_sc_mcu9t5v0__mux2_1
* cell instance $4446 m0 *1 508.48,1320.48
X$4446 22820 23948 24072 18834 23957 24118 gf180mcu_fd_sc_mcu9t5v0__dffrnq_2
* cell instance $4447 r0 *1 521.36,1330.56
X$4447 24271 24565 24566 24528 24414 24405 gf180mcu_fd_sc_mcu9t5v0__oai21_1
* cell instance $4448 m0 *1 549.36,1330.56
X$4448 24227 24232 24414 24272 gf180mcu_fd_sc_mcu9t5v0__clkinv_1
* cell instance $4449 m0 *1 492.8,1350.72
X$4449 25817 24820 24821 18834 24828 25000 gf180mcu_fd_sc_mcu9t5v0__dffrnq_2
* cell instance $4450 r0 *1 490,1320.48
X$4450 24118 24232 gf180mcu_fd_sc_mcu9t5v0__filltie
* cell instance $4451 m0 *1 537.04,1340.64
X$4451 24563 24565 24566 24528 24712 24567 gf180mcu_fd_sc_mcu9t5v0__oai21_1
* cell instance $4452 r0 *1 535.92,1350.72
X$4452 25110 25111 21531 25158 25000 24705 gf180mcu_fd_sc_mcu9t5v0__aoi21_1
* cell instance $4453 m0 *1 541.52,1340.64
X$4453 21531 24272 24567 24705 23004 24528 24712 21834
+ gf180mcu_fd_sc_mcu9t5v0__aoi221_1
* cell instance $4454 m0 *1 527.52,1320.48
X$4454 24072 23957 24118 23898 gf180mcu_fd_sc_mcu9t5v0__clkinv_1
* cell instance $4455 m0 *1 525.28,1340.64
X$4455 24562 24565 24566 24528 24712 24406 gf180mcu_fd_sc_mcu9t5v0__oai21_1
* cell instance $4456 m0 *1 515.2,1360.8
X$4456 25108 25260 25110 25158 25268 24822 gf180mcu_fd_sc_mcu9t5v0__oai21_1
* cell instance $4457 r0 *1 525.84,1350.72
X$4457 25110 25109 21531 25158 25000 24518 gf180mcu_fd_sc_mcu9t5v0__aoi21_1
* cell instance $4458 r0 *1 497.84,1330.56
X$4458 22820 24270 24271 18834 24528 24414 gf180mcu_fd_sc_mcu9t5v0__dffrnq_2
* cell instance $4459 r0 *1 503.44,1340.64
X$4459 23615 24821 24702 24828 24712 24820 gf180mcu_fd_sc_mcu9t5v0__mux2_1
* cell instance $4460 r0 *1 490,1330.56
X$4460 24414 24528 gf180mcu_fd_sc_mcu9t5v0__filltie
* cell instance $4461 r0 *1 490,1340.64
X$4461 24712 24828 gf180mcu_fd_sc_mcu9t5v0__filltie
* cell instance $4462 m0 *1 491.68,1360.8
X$4462 25817 25311 25259 18834 25158 25268 gf180mcu_fd_sc_mcu9t5v0__dffrnq_2
* cell instance $4463 r0 *1 490,1350.72
X$4463 25000 25158 gf180mcu_fd_sc_mcu9t5v0__filltie
* cell instance $4464 r0 *1 525.84,1330.56
X$4464 21531 23898 24406 24518 23004 24528 24414 21568
+ gf180mcu_fd_sc_mcu9t5v0__aoi221_1
* cell instance $4465 m0 *1 520.8,1340.64
X$4465 24517 24565 24566 24528 24712 24704 gf180mcu_fd_sc_mcu9t5v0__oai21_1
* cell instance $4466 r0 *1 523.04,1340.64
X$4466 24704 24822 21531 24828 24712 21989 gf180mcu_fd_sc_mcu9t5v0__aoi21_1
* cell instance $4467 m0 *1 530.32,1360.8
X$4467 25110 25534 21531 25158 25268 24073 gf180mcu_fd_sc_mcu9t5v0__aoi21_1
* cell instance $4468 r0 *1 511.84,1370.88
X$4468 25695 25260 25705 25581 25109 gf180mcu_fd_sc_mcu9t5v0__or2_1
* cell instance $4469 r0 *1 516.32,1370.88
X$4469 26327 25260 25110 25705 25581 25261 gf180mcu_fd_sc_mcu9t5v0__oai21_1
* cell instance $4470 r0 *1 520.8,1370.88
X$4470 25698 25993 18430 25705 25581 25110 gf180mcu_fd_sc_mcu9t5v0__aoi21_1
* cell instance $4471 m0 *1 533.12,1320.48
X$4471 21531 23359 24405 24073 23004 23957 24118 22835
+ gf180mcu_fd_sc_mcu9t5v0__aoi221_1
* cell instance $4472 m0 *1 524.16,1360.8
X$4472 25156 25261 21531 25158 25268 22569 gf180mcu_fd_sc_mcu9t5v0__aoi21_1
* cell instance $4473 r0 *1 490,1370.88
X$4473 25581 25705 gf180mcu_fd_sc_mcu9t5v0__filltie
* cell instance $4474 r0 *1 540.4,1350.72
X$4474 25110 25262 21531 25158 25000 24823 gf180mcu_fd_sc_mcu9t5v0__aoi21_1
* cell instance $4475 r0 *1 521.36,1350.72
X$4475 24988 24565 24566 25158 25000 25156 gf180mcu_fd_sc_mcu9t5v0__oai21_1
* cell instance $4476 m0 *1 519.68,1360.8
X$4476 25259 25260 25158 25268 25262 gf180mcu_fd_sc_mcu9t5v0__or2_1
* cell instance $4477 r0 *1 521.36,1320.48
X$4477 22572 22405 24232 24118 23897 gf180mcu_fd_sc_mcu9t5v0__nand2_1
* cell instance $4478 r0 *1 539.28,1360.8
X$4478 25312 25260 25110 25430 25268 25313 gf180mcu_fd_sc_mcu9t5v0__oai21_1
* cell instance $4479 r0 *1 490,1360.8
X$4479 25268 25430 gf180mcu_fd_sc_mcu9t5v0__filltie
* cell instance $4480 r0 *1 499.52,1360.8
X$4480 25697 25259 24819 25430 25268 25311 gf180mcu_fd_sc_mcu9t5v0__mux2_1
* cell instance $4481 r0 *1 538.16,1370.88
X$4481 25569 25312 24819 25705 25581 25820 gf180mcu_fd_sc_mcu9t5v0__mux2_1
* cell instance $4482 r0 *1 447.44,1340.64
X$4482 23306 24941 24942 18834 24828 24712 gf180mcu_fd_sc_mcu9t5v0__dffrnq_2
* cell instance $4483 m0 *1 434.56,1360.8
X$4483 19567 25158 25268 23306 gf180mcu_fd_sc_mcu9t5v0__clkbuf_8
* cell instance $4484 m0 *1 460.32,1340.64
X$4484 24942 24563 24819 24528 24712 24516 gf180mcu_fd_sc_mcu9t5v0__mux2_1
* cell instance $4485 r0 *1 448.56,1370.88
X$4485 26156 25695 24819 25705 25581 25694 gf180mcu_fd_sc_mcu9t5v0__mux2_1
* cell instance $4486 r0 *1 443.52,1350.72
X$4486 25426 25108 24819 25158 25000 25107 gf180mcu_fd_sc_mcu9t5v0__mux2_1
* cell instance $4487 r0 *1 431.76,1340.64
X$4487 22572 24701 24702 24828 24712 24818 gf180mcu_fd_sc_mcu9t5v0__mux2_1
* cell instance $4488 m0 *1 417.76,1330.56
X$4488 23306 24225 24226 18834 24232 24414 gf180mcu_fd_sc_mcu9t5v0__dffrnq_2
* cell instance $4489 r0 *1 426.72,1320.48
X$4489 24226 24070 24232 24118 24112 gf180mcu_fd_sc_mcu9t5v0__or2_1
* cell instance $4490 r0 *1 434.56,1350.72
X$4490 23306 25158 25000 gf180mcu_fd_sc_mcu9t5v0__clkbuf_4
* cell instance $4491 r0 *1 439.04,1340.64
X$4491 24701 24562 24819 24828 24712 24561 gf180mcu_fd_sc_mcu9t5v0__mux2_1
* cell instance $4492 m0 *1 421.12,1350.72
X$4492 23306 24818 24701 18834 24828 25000 gf180mcu_fd_sc_mcu9t5v0__dffrnq_2
* cell instance $4493 m0 *1 462.56,1320.48
X$4493 22820 23947 23667 18834 23957 24118 gf180mcu_fd_sc_mcu9t5v0__dffrnq_2
* cell instance $4494 m0 *1 432.32,1340.64
X$4494 23306 24561 24562 18834 24528 24712 gf180mcu_fd_sc_mcu9t5v0__dffrnq_2
* cell instance $4495 m0 *1 427.28,1320.48
X$4495 24226 22158 24070 23957 24118 24069 gf180mcu_fd_sc_mcu9t5v0__nand3_1
* cell instance $4496 r0 *1 423.92,1320.48
X$4496 24112 24069 24232 24118 24225 gf180mcu_fd_sc_mcu9t5v0__nand2_1
* cell instance $4497 r0 *1 456.4,1330.56
X$4497 23306 24516 24563 18834 24528 24414 gf180mcu_fd_sc_mcu9t5v0__dffrnq_2
* cell instance $4498 m0 *1 443.52,1320.48
X$4498 23306 24071 23895 18834 23957 24118 gf180mcu_fd_sc_mcu9t5v0__dffrnq_2
* cell instance $4499 m0 *1 468.72,1370.88
X$4499 20030 25427 24702 25430 25581 25310 gf180mcu_fd_sc_mcu9t5v0__mux2_1
* cell instance $4500 r0 *1 458.08,1360.8
X$4500 23306 25310 25427 18834 25430 25268 gf180mcu_fd_sc_mcu9t5v0__dffrnq_2
* cell instance $4501 r0 *1 471.52,1350.72
X$4501 25427 24988 24819 25158 25000 25155 gf180mcu_fd_sc_mcu9t5v0__mux2_1
* cell instance $4502 r0 *1 426.72,1370.88
X$4502 22441 25309 25693 25705 25581 25816 gf180mcu_fd_sc_mcu9t5v0__mux2_1
* cell instance $4503 r0 *1 428.4,1360.8
X$4503 25309 25426 24702 25430 25268 25425 gf180mcu_fd_sc_mcu9t5v0__mux2_1
* cell instance $4504 r0 *1 446.88,1320.48
X$4504 24070 23946 22568 24232 24118 24071 gf180mcu_fd_sc_mcu9t5v0__nand3_1
* cell instance $4505 m0 *1 454.72,1350.72
X$4505 21726 24942 24702 24828 25000 24941 gf180mcu_fd_sc_mcu9t5v0__mux2_1
* cell instance $4506 r0 *1 439.04,1360.8
X$4506 23306 25107 25108 18834 25430 25268 gf180mcu_fd_sc_mcu9t5v0__dffrnq_2
* cell instance $4507 m0 *1 421.68,1370.88
X$4507 23306 25425 25426 18834 25430 25581 gf180mcu_fd_sc_mcu9t5v0__dffrnq_2
* cell instance $4508 m0 *1 423.36,1249.92
X$4508 21874 21875 21529 21884 21997 21827 gf180mcu_fd_sc_mcu9t5v0__aoi21_1
* cell instance $4509 r0 *1 444.64,1280.16
X$4509 22567 22158 22163 23038 22885 22691 gf180mcu_fd_sc_mcu9t5v0__nand3_1
* cell instance $4510 m0 *1 425.6,1280.16
X$4510 22822 23033 22700 22885 22821 gf180mcu_fd_sc_mcu9t5v0__xnor2_1
* cell instance $4511 r0 *1 437.92,1249.92
X$4511 21988 21985 22113 22124 21997 22114 gf180mcu_fd_sc_mcu9t5v0__nand3_1
* cell instance $4512 r0 *1 444.08,1270.08
X$4512 22567 22163 22691 22700 22577 22690 gf180mcu_fd_sc_mcu9t5v0__oai21_1
* cell instance $4513 m0 *1 422.8,1280.16
X$4513 22158 22821 22700 22885 22875 gf180mcu_fd_sc_mcu9t5v0__nand2_1
* cell instance $4514 m0 *1 428.4,1260
X$4514 22401 21875 22124 22295 22157 gf180mcu_fd_sc_mcu9t5v0__nand2_1
* cell instance $4515 m0 *1 451.92,1300.32
X$4515 22820 23308 23192 18834 23319 23504 gf180mcu_fd_sc_mcu9t5v0__dffrnq_2
* cell instance $4516 r0 *1 414.96,1300.32
X$4516 23145 23610 23623 23504 23611 gf180mcu_fd_sc_mcu9t5v0__nand2_1
* cell instance $4517 m0 *1 425.6,1260
X$4517 22158 22157 22124 22295 22284 gf180mcu_fd_sc_mcu9t5v0__nand2_1
* cell instance $4518 r0 *1 443.52,1290.24
X$4518 23192 23319 23200 23191 gf180mcu_fd_sc_mcu9t5v0__clkinv_1
* cell instance $4519 m0 *1 472.08,1310.4
X$4519 23667 21876 23623 23797 23668 gf180mcu_fd_sc_mcu9t5v0__nand2_1
* cell instance $4520 m0 *1 465.92,1290.24
X$4520 21529 23146 23147 23038 23200 23193 gf180mcu_fd_sc_mcu9t5v0__oai21_1
* cell instance $4521 r0 *1 418.88,1249.92
X$4521 22124 21997 21987 gf180mcu_fd_sc_mcu9t5v0__tiel
* cell instance $4522 m0 *1 456.4,1260
X$4522 21709 22124 22295 21710 22285 gf180mcu_fd_sc_mcu9t5v0__xor2_1
* cell instance $4523 m0 *1 454.16,1270.08
X$4523 21529 22285 22568 22449 22577 22402 gf180mcu_fd_sc_mcu9t5v0__oai21_1
* cell instance $4524 m0 *1 456.4,1249.92
X$4524 21529 21876 21988 21884 21997 21707 gf180mcu_fd_sc_mcu9t5v0__oai21_1
* cell instance $4525 r0 *1 448.56,1260
X$4525 21348 22402 21709 18834 22449 22295 gf180mcu_fd_sc_mcu9t5v0__dffrnq_2
* cell instance $4526 m0 *1 414.4,1249.92
X$4526 21986 21828 21884 21997 21985 gf180mcu_fd_sc_mcu9t5v0__nor2_1
* cell instance $4527 r0 *1 474.88,1280.16
X$4527 21529 23000 23147 23038 22885 23001 gf180mcu_fd_sc_mcu9t5v0__oai21_1
* cell instance $4528 r0 *1 467.04,1290.24
X$4528 22158 22163 23319 23200 23309 gf180mcu_fd_sc_mcu9t5v0__nand2_1
* cell instance $4529 r0 *1 476.56,1270.08
X$4529 21529 21876 22700 22577 22403 gf180mcu_fd_sc_mcu9t5v0__nor2_1
* cell instance $4530 r0 *1 459.76,1290.24
X$4530 23192 23193 23309 23319 23200 23308 gf180mcu_fd_sc_mcu9t5v0__mux2_1
* cell instance $4531 r0 *1 474.32,1260
X$4531 22286 21878 22403 22449 22295 22439 gf180mcu_fd_sc_mcu9t5v0__mux2_1
* cell instance $4532 m0 *1 473.76,1249.92
X$4532 21832 21878 21884 21997 21711 gf180mcu_fd_sc_mcu9t5v0__or2_1
* cell instance $4533 m0 *1 474.88,1310.4
X$4533 23669 23668 23623 23797 23000 gf180mcu_fd_sc_mcu9t5v0__xnor2_1
* cell instance $4534 m0 *1 470.4,1249.92
X$4534 21832 21878 21884 21997 21877 gf180mcu_fd_sc_mcu9t5v0__nor2_1
* cell instance $4535 r0 *1 476,1300.32
X$4535 23667 21876 21529 23623 23504 22876 gf180mcu_fd_sc_mcu9t5v0__aoi21_1
* cell instance $4536 m0 *1 464.8,1249.92
X$4536 21877 21876 21884 21997 21710 gf180mcu_fd_sc_mcu9t5v0__nand2_1
* cell instance $4537 m0 *1 459.2,1290.24
X$4537 23192 23038 23200 22567 23146 gf180mcu_fd_sc_mcu9t5v0__xor2_1
* cell instance $4538 m0 *1 437.36,1249.92
X$4538 21348 21831 21708 18834 21884 21997 gf180mcu_fd_sc_mcu9t5v0__dffrnq_2
* cell instance $4539 r0 *1 421.12,1260
X$4539 21348 22284 22401 18834 22449 22295 gf180mcu_fd_sc_mcu9t5v0__dffrnq_2
* cell instance $4540 r0 *1 433.44,1249.92
X$4540 21829 22401 22124 21997 22113 gf180mcu_fd_sc_mcu9t5v0__nor2_1
* cell instance $4541 m0 *1 427.84,1290.24
X$4541 23144 22998 22822 23038 23200 23190 gf180mcu_fd_sc_mcu9t5v0__nor3_1
* cell instance $4542 m0 *1 417.76,1249.92
X$4542 21829 21986 21707 21828 21884 21997 21874
+ gf180mcu_fd_sc_mcu9t5v0__oai31_1
* cell instance $4543 r0 *1 419.44,1280.16
X$4543 22820 22875 22822 18834 23038 22885 gf180mcu_fd_sc_mcu9t5v0__dffrnq_2
* cell instance $4544 r0 *1 439.04,1290.24
X$4544 23191 22567 23190 23319 23200 23307 gf180mcu_fd_sc_mcu9t5v0__nand3_1
* cell instance $4545 m0 *1 439.04,1300.32
X$4545 23796 22163 23307 23319 23504 20692 gf180mcu_fd_sc_mcu9t5v0__nor3_1
* cell instance $4546 m0 *1 443.52,1300.32
X$4546 23192 22567 23319 23504 23496 gf180mcu_fd_sc_mcu9t5v0__or2_1
* cell instance $4547 r0 *1 437.92,1300.32
X$4547 23796 23496 22163 23623 23504 23145 gf180mcu_fd_sc_mcu9t5v0__or3_1
* cell instance $4548 m0 *1 415.52,1290.24
X$4548 23144 23145 23038 23200 22999 gf180mcu_fd_sc_mcu9t5v0__nor2_1
* cell instance $4549 m0 *1 443.52,1280.16
X$4549 22820 22690 22567 18834 22700 22885 gf180mcu_fd_sc_mcu9t5v0__dffrnq_2
* cell instance $4550 m0 *1 423.36,1290.24
X$4550 23144 22998 23145 23038 23200 23033 gf180mcu_fd_sc_mcu9t5v0__nor3_1
* cell instance $4551 r0 *1 421.12,1249.92
X$4551 21985 21706 22124 21997 21875 gf180mcu_fd_sc_mcu9t5v0__nand2_1
* cell instance $4552 r0 *1 497.84,1270.08
X$4552 22440 22700 22577 22692 gf180mcu_fd_sc_mcu9t5v0__clkinv_1
* cell instance $4553 m0 *1 489.44,1310.4
X$4553 22823 23623 23797 23669 gf180mcu_fd_sc_mcu9t5v0__clkinv_1
* cell instance $4554 r0 *1 493.36,1300.32
X$4554 22824 22823 23612 23623 23504 23498 gf180mcu_fd_sc_mcu9t5v0__aoi21_1
* cell instance $4555 r0 *1 490,1290.24
X$4555 23200 23319 gf180mcu_fd_sc_mcu9t5v0__filltie
* cell instance $4556 r0 *1 490,1260
X$4556 22295 22449 gf180mcu_fd_sc_mcu9t5v0__filltie
* cell instance $4557 m0 *1 492.8,1310.4
X$4557 22876 23497 23671 23623 23797 23670 gf180mcu_fd_sc_mcu9t5v0__oai21_1
* cell instance $4558 m0 *1 493.36,1290.24
X$4558 22824 22823 22158 23038 23200 22826 gf180mcu_fd_sc_mcu9t5v0__oai21_1
* cell instance $4559 r0 *1 491.12,1290.24
X$4559 19567 23319 23200 22820 gf180mcu_fd_sc_mcu9t5v0__clkbuf_8
* cell instance $4560 r0 *1 490,1270.08
X$4560 22577 22700 gf180mcu_fd_sc_mcu9t5v0__filltie
* cell instance $4561 m0 *1 490,1300.32
X$4561 22820 23319 23504 gf180mcu_fd_sc_mcu9t5v0__inv_4
* cell instance $4562 r0 *1 487.2,1290.24
X$4562 22568 23147 23319 23200 23034 gf180mcu_fd_sc_mcu9t5v0__nand2_1
* cell instance $4563 m0 *1 492.8,1280.16
X$4563 22824 22823 22826 22700 22885 22825 gf180mcu_fd_sc_mcu9t5v0__aoi21_1
* cell instance $4564 m0 *1 493.92,1270.08
X$4564 22440 21529 22449 22577 22568 gf180mcu_fd_sc_mcu9t5v0__nand2_1
* cell instance $4565 r0 *1 490,1280.16
X$4565 22885 23038 gf180mcu_fd_sc_mcu9t5v0__filltie
* cell instance $4566 m0 *1 503.44,1260
X$4566 22163 22124 22295 22160 gf180mcu_fd_sc_mcu9t5v0__clkinv_1
* cell instance $4567 r0 *1 494.48,1280.16
X$4567 22692 23147 23034 22825 23038 22885 23002
+ gf180mcu_fd_sc_mcu9t5v0__oai22_1
* cell instance $4568 r0 *1 530.88,1300.32
X$4568 23615 22405 23623 23504 23357 gf180mcu_fd_sc_mcu9t5v0__nand2_1
* cell instance $4569 r0 *1 490,1249.92
X$4569 21997 22124 gf180mcu_fd_sc_mcu9t5v0__filltie
* cell instance $4570 r0 *1 504.56,1280.16
X$4570 22824 22876 23038 22885 23003 gf180mcu_fd_sc_mcu9t5v0__nand2_1
* cell instance $4571 m0 *1 514.64,1290.24
X$4571 23195 22876 23038 23200 23148 gf180mcu_fd_sc_mcu9t5v0__nand2_1
* cell instance $4572 r0 *1 521.36,1270.08
X$4572 22820 22693 22571 18834 22700 22577 gf180mcu_fd_sc_mcu9t5v0__dffrnq_2
* cell instance $4573 m0 *1 498.4,1300.32
X$4573 21529 23355 23498 23319 23504 23356 gf180mcu_fd_sc_mcu9t5v0__nor3_1
* cell instance $4574 m0 *1 502.88,1300.32
X$4574 23034 23356 23319 23504 23497 gf180mcu_fd_sc_mcu9t5v0__nor2_1
* cell instance $4575 m0 *1 525.28,1270.08
X$4575 22570 22163 22162 22442 22449 22577 22693
+ gf180mcu_fd_sc_mcu9t5v0__aoi22_1
* cell instance $4576 r0 *1 521.36,1300.32
X$4576 23195 23667 21876 23355 23623 23504 23614
+ gf180mcu_fd_sc_mcu9t5v0__nand4_1
* cell instance $4577 r0 *1 529.2,1249.92
X$4577 21990 22124 21997 22115 gf180mcu_fd_sc_mcu9t5v0__clkinv_1
* cell instance $4578 r0 *1 548.24,1260
X$4578 22443 22405 22449 22295 21991 gf180mcu_fd_sc_mcu9t5v0__nand2_1
* cell instance $4579 m0 *1 544.32,1300.32
X$4579 23499 23319 23504 23359 gf180mcu_fd_sc_mcu9t5v0__clkinv_1
* cell instance $4580 m0 *1 502.32,1280.16
X$4580 22820 22827 22824 18834 22700 22885 gf180mcu_fd_sc_mcu9t5v0__dffrnq_2
* cell instance $4581 r0 *1 497.84,1300.32
X$4581 23612 22824 22823 23623 23504 23355 gf180mcu_fd_sc_mcu9t5v0__and3_1
* cell instance $4582 m0 *1 532,1270.08
X$4582 22571 22449 22577 22570 gf180mcu_fd_sc_mcu9t5v0__clkinv_1
* cell instance $4583 m0 *1 535.36,1270.08
X$4583 21531 22571 21714 22569 22449 22577 21713
+ gf180mcu_fd_sc_mcu9t5v0__aoi211_1
* cell instance $4584 r0 *1 546,1249.92
X$4584 21992 22163 21991 22162 22124 21997 22116
+ gf180mcu_fd_sc_mcu9t5v0__aoi22_1
* cell instance $4585 m0 *1 524.72,1260
X$4585 22115 22163 22162 22161 22124 22295 21879
+ gf180mcu_fd_sc_mcu9t5v0__aoi22_1
* cell instance $4586 r0 *1 534.8,1280.16
X$4586 23004 23038 22885 21714 gf180mcu_fd_sc_mcu9t5v0__buf_8
* cell instance $4587 r0 *1 523.6,1260
X$4587 22441 22405 22449 22295 22161 gf180mcu_fd_sc_mcu9t5v0__nand2_1
* cell instance $4588 m0 *1 524.72,1280.16
X$4588 20030 22405 22700 22885 22442 gf180mcu_fd_sc_mcu9t5v0__nand2_1
* cell instance $4589 m0 *1 536.48,1249.92
X$4589 21531 21990 21714 21989 21884 21997 17980
+ gf180mcu_fd_sc_mcu9t5v0__aoi211_1
* cell instance $4590 r0 *1 518,1300.32
X$4590 21529 23613 23623 23504 23310 gf180mcu_fd_sc_mcu9t5v0__nor2_1
* cell instance $4591 r0 *1 517.44,1290.24
X$4591 22820 23194 23195 18834 23319 23200 gf180mcu_fd_sc_mcu9t5v0__dffrnq_2
* cell instance $4592 r0 *1 491.12,1260
X$4592 22820 22404 22440 18834 22449 22295 gf180mcu_fd_sc_mcu9t5v0__dffrnq_2
* cell instance $4593 r0 *1 500.08,1280.16
X$4593 22876 23002 23003 23038 22885 22827 gf180mcu_fd_sc_mcu9t5v0__oai21_1
* cell instance $4594 m0 *1 517.44,1249.92
X$4594 22820 21879 21990 11958 21884 21997 gf180mcu_fd_sc_mcu9t5v0__dffrnq_2
* cell instance $4595 r0 *1 511.84,1290.24
X$4595 22876 23034 23310 23148 23319 23200 23194
+ gf180mcu_fd_sc_mcu9t5v0__oai31_1
* cell instance $4596 m0 *1 516.32,1300.32
X$4596 23195 23319 23504 23355 23613 gf180mcu_fd_sc_mcu9t5v0__xor2_1
* cell instance $4597 m0 *1 500.08,1249.92
X$4597 21567 21529 21884 21997 23147 gf180mcu_fd_sc_mcu9t5v0__nand2_1
* cell instance $4598 m0 *1 499.52,1270.08
X$4598 14850 22440 18441 22449 22577 22404 gf180mcu_fd_sc_mcu9t5v0__mux2_1
* cell instance $4599 m0 *1 505.68,1260
X$4599 21348 22160 21531 18834 22124 22295 gf180mcu_fd_sc_mcu9t5v0__dffrnq_2
* cell instance $4600 m0 *1 534.8,1300.32
X$4600 23359 22163 22162 23357 23319 23504 23358
+ gf180mcu_fd_sc_mcu9t5v0__aoi22_1
* cell instance $4601 r0 *1 490,1300.32
X$4601 23504 23623 gf180mcu_fd_sc_mcu9t5v0__filltie
* cell instance $4602 m0 *1 497.28,1310.4
X$4602 23612 22876 23623 23797 23671 gf180mcu_fd_sc_mcu9t5v0__nand2_1
* cell instance $4603 r0 *1 406,1270.08
X$4603 21529 22874 22700 22577 22566 gf180mcu_fd_sc_mcu9t5v0__nor2_1
* cell instance $4604 m0 *1 370.16,1320.48
X$4604 24118 23957 gf180mcu_fd_sc_mcu9t5v0__endcap
* cell instance $4605 m0 *1 370.16,1360.8
X$4605 25268 25158 gf180mcu_fd_sc_mcu9t5v0__endcap
* cell instance $4606 r0 *1 407.68,1320.48
X$4606 23894 24112 24232 24118 24224 gf180mcu_fd_sc_mcu9t5v0__nand2_1
* cell instance $4607 r0 *1 370.16,1340.64
X$4607 24712 24828 gf180mcu_fd_sc_mcu9t5v0__endcap
* cell instance $4608 r0 *1 370.16,1260
X$4608 22295 22449 gf180mcu_fd_sc_mcu9t5v0__endcap
* cell instance $4609 r0 *1 404.88,1320.48
X$4609 23892 24224 24232 24118 24111 gf180mcu_fd_sc_mcu9t5v0__nand2_1
* cell instance $4610 m0 *1 370.16,1260
X$4610 22295 22124 gf180mcu_fd_sc_mcu9t5v0__endcap
* cell instance $4611 m0 *1 370.16,1330.56
X$4611 24414 24232 gf180mcu_fd_sc_mcu9t5v0__endcap
* cell instance $4612 r0 *1 370.16,1290.24
X$4612 23200 23319 gf180mcu_fd_sc_mcu9t5v0__endcap
* cell instance $4613 r0 *1 404.32,1249.92
X$4613 21529 22112 22124 21997 22111 gf180mcu_fd_sc_mcu9t5v0__nor2_1
* cell instance $4614 r0 *1 408.8,1310.4
X$4614 23894 24112 23957 23797 23893 gf180mcu_fd_sc_mcu9t5v0__nor2_1
* cell instance $4615 m0 *1 370.16,1270.08
X$4615 22577 22449 gf180mcu_fd_sc_mcu9t5v0__endcap
* cell instance $4616 r0 *1 370.16,1300.32
X$4616 23504 23623 gf180mcu_fd_sc_mcu9t5v0__endcap
* cell instance $4617 r0 *1 405.44,1310.4
X$4617 21529 23893 23957 23797 23892 gf180mcu_fd_sc_mcu9t5v0__nor2_1
* cell instance $4618 m0 *1 411.04,1310.4
X$4618 23666 23892 23623 23797 23610 gf180mcu_fd_sc_mcu9t5v0__nand2_1
* cell instance $4619 r0 *1 370.16,1270.08
X$4619 22577 22700 gf180mcu_fd_sc_mcu9t5v0__endcap
* cell instance $4620 r0 *1 370.16,1330.56
X$4620 24414 24528 gf180mcu_fd_sc_mcu9t5v0__endcap
* cell instance $4621 r0 *1 370.16,1360.8
X$4621 25268 25430 gf180mcu_fd_sc_mcu9t5v0__endcap
* cell instance $4622 m0 *1 370.16,1370.88
X$4622 25581 25430 gf180mcu_fd_sc_mcu9t5v0__endcap
* cell instance $4623 m0 *1 370.16,1280.16
X$4623 22885 22700 gf180mcu_fd_sc_mcu9t5v0__endcap
* cell instance $4624 m0 *1 370.16,1310.4
X$4624 23797 23623 gf180mcu_fd_sc_mcu9t5v0__endcap
* cell instance $4625 r0 *1 370.16,1249.92
X$4625 21997 22124 gf180mcu_fd_sc_mcu9t5v0__endcap
* cell instance $4626 m0 *1 370.16,1249.92
X$4626 21997 21884 gf180mcu_fd_sc_mcu9t5v0__endcap
* cell instance $4627 m0 *1 370.16,1300.32
X$4627 23504 23319 gf180mcu_fd_sc_mcu9t5v0__endcap
* cell instance $4628 m0 *1 370.16,1350.72
X$4628 25000 24828 gf180mcu_fd_sc_mcu9t5v0__endcap
* cell instance $4629 r0 *1 370.16,1310.4
X$4629 23797 23957 gf180mcu_fd_sc_mcu9t5v0__endcap
* cell instance $4630 r0 *1 370.16,1370.88
X$4630 25581 25705 gf180mcu_fd_sc_mcu9t5v0__endcap
* cell instance $4631 m0 *1 370.16,1340.64
X$4631 24712 24528 gf180mcu_fd_sc_mcu9t5v0__endcap
* cell instance $4632 r0 *1 370.16,1280.16
X$4632 22885 23038 gf180mcu_fd_sc_mcu9t5v0__endcap
* cell instance $4633 r0 *1 370.16,1350.72
X$4633 25000 25158 gf180mcu_fd_sc_mcu9t5v0__endcap
* cell instance $4634 m0 *1 404.32,1290.24
X$4634 21529 23143 23038 23200 23189 gf180mcu_fd_sc_mcu9t5v0__nor2_1
* cell instance $4635 r0 *1 370.16,1320.48
X$4635 24118 24232 gf180mcu_fd_sc_mcu9t5v0__endcap
* cell instance $4636 m0 *1 370.16,1290.24
X$4636 23200 23038 gf180mcu_fd_sc_mcu9t5v0__endcap
* cell instance $4637 m0 *1 370.16,1118.88
X$4637 18104 17985 gf180mcu_fd_sc_mcu9t5v0__endcap
* cell instance $4638 r0 *1 370.16,1189.44
X$4638 20217 20379 gf180mcu_fd_sc_mcu9t5v0__endcap
* cell instance $4639 r0 *1 370.16,1169.28
X$4639 19605 19729 gf180mcu_fd_sc_mcu9t5v0__endcap
* cell instance $4640 m0 *1 370.16,1209.6
X$4640 20822 20637 gf180mcu_fd_sc_mcu9t5v0__endcap
* cell instance $4641 m0 *1 370.16,1199.52
X$4641 20507 20379 gf180mcu_fd_sc_mcu9t5v0__endcap
* cell instance $4642 m0 *1 370.16,1219.68
X$4642 21123 20936 gf180mcu_fd_sc_mcu9t5v0__endcap
* cell instance $4643 m0 *1 370.16,1159.2
X$4643 19282 19171 gf180mcu_fd_sc_mcu9t5v0__endcap
* cell instance $4644 r0 *1 370.16,1108.8
X$4644 17837 17985 gf180mcu_fd_sc_mcu9t5v0__endcap
* cell instance $4645 r0 *1 370.16,1118.88
X$4645 18104 18268 gf180mcu_fd_sc_mcu9t5v0__endcap
* cell instance $4646 m0 *1 370.16,1139.04
X$4646 18731 18553 gf180mcu_fd_sc_mcu9t5v0__endcap
* cell instance $4647 r0 *1 370.16,1209.6
X$4647 20822 20936 gf180mcu_fd_sc_mcu9t5v0__endcap
* cell instance $4648 m0 *1 370.16,1128.96
X$4648 18386 18268 gf180mcu_fd_sc_mcu9t5v0__endcap
* cell instance $4649 m0 *1 370.16,1149.12
X$4649 18996 18841 gf180mcu_fd_sc_mcu9t5v0__endcap
* cell instance $4650 m0 *1 370.16,1229.76
X$4650 21412 21241 gf180mcu_fd_sc_mcu9t5v0__endcap
* cell instance $4651 r0 *1 370.16,1128.96
X$4651 18386 18553 gf180mcu_fd_sc_mcu9t5v0__endcap
* cell instance $4652 r0 *1 370.16,1139.04
X$4652 18731 18841 gf180mcu_fd_sc_mcu9t5v0__endcap
* cell instance $4653 r0 *1 370.16,1149.12
X$4653 18996 19171 gf180mcu_fd_sc_mcu9t5v0__endcap
* cell instance $4654 r0 *1 370.16,1179.36
X$4654 19901 20028 gf180mcu_fd_sc_mcu9t5v0__endcap
* cell instance $4655 r0 *1 370.16,1199.52
X$4655 20507 20637 gf180mcu_fd_sc_mcu9t5v0__endcap
* cell instance $4656 r0 *1 370.16,1159.2
X$4656 19282 19448 gf180mcu_fd_sc_mcu9t5v0__endcap
* cell instance $4657 m0 *1 370.16,1189.44
X$4657 20217 20028 gf180mcu_fd_sc_mcu9t5v0__endcap
* cell instance $4658 m0 *1 370.16,1169.28
X$4658 19605 19448 gf180mcu_fd_sc_mcu9t5v0__endcap
* cell instance $4659 m0 *1 370.16,1179.36
X$4659 19901 19729 gf180mcu_fd_sc_mcu9t5v0__endcap
* cell instance $4660 r0 *1 370.16,1219.68
X$4660 21123 21241 gf180mcu_fd_sc_mcu9t5v0__endcap
* cell instance $4661 r0 *1 371.28,1139.04
X$4661 18833 18841 18731 18259 gf180mcu_fd_sc_mcu9t5v0__dlyc_1
* cell instance $4662 r0 *1 370.16,1229.76
X$4662 21412 21537 gf180mcu_fd_sc_mcu9t5v0__endcap
* cell instance $4663 m0 *1 370.16,1239.84
X$4663 21719 21537 gf180mcu_fd_sc_mcu9t5v0__endcap
* cell instance $4664 m0 *1 476.56,1239.84
X$4664 21348 21566 21832 11958 21537 21719 gf180mcu_fd_sc_mcu9t5v0__dffrnq_2
* cell instance $4665 r0 *1 444.64,1169.28
X$4665 19597 19598 19729 19605 19599 gf180mcu_fd_sc_mcu9t5v0__xnor2_1
* cell instance $4666 r0 *1 439.04,1169.28
X$4666 19554 19596 19597 19108 19729 19605 19887 gf180mcu_fd_sc_mcu9t5v0__nor4_1
* cell instance $4667 r0 *1 431.2,1169.28
X$4667 19596 19595 19729 19605 19594 gf180mcu_fd_sc_mcu9t5v0__xnor2_1
* cell instance $4668 m0 *1 421.68,1179.36
X$4668 19729 19901 19859 gf180mcu_fd_sc_mcu9t5v0__tiel
* cell instance $4669 m0 *1 432.88,1179.36
X$4669 19596 18366 19729 19901 19715 gf180mcu_fd_sc_mcu9t5v0__nand2_1
* cell instance $4670 r0 *1 426.72,1169.28
X$4670 19594 18949 19715 19729 19605 19714 gf180mcu_fd_sc_mcu9t5v0__oai21_1
* cell instance $4671 r0 *1 422.8,1169.28
X$4671 19554 18366 19729 19605 19842 gf180mcu_fd_sc_mcu9t5v0__nand2_1
* cell instance $4672 m0 *1 417.2,1179.36
X$4672 18949 19553 19842 19729 19901 19713 gf180mcu_fd_sc_mcu9t5v0__oai21_1
* cell instance $4673 r0 *1 491.12,1169.28
X$4673 18093 19717 19890 11958 19729 19605 gf180mcu_fd_sc_mcu9t5v0__dffrnq_2
* cell instance $4674 r0 *1 459.76,1169.28
X$4674 18093 19716 19597 11958 19729 19605 gf180mcu_fd_sc_mcu9t5v0__dffrnq_2
* cell instance $4675 r0 *1 530.32,1169.28
X$4675 20326 19718 18421 11958 19729 19605 gf180mcu_fd_sc_mcu9t5v0__dffrnq_2
* cell instance $4676 r0 *1 490,1169.28
X$4676 19605 19729 gf180mcu_fd_sc_mcu9t5v0__filltie
* cell instance $4677 m0 *1 519.68,1179.36
X$4677 19847 19729 19901 19848 gf180mcu_fd_sc_mcu9t5v0__buf_8
* cell instance $4678 r0 *1 517.44,1169.28
X$4678 3795 19114 19729 19605 19846 gf180mcu_fd_sc_mcu9t5v0__nand2_1
* cell instance $4679 m0 *1 534.24,1179.36
X$4679 19891 19848 19887 19729 19901 19719 gf180mcu_fd_sc_mcu9t5v0__nand3_1
* cell instance $4680 m0 *1 541.52,1179.36
X$4680 19849 19892 19729 19901 19718 gf180mcu_fd_sc_mcu9t5v0__nand2_1
* cell instance $4681 m0 *1 538.16,1179.36
X$4681 2137 19729 19901 19891 gf180mcu_fd_sc_mcu9t5v0__buf_1
* cell instance $4682 m0 *1 514.64,1179.36
X$4682 20365 19844 19729 19901 19845 gf180mcu_fd_sc_mcu9t5v0__nand2_1
* cell instance $4683 m0 *1 481.04,1179.36
X$4683 18421 19888 19729 19901 18949 gf180mcu_fd_sc_mcu9t5v0__nand2_1
* cell instance $4684 m0 *1 510.16,1179.36
X$4684 20365 19846 19845 19729 19901 19843 gf180mcu_fd_sc_mcu9t5v0__oai21_1
* cell instance $4685 m0 *1 485.52,1179.36
X$4685 18421 19889 19888 19729 19901 19556 gf180mcu_fd_sc_mcu9t5v0__oai21_1
* cell instance $4686 m0 *1 501.2,1179.36
X$4686 19843 19890 20494 19729 19901 19717 gf180mcu_fd_sc_mcu9t5v0__mux2_1
* cell instance $4687 m0 *1 483.28,1199.52
X$4687 20365 20366 20379 20507 20323 gf180mcu_fd_sc_mcu9t5v0__nand2_1
* cell instance $4688 m0 *1 478.24,1189.44
X$4688 20069 20068 20494 20028 20217 20201 gf180mcu_fd_sc_mcu9t5v0__mux2_1
* cell instance $4689 r0 *1 479.92,1209.6
X$4689 20976 20978 20936 20822 20631 gf180mcu_fd_sc_mcu9t5v0__or2_1
* cell instance $4690 r0 *1 479.92,1219.68
X$4690 20976 21241 21123 20978 21115 gf180mcu_fd_sc_mcu9t5v0__xor2_1
* cell instance $4691 r0 *1 465.36,1189.44
X$4691 21348 20201 20068 11958 20379 20217 gf180mcu_fd_sc_mcu9t5v0__dffrnq_2
* cell instance $4692 m0 *1 476,1219.68
X$4692 21348 20977 20976 11958 20936 21123 gf180mcu_fd_sc_mcu9t5v0__dffrnq_2
* cell instance $4693 m0 *1 482.72,1159.2
X$4693 18421 18988 19273 19556 19171 19282 19166
+ gf180mcu_fd_sc_mcu9t5v0__aoi211_1
* cell instance $4694 r0 *1 479.92,1128.96
X$4694 18421 18427 18092 18426 18553 18386 18424
+ gf180mcu_fd_sc_mcu9t5v0__oai31_1
* cell instance $4695 r0 *1 467.6,1149.12
X$4695 18093 19112 18567 11958 19171 18996 gf180mcu_fd_sc_mcu9t5v0__dffrnq_2
* cell instance $4696 m0 *1 478.8,1118.88
X$4696 18092 17280 16130 17985 18104 17940 gf180mcu_fd_sc_mcu9t5v0__mux2_1
* cell instance $4697 r0 *1 470.96,1108.8
X$4697 15996 17940 17280 11958 17985 17837 gf180mcu_fd_sc_mcu9t5v0__dffrnq_2
* cell instance $4698 r0 *1 539.84,1199.52
X$4698 20499 20680 20637 20507 20328 gf180mcu_fd_sc_mcu9t5v0__nor2_1
* cell instance $4699 r0 *1 534.8,1189.44
X$4699 20203 19719 20682 20328 20379 20217 20329
+ gf180mcu_fd_sc_mcu9t5v0__oai22_1
* cell instance $4700 r0 *1 533.68,1209.6
X$4700 20928 20683 20936 20822 20812 gf180mcu_fd_sc_mcu9t5v0__nand2_1
* cell instance $4701 m0 *1 546.56,1209.6
X$4701 20499 20680 20633 20637 20822 20813 gf180mcu_fd_sc_mcu9t5v0__oai21_1
* cell instance $4702 r0 *1 535.36,1179.36
X$4702 18421 19719 20028 19901 19892 gf180mcu_fd_sc_mcu9t5v0__nand2_1
* cell instance $4703 r0 *1 506.8,1219.68
X$4703 20979 20494 21116 21241 21123 21351 gf180mcu_fd_sc_mcu9t5v0__aoi21_1
* cell instance $4704 m0 *1 502.32,1189.44
X$4704 20070 20068 20028 20217 20021 gf180mcu_fd_sc_mcu9t5v0__nor2_1
* cell instance $4705 m0 *1 497.84,1209.6
X$4705 20681 19890 20367 20976 20637 20822 20679 gf180mcu_fd_sc_mcu9t5v0__nor4_1
* cell instance $4706 r0 *1 520.24,1229.76
X$4706 21348 21401 21352 11958 21537 21412 gf180mcu_fd_sc_mcu9t5v0__dffrnq_2
* cell instance $4707 m0 *1 502.32,1239.84
X$4707 19276 21567 18441 21537 21719 21712 gf180mcu_fd_sc_mcu9t5v0__mux2_1
* cell instance $4708 m0 *1 517.44,1199.52
X$4708 20326 20371 20367 11958 20379 20507 gf180mcu_fd_sc_mcu9t5v0__dffrnq_2
* cell instance $4709 r0 *1 520.8,1199.52
X$4709 20367 20494 20637 20507 20327 gf180mcu_fd_sc_mcu9t5v0__nand2_1
* cell instance $4710 r0 *1 519.12,1189.44
X$4710 20494 20202 20327 20379 20217 20371 gf180mcu_fd_sc_mcu9t5v0__oai21_1
* cell instance $4711 m0 *1 529.76,1209.6
X$4711 20365 20637 20822 20630 gf180mcu_fd_sc_mcu9t5v0__clkinv_1
* cell instance $4712 m0 *1 517.44,1219.68
X$4712 20812 20936 21123 20494 gf180mcu_fd_sc_mcu9t5v0__buf_8
* cell instance $4713 m0 *1 492.8,1209.6
X$4713 20070 20498 20497 20679 20637 20822 20680
+ gf180mcu_fd_sc_mcu9t5v0__nand4_1
* cell instance $4714 r0 *1 490,1209.6
X$4714 20822 20936 gf180mcu_fd_sc_mcu9t5v0__filltie
* cell instance $4715 r0 *1 503.44,1179.36
X$4715 19890 20028 19901 20021 19844 gf180mcu_fd_sc_mcu9t5v0__xor2_1
* cell instance $4716 r0 *1 536.48,1209.6
X$4716 20630 20328 20683 20936 20822 20929 gf180mcu_fd_sc_mcu9t5v0__oai21_1
* cell instance $4717 r0 *1 502.88,1189.44
X$4717 20070 20068 19890 20367 20379 20217 20368
+ gf180mcu_fd_sc_mcu9t5v0__oai31_1
* cell instance $4718 m0 *1 492.24,1199.52
X$4718 20068 20379 20507 20498 gf180mcu_fd_sc_mcu9t5v0__clkinv_1
* cell instance $4719 r0 *1 490,1189.44
X$4719 20217 20379 gf180mcu_fd_sc_mcu9t5v0__filltie
* cell instance $4720 m0 *1 488.88,1199.52
X$4720 20070 20498 20379 20507 20324 gf180mcu_fd_sc_mcu9t5v0__nor2_1
* cell instance $4721 m0 *1 486.08,1199.52
X$4721 20070 20498 20379 20507 20366 gf180mcu_fd_sc_mcu9t5v0__nand2_1
* cell instance $4722 m0 *1 507.36,1219.68
X$4722 20681 20936 21123 20979 gf180mcu_fd_sc_mcu9t5v0__clkinv_1
* cell instance $4723 r0 *1 484.4,1189.44
X$4723 14850 20325 20324 20323 20379 20217 20069
+ gf180mcu_fd_sc_mcu9t5v0__oai22_1
* cell instance $4724 m0 *1 502.32,1199.52
X$4724 20070 20068 19890 20367 20379 20507 20369 gf180mcu_fd_sc_mcu9t5v0__nor4_1
* cell instance $4725 m0 *1 509.6,1219.68
X$4725 20979 20369 20936 21123 20926 gf180mcu_fd_sc_mcu9t5v0__xnor2_1
* cell instance $4726 r0 *1 490,1229.76
X$4726 21412 21537 gf180mcu_fd_sc_mcu9t5v0__filltie
* cell instance $4727 m0 *1 504,1219.68
X$4727 20979 20369 20936 21123 20978 gf180mcu_fd_sc_mcu9t5v0__nand2_1
* cell instance $4728 r0 *1 490,1199.52
X$4728 20507 20637 gf180mcu_fd_sc_mcu9t5v0__filltie
* cell instance $4729 m0 *1 509.04,1199.52
X$4729 20365 20368 20379 20507 20370 gf180mcu_fd_sc_mcu9t5v0__nand2_1
* cell instance $4730 r0 *1 491.12,1189.44
X$4730 20630 19114 20379 20217 20325 gf180mcu_fd_sc_mcu9t5v0__nand2_1
* cell instance $4731 m0 *1 531.44,1229.76
X$4731 20927 21352 20929 21241 21412 21401 gf180mcu_fd_sc_mcu9t5v0__mux2_1
* cell instance $4732 r0 *1 513.52,1189.44
X$4732 20365 18573 20369 20370 20379 20217 20202
+ gf180mcu_fd_sc_mcu9t5v0__oai22_1
* cell instance $4733 m0 *1 542.08,1209.6
X$4733 20683 20682 20637 20822 20684 gf180mcu_fd_sc_mcu9t5v0__and2_1
* cell instance $4734 r0 *1 490,1219.68
X$4734 21123 21241 gf180mcu_fd_sc_mcu9t5v0__filltie
* cell instance $4735 r0 *1 490,1179.36
X$4735 19901 20028 gf180mcu_fd_sc_mcu9t5v0__filltie
* cell instance $4736 m0 *1 497.84,1229.76
X$4736 21348 21351 20681 11958 21241 21412 gf180mcu_fd_sc_mcu9t5v0__dffrnq_2
* cell instance $4737 r0 *1 516.88,1209.6
X$4737 20365 20926 20927 20812 20936 20822 21116
+ gf180mcu_fd_sc_mcu9t5v0__aoi211_1
* cell instance $4738 r0 *1 540.96,1209.6
X$4738 20365 20499 20936 20822 20928 gf180mcu_fd_sc_mcu9t5v0__nand2_1
* cell instance $4739 m0 *1 537.04,1209.6
X$4739 20630 19889 19849 20637 20822 20683 gf180mcu_fd_sc_mcu9t5v0__oai21_1
* cell instance $4740 r0 *1 539.28,1229.76
X$4740 21531 18430 21353 21352 21537 21412 20499
+ gf180mcu_fd_sc_mcu9t5v0__oai31_1
* cell instance $4741 m0 *1 542.08,1189.44
X$4741 18421 20028 20217 20203 gf180mcu_fd_sc_mcu9t5v0__clkinv_1
* cell instance $4742 r0 *1 548.8,1199.52
X$4742 20365 20633 20637 20507 20682 gf180mcu_fd_sc_mcu9t5v0__nand2_1
* cell instance $4743 r0 *1 458.08,1189.44
X$4743 19114 20322 20365 20379 20217 20020 gf180mcu_fd_sc_mcu9t5v0__mux2_1
* cell instance $4744 m0 *1 441.84,1219.68
X$4744 20630 20494 20975 20925 20936 21123 21113
+ gf180mcu_fd_sc_mcu9t5v0__oai31_1
* cell instance $4745 m0 *1 447.44,1209.6
X$4745 20632 20631 20637 20822 20677 gf180mcu_fd_sc_mcu9t5v0__nor2_1
* cell instance $4746 m0 *1 440.72,1209.6
X$4746 20496 20677 20637 20822 20495 gf180mcu_fd_sc_mcu9t5v0__xnor2_1
* cell instance $4747 r0 *1 438.48,1199.52
X$4747 20630 20494 20495 20493 20637 20507 20492
+ gf180mcu_fd_sc_mcu9t5v0__oai31_1
* cell instance $4748 m0 *1 447.44,1219.68
X$4748 20632 20936 21123 20631 20975 gf180mcu_fd_sc_mcu9t5v0__xor2_1
* cell instance $4749 r0 *1 452.48,1199.52
X$4749 20632 20496 20019 20637 20507 20497 gf180mcu_fd_sc_mcu9t5v0__nor3_1
* cell instance $4750 r0 *1 419.44,1229.76
X$4750 21529 21528 21537 21412 21349 gf180mcu_fd_sc_mcu9t5v0__nor2_1
* cell instance $4751 m0 *1 436.24,1189.44
X$4751 21348 20067 20019 18834 20028 20217 gf180mcu_fd_sc_mcu9t5v0__dffrnq_2
* cell instance $4752 r0 *1 445.2,1209.6
X$4752 20632 20494 20936 20822 20925 gf180mcu_fd_sc_mcu9t5v0__nand2_1
* cell instance $4753 m0 *1 454.72,1229.76
X$4753 21348 21241 21412 gf180mcu_fd_sc_mcu9t5v0__clkbuf_4
* cell instance $4754 r0 *1 434,1229.76
X$4754 21348 21400 21530 18834 21537 21412 gf180mcu_fd_sc_mcu9t5v0__dffrnq_2
* cell instance $4755 m0 *1 416.08,1229.76
X$4755 21348 21349 21829 18834 21241 21412 gf180mcu_fd_sc_mcu9t5v0__dffrnq_2
* cell instance $4756 m0 *1 417.2,1189.44
X$4756 21348 19714 19596 18834 20028 20217 gf180mcu_fd_sc_mcu9t5v0__dffrnq_2
* cell instance $4757 m0 *1 456.96,1239.84
X$4757 21530 21565 21537 21719 21350 gf180mcu_fd_sc_mcu9t5v0__xnor2_1
* cell instance $4758 m0 *1 437.92,1229.76
X$4758 21529 21350 21241 21412 21400 gf180mcu_fd_sc_mcu9t5v0__nor2_1
* cell instance $4759 r0 *1 447.44,1179.36
X$4759 20020 20019 20494 20028 19901 20067 gf180mcu_fd_sc_mcu9t5v0__mux2_1
* cell instance $4760 r0 *1 439.6,1209.6
X$4760 20496 20494 20936 20822 20493 gf180mcu_fd_sc_mcu9t5v0__nand2_1
* cell instance $4761 r0 *1 460.88,1209.6
X$4761 21348 20811 20070 11958 20936 20822 gf180mcu_fd_sc_mcu9t5v0__dffrnq_2
* cell instance $4762 m0 *1 419.44,1239.84
X$4762 21829 21537 21719 21707 21528 gf180mcu_fd_sc_mcu9t5v0__xor2_1
* cell instance $4763 m0 *1 474.32,1209.6
X$4763 20070 20630 20637 20822 20678 gf180mcu_fd_sc_mcu9t5v0__nor2_1
* cell instance $4764 m0 *1 467.04,1209.6
X$4764 20678 20070 20494 20637 20822 20811 gf180mcu_fd_sc_mcu9t5v0__mux2_1
* cell instance $4765 r0 *1 454.72,1229.76
X$4765 19567 21537 21412 21348 gf180mcu_fd_sc_mcu9t5v0__clkbuf_8
* cell instance $4766 m0 *1 463.68,1239.84
X$4766 21709 21710 21537 21719 21565 gf180mcu_fd_sc_mcu9t5v0__nor2_1
* cell instance $4767 m0 *1 473.2,1219.68
X$4767 20976 20494 20936 21123 21114 gf180mcu_fd_sc_mcu9t5v0__nand2_1
* cell instance $4768 r0 *1 474.32,1219.68
X$4768 20630 20494 21115 21114 21241 21123 20977
+ gf180mcu_fd_sc_mcu9t5v0__oai31_1
* cell instance $4769 r0 *1 445.76,1219.68
X$4769 21348 21113 20632 18834 21241 21123 gf180mcu_fd_sc_mcu9t5v0__dffrnq_2
* cell instance $4770 r0 *1 448,1199.52
X$4770 20632 20496 20631 20637 20507 20364 gf180mcu_fd_sc_mcu9t5v0__nor3_1
* cell instance $4771 m0 *1 451.92,1199.52
X$4771 20019 20379 20507 20364 20322 gf180mcu_fd_sc_mcu9t5v0__xor2_1
* cell instance $4772 m0 *1 421.12,1209.6
X$4772 21348 20492 20496 18834 20637 20822 gf180mcu_fd_sc_mcu9t5v0__dffrnq_2
* cell instance $4773 m0 *1 436.24,1128.96
X$4773 18366 18368 18261 18367 18268 18386 18129
+ gf180mcu_fd_sc_mcu9t5v0__oai31_1
* cell instance $4774 m0 *1 478.24,1169.28
X$4774 19442 19443 19599 18421 19448 19605 19557
+ gf180mcu_fd_sc_mcu9t5v0__aoi22_1
* cell instance $4775 r0 *1 443.52,1139.04
X$4775 19442 18368 18726 18421 18841 18731 18420
+ gf180mcu_fd_sc_mcu9t5v0__aoi22_1
* cell instance $4776 m0 *1 428.96,1149.12
X$4776 18419 18260 18565 18951 18841 18996 19107
+ gf180mcu_fd_sc_mcu9t5v0__oai31_1
* cell instance $4777 r0 *1 423.36,1128.96
X$4777 18420 18419 18366 18553 18386 18564 gf180mcu_fd_sc_mcu9t5v0__mux2_1
* cell instance $4778 m0 *1 437.92,1139.04
X$4778 18260 18565 18553 18731 18566 gf180mcu_fd_sc_mcu9t5v0__nor2_1
* cell instance $4779 m0 *1 434.56,1149.12
X$4779 18419 18951 18841 18996 18952 gf180mcu_fd_sc_mcu9t5v0__nor2_1
* cell instance $4780 m0 *1 437.92,1149.12
X$4780 18566 18952 18841 18996 19555 gf180mcu_fd_sc_mcu9t5v0__nand2_1
* cell instance $4781 m0 *1 432.32,1169.28
X$4781 19554 19555 19448 19605 19595 gf180mcu_fd_sc_mcu9t5v0__nor2_1
* cell instance $4782 r0 *1 425.04,1149.12
X$4782 19555 19107 19171 18996 18948 gf180mcu_fd_sc_mcu9t5v0__and2_1
* cell instance $4783 m0 *1 470.96,1169.28
X$4783 19557 19597 19556 19448 19605 19716 gf180mcu_fd_sc_mcu9t5v0__mux2_1
* cell instance $4784 m0 *1 439.04,1169.28
X$4784 19554 19596 19555 19448 19605 19598 gf180mcu_fd_sc_mcu9t5v0__nor3_1
* cell instance $4785 r0 *1 451.92,1149.12
X$4785 19110 18366 19171 18996 19111 gf180mcu_fd_sc_mcu9t5v0__nand2_1
* cell instance $4786 r0 *1 449.68,1139.04
X$4786 18422 18260 18841 18731 18835 gf180mcu_fd_sc_mcu9t5v0__nor2_1
* cell instance $4787 m0 *1 417.2,1169.28
X$4787 19554 19448 19605 19555 19553 gf180mcu_fd_sc_mcu9t5v0__xor2_1
* cell instance $4788 r0 *1 450.8,1159.2
X$4788 19110 18949 19111 19448 19282 19165 gf180mcu_fd_sc_mcu9t5v0__oai21_1
* cell instance $4789 r0 *1 444.08,1128.96
X$4789 18260 18565 18421 18553 18386 18369 gf180mcu_fd_sc_mcu9t5v0__oai21_1
* cell instance $4790 r0 *1 436.24,1139.04
X$4790 18419 18566 18841 18731 18726 gf180mcu_fd_sc_mcu9t5v0__xnor2_1
* cell instance $4791 m0 *1 476,1149.12
X$4791 19110 18567 18841 18996 18988 gf180mcu_fd_sc_mcu9t5v0__xnor2_1
* cell instance $4792 m0 *1 473.2,1139.04
X$4792 19110 18567 18422 18553 18731 18425 gf180mcu_fd_sc_mcu9t5v0__oai21_1
* cell instance $4793 m0 *1 441.84,1128.96
X$4793 18260 18565 18369 18268 18386 18261 gf180mcu_fd_sc_mcu9t5v0__aoi21_1
* cell instance $4794 r0 *1 463.12,1149.12
X$4794 19109 18366 19166 19171 18996 19112 gf180mcu_fd_sc_mcu9t5v0__aoi21_1
* cell instance $4795 r0 *1 446.32,1149.12
X$4795 19110 19109 18835 18952 19171 18996 19108
+ gf180mcu_fd_sc_mcu9t5v0__nand4_1
* cell instance $4796 r0 *1 472.64,1128.96
X$4796 18421 18565 18425 18553 18386 18426 gf180mcu_fd_sc_mcu9t5v0__nand3_1
* cell instance $4797 r0 *1 459.76,1128.96
X$4797 18366 18424 18423 18553 18386 18370 gf180mcu_fd_sc_mcu9t5v0__oai21_1
* cell instance $4798 r0 *1 451.92,1108.8
X$4798 15996 17939 17825 11958 17985 17837 gf180mcu_fd_sc_mcu9t5v0__dffrnq_2
* cell instance $4799 m0 *1 452.48,1169.28
X$4799 19556 19448 19605 18366 gf180mcu_fd_sc_mcu9t5v0__buf_8
* cell instance $4800 r0 *1 456.96,1128.96
X$4800 18422 18366 18553 18386 18423 gf180mcu_fd_sc_mcu9t5v0__nand2_1
* cell instance $4801 m0 *1 467.04,1139.04
X$4801 19110 18567 18422 18553 18731 18565 gf180mcu_fd_sc_mcu9t5v0__or3_1
* cell instance $4802 m0 *1 468.72,1149.12
X$4802 18567 18841 18996 19109 gf180mcu_fd_sc_mcu9t5v0__clkinv_1
* cell instance $4803 m0 *1 449.68,1159.2
X$4803 18093 19165 19110 11958 19171 19282 gf180mcu_fd_sc_mcu9t5v0__dffrnq_2
* cell instance $4804 m0 *1 456.4,1128.96
X$4804 18093 18370 18422 11958 18268 18386 gf180mcu_fd_sc_mcu9t5v0__dffrnq_2
* cell instance $4805 m0 *1 433.44,1128.96
X$4805 18260 18366 18268 18386 18367 gf180mcu_fd_sc_mcu9t5v0__nand2_1
* cell instance $4806 r0 *1 434,1118.88
X$4806 18093 18129 18260 11958 18268 18104 gf180mcu_fd_sc_mcu9t5v0__dffrnq_2
* cell instance $4807 m0 *1 422.24,1159.2
X$4807 18951 18366 19171 19282 18950 gf180mcu_fd_sc_mcu9t5v0__nand2_1
* cell instance $4808 m0 *1 418.32,1149.12
X$4808 18949 18948 18950 18841 18996 18947 gf180mcu_fd_sc_mcu9t5v0__oai21_1
* cell instance $4809 r0 *1 496.72,1159.2
X$4809 19276 19442 19448 19282 18092 gf180mcu_fd_sc_mcu9t5v0__nor2_1
* cell instance $4810 r0 *1 490,1118.88
X$4810 18104 18268 gf180mcu_fd_sc_mcu9t5v0__filltie
* cell instance $4811 r0 *1 494.48,1149.12
X$4811 18421 19115 19114 19171 18996 18368 gf180mcu_fd_sc_mcu9t5v0__nor3_1
* cell instance $4812 r0 *1 500.64,1108.8
X$4812 15565 17985 17837 16130 gf180mcu_fd_sc_mcu9t5v0__buf_8
* cell instance $4813 m0 *1 484.4,1149.12
X$4813 19567 18841 18996 18093 gf180mcu_fd_sc_mcu9t5v0__clkbuf_8
* cell instance $4814 r0 *1 516.88,1139.04
X$4814 18432 18374 18841 18731 18836 gf180mcu_fd_sc_mcu9t5v0__nand2_1
* cell instance $4815 m0 *1 493.36,1128.96
X$4815 3795 18268 18386 14850 gf180mcu_fd_sc_mcu9t5v0__buf_1
* cell instance $4816 r0 *1 490,1128.96
X$4816 18386 18553 gf180mcu_fd_sc_mcu9t5v0__filltie
* cell instance $4817 r0 *1 491.68,1108.8
X$4817 17826 16130 17985 17837 17560 gf180mcu_fd_sc_mcu9t5v0__nand2_1
* cell instance $4818 m0 *1 508.48,1139.04
X$4818 18432 18374 18553 18731 18569 gf180mcu_fd_sc_mcu9t5v0__xnor2_1
* cell instance $4819 r0 *1 507.36,1139.04
X$4819 18373 18569 18841 18731 18568 gf180mcu_fd_sc_mcu9t5v0__nor2_1
* cell instance $4820 m0 *1 510.16,1128.96
X$4820 18374 18373 18372 18268 18386 18371 gf180mcu_fd_sc_mcu9t5v0__nor3_1
* cell instance $4821 m0 *1 519.68,1159.2
X$4821 19275 19274 19171 19282 18573 gf180mcu_fd_sc_mcu9t5v0__nor2_1
* cell instance $4822 r0 *1 490,1139.04
X$4822 18731 18841 gf180mcu_fd_sc_mcu9t5v0__filltie
* cell instance $4823 m0 *1 507.92,1159.2
X$4823 5662 19171 19282 19275 gf180mcu_fd_sc_mcu9t5v0__clkinv_1
* cell instance $4824 r0 *1 484.4,1139.04
X$4824 18093 18841 18731 gf180mcu_fd_sc_mcu9t5v0__inv_4
* cell instance $4825 r0 *1 509.04,1159.2
X$4825 3795 19448 19282 19276 gf180mcu_fd_sc_mcu9t5v0__clkinv_1
* cell instance $4826 r0 *1 490,1149.12
X$4826 18996 19171 gf180mcu_fd_sc_mcu9t5v0__filltie
* cell instance $4827 m0 *1 516.32,1149.12
X$4827 18434 18841 18996 18836 19167 gf180mcu_fd_sc_mcu9t5v0__xor2_1
* cell instance $4828 r0 *1 490,1108.8
X$4828 17837 17985 gf180mcu_fd_sc_mcu9t5v0__filltie
* cell instance $4829 m0 *1 493.36,1159.2
X$4829 3795 18421 19274 19171 19282 19273 gf180mcu_fd_sc_mcu9t5v0__nor3_1
* cell instance $4830 r0 *1 503.44,1128.96
X$4830 18093 18371 18428 11958 18553 18386 gf180mcu_fd_sc_mcu9t5v0__dffrnq_2
* cell instance $4831 m0 *1 489.44,1139.04
X$4831 18093 18568 18432 11958 18553 18731 gf180mcu_fd_sc_mcu9t5v0__dffrnq_2
* cell instance $4832 r0 *1 520.8,1118.88
X$4832 18093 18130 18094 11958 18268 18104 gf180mcu_fd_sc_mcu9t5v0__dffrnq_2
* cell instance $4833 m0 *1 541.52,1149.12
X$4833 18954 18953 18841 18996 17228 gf180mcu_fd_sc_mcu9t5v0__nor2_1
* cell instance $4834 r0 *1 547.68,1118.88
X$4834 17231 17228 17941 18268 18104 18131 gf180mcu_fd_sc_mcu9t5v0__aoi21_1
* cell instance $4835 m0 *1 497.84,1159.2
X$4835 19275 19274 19171 19282 19442 gf180mcu_fd_sc_mcu9t5v0__or2_1
* cell instance $4836 m0 *1 549.36,1149.12
X$4836 18956 18955 18841 18996 18954 gf180mcu_fd_sc_mcu9t5v0__nand2_1
* cell instance $4837 r0 *1 530.32,1128.96
X$4837 18094 18429 18431 18430 18553 18386 18375
+ gf180mcu_fd_sc_mcu9t5v0__oai22_1
* cell instance $4838 m0 *1 527.52,1128.96
X$4838 18094 18429 18375 18268 18386 18130 gf180mcu_fd_sc_mcu9t5v0__aoi21_1
* cell instance $4839 r0 *1 523.6,1128.96
X$4839 18094 18428 18429 18553 18386 18374 gf180mcu_fd_sc_mcu9t5v0__and3_1
* cell instance $4840 r0 *1 531.44,1149.12
X$4840 18093 18954 19117 11958 18996 19171 gf180mcu_fd_sc_mcu9t5v0__dffsnq_2
* cell instance $4841 r0 *1 539.84,1118.88
X$4841 18429 18373 18131 18268 18104 18095 gf180mcu_fd_sc_mcu9t5v0__nor3_1
* cell instance $4842 m0 *1 533.12,1149.12
X$4842 18430 18431 18841 18996 18373 gf180mcu_fd_sc_mcu9t5v0__nor2_1
* cell instance $4843 m0 *1 523.04,1128.96
X$4843 18094 18429 18428 18268 18386 18372 gf180mcu_fd_sc_mcu9t5v0__aoi21_1
* cell instance $4844 m0 *1 544.88,1149.12
X$4844 18430 19117 18841 18996 18953 gf180mcu_fd_sc_mcu9t5v0__nor2_1
* cell instance $4845 r0 *1 512.4,1149.12
X$4845 18093 19116 18434 11958 19171 18996 gf180mcu_fd_sc_mcu9t5v0__dffrnq_2
* cell instance $4846 r0 *1 490,1159.2
X$4846 19282 19448 gf180mcu_fd_sc_mcu9t5v0__filltie
* cell instance $4847 m0 *1 515.76,1159.2
X$4847 18373 19167 19171 19282 19116 gf180mcu_fd_sc_mcu9t5v0__nor2_1
* cell instance $4848 m0 *1 578.48,1380.96
X$4848 26279 25698 24819 25705 25870 25572 gf180mcu_fd_sc_mcu9t5v0__mux2_1
* cell instance $4849 r0 *1 828.24,1128.96
X$4849 19283 18389 18390 13331 18553 18386 gf180mcu_fd_sc_mcu9t5v0__dffrnq_2
* cell instance $4850 m0 *1 814.8,1471.68
X$4850 18834 28378 28530 11958 gf180mcu_fd_sc_mcu9t5v0__buf_20
* cell instance $4851 m0 *1 842.8,1380.96
X$4851 25707 25871 25546 25705 25870 25872 gf180mcu_fd_sc_mcu9t5v0__aoi21_1
* cell instance $4852 r0 *1 970.48,1380.96
X$4852 25164 25880 25842 13331 25997 25870 gf180mcu_fd_sc_mcu9t5v0__dffrnq_2
* cell instance $4853 m0 *1 973.28,1380.96
X$4853 25842 23213 25705 25870 25879 gf180mcu_fd_sc_mcu9t5v0__nand2_1
* cell instance $4854 r0 *1 908.88,1380.96
X$4854 24579 25840 25997 25870 25876 gf180mcu_fd_sc_mcu9t5v0__nor2_1
* cell instance $4855 m0 *1 908.32,1380.96
X$4855 13895 25583 25840 25839 25705 25870 25132
+ gf180mcu_fd_sc_mcu9t5v0__oai22_1
* cell instance $4856 m0 *1 861.28,1380.96
X$4856 25708 25705 25870 25838 gf180mcu_fd_sc_mcu9t5v0__buf_8
* cell instance $4857 m0 *1 858.48,1380.96
X$4857 24280 25708 25705 25870 25873 gf180mcu_fd_sc_mcu9t5v0__nand2_1
* cell instance $4858 r0 *1 861.28,1380.96
X$4858 25575 25873 25874 25997 25870 26037 gf180mcu_fd_sc_mcu9t5v0__oai21_1
* cell instance $4859 m0 *1 875.84,1380.96
X$4859 25160 25875 25874 12383 25705 25870 gf180mcu_fd_sc_mcu9t5v0__dffrnq_2
* cell instance $4860 r0 *1 880.88,1380.96
X$4860 14820 26001 25997 25870 25875 gf180mcu_fd_sc_mcu9t5v0__nand2_1
* cell instance $4861 m0 *1 849.52,1380.96
X$4861 25870 25705 gf180mcu_fd_sc_mcu9t5v0__filltie
* cell instance $4862 r0 *1 953.68,1380.96
X$4862 26003 23213 25997 25870 25878 gf180mcu_fd_sc_mcu9t5v0__nand2_1
* cell instance $4863 r0 *1 969.36,1380.96
X$4863 25870 25997 gf180mcu_fd_sc_mcu9t5v0__filltie
* cell instance $4864 m0 *1 929.04,1380.96
X$4864 19000 25841 26760 25705 25870 25710 gf180mcu_fd_sc_mcu9t5v0__nand3_1
* cell instance $4865 m0 *1 921.76,1380.96
X$4865 25841 25163 25877 25705 25870 25840 gf180mcu_fd_sc_mcu9t5v0__aoi21_1
* cell instance $4866 r0 *1 946.96,1380.96
X$4866 18614 23213 23629 25878 25997 25870 26002
+ gf180mcu_fd_sc_mcu9t5v0__oai31_1
* cell instance $4867 r0 *1 963.76,1380.96
X$4867 18614 23213 22131 25879 25997 25870 25880
+ gf180mcu_fd_sc_mcu9t5v0__oai31_1
* cell instance $4868 r0 *1 912.24,1380.96
X$4868 24826 25870 25997 19402 gf180mcu_fd_sc_mcu9t5v0__clkbuf_16
* cell instance $4869 m0 *1 1021.44,1380.96
X$4869 25164 25585 25844 13331 25705 25870 gf180mcu_fd_sc_mcu9t5v0__dffrnq_2
* cell instance $4870 r0 *1 1015.84,1380.96
X$4870 19402 25997 25870 25164 gf180mcu_fd_sc_mcu9t5v0__clkbuf_8
* cell instance $4871 m0 *1 1015.84,1380.96
X$4871 25164 25705 25870 33565 gf180mcu_fd_sc_mcu9t5v0__clkinv_1
* cell instance $4872 m0 *1 983.36,1380.96
X$4872 25877 25881 25705 25870 25843 gf180mcu_fd_sc_mcu9t5v0__nand2_1
* cell instance $4873 r0 *1 1011.36,1380.96
X$4873 18614 20995 26007 25997 25870 26006 gf180mcu_fd_sc_mcu9t5v0__oai21_1
* cell instance $4874 r0 *1 1030.4,1380.96
X$4874 26043 26006 24836 25997 25870 26008 gf180mcu_fd_sc_mcu9t5v0__mux2_1
* cell instance $4875 m0 *1 987.28,1380.96
X$4875 25843 25705 25870 13024 gf180mcu_fd_sc_mcu9t5v0__buf_8
* cell instance $4876 r0 *1 1002.4,1380.96
X$4876 26005 26004 25997 25870 26303 gf180mcu_fd_sc_mcu9t5v0__nand2_1
* cell instance $4877 r0 *1 1057.84,1380.96
X$4877 26005 25842 25997 25870 26009 gf180mcu_fd_sc_mcu9t5v0__nand2_1
* cell instance $4878 m0 *1 1089.2,1380.96
X$4878 25870 25705 gf180mcu_fd_sc_mcu9t5v0__filltie
* cell instance $4879 r0 *1 1075.76,1380.96
X$4879 26010 26307 26045 25997 25870 25885 gf180mcu_fd_sc_mcu9t5v0__or3_1
* cell instance $4880 r0 *1 1061.2,1380.96
X$4880 26005 25997 25870 25842 25884 gf180mcu_fd_sc_mcu9t5v0__xor2_1
* cell instance $4881 r0 *1 1081.92,1380.96
X$4881 26175 25885 25997 25870 24536 gf180mcu_fd_sc_mcu9t5v0__nand2_1
* cell instance $4882 r0 *1 1049.44,1380.96
X$4882 26172 26044 25882 25997 25870 25551 gf180mcu_fd_sc_mcu9t5v0__and3_1
* cell instance $4883 m0 *1 630,1380.96
X$4883 18551 25823 12245 25705 25870 25822 gf180mcu_fd_sc_mcu9t5v0__mux2_1
* cell instance $4884 m0 *1 637.28,1380.96
X$4884 25823 24990 18551 25825 25824 25705 25870 25865
+ gf180mcu_fd_sc_mcu9t5v0__aoi221_2
* cell instance $4885 m0 *1 613.76,1380.96
X$4885 25699 24990 17284 25114 25705 25870 25864
+ gf180mcu_fd_sc_mcu9t5v0__aoi22_1
* cell instance $4886 m0 *1 609.84,1380.96
X$4886 25870 25705 gf180mcu_fd_sc_mcu9t5v0__filltie
* cell instance $4887 m0 *1 590.8,1380.96
X$4887 23036 25821 25699 18834 25705 25870 gf180mcu_fd_sc_mcu9t5v0__dffrnq_2
* cell instance $4888 m0 *1 661.92,1380.96
X$4888 25867 25705 25870 25826 gf180mcu_fd_sc_mcu9t5v0__clkinv_1
* cell instance $4889 r0 *1 656.32,1380.96
X$4889 27208 25826 25825 25997 25870 25116 gf180mcu_fd_sc_mcu9t5v0__nor3_1
* cell instance $4890 r0 *1 666.4,1380.96
X$4890 25994 24702 25866 25997 25870 25700 gf180mcu_fd_sc_mcu9t5v0__aoi21_1
* cell instance $4891 r0 *1 661.92,1380.96
X$4891 25867 25866 13154 25997 25870 26027 gf180mcu_fd_sc_mcu9t5v0__aoi21_1
* cell instance $4892 r0 *1 682.08,1380.96
X$4892 25826 25866 16499 25825 25575 25997 25870 25995
+ gf180mcu_fd_sc_mcu9t5v0__oai221_1
* cell instance $4893 m0 *1 683.2,1380.96
X$4893 25537 25827 24946 25705 25870 25575 gf180mcu_fd_sc_mcu9t5v0__oai21_4
* cell instance $4894 r0 *1 821.52,1471.68
X$4894 27519 28636 28345 18834 28635 28530 gf180mcu_fd_sc_mcu9t5v0__dffrnq_2
* cell instance $4895 r0 *1 809.2,1431.36
X$4895 25160 27368 11958 27367 24947 27517 gf180mcu_fd_sc_mcu9t5v0__dffrnq_4
* cell instance $4896 r0 *1 813.12,1461.6
X$4896 27519 27980 23154 18834 28378 28239 gf180mcu_fd_sc_mcu9t5v0__dffrnq_2
* cell instance $4897 r0 *1 730.8,1380.96
X$4897 24951 25996 26289 25997 25870 25703 gf180mcu_fd_sc_mcu9t5v0__aoi21_1
* cell instance $4898 r0 *1 761.6,1380.96
X$4898 25543 24412 25997 25870 25869 gf180mcu_fd_sc_mcu9t5v0__nand2_1
* cell instance $4899 m0 *1 758.8,1380.96
X$4899 25834 25832 26877 25705 25870 25835 gf180mcu_fd_sc_mcu9t5v0__aoi21_1
* cell instance $4900 r0 *1 740.88,1380.96
X$4900 25119 25830 25829 25997 25870 25578 gf180mcu_fd_sc_mcu9t5v0__nand3_1
* cell instance $4901 m0 *1 741.44,1380.96
X$4901 25831 24080 15575 25705 25870 25824 gf180mcu_fd_sc_mcu9t5v0__aoi21_1
* cell instance $4902 m0 *1 763.28,1380.96
X$4902 24234 25869 25834 25705 25870 25833 gf180mcu_fd_sc_mcu9t5v0__nand3_1
* cell instance $4903 m0 *1 736.4,1380.96
X$4903 25830 25829 25119 25705 25870 25828 gf180mcu_fd_sc_mcu9t5v0__aoi21_1
* cell instance $4904 m0 *1 730.24,1380.96
X$4904 25828 25703 25868 26029 25705 25870 25541
+ gf180mcu_fd_sc_mcu9t5v0__oai211_1
* cell instance $4905 m0 *1 719.04,1380.96
X$4905 25119 26877 25705 25870 25540 gf180mcu_fd_sc_mcu9t5v0__nand2_1
* cell instance $4906 r0 *1 729.68,1380.96
X$4906 25870 25997 gf180mcu_fd_sc_mcu9t5v0__filltie
* cell instance $4907 r0 *1 800.24,1380.96
X$4907 25160 26034 17087 11958 25997 25870 gf180mcu_fd_sc_mcu9t5v0__dffrnq_2
* cell instance $4908 r0 *1 824.32,1370.88
X$4908 25160 25706 25707 12383 25705 25581 gf180mcu_fd_sc_mcu9t5v0__dffrnq_2
* cell instance $4909 r0 *1 818.72,1401.12
X$4909 26636 26632 26456 15399 gf180mcu_fd_sc_mcu9t5v0__buf_8
* cell instance $4910 m0 *1 825.44,1380.96
X$4910 25545 25871 25705 25870 25837 gf180mcu_fd_sc_mcu9t5v0__xnor2_1
* cell instance $4911 m0 *1 820.96,1380.96
X$4911 25836 25837 25705 25870 25706 gf180mcu_fd_sc_mcu9t5v0__and2_1
* cell instance $4912 m0 *1 820.96,1421.28
X$4912 25160 26943 26944 11958 26942 27078 gf180mcu_fd_sc_mcu9t5v0__dffrnq_2
* cell instance $4913 m0 *1 819.84,1401.12
X$4913 26458 26331 26456 26287 gf180mcu_fd_sc_mcu9t5v0__buf_8
* cell instance $4914 r0 *1 823.76,1380.96
X$4914 24576 25999 25997 25870 25871 gf180mcu_fd_sc_mcu9t5v0__and2_1
* cell instance $4915 r0 *1 828.24,1380.96
X$4915 25871 26000 25997 25870 25161 gf180mcu_fd_sc_mcu9t5v0__nor2_1
* cell instance $4916 r0 *1 797.44,1380.96
X$4916 17087 14820 25997 25870 25998 gf180mcu_fd_sc_mcu9t5v0__nand2_1
* cell instance $4917 r0 *1 813.12,1350.72
X$4917 22838 25129 25130 12383 25158 25000 gf180mcu_fd_sc_mcu9t5v0__dffrnq_2
* cell instance $4918 m0 *1 810.32,1340.64
X$4918 22838 24530 20383 11958 24528 24712 gf180mcu_fd_sc_mcu9t5v0__dffrnq_2
* cell instance $4919 m0 *1 825.44,1330.56
X$4919 22839 24283 24119 12383 24232 24414 gf180mcu_fd_sc_mcu9t5v0__dffrnq_2
* cell instance $4920 r0 *1 825.44,1300.32
X$4920 11323 20818 23623 23504 23505 gf180mcu_fd_sc_mcu9t5v0__or2_1
* cell instance $4921 m0 *1 827.12,1360.8
X$4921 25160 25161 25273 12383 25158 25268 gf180mcu_fd_sc_mcu9t5v0__dffrnq_2
* cell instance $4922 r0 *1 826,1239.84
X$4922 21409 21720 21721 21884 21719 gf180mcu_fd_sc_mcu9t5v0__dffq_2
* cell instance $4923 r0 *1 819.84,1280.16
X$4923 22839 23008 23009 12383 23038 22885 gf180mcu_fd_sc_mcu9t5v0__dffrnq_2
* cell instance $4924 m0 *1 827.12,1290.24
X$4924 23009 14850 21122 23038 23200 23008 gf180mcu_fd_sc_mcu9t5v0__mux2_1
* cell instance $4925 m0 *1 812,1260
X$4925 21409 22128 22000 12383 22124 22295 gf180mcu_fd_sc_mcu9t5v0__dffrnq_2
* cell instance $4926 r0 *1 818.16,1169.28
X$4926 19283 19606 19607 19729 19605 gf180mcu_fd_sc_mcu9t5v0__dffq_2
* cell instance $4927 m0 *1 821.52,1169.28
X$4927 19401 19607 18585 19448 19605 19606 gf180mcu_fd_sc_mcu9t5v0__mux2_1
* cell instance $4928 r0 *1 817.04,1179.36
X$4928 18581 19902 19903 12383 20028 19901 gf180mcu_fd_sc_mcu9t5v0__dffrnq_2
* cell instance $4929 r0 *1 823.2,1199.52
X$4929 21409 20511 20512 20637 20507 gf180mcu_fd_sc_mcu9t5v0__dffq_2
* cell instance $4930 m0 *1 812.56,1199.52
X$4930 18581 20509 20510 20379 20507 gf180mcu_fd_sc_mcu9t5v0__dffq_2
* cell instance $4931 m0 *1 822.64,1179.36
X$4931 15401 19903 19284 19729 19901 19902 gf180mcu_fd_sc_mcu9t5v0__mux2_1
* cell instance $4932 m0 *1 827.12,1209.6
X$4932 20380 20512 18585 20637 20822 20511 gf180mcu_fd_sc_mcu9t5v0__mux2_1
* cell instance $4933 r0 *1 827.12,1149.12
X$4933 14166 19128 19284 19171 18996 19127 gf180mcu_fd_sc_mcu9t5v0__mux2_1
* cell instance $4934 m0 *1 815.92,1149.12
X$4934 19283 18843 18586 18841 18996 gf180mcu_fd_sc_mcu9t5v0__dffq_2
* cell instance $4935 m0 *1 823.2,1159.2
X$4935 19283 19127 19128 12383 19171 19282 gf180mcu_fd_sc_mcu9t5v0__dffrnq_2
* cell instance $4936 m0 *1 812,1128.96
X$4936 18581 18387 18388 13331 18268 18386 gf180mcu_fd_sc_mcu9t5v0__dffrnq_2
* cell instance $4937 m0 *1 958.72,1431.36
X$4937 27371 27257 27256 27255 27213 27367 24961
+ gf180mcu_fd_sc_mcu9t5v0__oai31_4
* cell instance $4938 r0 *1 963.76,1491.84
X$4938 28993 28992 29045 28989 28937 28991 gf180mcu_fd_sc_mcu9t5v0__aoi21_1
* cell instance $4939 m0 *1 962.64,1522.08
X$4939 27490 29287 29266 12383 29285 29335 gf180mcu_fd_sc_mcu9t5v0__dffrnq_2
* cell instance $4940 m0 *1 991.2,1522.08
X$4940 18590 29341 29268 29285 29335 29340 gf180mcu_fd_sc_mcu9t5v0__aoi21_1
* cell instance $4941 m0 *1 1022.56,1522.08
X$4941 29343 29285 29335 22854 gf180mcu_fd_sc_mcu9t5v0__buf_8
* cell instance $4942 m0 *1 986.16,1522.08
X$4942 28992 29340 29285 29335 29267 gf180mcu_fd_sc_mcu9t5v0__nor2_1
* cell instance $4943 m0 *1 1008,1522.08
X$4943 29356 18590 4952 16443 18614 29285 29335 29342
+ gf180mcu_fd_sc_mcu9t5v0__aoi221_1
* cell instance $4944 m0 *1 1089.2,1522.08
X$4944 29130 29289 29285 29335 29290 gf180mcu_fd_sc_mcu9t5v0__xnor2_1
* cell instance $4945 m0 *1 1067.92,1522.08
X$4945 29213 29270 29285 29335 29345 gf180mcu_fd_sc_mcu9t5v0__xnor2_1
* cell instance $4946 m0 *1 1064.56,1522.08
X$4946 18614 25435 29285 29335 29344 gf180mcu_fd_sc_mcu9t5v0__nor2_1
* cell instance $4947 m0 *1 1081.92,1522.08
X$4947 29335 29285 gf180mcu_fd_sc_mcu9t5v0__filltie
* cell instance $4948 m0 *1 1044.4,1522.08
X$4948 19402 29285 29335 27959 gf180mcu_fd_sc_mcu9t5v0__clkbuf_8
* cell instance $4949 m0 *1 1086.4,1522.08
X$4949 26962 29271 29285 29335 29289 gf180mcu_fd_sc_mcu9t5v0__nand2_1
* cell instance $4950 m0 *1 951.44,1562.4
X$4950 27959 29892 29911 18834 29841 29903 gf180mcu_fd_sc_mcu9t5v0__dffrnq_2
* cell instance $4951 m0 *1 953.68,1602.72
X$4951 30494 30408 29338 18834 30361 30419 gf180mcu_fd_sc_mcu9t5v0__dffrnq_2
* cell instance $4952 m0 *1 955.36,1582.56
X$4952 30494 30094 30095 18834 30106 30159 gf180mcu_fd_sc_mcu9t5v0__dffrnq_2
* cell instance $4953 r0 *1 964.88,1592.64
X$4953 29624 29562 20996 30351 18444 30361 30295 30363
+ gf180mcu_fd_sc_mcu9t5v0__oai221_1
* cell instance $4954 r0 *1 963.2,1602.72
X$4954 18590 29914 29338 30489 30419 30490 gf180mcu_fd_sc_mcu9t5v0__aoi21_1
* cell instance $4955 r0 *1 963.2,1572.48
X$4955 30092 29148 30095 30106 30039 30093 gf180mcu_fd_sc_mcu9t5v0__aoi21_1
* cell instance $4956 m0 *1 851.2,1522.08
X$4956 29334 26288 28662 27810 29285 29335 29284
+ gf180mcu_fd_sc_mcu9t5v0__aoi22_1
* cell instance $4957 m0 *1 848.96,1522.08
X$4957 29284 29285 29335 29333 gf180mcu_fd_sc_mcu9t5v0__clkinv_1
* cell instance $4958 m0 *1 952,1501.92
X$4958 27490 28991 28993 12383 28989 29062 gf180mcu_fd_sc_mcu9t5v0__dffrnq_2
* cell instance $4959 r0 *1 965.44,1522.08
X$4959 25003 19736 29408 29335 29411 gf180mcu_fd_sc_mcu9t5v0__nand2_1
* cell instance $4960 m0 *1 939.12,1522.08
X$4960 29063 29339 29268 29338 29285 29335 29337 gf180mcu_fd_sc_mcu9t5v0__nor4_1
* cell instance $4961 m0 *1 953.12,1532.16
X$4961 29463 29408 29482 18590 gf180mcu_fd_sc_mcu9t5v0__buf_8
* cell instance $4962 m0 *1 956.48,1542.24
X$4962 27519 29637 29696 18834 29559 29636 gf180mcu_fd_sc_mcu9t5v0__dffrnq_2
* cell instance $4963 r0 *1 963.76,1542.24
X$4963 29694 29148 29696 29714 29636 29695 gf180mcu_fd_sc_mcu9t5v0__aoi21_1
* cell instance $4964 m0 *1 944.72,1522.08
X$4964 29339 29268 29338 29285 29335 28665 gf180mcu_fd_sc_mcu9t5v0__nor3_1
* cell instance $4965 m0 *1 927.92,1522.08
X$4965 29286 27815 27630 29336 29285 29335 28352
+ gf180mcu_fd_sc_mcu9t5v0__nand4_1
* cell instance $4966 m0 *1 959.28,1451.52
X$4966 27954 27783 27784 27807 27945 27256 gf180mcu_fd_sc_mcu9t5v0__nor3_2
* cell instance $4967 m0 *1 959.84,1481.76
X$4967 27782 25003 28507 28635 28661 28667 gf180mcu_fd_sc_mcu9t5v0__mux2_1
* cell instance $4968 m0 *1 962.64,1441.44
X$4968 27631 27632 27517 27666 27257 gf180mcu_fd_sc_mcu9t5v0__and2_2
* cell instance $4969 m0 *1 966.56,1461.6
X$4969 27816 28103 28239 27783 gf180mcu_fd_sc_mcu9t5v0__inv_1
* cell instance $4970 r0 *1 951.44,1471.68
X$4970 27490 28532 27987 28635 28530 gf180mcu_fd_sc_mcu9t5v0__dffq_2
* cell instance $4971 m0 *1 948.64,1622.88
X$4971 30348 30635 30351 18834 30634 30705 gf180mcu_fd_sc_mcu9t5v0__dffrnq_2
* cell instance $4972 r0 *1 950.32,1421.28
X$4972 27490 27084 26040 12383 27213 27078 gf180mcu_fd_sc_mcu9t5v0__dffrnq_2
* cell instance $4973 r0 *1 949.76,1401.12
X$4973 25164 26464 26640 12383 26632 26456 gf180mcu_fd_sc_mcu9t5v0__dffrnq_2
* cell instance $4974 r0 *1 963.76,1632.96
X$4974 30348 30838 30636 18834 30912 30837 gf180mcu_fd_sc_mcu9t5v0__dffrnq_2
* cell instance $4975 m0 *1 842.24,1522.08
X$4975 29335 29285 gf180mcu_fd_sc_mcu9t5v0__endcap
* cell instance $4976 m0 *1 949.76,1653.12
X$4976 30348 31056 31127 18834 31054 31118 gf180mcu_fd_sc_mcu9t5v0__dffrnq_2
* cell instance $4977 m0 *1 1069.04,1592.64
X$4977 30286 30288 30233 30231 30295 30162 30284 gf180mcu_fd_sc_mcu9t5v0__nor4_2
* cell instance $4978 m0 *1 1057.84,1592.64
X$4978 29701 30410 30231 30295 29914 gf180mcu_fd_sc_mcu9t5v0__nand2_1
* cell instance $4979 m0 *1 1081.92,1592.64
X$4979 30295 30231 gf180mcu_fd_sc_mcu9t5v0__filltie
* cell instance $4980 m0 *1 1009.68,1592.64
X$4980 30096 30030 30284 30231 30295 30282 gf180mcu_fd_sc_mcu9t5v0__aoi21_4
* cell instance $4981 m0 *1 1028.16,1592.64
X$4981 30172 30285 30231 30295 30637 gf180mcu_fd_sc_mcu9t5v0__nor2_1
* cell instance $4982 m0 *1 1004.08,1592.64
X$4982 30172 30282 30173 30283 30231 30295 30298 gf180mcu_fd_sc_mcu9t5v0__nor4_1
* cell instance $4983 r0 *1 1033.76,1562.4
X$4983 29974 29973 29903 29977 gf180mcu_fd_sc_mcu9t5v0__clkinv_1
* cell instance $4984 r0 *1 1028.72,1592.64
X$4984 30030 30096 30356 30361 30295 30355 gf180mcu_fd_sc_mcu9t5v0__aoi21_2
* cell instance $4985 r0 *1 1028.16,1582.56
X$4985 30172 30285 30232 30231 30159 30160 gf180mcu_fd_sc_mcu9t5v0__oai21_2
* cell instance $4986 r0 *1 1033.76,1542.24
X$4986 29627 23213 29714 29636 29628 gf180mcu_fd_sc_mcu9t5v0__nand2_1
* cell instance $4987 m0 *1 1031.52,1592.64
X$4987 30030 30096 30286 30231 30295 30285 gf180mcu_fd_sc_mcu9t5v0__aoi21_4
* cell instance $4988 m0 *1 1034.88,1582.56
X$4988 30030 30096 30150 30106 30159 30099 gf180mcu_fd_sc_mcu9t5v0__aoi21_4
* cell instance $4989 m0 *1 1021.44,1542.24
X$4989 29640 28386 29639 29566 29559 29636 29627
+ gf180mcu_fd_sc_mcu9t5v0__oai31_4
* cell instance $4990 r0 *1 1024.24,1532.16
X$4990 29640 28386 29639 29546 29559 29482 29467
+ gf180mcu_fd_sc_mcu9t5v0__oai31_4
* cell instance $4991 m0 *1 1032.08,1622.88
X$4991 30494 30634 30705 gf180mcu_fd_sc_mcu9t5v0__inv_4
* cell instance $4992 r0 *1 1032.08,1622.88
X$4992 19402 30767 30705 30494 gf180mcu_fd_sc_mcu9t5v0__clkbuf_8
* cell instance $4993 r0 *1 1026.48,1643.04
X$4993 30494 31040 30626 18834 31054 30982 gf180mcu_fd_sc_mcu9t5v0__dffrnq_2
* cell instance $4994 m0 *1 1023.68,1632.96
X$4994 30494 30768 30439 18834 30767 30837 gf180mcu_fd_sc_mcu9t5v0__dffrnq_2
* cell instance $4995 m0 *1 1033.76,1653.12
X$4995 31106 31118 31054 30100 gf180mcu_fd_sc_mcu9t5v0__clkbuf_16
* cell instance $4996 m0 *1 1081.92,1612.8
X$4996 30570 30489 gf180mcu_fd_sc_mcu9t5v0__filltie
* cell instance $4997 m0 *1 1075.2,1602.72
X$4997 30499 30361 30419 30286 gf180mcu_fd_sc_mcu9t5v0__clkinv_1
* cell instance $4998 r0 *1 1053.92,1592.64
X$4998 30287 30361 30295 30356 gf180mcu_fd_sc_mcu9t5v0__clkinv_1
* cell instance $4999 r0 *1 1042.72,1602.72
X$4999 30425 30495 30489 30419 30496 gf180mcu_fd_sc_mcu9t5v0__nand2_1
* cell instance $5000 m0 *1 1079.68,1602.72
X$5000 30175 30361 30419 30353 gf180mcu_fd_sc_mcu9t5v0__clkinv_1
* cell instance $5001 r0 *1 1072.96,1602.72
X$5001 30499 30410 30489 30419 30498 gf180mcu_fd_sc_mcu9t5v0__nand2_1
* cell instance $5002 m0 *1 1070.72,1612.8
X$5002 30498 29272 30489 30570 30571 gf180mcu_fd_sc_mcu9t5v0__nand2_1
* cell instance $5003 m0 *1 1084.16,1602.72
X$5003 30353 30151 19292 30361 30419 30411 gf180mcu_fd_sc_mcu9t5v0__oai21_1
* cell instance $5004 m0 *1 1081.92,1643.04
X$5004 30982 30912 gf180mcu_fd_sc_mcu9t5v0__filltie
* cell instance $5005 r0 *1 1091.44,1632.96
X$5005 30105 30897 30912 30837 30840 gf180mcu_fd_sc_mcu9t5v0__or2_1
* cell instance $5006 m0 *1 1095.92,1653.12
X$5006 30040 30840 31110 31054 31118 31059 gf180mcu_fd_sc_mcu9t5v0__mux2_1
* cell instance $5007 r0 *1 1061.76,1632.96
X$5007 30839 30495 30912 30837 30755 gf180mcu_fd_sc_mcu9t5v0__nand2_1
* cell instance $5008 m0 *1 1081.92,1653.12
X$5008 31118 31054 gf180mcu_fd_sc_mcu9t5v0__filltie
* cell instance $5009 r0 *1 1095.92,1632.96
X$5009 30826 30840 30912 30837 30827 gf180mcu_fd_sc_mcu9t5v0__nand2_1
* cell instance $5010 m0 *1 1090.32,1632.96
X$5010 30105 30826 30827 18614 30767 30837 30772
+ gf180mcu_fd_sc_mcu9t5v0__oai211_1
* cell instance $5011 m0 *1 1095.92,1632.96
X$5011 29844 30772 30767 30837 30757 gf180mcu_fd_sc_mcu9t5v0__nand2_1
* cell instance $5012 m0 *1 1088.64,1653.12
X$5012 30040 29548 31333 31110 31054 31118 30920 gf180mcu_fd_sc_mcu9t5v0__and4_1
* cell instance $5013 m0 *1 1090.88,1643.04
X$5013 30897 30826 30920 30912 30982 29703 gf180mcu_fd_sc_mcu9t5v0__nand3_1
* cell instance $5014 m0 *1 1097.6,1602.72
X$5014 30364 30096 30361 30419 30410 gf180mcu_fd_sc_mcu9t5v0__nand2_1
* cell instance $5015 r0 *1 1045.52,1602.72
X$5015 30494 30496 30287 12383 30489 30419 gf180mcu_fd_sc_mcu9t5v0__dffrnq_2
* cell instance $5016 r0 *1 1070.72,1612.8
X$5016 30494 30571 30499 12383 30634 30570 gf180mcu_fd_sc_mcu9t5v0__dffrnq_2
* cell instance $5017 r0 *1 1085.28,1602.72
X$5017 30177 30411 30175 12383 30489 30419 gf180mcu_fd_sc_mcu9t5v0__dffrnq_2
* cell instance $5018 r0 *1 1081.92,1632.96
X$5018 18614 29548 30912 30837 31119 gf180mcu_fd_sc_mcu9t5v0__nand2_1
* cell instance $5019 m0 *1 1078,1653.12
X$5019 31029 30495 31054 31118 31120 gf180mcu_fd_sc_mcu9t5v0__nand2_1
* cell instance $5020 m0 *1 1072.4,1653.12
X$5020 30495 31119 31121 31120 31054 31118 31042
+ gf180mcu_fd_sc_mcu9t5v0__oai31_1
* cell instance $5021 r0 *1 1046.64,1643.04
X$5021 30494 31041 31131 18834 31054 30982 gf180mcu_fd_sc_mcu9t5v0__dffrnq_2
* cell instance $5022 r0 *1 1074.64,1643.04
X$5022 30494 31042 31029 18834 31054 30982 gf180mcu_fd_sc_mcu9t5v0__dffrnq_2
* cell instance $5023 m0 *1 1055.04,1632.96
X$5023 30494 30769 30839 18834 30767 30837 gf180mcu_fd_sc_mcu9t5v0__dffrnq_2
* cell instance $5024 m0 *1 1081.92,1632.96
X$5024 30837 30767 gf180mcu_fd_sc_mcu9t5v0__filltie
* cell instance $5025 m0 *1 1067.92,1653.12
X$5025 31109 31108 31054 31118 29548 gf180mcu_fd_sc_mcu9t5v0__or2_1
* cell instance $5026 r0 *1 1039.36,1592.64
X$5026 30030 30361 30295 30364 gf180mcu_fd_sc_mcu9t5v0__buf_8
* cell instance $5027 r0 *1 1042.72,1612.8
X$5027 30109 30625 30634 30570 30639 gf180mcu_fd_sc_mcu9t5v0__nand2_1
* cell instance $5028 m0 *1 1064,1612.8
X$5028 30174 30410 30489 30570 30497 gf180mcu_fd_sc_mcu9t5v0__nand2_1
* cell instance $5029 m0 *1 1063.44,1622.88
X$5029 30497 30639 30634 30705 30653 gf180mcu_fd_sc_mcu9t5v0__nand2_1
* cell instance $5030 r0 *1 1055.6,1622.88
X$5030 30495 30756 29342 30755 30767 30705 30769
+ gf180mcu_fd_sc_mcu9t5v0__oai31_1
* cell instance $5031 r0 *1 1084.72,1622.88
X$5031 30639 30767 30705 30770 gf180mcu_fd_sc_mcu9t5v0__clkinv_1
* cell instance $5032 r0 *1 1064,1622.88
X$5032 30494 30653 30174 18834 30767 30705 gf180mcu_fd_sc_mcu9t5v0__dffrnq_2
* cell instance $5033 m0 *1 1081.92,1622.88
X$5033 30705 30634 gf180mcu_fd_sc_mcu9t5v0__filltie
* cell instance $5034 m0 *1 1037.68,1622.88
X$5034 30652 30634 30705 29272 gf180mcu_fd_sc_mcu9t5v0__buf_8
* cell instance $5035 m0 *1 1090.88,1622.88
X$5035 30639 30031 30655 30634 30705 30654 gf180mcu_fd_sc_mcu9t5v0__oai21_1
* cell instance $5036 r0 *1 1090.88,1622.88
X$5036 18614 30109 30767 30705 30771 gf180mcu_fd_sc_mcu9t5v0__nand2_1
* cell instance $5037 m0 *1 1061.76,1653.12
X$5037 31109 31108 31119 31054 31118 30756 gf180mcu_fd_sc_mcu9t5v0__aoi21_1
* cell instance $5038 r0 *1 1064.56,1602.72
X$5038 18614 30498 30497 29914 30489 30419 30283
+ gf180mcu_fd_sc_mcu9t5v0__nand4_1
* cell instance $5039 m0 *1 1055.04,1602.72
X$5039 30287 30410 30361 30419 30425 gf180mcu_fd_sc_mcu9t5v0__nand2_1
* cell instance $5040 m0 *1 1081.92,1602.72
X$5040 30419 30361 gf180mcu_fd_sc_mcu9t5v0__filltie
* cell instance $5041 r0 *1 1033.2,1612.8
X$5041 30626 30634 30570 29286 gf180mcu_fd_sc_mcu9t5v0__clkinv_1
* cell instance $5042 r0 *1 1000.16,1592.64
X$5042 30096 30030 30353 30361 30295 30173 gf180mcu_fd_sc_mcu9t5v0__aoi21_4
* cell instance $5043 r0 *1 1001.84,1612.8
X$5043 30624 30637 30493 30636 30109 30623 30634 30570 29825
+ gf180mcu_fd_sc_mcu9t5v0__oai222_1
* cell instance $5044 r0 *1 1017.52,1602.72
X$5044 30439 30438 30489 30419 29336 gf180mcu_fd_sc_mcu9t5v0__nor2_1
* cell instance $5045 m0 *1 984.48,1612.8
X$5045 30491 30489 30570 19292 gf180mcu_fd_sc_mcu9t5v0__buf_8
* cell instance $5046 m0 *1 1002.96,1602.72
X$5046 30172 30282 30361 30419 30409 gf180mcu_fd_sc_mcu9t5v0__nor2_1
* cell instance $5047 m0 *1 986.72,1602.72
X$5047 30520 30424 30409 30351 30361 30419 29893
+ gf180mcu_fd_sc_mcu9t5v0__oai22_1
* cell instance $5048 m0 *1 1025.92,1602.72
X$5048 30172 30355 30361 30419 30424 gf180mcu_fd_sc_mcu9t5v0__nor2_1
* cell instance $5049 m0 *1 1010.8,1612.8
X$5049 30438 29562 20996 30520 18444 30489 30570 30521
+ gf180mcu_fd_sc_mcu9t5v0__oai221_1
* cell instance $5050 r0 *1 1002.96,1632.96
X$5050 30770 29148 30623 30912 30837 30918 gf180mcu_fd_sc_mcu9t5v0__aoi21_1
* cell instance $5051 m0 *1 995.68,1643.04
X$5051 29464 30918 30912 30982 30919 gf180mcu_fd_sc_mcu9t5v0__nor2_1
* cell instance $5052 m0 *1 1025.92,1612.8
X$5052 30424 30521 30489 30570 30495 gf180mcu_fd_sc_mcu9t5v0__nand2_1
* cell instance $5053 r0 *1 986.16,1643.04
X$5053 31039 29464 31054 30982 31038 gf180mcu_fd_sc_mcu9t5v0__nor2_1
* cell instance $5054 m0 *1 1014.72,1653.12
X$5054 18590 31057 30438 31054 31118 31058 gf180mcu_fd_sc_mcu9t5v0__aoi21_1
* cell instance $5055 m0 *1 1029.84,1643.04
X$5055 18590 30770 30626 30912 30982 30971 gf180mcu_fd_sc_mcu9t5v0__aoi21_1
* cell instance $5056 m0 *1 974.4,1632.96
X$5056 22721 29148 30636 30767 30837 30824 gf180mcu_fd_sc_mcu9t5v0__aoi21_1
* cell instance $5057 m0 *1 999.04,1643.04
X$5057 30494 30919 30623 18834 30912 30982 gf180mcu_fd_sc_mcu9t5v0__dffrnq_2
* cell instance $5058 r0 *1 1024.8,1602.72
X$5058 30438 30489 30419 30354 gf180mcu_fd_sc_mcu9t5v0__clkinv_1
* cell instance $5059 r0 *1 1020.88,1592.64
X$5059 30355 30172 30354 30361 30295 30098 gf180mcu_fd_sc_mcu9t5v0__oai21_2
* cell instance $5060 r0 *1 1031.52,1602.72
X$5060 30439 30489 30419 30232 gf180mcu_fd_sc_mcu9t5v0__clkinv_1
* cell instance $5061 r0 *1 1016.96,1612.8
X$5061 30439 29562 20996 30624 18444 30634 30570 30638
+ gf180mcu_fd_sc_mcu9t5v0__oai221_1
* cell instance $5062 r0 *1 1026.48,1612.8
X$5062 30626 29562 20996 30623 18444 30634 30570 30625
+ gf180mcu_fd_sc_mcu9t5v0__oai221_1
* cell instance $5063 m0 *1 1006.32,1602.72
X$5063 30172 30173 30361 30419 30493 gf180mcu_fd_sc_mcu9t5v0__nor2_1
* cell instance $5064 m0 *1 967.68,1632.96
X$5064 29464 30824 30767 30837 30838 gf180mcu_fd_sc_mcu9t5v0__nor2_1
* cell instance $5065 r0 *1 981.12,1612.8
X$5065 29560 29562 20996 30636 18444 30634 30570 30492
+ gf180mcu_fd_sc_mcu9t5v0__oai221_1
* cell instance $5066 m0 *1 974.96,1602.72
X$5066 30409 30363 30361 30419 30352 gf180mcu_fd_sc_mcu9t5v0__nand2_1
* cell instance $5067 r0 *1 1023.12,1643.04
X$5067 28992 30971 31054 30982 31040 gf180mcu_fd_sc_mcu9t5v0__nor2_1
* cell instance $5068 m0 *1 974.4,1622.88
X$5068 18590 22721 29560 30634 30705 30650 gf180mcu_fd_sc_mcu9t5v0__aoi21_1
* cell instance $5069 r0 *1 967.68,1622.88
X$5069 28992 30650 30767 30705 30754 gf180mcu_fd_sc_mcu9t5v0__nor2_1
* cell instance $5070 m0 *1 1002.96,1622.88
X$5070 26904 29148 30624 30634 30705 30651 gf180mcu_fd_sc_mcu9t5v0__aoi21_1
* cell instance $5071 m0 *1 996.8,1622.88
X$5071 29464 30651 30634 30705 30706 gf180mcu_fd_sc_mcu9t5v0__nor2_1
* cell instance $5072 r0 *1 994,1622.88
X$5072 30494 30706 30624 18834 30767 30705 gf180mcu_fd_sc_mcu9t5v0__dffrnq_2
* cell instance $5073 r0 *1 971.04,1622.88
X$5073 30348 30754 29560 18834 30767 30705 gf180mcu_fd_sc_mcu9t5v0__dffrnq_2
* cell instance $5074 m0 *1 1019.2,1632.96
X$5074 18590 26904 30439 30767 30837 30825 gf180mcu_fd_sc_mcu9t5v0__aoi21_1
* cell instance $5075 m0 *1 1026.48,1622.88
X$5075 30637 30638 30634 30705 30652 gf180mcu_fd_sc_mcu9t5v0__nand2_1
* cell instance $5076 r0 *1 1023.68,1622.88
X$5076 28992 30825 30767 30705 30768 gf180mcu_fd_sc_mcu9t5v0__nor2_1
* cell instance $5077 r0 *1 991.2,1643.04
X$5077 31057 29148 30520 31054 30982 31039 gf180mcu_fd_sc_mcu9t5v0__aoi21_1
* cell instance $5078 r0 *1 987.28,1602.72
X$5078 30493 30492 30489 30419 30491 gf180mcu_fd_sc_mcu9t5v0__nand2_1
* cell instance $5079 r0 *1 974.96,1592.64
X$5079 30352 30361 30295 18272 gf180mcu_fd_sc_mcu9t5v0__buf_8
* cell instance $5080 m0 *1 1011.36,1653.12
X$5080 28992 31058 31054 31118 31107 gf180mcu_fd_sc_mcu9t5v0__nor2_1
* cell instance $5081 m0 *1 982.24,1653.12
X$5081 30348 31038 30520 18834 31054 31118 gf180mcu_fd_sc_mcu9t5v0__dffrnq_2
* cell instance $5082 m0 *1 1015.28,1582.56
X$5082 30160 30028 30027 30106 30159 29699 gf180mcu_fd_sc_mcu9t5v0__nand3_1
* cell instance $5083 r0 *1 969.36,1562.4
X$5083 29913 29973 29903 29842 gf180mcu_fd_sc_mcu9t5v0__clkinv_1
* cell instance $5084 r0 *1 972.16,1572.48
X$5084 29625 29562 20996 30095 18444 30106 30039 30107
+ gf180mcu_fd_sc_mcu9t5v0__oai221_1
* cell instance $5085 r0 *1 1014.72,1572.48
X$5085 30098 30029 29565 30106 30039 29976 gf180mcu_fd_sc_mcu9t5v0__nand3_1
* cell instance $5086 m0 *1 1002.4,1582.56
X$5086 30172 30026 30106 30159 29915 gf180mcu_fd_sc_mcu9t5v0__nor2_1
* cell instance $5087 m0 *1 1004.08,1572.48
X$5087 30026 30172 30025 29973 30039 29975 gf180mcu_fd_sc_mcu9t5v0__oai21_2
* cell instance $5088 r0 *1 973.28,1562.4
X$5088 29974 29914 29973 29903 29913 gf180mcu_fd_sc_mcu9t5v0__nand2_1
* cell instance $5089 r0 *1 972.72,1542.24
X$5089 29638 29714 29636 29694 gf180mcu_fd_sc_mcu9t5v0__clkinv_1
* cell instance $5090 r0 *1 975.52,1532.16
X$5090 29696 29064 29411 29562 29559 29482 29543
+ gf180mcu_fd_sc_mcu9t5v0__oai22_1
* cell instance $5091 r0 *1 1027.04,1572.48
X$5091 30099 30172 29286 30106 30039 30028 gf180mcu_fd_sc_mcu9t5v0__oai21_2
* cell instance $5092 r0 *1 1018.64,1532.16
X$5092 29564 29467 29485 15583 29559 29482 29563
+ gf180mcu_fd_sc_mcu9t5v0__aoi211_1
* cell instance $5093 r0 *1 990.08,1532.16
X$5093 27959 29484 29485 12383 29559 29482 gf180mcu_fd_sc_mcu9t5v0__dffrnq_2
* cell instance $5094 r0 *1 985.6,1552.32
X$5094 29698 29825 29841 29769 29823 gf180mcu_fd_sc_mcu9t5v0__nor2_1
* cell instance $5095 r0 *1 1025.36,1542.24
X$5095 29564 29627 29714 29636 29697 gf180mcu_fd_sc_mcu9t5v0__and2_1
* cell instance $5096 m0 *1 1020.88,1572.48
X$5096 30030 30096 29894 29338 29973 30039 29917
+ gf180mcu_fd_sc_mcu9t5v0__aoi211_2
* cell instance $5097 r0 *1 982.8,1552.32
X$5097 29824 29823 29841 29769 27254 gf180mcu_fd_sc_mcu9t5v0__nand2_1
* cell instance $5098 r0 *1 1000.72,1582.56
X$5098 30282 30172 30170 30231 30159 30097 gf180mcu_fd_sc_mcu9t5v0__oai21_2
* cell instance $5099 r0 *1 978.88,1542.24
X$5099 29697 29543 29714 29636 29638 gf180mcu_fd_sc_mcu9t5v0__nand2_1
* cell instance $5100 r0 *1 1020.88,1542.24
X$5100 29627 29564 29411 29714 29636 29700 gf180mcu_fd_sc_mcu9t5v0__aoi21_1
* cell instance $5101 r0 *1 1023.68,1522.08
X$5101 22854 29408 29335 29341 gf180mcu_fd_sc_mcu9t5v0__clkinv_1
* cell instance $5102 r0 *1 999.6,1522.08
X$5102 25003 29408 29335 29356 gf180mcu_fd_sc_mcu9t5v0__clkinv_1
* cell instance $5103 r0 *1 1019.76,1572.48
X$5103 30098 30097 30160 30106 30039 29829 gf180mcu_fd_sc_mcu9t5v0__nand3_2
* cell instance $5104 r0 *1 988.96,1552.32
X$5104 29715 29841 29769 28992 gf180mcu_fd_sc_mcu9t5v0__buf_8
* cell instance $5105 m0 *1 976.08,1542.24
X$5105 29638 29559 29636 23213 gf180mcu_fd_sc_mcu9t5v0__buf_8
* cell instance $5106 m0 *1 985.6,1562.4
X$5106 29563 29893 29916 29841 29903 29824 gf180mcu_fd_sc_mcu9t5v0__nor3_1
* cell instance $5107 m0 *1 977.2,1582.56
X$5107 29915 30107 30106 30159 30149 gf180mcu_fd_sc_mcu9t5v0__nand2_1
* cell instance $5108 r0 *1 1006.32,1522.08
X$5108 29356 29268 29408 29335 29544 gf180mcu_fd_sc_mcu9t5v0__or2_1
* cell instance $5109 m0 *1 1010.8,1542.24
X$5109 29467 29564 29544 29559 29636 29626 gf180mcu_fd_sc_mcu9t5v0__aoi21_2
* cell instance $5110 m0 *1 1008,1552.32
X$5110 29700 29626 29714 29769 29827 gf180mcu_fd_sc_mcu9t5v0__or2_2
* cell instance $5111 r0 *1 1004.08,1552.32
X$5111 29828 29829 29827 29339 29841 29769 29757
+ gf180mcu_fd_sc_mcu9t5v0__oai31_4
* cell instance $5112 m0 *1 997.36,1532.16
X$5112 29341 29148 29485 29408 29482 29465 gf180mcu_fd_sc_mcu9t5v0__aoi21_1
* cell instance $5113 m0 *1 1019.2,1542.24
X$5113 29626 29559 29636 29565 gf180mcu_fd_sc_mcu9t5v0__clkinv_1
* cell instance $5114 m0 *1 994,1532.16
X$5114 29464 29465 29408 29482 29484 gf180mcu_fd_sc_mcu9t5v0__nor2_1
* cell instance $5115 r0 *1 1014.16,1542.24
X$5115 29700 29826 29699 29976 29714 29636 29715 gf180mcu_fd_sc_mcu9t5v0__nor4_1
* cell instance $5116 m0 *1 1013.6,1552.32
X$5116 29757 29714 29769 19732 gf180mcu_fd_sc_mcu9t5v0__clkbuf_8
* cell instance $5117 r0 *1 982.8,1542.24
X$5117 29696 15583 29697 29714 29636 29698 gf180mcu_fd_sc_mcu9t5v0__nor3_1
* cell instance $5118 r0 *1 1013.04,1532.16
X$5118 29485 29064 29544 29562 29559 29482 29545
+ gf180mcu_fd_sc_mcu9t5v0__oai22_1
* cell instance $5119 m0 *1 1024.24,1532.16
X$5119 29564 29467 29545 29408 29482 29343 gf180mcu_fd_sc_mcu9t5v0__nand3_1
* cell instance $5120 m0 *1 1030.96,1532.16
X$5120 29467 22854 29408 29482 29466 gf180mcu_fd_sc_mcu9t5v0__nand2_1
* cell instance $5121 r0 *1 1022.56,1562.4
X$5121 29917 29562 29973 29903 30029 gf180mcu_fd_sc_mcu9t5v0__nor2_2
* cell instance $5122 r0 *1 996.8,1572.48
X$5122 30096 30030 30108 30106 30039 30026 gf180mcu_fd_sc_mcu9t5v0__aoi21_4
* cell instance $5123 r0 *1 988.96,1582.56
X$5123 29560 30231 30159 30171 gf180mcu_fd_sc_mcu9t5v0__clkinv_1
* cell instance $5124 r0 *1 1008.56,1582.56
X$5124 30173 30172 30171 30231 30159 30027 gf180mcu_fd_sc_mcu9t5v0__oai21_2
* cell instance $5125 m0 *1 1011.92,1572.48
X$5125 30028 30029 30027 29973 30039 29975 29828
+ gf180mcu_fd_sc_mcu9t5v0__nand4_2
* cell instance $5126 r0 *1 976.08,1562.4
X$5126 29911 29914 29915 30095 4952 29973 29903 29916
+ gf180mcu_fd_sc_mcu9t5v0__oai221_1
* cell instance $5127 m0 *1 1031.52,1582.56
X$5127 30172 30099 30106 30159 30109 gf180mcu_fd_sc_mcu9t5v0__nor2_1
* cell instance $5128 m0 *1 980,1582.56
X$5128 30149 30106 30159 26004 gf180mcu_fd_sc_mcu9t5v0__buf_8
* cell instance $5129 r0 *1 991.2,1582.56
X$5129 30425 29915 30298 30231 30159 29691 gf180mcu_fd_sc_mcu9t5v0__nand3_1
* cell instance $5130 r0 *1 983.92,1572.48
X$5130 29625 30106 30039 30025 gf180mcu_fd_sc_mcu9t5v0__clkinv_1
* cell instance $5131 r0 *1 972.16,1582.56
X$5131 29624 30231 30159 30170 gf180mcu_fd_sc_mcu9t5v0__clkinv_1
* cell instance $5132 m0 *1 999.6,1582.56
X$5132 30097 29975 30106 30159 29826 gf180mcu_fd_sc_mcu9t5v0__nand2_1
* cell instance $5133 m0 *1 1083.04,1562.4
X$5133 27959 29907 29897 12383 29841 29903 gf180mcu_fd_sc_mcu9t5v0__dffrnq_2
* cell instance $5134 m0 *1 1074.64,1562.4
X$5134 29843 29897 29913 29841 29903 29907 gf180mcu_fd_sc_mcu9t5v0__mux2_1
* cell instance $5135 m0 *1 1051.68,1562.4
X$5135 29701 29843 29896 29841 29903 29895 gf180mcu_fd_sc_mcu9t5v0__oai21_1
* cell instance $5136 m0 *1 1075.2,1552.32
X$5136 29561 29412 29772 29703 29714 29769 29773
+ gf180mcu_fd_sc_mcu9t5v0__aoi22_1
* cell instance $5137 m0 *1 1081.92,1542.24
X$5137 29636 29559 gf180mcu_fd_sc_mcu9t5v0__filltie
* cell instance $5138 m0 *1 1036.56,1562.4
X$5138 29894 29977 29895 29841 29903 29564 gf180mcu_fd_sc_mcu9t5v0__aoi21_1
* cell instance $5139 r0 *1 1049.44,1582.56
X$5139 30494 30161 29701 12383 30231 30159 gf180mcu_fd_sc_mcu9t5v0__dffrnq_2
* cell instance $5140 r0 *1 1062.32,1532.16
X$5140 29547 29559 29482 26053 gf180mcu_fd_sc_mcu9t5v0__buf_8
* cell instance $5141 m0 *1 1048.32,1582.56
X$5141 29977 29914 30106 30159 30161 gf180mcu_fd_sc_mcu9t5v0__nand2_1
* cell instance $5142 m0 *1 1083.04,1542.24
X$5142 29629 29559 29636 26962 gf180mcu_fd_sc_mcu9t5v0__buf_8
* cell instance $5143 r0 *1 1081.36,1542.24
X$5143 29548 29703 29714 29636 29629 gf180mcu_fd_sc_mcu9t5v0__nand2_1
* cell instance $5144 r0 *1 1044.4,1522.08
X$5144 27959 29408 29335 gf180mcu_fd_sc_mcu9t5v0__inv_4
* cell instance $5145 r0 *1 1058.96,1542.24
X$5145 29701 29566 29546 29547 29714 29636 29702 gf180mcu_fd_sc_mcu9t5v0__and4_1
* cell instance $5146 r0 *1 1079.68,1522.08
X$5146 16789 4952 18614 29408 29335 29412 gf180mcu_fd_sc_mcu9t5v0__aoi21_1
* cell instance $5147 r0 *1 1064.56,1552.32
X$5147 29897 29841 29769 29830 gf180mcu_fd_sc_mcu9t5v0__inv_1
* cell instance $5148 r0 *1 1099.28,1552.32
X$5148 29640 29841 29769 29906 gf180mcu_fd_sc_mcu9t5v0__clkinv_1
* cell instance $5149 m0 *1 1097.6,1542.24
X$5149 18614 22854 21418 29630 29559 29636 29641
+ gf180mcu_fd_sc_mcu9t5v0__oai31_1
* cell instance $5150 r0 *1 1057.84,1552.32
X$5150 29640 29830 29701 29841 29769 29896 gf180mcu_fd_sc_mcu9t5v0__oai21_1
* cell instance $5151 m0 *1 1041.6,1542.24
X$5151 27959 29628 29566 12383 29559 29636 gf180mcu_fd_sc_mcu9t5v0__dffrnq_2
* cell instance $5152 m0 *1 1081.92,1562.4
X$5152 29903 29841 gf180mcu_fd_sc_mcu9t5v0__filltie
* cell instance $5153 r0 *1 1084.16,1532.16
X$5153 29548 29703 29559 29482 27995 gf180mcu_fd_sc_mcu9t5v0__and2_1
* cell instance $5154 m0 *1 1081.92,1582.56
X$5154 30159 30106 gf180mcu_fd_sc_mcu9t5v0__filltie
* cell instance $5155 m0 *1 1081.92,1552.32
X$5155 29769 29714 gf180mcu_fd_sc_mcu9t5v0__filltie
* cell instance $5156 m0 *1 1043.28,1532.16
X$5156 27959 29466 29546 12383 29408 29482 gf180mcu_fd_sc_mcu9t5v0__dffrnq_2
* cell instance $5157 m0 *1 1071.28,1552.32
X$5157 29064 29561 29714 29769 29771 gf180mcu_fd_sc_mcu9t5v0__nand2_1
* cell instance $5158 m0 *1 1081.92,1572.48
X$5158 30039 29973 gf180mcu_fd_sc_mcu9t5v0__filltie
* cell instance $5159 r0 *1 1093.68,1522.08
X$5159 18614 29290 29355 29272 29408 29335 29357
+ gf180mcu_fd_sc_mcu9t5v0__aoi211_1
* cell instance $5160 r0 *1 1066.24,1562.4
X$5160 29906 29894 29897 29973 29903 29920 gf180mcu_fd_sc_mcu9t5v0__nor3_2
* cell instance $5161 r0 *1 1075.76,1562.4
X$5161 30105 29548 18444 29973 29903 29772 gf180mcu_fd_sc_mcu9t5v0__aoi21_1
* cell instance $5162 r0 *1 1072.96,1522.08
X$5162 18614 29345 29344 29272 29408 29335 29567
+ gf180mcu_fd_sc_mcu9t5v0__aoi211_1
* cell instance $5163 r0 *1 1085.28,1552.32
X$5163 18444 29771 29841 29769 29844 gf180mcu_fd_sc_mcu9t5v0__nand2_1
* cell instance $5164 r0 *1 1046.08,1552.32
X$5164 29064 29561 29840 29841 29769 29843 gf180mcu_fd_sc_mcu9t5v0__aoi21_2
* cell instance $5165 m0 *1 1044.4,1572.48
X$5165 29978 29973 30039 30172 gf180mcu_fd_sc_mcu9t5v0__buf_8
* cell instance $5166 r0 *1 1058.96,1562.4
X$5166 29701 29843 29973 29903 29919 gf180mcu_fd_sc_mcu9t5v0__nor2_1
* cell instance $5167 m0 *1 1077.44,1582.56
X$5167 30108 30151 26004 30106 30159 30163 gf180mcu_fd_sc_mcu9t5v0__oai21_1
* cell instance $5168 m0 *1 1075.2,1582.56
X$5168 30162 30106 30159 29639 gf180mcu_fd_sc_mcu9t5v0__inv_1
* cell instance $5169 r0 *1 1080.24,1582.56
X$5169 30176 30231 30159 30108 gf180mcu_fd_sc_mcu9t5v0__clkinv_1
* cell instance $5170 r0 *1 1046.08,1562.4
X$5170 29894 29977 29973 29903 29918 gf180mcu_fd_sc_mcu9t5v0__nand2_1
* cell instance $5171 r0 *1 1048.88,1562.4
X$5171 29919 29896 29920 29918 29973 29903 29978
+ gf180mcu_fd_sc_mcu9t5v0__oai31_2
* cell instance $5172 m0 *1 1076.32,1572.48
X$5172 18614 31242 29843 29973 30039 30031 gf180mcu_fd_sc_mcu9t5v0__aoi21_1
* cell instance $5173 r0 *1 1062.88,1562.4
X$5173 29920 29702 29973 29903 30288 gf180mcu_fd_sc_mcu9t5v0__nor2_1
* cell instance $5174 r0 *1 1070.16,1582.56
X$5174 30174 30287 30176 30175 30231 30159 30233
+ gf180mcu_fd_sc_mcu9t5v0__nand4_1
* cell instance $5175 m0 *1 1088.08,1572.48
X$5175 29844 29640 29913 29973 30039 30032 gf180mcu_fd_sc_mcu9t5v0__mux2_1
* cell instance $5176 m0 *1 1061.76,1582.56
X$5176 30174 30106 30159 30150 gf180mcu_fd_sc_mcu9t5v0__clkinv_1
* cell instance $5177 r0 *1 1082.48,1582.56
X$5177 30177 30163 30176 12383 30231 30159 gf180mcu_fd_sc_mcu9t5v0__dffrnq_2
* cell instance $5178 m0 *1 1098.16,1532.16
X$5178 18444 22710 29272 29408 29482 29468 gf180mcu_fd_sc_mcu9t5v0__aoi21_1
* cell instance $5179 r0 *1 1065.12,1542.24
X$5179 29640 29830 29714 29636 29547 gf180mcu_fd_sc_mcu9t5v0__nor2_1
* cell instance $5180 m0 *1 1081.92,1532.16
X$5180 29482 29408 gf180mcu_fd_sc_mcu9t5v0__filltie
* cell instance $5181 r0 *1 1076.88,1582.56
X$5181 29288 29639 30231 30159 30151 gf180mcu_fd_sc_mcu9t5v0__nor2_1
* cell instance $5182 m0 *1 1060.64,1562.4
X$5182 29701 29841 29903 29894 gf180mcu_fd_sc_mcu9t5v0__clkinv_1
* cell instance $5183 r0 *1 886.48,1562.4
X$5183 28500 29904 29822 18834 29973 29903 gf180mcu_fd_sc_mcu9t5v0__dffrnq_2
* cell instance $5184 r0 *1 894.32,1572.48
X$5184 30147 28662 30104 30106 30039 30148 gf180mcu_fd_sc_mcu9t5v0__mux2_1
* cell instance $5185 m0 *1 876.96,1592.64
X$5185 30281 30158 30231 30295 30087 gf180mcu_fd_sc_mcu9t5v0__or2_1
* cell instance $5186 m0 *1 889.84,1592.64
X$5186 23621 30158 28662 30231 30295 30297 gf180mcu_fd_sc_mcu9t5v0__aoi21_1
* cell instance $5187 r0 *1 896.56,1592.64
X$5187 24411 30346 30361 30295 30347 gf180mcu_fd_sc_mcu9t5v0__nand2_1
* cell instance $5188 m0 *1 882,1532.16
X$5188 27519 29461 29063 18834 29408 29482 gf180mcu_fd_sc_mcu9t5v0__dffrnq_2
* cell instance $5189 m0 *1 895.44,1582.56
X$5189 28500 30148 30104 18834 30106 30159 gf180mcu_fd_sc_mcu9t5v0__dffrnq_2
* cell instance $5190 m0 *1 938.56,1592.64
X$5190 18590 25548 29624 30231 30295 30407 gf180mcu_fd_sc_mcu9t5v0__aoi21_1
* cell instance $5191 r0 *1 891.52,1632.96
X$5191 30910 30912 30837 30645 30819 gf180mcu_fd_sc_mcu9t5v0__xor2_1
* cell instance $5192 m0 *1 842.24,1592.64
X$5192 30295 30231 gf180mcu_fd_sc_mcu9t5v0__endcap
* cell instance $5193 m0 *1 918.4,1592.64
X$5193 18272 30231 30295 25548 gf180mcu_fd_sc_mcu9t5v0__clkinv_1
* cell instance $5194 m0 *1 895.44,1602.72
X$5194 30346 30420 30361 30419 30405 gf180mcu_fd_sc_mcu9t5v0__nand2_1
* cell instance $5195 m0 *1 894.32,1592.64
X$5195 24411 30158 30231 30295 30296 gf180mcu_fd_sc_mcu9t5v0__nand2_1
* cell instance $5196 r0 *1 957.04,1602.72
X$5196 28992 30490 30489 30419 30408 gf180mcu_fd_sc_mcu9t5v0__nor2_1
* cell instance $5197 r0 *1 900.48,1612.8
X$5197 30348 30422 30633 18834 30634 30570 gf180mcu_fd_sc_mcu9t5v0__dffrnq_2
* cell instance $5198 r0 *1 915.6,1592.64
X$5198 30348 30349 30406 18834 30361 30295 gf180mcu_fd_sc_mcu9t5v0__dffrnq_2
* cell instance $5199 r0 *1 940.8,1612.8
X$5199 30406 30517 30634 30570 30649 gf180mcu_fd_sc_mcu9t5v0__nand2_1
* cell instance $5200 m0 *1 905.52,1653.12
X$5200 31028 31053 31054 31118 31103 gf180mcu_fd_sc_mcu9t5v0__nand2_1
* cell instance $5201 m0 *1 937.44,1602.72
X$5201 28992 30407 30361 30419 30350 gf180mcu_fd_sc_mcu9t5v0__nor2_1
* cell instance $5202 r0 *1 951.44,1612.8
X$5202 25548 29148 30351 30634 30570 30622 gf180mcu_fd_sc_mcu9t5v0__aoi21_1
* cell instance $5203 r0 *1 948.08,1612.8
X$5203 29464 30622 30634 30570 30635 gf180mcu_fd_sc_mcu9t5v0__nor2_1
* cell instance $5204 r0 *1 962.08,1592.64
X$5204 30295 30361 gf180mcu_fd_sc_mcu9t5v0__filltie
* cell instance $5205 r0 *1 902.16,1643.04
X$5205 31028 30911 31054 30982 31027 31053 gf180mcu_fd_sc_mcu9t5v0__xnor3_1
* cell instance $5206 r0 *1 919.52,1612.8
X$5206 30406 30487 30634 30570 30488 gf180mcu_fd_sc_mcu9t5v0__and2_1
* cell instance $5207 m0 *1 930.72,1612.8
X$5207 30406 30517 30489 30570 30518 gf180mcu_fd_sc_mcu9t5v0__nor2_1
* cell instance $5208 r0 *1 927.92,1612.8
X$5208 30406 30648 30634 30570 30632 30517 gf180mcu_fd_sc_mcu9t5v0__xnor3_1
* cell instance $5209 r0 *1 962.08,1602.72
X$5209 30419 30489 gf180mcu_fd_sc_mcu9t5v0__filltie
* cell instance $5210 m0 *1 943.6,1632.96
X$5210 30040 30767 30837 30105 gf180mcu_fd_sc_mcu9t5v0__clkinv_1
* cell instance $5211 m0 *1 946.96,1653.12
X$5211 31127 31105 31054 31118 31055 gf180mcu_fd_sc_mcu9t5v0__nand2_1
* cell instance $5212 r0 *1 962.08,1632.96
X$5212 30837 30912 gf180mcu_fd_sc_mcu9t5v0__filltie
* cell instance $5213 m0 *1 938,1643.04
X$5213 30519 31105 30912 30982 30896 gf180mcu_fd_sc_mcu9t5v0__and2_1
* cell instance $5214 r0 *1 962.08,1612.8
X$5214 30570 30634 gf180mcu_fd_sc_mcu9t5v0__filltie
* cell instance $5215 m0 *1 913.92,1632.96
X$5215 30633 30820 30767 30837 30894 gf180mcu_fd_sc_mcu9t5v0__or2_1
* cell instance $5216 r0 *1 916.16,1632.96
X$5216 30633 30820 30912 30837 30895 gf180mcu_fd_sc_mcu9t5v0__and2_1
* cell instance $5217 m0 *1 921.76,1602.72
X$5217 30406 30487 30361 30419 30362 gf180mcu_fd_sc_mcu9t5v0__nor2_1
* cell instance $5218 r0 *1 903.84,1602.72
X$5218 30421 30488 30489 30419 30420 30646 gf180mcu_fd_sc_mcu9t5v0__xnor3_1
* cell instance $5219 r0 *1 911.68,1632.96
X$5219 30647 30894 30895 30912 30837 30911 gf180mcu_fd_sc_mcu9t5v0__aoi21_1
* cell instance $5220 m0 *1 912.8,1653.12
X$5220 31028 31053 31054 31118 31104 gf180mcu_fd_sc_mcu9t5v0__nor2_1
* cell instance $5221 m0 *1 913.36,1602.72
X$5221 30406 31515 30361 30419 30423 gf180mcu_fd_sc_mcu9t5v0__nand2_1
* cell instance $5222 r0 *1 935.76,1632.96
X$5222 30348 30896 30519 18834 30912 30837 gf180mcu_fd_sc_mcu9t5v0__dffrnq_2
* cell instance $5223 r0 *1 950.88,1643.04
X$5223 31258 30916 31055 31054 30982 31056 gf180mcu_fd_sc_mcu9t5v0__oai21_1
* cell instance $5224 r0 *1 932.4,1643.04
X$5224 23621 30916 31054 30982 31105 gf180mcu_fd_sc_mcu9t5v0__and2_1
* cell instance $5225 m0 *1 916.16,1602.72
X$5225 30488 30347 30362 30423 30361 30419 30349
+ gf180mcu_fd_sc_mcu9t5v0__oai31_1
* cell instance $5226 m0 *1 918.4,1643.04
X$5226 30633 30646 30912 30982 30822 gf180mcu_fd_sc_mcu9t5v0__or2_1
* cell instance $5227 r0 *1 920.64,1632.96
X$5227 30633 30646 30912 30837 30823 gf180mcu_fd_sc_mcu9t5v0__and2_1
* cell instance $5228 m0 *1 920.08,1632.96
X$5228 30488 30822 30823 30767 30837 30821 gf180mcu_fd_sc_mcu9t5v0__aoi21_1
* cell instance $5229 r0 *1 962.08,1643.04
X$5229 30982 31054 gf180mcu_fd_sc_mcu9t5v0__filltie
* cell instance $5230 m0 *1 938,1622.88
X$5230 30104 30519 30634 30705 30648 gf180mcu_fd_sc_mcu9t5v0__nand2_1
* cell instance $5231 m0 *1 932.96,1622.88
X$5231 30648 30518 30649 30634 30705 30647 gf180mcu_fd_sc_mcu9t5v0__oai21_1
* cell instance $5232 r0 *1 962.08,1622.88
X$5232 30705 30767 gf180mcu_fd_sc_mcu9t5v0__filltie
* cell instance $5233 m0 *1 910.56,1622.88
X$5233 30633 30634 30705 30421 gf180mcu_fd_sc_mcu9t5v0__clkinv_1
* cell instance $5234 r0 *1 905.52,1622.88
X$5234 30421 30647 30767 30705 30645 30820 gf180mcu_fd_sc_mcu9t5v0__xnor3_1
* cell instance $5235 m0 *1 934.08,1612.8
X$5235 30104 30489 30570 30519 30485 gf180mcu_fd_sc_mcu9t5v0__xor2_1
* cell instance $5236 r0 *1 934.64,1592.64
X$5236 30348 30350 29624 18834 30361 30295 gf180mcu_fd_sc_mcu9t5v0__dffrnq_2
* cell instance $5237 m0 *1 898.24,1602.72
X$5237 30421 30297 30405 27074 30361 30419 30422
+ gf180mcu_fd_sc_mcu9t5v0__oai22_1
* cell instance $5238 m0 *1 908.32,1653.12
X$5238 31103 30911 31104 31054 31118 31102 gf180mcu_fd_sc_mcu9t5v0__aoi21_1
* cell instance $5239 r0 *1 861.84,1643.04
X$5239 31035 31026 31054 30982 30970 30891 gf180mcu_fd_sc_mcu9t5v0__xor3_1
* cell instance $5240 m0 *1 856.8,1632.96
X$5240 29334 30767 30837 30836 gf180mcu_fd_sc_mcu9t5v0__clkinv_1
* cell instance $5241 r0 *1 880.32,1602.72
X$5241 29334 30487 30489 30419 30486 gf180mcu_fd_sc_mcu9t5v0__nand2_1
* cell instance $5242 m0 *1 858.48,1643.04
X$5242 30836 30970 30912 30982 30892 gf180mcu_fd_sc_mcu9t5v0__nand2_1
* cell instance $5243 r0 *1 873.6,1602.72
X$5243 30485 30486 30489 30419 27947 gf180mcu_fd_sc_mcu9t5v0__xnor2_1
* cell instance $5244 r0 *1 890.4,1592.64
X$5244 30281 30297 30361 30295 30346 gf180mcu_fd_sc_mcu9t5v0__and2_1
* cell instance $5245 r0 *1 887.6,1592.64
X$5245 30296 29693 30361 30295 31515 gf180mcu_fd_sc_mcu9t5v0__nand2_1
* cell instance $5246 r0 *1 884.24,1612.8
X$5246 30487 30485 30620 30634 30570 30621 gf180mcu_fd_sc_mcu9t5v0__nand3_1
* cell instance $5247 r0 *1 890.96,1643.04
X$5247 23621 30281 31054 30982 31052 gf180mcu_fd_sc_mcu9t5v0__nand2_1
* cell instance $5248 r0 *1 884.24,1643.04
X$5248 31037 31054 30982 31027 30917 gf180mcu_fd_sc_mcu9t5v0__xor2_1
* cell instance $5249 m0 *1 890.4,1612.8
X$5249 30516 30621 30489 30570 30753 gf180mcu_fd_sc_mcu9t5v0__nand2_1
* cell instance $5250 r0 *1 881.44,1643.04
X$5250 31037 31027 31054 30982 31051 gf180mcu_fd_sc_mcu9t5v0__nand2_1
* cell instance $5251 m0 *1 877.52,1612.8
X$5251 30487 30485 30489 30570 30515 gf180mcu_fd_sc_mcu9t5v0__nand2_1
* cell instance $5252 r0 *1 856.24,1632.96
X$5252 30836 30891 30892 26287 30912 30837 25831
+ gf180mcu_fd_sc_mcu9t5v0__oai211_1
* cell instance $5253 m0 *1 881.44,1643.04
X$5253 30917 30915 30912 30982 30914 gf180mcu_fd_sc_mcu9t5v0__xnor2_1
* cell instance $5254 r0 *1 875.28,1632.96
X$5254 29334 30914 30912 30837 30818 gf180mcu_fd_sc_mcu9t5v0__nand2_1
* cell instance $5255 m0 *1 870.24,1632.96
X$5255 29334 31027 30818 26287 30767 30837 24525
+ gf180mcu_fd_sc_mcu9t5v0__oai211_1
* cell instance $5256 r0 *1 894.88,1612.8
X$5256 30646 30632 30634 30570 30516 gf180mcu_fd_sc_mcu9t5v0__nand2_1
* cell instance $5257 r0 *1 888.72,1632.96
X$5257 30910 30645 30912 30837 30909 gf180mcu_fd_sc_mcu9t5v0__nand2_1
* cell instance $5258 r0 *1 842.24,1612.8
X$5258 30570 30634 gf180mcu_fd_sc_mcu9t5v0__endcap
* cell instance $5259 m0 *1 842.24,1612.8
X$5259 30570 30489 gf180mcu_fd_sc_mcu9t5v0__endcap
* cell instance $5260 m0 *1 869.68,1653.12
X$5260 31035 30970 31054 31118 31101 gf180mcu_fd_sc_mcu9t5v0__nor2_1
* cell instance $5261 r0 *1 853.44,1632.96
X$5261 29334 30908 30912 30837 30817 gf180mcu_fd_sc_mcu9t5v0__nand2_1
* cell instance $5262 r0 *1 842.24,1592.64
X$5262 30295 30361 gf180mcu_fd_sc_mcu9t5v0__endcap
* cell instance $5263 m0 *1 842.24,1602.72
X$5263 30419 30361 gf180mcu_fd_sc_mcu9t5v0__endcap
* cell instance $5264 r0 *1 842.24,1602.72
X$5264 30419 30489 gf180mcu_fd_sc_mcu9t5v0__endcap
* cell instance $5265 r0 *1 887.6,1622.88
X$5265 30753 30819 30767 30705 30752 gf180mcu_fd_sc_mcu9t5v0__xnor2_1
* cell instance $5266 r0 *1 873.04,1622.88
X$5266 29334 30752 30767 30705 30704 gf180mcu_fd_sc_mcu9t5v0__nand2_1
* cell instance $5267 m0 *1 868,1622.88
X$5267 29334 30645 30704 26287 30634 30705 25128
+ gf180mcu_fd_sc_mcu9t5v0__oai211_1
* cell instance $5268 r0 *1 842.24,1622.88
X$5268 30705 30767 gf180mcu_fd_sc_mcu9t5v0__endcap
* cell instance $5269 m0 *1 842.24,1622.88
X$5269 30705 30634 gf180mcu_fd_sc_mcu9t5v0__endcap
* cell instance $5270 r0 *1 842.24,1643.04
X$5270 30982 31054 gf180mcu_fd_sc_mcu9t5v0__endcap
* cell instance $5271 m0 *1 842.24,1653.12
X$5271 31118 31054 gf180mcu_fd_sc_mcu9t5v0__endcap
* cell instance $5272 m0 *1 842.24,1632.96
X$5272 30837 30767 gf180mcu_fd_sc_mcu9t5v0__endcap
* cell instance $5273 r0 *1 842.24,1632.96
X$5273 30837 30912 gf180mcu_fd_sc_mcu9t5v0__endcap
* cell instance $5274 m0 *1 842.24,1643.04
X$5274 30982 30912 gf180mcu_fd_sc_mcu9t5v0__endcap
* cell instance $5275 m0 *1 890.4,1632.96
X$5275 30753 30819 30767 30837 30893 gf180mcu_fd_sc_mcu9t5v0__nand2_1
* cell instance $5276 m0 *1 865.2,1653.12
X$5276 31026 31100 31101 31054 31118 31123 gf180mcu_fd_sc_mcu9t5v0__aoi21_1
* cell instance $5277 m0 *1 868,1612.8
X$5277 29334 30632 30514 26287 30489 30570 26457
+ gf180mcu_fd_sc_mcu9t5v0__oai211_1
* cell instance $5278 r0 *1 875.84,1612.8
X$5278 30515 30634 30570 30620 30619 gf180mcu_fd_sc_mcu9t5v0__xor2_1
* cell instance $5279 r0 *1 885.92,1632.96
X$5279 30909 30893 30912 30837 30915 gf180mcu_fd_sc_mcu9t5v0__nand2_1
* cell instance $5280 m0 *1 888.16,1643.04
X$5280 30917 30915 30912 30982 31036 gf180mcu_fd_sc_mcu9t5v0__nand2_1
* cell instance $5281 r0 *1 878.64,1643.04
X$5281 31051 31036 31054 30982 31026 gf180mcu_fd_sc_mcu9t5v0__nand2_1
* cell instance $5282 m0 *1 862.4,1653.12
X$5282 31035 30970 31054 31118 31100 gf180mcu_fd_sc_mcu9t5v0__nand2_1
* cell instance $5283 m0 *1 850.64,1643.04
X$5283 29334 30969 30912 30982 30890 gf180mcu_fd_sc_mcu9t5v0__nand2_1
* cell instance $5284 r0 *1 847.84,1632.96
X$5284 29334 30889 30890 26287 30912 30837 25266
+ gf180mcu_fd_sc_mcu9t5v0__oai211_1
* cell instance $5285 r0 *1 888.16,1612.8
X$5285 30646 30634 30570 30632 30620 gf180mcu_fd_sc_mcu9t5v0__xor2_1
* cell instance $5286 m0 *1 849.52,1632.96
X$5286 29334 30816 30817 26287 30767 30837 24950
+ gf180mcu_fd_sc_mcu9t5v0__oai211_1
* cell instance $5287 m0 *1 873.6,1612.8
X$5287 29334 30619 30489 30570 30514 gf180mcu_fd_sc_mcu9t5v0__nand2_1
* cell instance $5288 r0 *1 855.12,1542.24
X$5288 29334 26288 29714 29636 29712 gf180mcu_fd_sc_mcu9t5v0__xnor2_1
* cell instance $5289 r0 *1 877.52,1552.32
X$5289 27984 28662 29841 29769 29692 gf180mcu_fd_sc_mcu9t5v0__nand2_1
* cell instance $5290 m0 *1 864.64,1552.32
X$5290 29334 26296 29714 29769 29768 gf180mcu_fd_sc_mcu9t5v0__nand2_1
* cell instance $5291 r0 *1 866.88,1552.32
X$5291 29713 29712 29768 29841 29769 30024 gf180mcu_fd_sc_mcu9t5v0__oai21_1
* cell instance $5292 m0 *1 848.96,1532.16
X$5292 27253 27074 29408 29482 26296 gf180mcu_fd_sc_mcu9t5v0__nor2_1
* cell instance $5293 m0 *1 862.96,1532.16
X$5293 28500 29460 29126 18834 29408 29482 gf180mcu_fd_sc_mcu9t5v0__dffrnq_2
* cell instance $5294 r0 *1 884.24,1522.08
X$5294 29126 29168 29408 29335 29538 29063 gf180mcu_fd_sc_mcu9t5v0__xnor3_1
* cell instance $5295 r0 *1 885.92,1532.16
X$5295 29063 29538 29352 29559 29482 29461 gf180mcu_fd_sc_mcu9t5v0__mux2_1
* cell instance $5296 r0 *1 875.84,1522.08
X$5296 29126 29408 29335 29352 29460 gf180mcu_fd_sc_mcu9t5v0__xor2_1
* cell instance $5297 m0 *1 871.36,1552.32
X$5297 28500 29755 27984 18834 29714 29769 gf180mcu_fd_sc_mcu9t5v0__dffrnq_2
* cell instance $5298 r0 *1 852.32,1552.32
X$5298 19402 29841 29769 28500 gf180mcu_fd_sc_mcu9t5v0__clkbuf_8
* cell instance $5299 m0 *1 856.24,1542.24
X$5299 29623 26287 29559 29636 29821 gf180mcu_fd_sc_mcu9t5v0__nor2_1
* cell instance $5300 r0 *1 894.88,1552.32
X$5300 29822 23621 29841 29769 29838 gf180mcu_fd_sc_mcu9t5v0__nand2_1
* cell instance $5301 m0 *1 868.56,1552.32
X$5301 27253 28872 29714 29769 29713 gf180mcu_fd_sc_mcu9t5v0__nand2_1
* cell instance $5302 m0 *1 853.44,1542.24
X$5302 29623 26296 29559 29636 29622 gf180mcu_fd_sc_mcu9t5v0__nand2_1
* cell instance $5303 m0 *1 842.24,1562.4
X$5303 29903 29841 gf180mcu_fd_sc_mcu9t5v0__endcap
* cell instance $5304 r0 *1 842.24,1562.4
X$5304 29903 29973 gf180mcu_fd_sc_mcu9t5v0__endcap
* cell instance $5305 r0 *1 875.28,1542.24
X$5305 29713 29691 29692 29714 29636 29755 gf180mcu_fd_sc_mcu9t5v0__oai21_1
* cell instance $5306 m0 *1 842.24,1582.56
X$5306 30159 30106 gf180mcu_fd_sc_mcu9t5v0__endcap
* cell instance $5307 r0 *1 842.24,1522.08
X$5307 29335 29408 gf180mcu_fd_sc_mcu9t5v0__endcap
* cell instance $5308 m0 *1 890.96,1582.56
X$5308 30296 28506 30106 30159 30147 gf180mcu_fd_sc_mcu9t5v0__nor2_1
* cell instance $5309 m0 *1 842.24,1532.16
X$5309 29482 29408 gf180mcu_fd_sc_mcu9t5v0__endcap
* cell instance $5310 r0 *1 842.24,1532.16
X$5310 29482 29559 gf180mcu_fd_sc_mcu9t5v0__endcap
* cell instance $5311 m0 *1 842.24,1542.24
X$5311 29636 29559 gf180mcu_fd_sc_mcu9t5v0__endcap
* cell instance $5312 r0 *1 842.24,1542.24
X$5312 29636 29714 gf180mcu_fd_sc_mcu9t5v0__endcap
* cell instance $5313 r0 *1 842.24,1582.56
X$5313 30159 30231 gf180mcu_fd_sc_mcu9t5v0__endcap
* cell instance $5314 r0 *1 874.16,1572.48
X$5314 25838 30086 30087 30106 30039 28209 gf180mcu_fd_sc_mcu9t5v0__aoi21_1
* cell instance $5315 m0 *1 876.4,1582.56
X$5315 30086 30158 30106 30159 27779 gf180mcu_fd_sc_mcu9t5v0__or2_1
* cell instance $5316 m0 *1 842.24,1572.48
X$5316 30039 29973 gf180mcu_fd_sc_mcu9t5v0__endcap
* cell instance $5317 r0 *1 842.24,1572.48
X$5317 30039 30106 gf180mcu_fd_sc_mcu9t5v0__endcap
* cell instance $5318 m0 *1 859.04,1572.48
X$5318 28500 30024 29334 18834 29973 30039 gf180mcu_fd_sc_mcu9t5v0__dffrnq_2
* cell instance $5319 r0 *1 878.64,1572.48
X$5319 25838 30086 27667 30088 30106 30039 30916
+ gf180mcu_fd_sc_mcu9t5v0__nand4_1
* cell instance $5320 r0 *1 850.64,1542.24
X$5320 29623 26287 29714 29636 26288 gf180mcu_fd_sc_mcu9t5v0__and2_1
* cell instance $5321 m0 *1 842.24,1552.32
X$5321 29769 29714 gf180mcu_fd_sc_mcu9t5v0__endcap
* cell instance $5322 r0 *1 842.24,1552.32
X$5322 29769 29841 gf180mcu_fd_sc_mcu9t5v0__endcap
* cell instance $5323 r0 *1 888.72,1552.32
X$5323 28917 29838 29841 29769 29839 gf180mcu_fd_sc_mcu9t5v0__nand2_1
* cell instance $5324 r0 *1 846.16,1522.08
X$5324 28500 29333 27810 18834 29408 29335 gf180mcu_fd_sc_mcu9t5v0__dffrnq_2
* cell instance $5325 m0 *1 887.04,1562.4
X$5325 29691 29839 29841 29903 29904 gf180mcu_fd_sc_mcu9t5v0__and2_1
* cell instance $5326 m0 *1 852.32,1562.4
X$5326 28500 29841 29903 gf180mcu_fd_sc_mcu9t5v0__inv_8
* cell instance $5327 r0 *1 881.44,1542.24
X$5327 26296 28872 29714 29636 29693 gf180mcu_fd_sc_mcu9t5v0__nor2_1
* cell instance $5328 m0 *1 845.6,1552.32
X$5328 28500 29754 29623 18834 29714 29769 gf180mcu_fd_sc_mcu9t5v0__dffrnq_2
* cell instance $5329 r0 *1 846.72,1552.32
X$5329 26288 29713 29821 29622 29841 29769 29754
+ gf180mcu_fd_sc_mcu9t5v0__oai31_1
* cell instance $5330 r0 *1 883.68,1572.48
X$5330 30087 30106 30039 30088 gf180mcu_fd_sc_mcu9t5v0__clkinv_1
* cell instance $5331 m0 *1 878.08,1572.48
X$5331 25838 27667 29973 30039 28506 gf180mcu_fd_sc_mcu9t5v0__nand2_1
* cell instance $5332 r0 *1 958.72,1542.24
X$5332 29464 29695 29714 29636 29637 gf180mcu_fd_sc_mcu9t5v0__nor2_1
* cell instance $5333 r0 *1 957.6,1552.32
X$5333 29842 29148 29911 29841 29769 29912 gf180mcu_fd_sc_mcu9t5v0__aoi21_1
* cell instance $5334 m0 *1 941.92,1532.16
X$5334 29147 27815 29483 29408 29482 29463 gf180mcu_fd_sc_mcu9t5v0__and3_1
* cell instance $5335 r0 *1 962.08,1572.48
X$5335 30039 30106 gf180mcu_fd_sc_mcu9t5v0__filltie
* cell instance $5336 r0 *1 962.08,1532.16
X$5336 29482 29559 gf180mcu_fd_sc_mcu9t5v0__filltie
* cell instance $5337 r0 *1 962.08,1582.56
X$5337 30159 30231 gf180mcu_fd_sc_mcu9t5v0__filltie
* cell instance $5338 m0 *1 934.64,1582.56
X$5338 27959 30091 29625 18834 30106 30159 gf180mcu_fd_sc_mcu9t5v0__dffrnq_2
* cell instance $5339 r0 *1 915.04,1572.48
X$5339 30105 24411 24115 30106 30039 30089 gf180mcu_fd_sc_mcu9t5v0__aoi21_1
* cell instance $5340 m0 *1 940.8,1542.24
X$5340 26040 29625 29624 29560 29559 29636 28666 gf180mcu_fd_sc_mcu9t5v0__nor4_1
* cell instance $5341 r0 *1 921.76,1552.32
X$5341 27519 29770 28773 18834 29841 29769 gf180mcu_fd_sc_mcu9t5v0__dffrnq_2
* cell instance $5342 r0 *1 937.44,1522.08
X$5342 26462 29286 29336 29337 29408 29335 29409
+ gf180mcu_fd_sc_mcu9t5v0__nand4_1
* cell instance $5343 m0 *1 935.2,1542.24
X$5343 29625 29624 29560 29409 29559 29636 29265 gf180mcu_fd_sc_mcu9t5v0__nor4_1
* cell instance $5344 m0 *1 899.92,1542.24
X$5344 27519 29540 29542 18834 29559 29636 gf180mcu_fd_sc_mcu9t5v0__dffrnq_2
* cell instance $5345 m0 *1 936.88,1562.4
X$5345 29410 29841 29903 29562 gf180mcu_fd_sc_mcu9t5v0__buf_8
* cell instance $5346 r0 *1 908.88,1562.4
X$5346 29905 29973 29903 18444 gf180mcu_fd_sc_mcu9t5v0__buf_8
* cell instance $5347 r0 *1 905.52,1552.32
X$5347 29840 29841 29769 18614 gf180mcu_fd_sc_mcu9t5v0__buf_8
* cell instance $5348 r0 *1 904.96,1532.16
X$5348 29168 29353 29558 29559 29482 29539 gf180mcu_fd_sc_mcu9t5v0__mux2_1
* cell instance $5349 m0 *1 906.08,1562.4
X$5349 27253 29822 29841 29903 29905 gf180mcu_fd_sc_mcu9t5v0__nand2_1
* cell instance $5350 r0 *1 905.52,1522.08
X$5350 29168 29353 29408 29335 29352 gf180mcu_fd_sc_mcu9t5v0__nand2_1
* cell instance $5351 r0 *1 912.24,1532.16
X$5351 29542 29168 29353 29559 29482 29541 gf180mcu_fd_sc_mcu9t5v0__nand3_1
* cell instance $5352 m0 *1 911.68,1532.16
X$5352 27519 29462 29354 18834 29408 29482 gf180mcu_fd_sc_mcu9t5v0__dffrnq_2
* cell instance $5353 r0 *1 918.96,1532.16
X$5353 29354 29559 29482 29542 29558 gf180mcu_fd_sc_mcu9t5v0__xor2_1
* cell instance $5354 r0 *1 959.28,1532.16
X$5354 25003 29463 29559 29482 29561 gf180mcu_fd_sc_mcu9t5v0__nand2_1
* cell instance $5355 r0 *1 902.16,1532.16
X$5355 29541 29539 29559 29482 29540 gf180mcu_fd_sc_mcu9t5v0__nand2_1
* cell instance $5356 r0 *1 901.04,1552.32
X$5356 27253 29822 29841 29769 29840 gf180mcu_fd_sc_mcu9t5v0__and2_1
* cell instance $5357 r0 *1 962.08,1542.24
X$5357 29636 29714 gf180mcu_fd_sc_mcu9t5v0__filltie
* cell instance $5358 m0 *1 930.72,1552.32
X$5358 18590 29694 28773 29714 29769 29756 gf180mcu_fd_sc_mcu9t5v0__aoi21_1
* cell instance $5359 m0 *1 938,1532.16
X$5359 29339 27815 29483 29408 29482 29410 gf180mcu_fd_sc_mcu9t5v0__nand3_1
* cell instance $5360 r0 *1 958.72,1572.48
X$5360 29464 30093 30106 30039 30094 gf180mcu_fd_sc_mcu9t5v0__nor2_1
* cell instance $5361 r0 *1 925.12,1522.08
X$5361 29354 29542 29408 29335 27630 gf180mcu_fd_sc_mcu9t5v0__nor2_2
* cell instance $5362 m0 *1 926.8,1552.32
X$5362 28992 29756 29714 29769 29770 gf180mcu_fd_sc_mcu9t5v0__nor2_1
* cell instance $5363 r0 *1 925.68,1532.16
X$5363 29354 29542 29559 29482 29483 gf180mcu_fd_sc_mcu9t5v0__nand2_1
* cell instance $5364 r0 *1 955.36,1562.4
X$5364 29464 29912 29973 29903 29892 gf180mcu_fd_sc_mcu9t5v0__nor2_1
* cell instance $5365 r0 *1 941.92,1572.48
X$5365 18590 30092 29625 30106 30039 30090 gf180mcu_fd_sc_mcu9t5v0__aoi21_1
* cell instance $5366 r0 *1 919.52,1572.48
X$5366 28500 30089 30040 18834 30106 30039 gf180mcu_fd_sc_mcu9t5v0__dffrnq_2
* cell instance $5367 r0 *1 938.56,1572.48
X$5367 28992 30090 30106 30039 30091 gf180mcu_fd_sc_mcu9t5v0__nor2_1
* cell instance $5368 r0 *1 962.08,1562.4
X$5368 29903 29973 gf180mcu_fd_sc_mcu9t5v0__filltie
* cell instance $5369 r0 *1 918.4,1522.08
X$5369 29354 29408 29335 29352 29462 gf180mcu_fd_sc_mcu9t5v0__xor2_1
* cell instance $5370 r0 *1 938,1562.4
X$5370 29338 29410 28990 29911 29905 29973 29903 29974
+ gf180mcu_fd_sc_mcu9t5v0__oai221_1
* cell instance $5371 r0 *1 962.08,1552.32
X$5371 29769 29841 gf180mcu_fd_sc_mcu9t5v0__filltie
* cell instance $5372 r0 *1 962.08,1522.08
X$5372 29335 29408 gf180mcu_fd_sc_mcu9t5v0__filltie
* cell instance $5373 m0 *1 876.96,1451.52
X$5373 25838 27780 27779 27807 27945 27950 gf180mcu_fd_sc_mcu9t5v0__and3_1
* cell instance $5374 m0 *1 888.16,1461.6
X$5374 28242 28103 28239 19910 gf180mcu_fd_sc_mcu9t5v0__buf_8
* cell instance $5375 m0 *1 849.52,1451.52
X$5375 27945 27807 gf180mcu_fd_sc_mcu9t5v0__filltie
* cell instance $5376 r0 *1 895.44,1451.52
X$5376 27985 28103 27945 16010 gf180mcu_fd_sc_mcu9t5v0__buf_8
* cell instance $5377 r0 *1 887.6,1471.68
X$5377 28638 28635 28530 27074 gf180mcu_fd_sc_mcu9t5v0__buf_8
* cell instance $5378 r0 *1 896.56,1421.28
X$5378 26298 27213 27078 25583 gf180mcu_fd_sc_mcu9t5v0__clkinv_1
* cell instance $5379 r0 *1 883.68,1491.84
X$5379 19402 28989 28937 27519 gf180mcu_fd_sc_mcu9t5v0__clkbuf_8
* cell instance $5380 m0 *1 894.32,1421.28
X$5380 27081 26942 27078 13214 gf180mcu_fd_sc_mcu9t5v0__buf_8
* cell instance $5381 r0 *1 893.76,1391.04
X$5381 26298 26299 26167 26331 26166 26038 gf180mcu_fd_sc_mcu9t5v0__aoi21_1
* cell instance $5382 m0 *1 895.44,1512
X$5382 29126 29063 29168 29146 29212 29125 gf180mcu_fd_sc_mcu9t5v0__nor3_1
* cell instance $5383 r0 *1 892.64,1501.92
X$5383 29043 29123 29146 29062 29122 gf180mcu_fd_sc_mcu9t5v0__xnor2_1
* cell instance $5384 m0 *1 883.68,1501.92
X$5384 27519 29122 29043 18834 28989 29062 gf180mcu_fd_sc_mcu9t5v0__dffrnq_2
* cell instance $5385 m0 *1 828.8,1451.52
X$5385 25160 27809 27811 18834 27945 27807 gf180mcu_fd_sc_mcu9t5v0__dffsnq_2
* cell instance $5386 m0 *1 880.88,1431.36
X$5386 27519 27370 26298 12383 27213 27367 gf180mcu_fd_sc_mcu9t5v0__dffrnq_2
* cell instance $5387 m0 *1 897.12,1441.44
X$5387 27489 27517 27666 27253 gf180mcu_fd_sc_mcu9t5v0__buf_8
* cell instance $5388 m0 *1 931.84,1451.52
X$5388 27815 26760 27807 27945 27951 gf180mcu_fd_sc_mcu9t5v0__nand2_1
* cell instance $5389 m0 *1 922.32,1451.52
X$5389 27489 27781 27807 27945 27815 gf180mcu_fd_sc_mcu9t5v0__nor2_1
* cell instance $5390 m0 *1 916.16,1451.52
X$5390 15739 27814 27807 27945 27952 gf180mcu_fd_sc_mcu9t5v0__nand2_1
* cell instance $5391 m0 *1 955.36,1451.52
X$5391 27816 27784 27807 27945 27953 gf180mcu_fd_sc_mcu9t5v0__nor2_1
* cell instance $5392 m0 *1 948.08,1451.52
X$5392 27953 27816 27951 27807 27945 27986 gf180mcu_fd_sc_mcu9t5v0__mux2_1
* cell instance $5393 m0 *1 854,1451.52
X$5393 27253 27950 27807 27945 27776 gf180mcu_fd_sc_mcu9t5v0__nand2_1
* cell instance $5394 r0 *1 889.28,1431.36
X$5394 24947 27517 27367 27489 gf180mcu_fd_sc_mcu9t5v0__buf_8
* cell instance $5395 m0 *1 850.64,1451.52
X$5395 27811 27982 27807 27945 27775 gf180mcu_fd_sc_mcu9t5v0__nor2_1
* cell instance $5396 m0 *1 911.12,1501.92
X$5396 29126 29043 29063 28989 29062 28873 gf180mcu_fd_sc_mcu9t5v0__nor3_1
* cell instance $5397 r0 *1 900.48,1481.76
X$5397 18614 22706 28874 28661 29044 gf180mcu_fd_sc_mcu9t5v0__nor2_1
* cell instance $5398 r0 *1 962.08,1491.84
X$5398 28937 28989 gf180mcu_fd_sc_mcu9t5v0__filltie
* cell instance $5399 m0 *1 935.76,1501.92
X$5399 28990 28989 29062 20996 gf180mcu_fd_sc_mcu9t5v0__buf_8
* cell instance $5400 m0 *1 927.36,1501.92
X$5400 28773 28989 29062 19736 gf180mcu_fd_sc_mcu9t5v0__clkinv_1
* cell instance $5401 r0 *1 942.48,1512
X$5401 29147 29285 29212 29339 gf180mcu_fd_sc_mcu9t5v0__buf_8
* cell instance $5402 r0 *1 924.56,1501.92
X$5402 27519 20825 29147 12383 29146 29062 gf180mcu_fd_sc_mcu9t5v0__dffrnq_2
* cell instance $5403 r0 *1 903.28,1501.92
X$5403 29126 29063 28992 27951 29146 29062 29124 gf180mcu_fd_sc_mcu9t5v0__and4_1
* cell instance $5404 r0 *1 899.36,1501.92
X$5404 29125 29124 29146 29062 29123 gf180mcu_fd_sc_mcu9t5v0__nor2_1
* cell instance $5405 m0 *1 904.96,1481.76
X$5405 24116 28352 28664 28635 28661 28638 gf180mcu_fd_sc_mcu9t5v0__nor3_1
* cell instance $5406 m0 *1 909.44,1481.76
X$5406 24116 28352 28664 28635 28661 23621 gf180mcu_fd_sc_mcu9t5v0__or3_1
* cell instance $5407 r0 *1 909.44,1481.76
X$5407 23154 28773 28874 28661 28772 gf180mcu_fd_sc_mcu9t5v0__nor2_1
* cell instance $5408 r0 *1 920.08,1491.84
X$5408 27630 28938 29265 28875 28989 28937 24411
+ gf180mcu_fd_sc_mcu9t5v0__nand4_1
* cell instance $5409 r0 *1 911.68,1491.84
X$5409 29126 27253 29043 27781 28989 28937 28938 gf180mcu_fd_sc_mcu9t5v0__nor4_1
* cell instance $5410 r0 *1 907.76,1461.6
X$5410 19735 28353 28352 28351 28378 28239 27985 gf180mcu_fd_sc_mcu9t5v0__nor4_1
* cell instance $5411 r0 *1 929.6,1471.68
X$5411 28531 28635 28530 4952 gf180mcu_fd_sc_mcu9t5v0__buf_8
* cell instance $5412 r0 *1 917.84,1481.76
X$5412 23154 28773 24116 28874 28661 28875 gf180mcu_fd_sc_mcu9t5v0__nor3_1
* cell instance $5413 m0 *1 915.6,1481.76
X$5413 24116 28666 28665 28635 28661 28351 gf180mcu_fd_sc_mcu9t5v0__nand3_1
* cell instance $5414 r0 *1 913.36,1461.6
X$5414 19735 28353 28352 28351 28378 28239 15739 gf180mcu_fd_sc_mcu9t5v0__or4_1
* cell instance $5415 r0 *1 925.12,1471.68
X$5415 27781 26947 28635 28530 28531 gf180mcu_fd_sc_mcu9t5v0__and2_1
* cell instance $5416 m0 *1 934.64,1471.68
X$5416 15013 28531 28378 28530 29064 gf180mcu_fd_sc_mcu9t5v0__nand2_1
* cell instance $5417 r0 *1 962.64,1451.52
X$5417 27783 27784 27987 28103 27945 27988 gf180mcu_fd_sc_mcu9t5v0__nand3_1
* cell instance $5418 r0 *1 931.28,1491.84
X$5418 27781 26947 28989 28937 28990 gf180mcu_fd_sc_mcu9t5v0__nand2_1
* cell instance $5419 r0 *1 932.96,1451.52
X$5419 27490 27986 27816 12383 28103 27945 gf180mcu_fd_sc_mcu9t5v0__dffrnq_2
* cell instance $5420 m0 *1 938,1461.6
X$5420 27490 28210 27784 12383 28103 28239 gf180mcu_fd_sc_mcu9t5v0__dffrnq_2
* cell instance $5421 m0 *1 910.56,1512
X$5421 28992 27951 29146 29212 29168 gf180mcu_fd_sc_mcu9t5v0__or2_1
* cell instance $5422 r0 *1 912.8,1481.76
X$5422 28873 28666 28665 28772 28874 28661 28664
+ gf180mcu_fd_sc_mcu9t5v0__nand4_1
* cell instance $5423 m0 *1 943.04,1481.76
X$5423 27490 28667 27782 28635 28661 gf180mcu_fd_sc_mcu9t5v0__dffq_2
* cell instance $5424 m0 *1 935.2,1491.84
X$5424 26040 28874 28937 26462 gf180mcu_fd_sc_mcu9t5v0__clkinv_1
* cell instance $5425 m0 *1 958.72,1471.68
X$5425 27987 22708 28507 28378 28530 28532 gf180mcu_fd_sc_mcu9t5v0__mux2_1
* cell instance $5426 m0 *1 957.04,1461.6
X$5426 28211 27784 27951 28103 28239 28210 gf180mcu_fd_sc_mcu9t5v0__mux2_1
* cell instance $5427 r0 *1 910.56,1512
X$5427 28992 27951 29285 29212 29353 gf180mcu_fd_sc_mcu9t5v0__nand2_1
* cell instance $5428 r0 *1 962.08,1481.76
X$5428 28661 28874 gf180mcu_fd_sc_mcu9t5v0__filltie
* cell instance $5429 m0 *1 913.36,1461.6
X$5429 27519 27952 27781 12383 28103 28239 gf180mcu_fd_sc_mcu9t5v0__dffrnq_2
* cell instance $5430 r0 *1 909.44,1501.92
X$5430 29126 29043 29063 29146 29062 28353 gf180mcu_fd_sc_mcu9t5v0__or3_1
* cell instance $5431 r0 *1 949.76,1501.92
X$5431 20996 26888 29146 29062 29148 gf180mcu_fd_sc_mcu9t5v0__nand2_1
* cell instance $5432 r0 *1 962.08,1501.92
X$5432 29062 29146 gf180mcu_fd_sc_mcu9t5v0__filltie
* cell instance $5433 r0 *1 962.08,1512
X$5433 29212 29285 gf180mcu_fd_sc_mcu9t5v0__filltie
* cell instance $5434 r0 *1 948.64,1491.84
X$5434 26947 26888 28989 28937 29464 gf180mcu_fd_sc_mcu9t5v0__nor2_1
* cell instance $5435 m0 *1 843.36,1512
X$5435 29167 29212 29146 29144 gf180mcu_fd_sc_mcu9t5v0__clkbuf_16
* cell instance $5436 r0 *1 851.76,1491.84
X$5436 28662 28870 28989 28937 28987 gf180mcu_fd_sc_mcu9t5v0__and2_1
* cell instance $5437 m0 *1 843.36,1501.92
X$5437 27519 29042 28770 18834 28989 29062 gf180mcu_fd_sc_mcu9t5v0__dffrnq_2
* cell instance $5438 r0 *1 858.48,1491.84
X$5438 28770 28870 28989 28937 28871 gf180mcu_fd_sc_mcu9t5v0__nor2_1
* cell instance $5439 r0 *1 873.6,1481.76
X$5439 27074 27950 28874 28661 28872 gf180mcu_fd_sc_mcu9t5v0__nor2_1
* cell instance $5440 r0 *1 863.52,1501.92
X$5440 29120 28988 29146 29062 29264 gf180mcu_fd_sc_mcu9t5v0__nand2_1
* cell instance $5441 r0 *1 860.72,1501.92
X$5441 28918 28987 29146 29062 29120 gf180mcu_fd_sc_mcu9t5v0__nand2_1
* cell instance $5442 r0 *1 879.2,1491.84
X$5442 27519 28989 28937 gf180mcu_fd_sc_mcu9t5v0__inv_3
* cell instance $5443 r0 *1 855.12,1501.92
X$5443 28770 28987 29146 29062 29145 gf180mcu_fd_sc_mcu9t5v0__nand2_1
* cell instance $5444 r0 *1 844.48,1471.68
X$5444 27950 26961 28637 28635 28530 28636 gf180mcu_fd_sc_mcu9t5v0__oai21_1
* cell instance $5445 r0 *1 857.92,1512
X$5445 27519 29264 28918 18834 29285 29212 gf180mcu_fd_sc_mcu9t5v0__dffrnq_2
* cell instance $5446 m0 *1 843.92,1481.76
X$5446 28345 28662 28635 28661 28637 gf180mcu_fd_sc_mcu9t5v0__nand2_1
* cell instance $5447 m0 *1 842.24,1491.84
X$5447 28937 28874 gf180mcu_fd_sc_mcu9t5v0__endcap
* cell instance $5448 r0 *1 832.16,1461.6
X$5448 27519 28240 27981 18834 28378 28239 gf180mcu_fd_sc_mcu9t5v0__dffrnq_2
* cell instance $5449 r0 *1 832.16,1451.52
X$5449 27253 27772 28103 27945 27949 gf180mcu_fd_sc_mcu9t5v0__nand2_1
* cell instance $5450 r0 *1 842.24,1481.76
X$5450 28661 28874 gf180mcu_fd_sc_mcu9t5v0__endcap
* cell instance $5451 r0 *1 869.12,1451.52
X$5451 27667 27079 28103 27945 27983 gf180mcu_fd_sc_mcu9t5v0__nand2_1
* cell instance $5452 m0 *1 865.76,1501.92
X$5452 28872 28871 28989 29062 29061 gf180mcu_fd_sc_mcu9t5v0__nand2_1
* cell instance $5453 m0 *1 878.64,1481.76
X$5453 27253 27950 27074 28635 28661 28662 gf180mcu_fd_sc_mcu9t5v0__aoi21_1
* cell instance $5454 m0 *1 866.88,1461.6
X$5454 27772 28209 27983 28103 28239 28207 gf180mcu_fd_sc_mcu9t5v0__nor3_1
* cell instance $5455 m0 *1 866.88,1491.84
X$5455 28918 28874 28937 28771 gf180mcu_fd_sc_mcu9t5v0__clkinv_1
* cell instance $5456 r0 *1 859.04,1481.76
X$5456 28771 28770 28874 28661 28769 gf180mcu_fd_sc_mcu9t5v0__nand2_1
* cell instance $5457 r0 *1 842.24,1491.84
X$5457 28937 28989 gf180mcu_fd_sc_mcu9t5v0__endcap
* cell instance $5458 r0 *1 854.56,1481.76
X$5458 28870 28769 28874 28661 28663 gf180mcu_fd_sc_mcu9t5v0__nor2_1
* cell instance $5459 r0 *1 883.12,1481.76
X$5459 28917 28874 28661 26961 gf180mcu_fd_sc_mcu9t5v0__buf_8
* cell instance $5460 r0 *1 842.24,1512
X$5460 29212 29285 gf180mcu_fd_sc_mcu9t5v0__endcap
* cell instance $5461 r0 *1 852.32,1501.92
X$5461 29145 29061 29146 29062 29042 gf180mcu_fd_sc_mcu9t5v0__nand2_1
* cell instance $5462 r0 *1 868.56,1481.76
X$5462 28771 28871 28874 28661 28242 gf180mcu_fd_sc_mcu9t5v0__nand2_1
* cell instance $5463 m0 *1 855.12,1461.6
X$5463 27812 28207 28208 28103 28239 28240 gf180mcu_fd_sc_mcu9t5v0__or3_1
* cell instance $5464 r0 *1 869.68,1501.92
X$5464 28918 28871 29146 29062 29121 gf180mcu_fd_sc_mcu9t5v0__nand2_1
* cell instance $5465 m0 *1 842.24,1501.92
X$5465 29062 28989 gf180mcu_fd_sc_mcu9t5v0__endcap
* cell instance $5466 r0 *1 842.24,1501.92
X$5466 29062 29146 gf180mcu_fd_sc_mcu9t5v0__endcap
* cell instance $5467 r0 *1 872.48,1501.92
X$5467 29121 29146 29062 28672 gf180mcu_fd_sc_mcu9t5v0__buf_8
* cell instance $5468 m0 *1 849.52,1481.76
X$5468 28661 28635 gf180mcu_fd_sc_mcu9t5v0__filltie
* cell instance $5469 m0 *1 861.28,1461.6
X$5469 27812 27778 28207 27982 28103 28239 28241
+ gf180mcu_fd_sc_mcu9t5v0__oai31_1
* cell instance $5470 m0 *1 874.72,1471.68
X$5470 27779 28506 28241 28378 28530 28382 gf180mcu_fd_sc_mcu9t5v0__oai21_1
* cell instance $5471 r0 *1 875.84,1451.52
X$5471 27981 27984 28103 27945 26759 gf180mcu_fd_sc_mcu9t5v0__nand2_1
* cell instance $5472 m0 *1 861.28,1491.84
X$5472 28918 28770 27253 28237 28874 28937 28917
+ gf180mcu_fd_sc_mcu9t5v0__nand4_1
* cell instance $5473 m0 *1 852.88,1481.76
X$5473 28663 28635 28661 19287 gf180mcu_fd_sc_mcu9t5v0__buf_8
* cell instance $5474 r0 *1 857.36,1461.6
X$5474 25836 28350 28378 28239 28208 gf180mcu_fd_sc_mcu9t5v0__nand2_1
* cell instance $5475 m0 *1 842.24,1512
X$5475 29212 29146 gf180mcu_fd_sc_mcu9t5v0__endcap
* cell instance $5476 r0 *1 850.64,1481.76
X$5476 27253 28237 28874 28661 28870 gf180mcu_fd_sc_mcu9t5v0__nand2_1
* cell instance $5477 r0 *1 859.04,1451.52
X$5477 27981 27778 28103 27945 28350 gf180mcu_fd_sc_mcu9t5v0__nand2_1
* cell instance $5478 m0 *1 872.48,1461.6
X$5478 27981 27984 28209 28103 28239 26515 gf180mcu_fd_sc_mcu9t5v0__nand3_1
* cell instance $5479 m0 *1 849.52,1471.68
X$5479 28530 28378 gf180mcu_fd_sc_mcu9t5v0__filltie
* cell instance $5480 m0 *1 877.52,1491.84
X$5480 28672 28874 28937 28919 gf180mcu_fd_sc_mcu9t5v0__clkinv_1
* cell instance $5481 m0 *1 871.92,1491.84
X$5481 19287 28919 28872 28874 28937 28988 gf180mcu_fd_sc_mcu9t5v0__oai21_1
* cell instance $5482 r0 *1 874.72,1461.6
X$5482 27519 28382 27982 18834 28378 28239 gf180mcu_fd_sc_mcu9t5v0__dffrnq_2
* cell instance $5483 r0 *1 848.96,1451.52
X$5483 27981 28103 27945 26335 gf180mcu_fd_sc_mcu9t5v0__clkinv_1
* cell instance $5484 m0 *1 849.52,1461.6
X$5484 28239 28103 gf180mcu_fd_sc_mcu9t5v0__filltie
* cell instance $5485 m0 *1 876.4,1431.36
X$5485 27253 27251 26296 27213 27367 27252 gf180mcu_fd_sc_mcu9t5v0__aoi21_1
* cell instance $5486 m0 *1 864.08,1431.36
X$5486 27772 26638 27221 27219 26336 27213 27367 27778
+ gf180mcu_fd_sc_mcu9t5v0__oai221_1
* cell instance $5487 m0 *1 870.8,1431.36
X$5487 27220 27219 27252 25583 27213 27367 27370
+ gf180mcu_fd_sc_mcu9t5v0__oai22_1
* cell instance $5488 m0 *1 865.76,1441.44
X$5488 26336 26638 27813 27517 27666 27777 gf180mcu_fd_sc_mcu9t5v0__nand3_1
* cell instance $5489 r0 *1 849.52,1441.44
X$5489 27776 26167 27807 27666 27812 gf180mcu_fd_sc_mcu9t5v0__nor2_1
* cell instance $5490 r0 *1 889.84,1391.04
X$5490 14189 26298 24579 26331 26166 26338 gf180mcu_fd_sc_mcu9t5v0__nand3_1
* cell instance $5491 m0 *1 877.52,1411.2
X$5491 26461 26632 26757 13895 gf180mcu_fd_sc_mcu9t5v0__buf_8
* cell instance $5492 r0 *1 847.84,1411.2
X$5492 25838 26636 26942 26757 26945 gf180mcu_fd_sc_mcu9t5v0__nand2_1
* cell instance $5493 r0 *1 871.36,1401.12
X$5493 25838 26295 26759 26632 26456 26337 gf180mcu_fd_sc_mcu9t5v0__nand3_1
* cell instance $5494 m0 *1 882.56,1391.04
X$5494 26296 26038 25874 25997 26166 26001 gf180mcu_fd_sc_mcu9t5v0__oai21_1
* cell instance $5495 m0 *1 869.68,1411.2
X$5495 26295 26759 27079 26632 26757 26638 gf180mcu_fd_sc_mcu9t5v0__nand3_1
* cell instance $5496 m0 *1 849.52,1401.12
X$5496 26456 26331 gf180mcu_fd_sc_mcu9t5v0__filltie
* cell instance $5497 r0 *1 862.96,1391.04
X$5497 26036 26294 26331 26166 26336 gf180mcu_fd_sc_mcu9t5v0__and2_1
* cell instance $5498 r0 *1 836.64,1441.44
X$5498 27772 27079 26758 27807 27666 27774 gf180mcu_fd_sc_mcu9t5v0__nand3_1
* cell instance $5499 r0 *1 889.28,1401.12
X$5499 26516 23621 26168 26632 26456 25999 gf180mcu_fd_sc_mcu9t5v0__nand3_1
* cell instance $5500 m0 *1 854,1421.28
X$5500 24411 26945 26942 27078 26167 gf180mcu_fd_sc_mcu9t5v0__nand2_1
* cell instance $5501 r0 *1 831.04,1441.44
X$5501 27251 27949 27773 27774 27807 27666 27809
+ gf180mcu_fd_sc_mcu9t5v0__oai211_1
* cell instance $5502 r0 *1 862.96,1411.2
X$5502 26298 27074 25999 26942 26757 25836 gf180mcu_fd_sc_mcu9t5v0__oai21_1
* cell instance $5503 r0 *1 868,1421.28
X$5503 26298 27220 27082 27213 27078 27221 gf180mcu_fd_sc_mcu9t5v0__nand3_1
* cell instance $5504 r0 *1 852.88,1441.44
X$5504 27812 27369 27777 27811 27807 27666 27773
+ gf180mcu_fd_sc_mcu9t5v0__oai31_1
* cell instance $5505 m0 *1 849.52,1441.44
X$5505 27666 27517 gf180mcu_fd_sc_mcu9t5v0__filltie
* cell instance $5506 r0 *1 836.64,1391.04
X$5506 25160 26035 25546 12383 26331 26166 gf180mcu_fd_sc_mcu9t5v0__dffrnq_2
* cell instance $5507 m0 *1 845.6,1421.28
X$5507 25838 26636 27251 26942 27078 27219 gf180mcu_fd_sc_mcu9t5v0__nand3_1
* cell instance $5508 m0 *1 842.8,1391.04
X$5508 25999 26036 25872 25997 26166 26035 gf180mcu_fd_sc_mcu9t5v0__aoi21_1
* cell instance $5509 m0 *1 849.52,1411.2
X$5509 26757 26632 gf180mcu_fd_sc_mcu9t5v0__filltie
* cell instance $5510 m0 *1 850.64,1421.28
X$5510 27081 27074 26942 27078 27080 gf180mcu_fd_sc_mcu9t5v0__nor2_1
* cell instance $5511 r0 *1 848.4,1421.28
X$5511 27216 26945 27213 27078 27079 gf180mcu_fd_sc_mcu9t5v0__nor2_1
* cell instance $5512 m0 *1 840,1421.28
X$5512 26944 26942 27078 26513 gf180mcu_fd_sc_mcu9t5v0__clkinv_1
* cell instance $5513 m0 *1 829.92,1411.2
X$5513 19402 26632 26757 25160 gf180mcu_fd_sc_mcu9t5v0__clkbuf_8
* cell instance $5514 r0 *1 839.44,1401.12
X$5514 25546 26513 25874 26632 26456 26637 gf180mcu_fd_sc_mcu9t5v0__nand3_1
* cell instance $5515 r0 *1 886.48,1431.36
X$5515 27253 25583 27517 27367 26516 gf180mcu_fd_sc_mcu9t5v0__nand2_1
* cell instance $5516 r0 *1 829.92,1411.2
X$5516 25160 26942 26757 gf180mcu_fd_sc_mcu9t5v0__inv_4
* cell instance $5517 r0 *1 843.36,1401.12
X$5517 24947 26632 26456 26459 gf180mcu_fd_sc_mcu9t5v0__buf_8
* cell instance $5518 r0 *1 837.76,1421.28
X$5518 26513 27218 27219 27213 27078 26943 gf180mcu_fd_sc_mcu9t5v0__oai21_1
* cell instance $5519 r0 *1 846.72,1441.44
X$5519 26335 27775 27807 27666 26334 gf180mcu_fd_sc_mcu9t5v0__nand2_1
* cell instance $5520 m0 *1 840,1401.12
X$5520 26459 24946 26334 26331 26456 26460 gf180mcu_fd_sc_mcu9t5v0__nand3_1
* cell instance $5521 m0 *1 844.48,1411.2
X$5521 26460 26637 26632 26757 26636 gf180mcu_fd_sc_mcu9t5v0__nor2_1
* cell instance $5522 r0 *1 881.44,1441.44
X$5522 26516 26759 27807 27666 27667 gf180mcu_fd_sc_mcu9t5v0__nor2_1
* cell instance $5523 r0 *1 886.48,1411.2
X$5523 26459 26942 26757 26461 gf180mcu_fd_sc_mcu9t5v0__inv_2
* cell instance $5524 m0 *1 864.08,1401.12
X$5524 26461 26298 26331 26456 26295 gf180mcu_fd_sc_mcu9t5v0__nor2_2
* cell instance $5525 r0 *1 867.44,1391.04
X$5525 26334 26295 26037 26331 26166 26039 gf180mcu_fd_sc_mcu9t5v0__nand3_1
* cell instance $5526 m0 *1 843.92,1401.12
X$5526 27810 25546 26335 26460 26331 26456 26458 gf180mcu_fd_sc_mcu9t5v0__nor4_1
* cell instance $5527 r0 *1 842.24,1421.28
X$5527 27080 27251 26296 27213 27078 27218 gf180mcu_fd_sc_mcu9t5v0__aoi21_1
* cell instance $5528 r0 *1 862.96,1421.28
X$5528 27216 27213 27078 27220 gf180mcu_fd_sc_mcu9t5v0__clkinv_1
* cell instance $5529 m0 *1 849.52,1421.28
X$5529 27078 26942 gf180mcu_fd_sc_mcu9t5v0__filltie
* cell instance $5530 r0 *1 871.92,1421.28
X$5530 13895 27772 27213 27078 27082 gf180mcu_fd_sc_mcu9t5v0__nor2_1
* cell instance $5531 r0 *1 875.28,1401.12
X$5531 26295 26515 26632 26456 26514 gf180mcu_fd_sc_mcu9t5v0__nand2_1
* cell instance $5532 r0 *1 868.56,1401.12
X$5532 26338 26514 26632 26456 26758 gf180mcu_fd_sc_mcu9t5v0__nand2_1
* cell instance $5533 m0 *1 871.36,1401.12
X$5533 26338 26337 26167 26331 26456 26297 gf180mcu_fd_sc_mcu9t5v0__aoi21_1
* cell instance $5534 r0 *1 870.8,1441.44
X$5534 27667 27779 27079 27807 27666 27813 gf180mcu_fd_sc_mcu9t5v0__nand3_1
* cell instance $5535 r0 *1 871.36,1391.04
X$5535 26296 26297 26331 26166 26294 gf180mcu_fd_sc_mcu9t5v0__nor2_1
* cell instance $5536 m0 *1 849.52,1391.04
X$5536 26166 25997 gf180mcu_fd_sc_mcu9t5v0__filltie
* cell instance $5537 r0 *1 878.08,1441.44
X$5537 26298 26759 27807 27666 27780 gf180mcu_fd_sc_mcu9t5v0__nor2_1
* cell instance $5538 m0 *1 855.12,1431.36
X$5538 25583 27216 27219 27213 27367 27369 gf180mcu_fd_sc_mcu9t5v0__nor3_1
* cell instance $5539 m0 *1 849.52,1431.36
X$5539 27367 27213 gf180mcu_fd_sc_mcu9t5v0__filltie
* cell instance $5540 m0 *1 894.32,1391.04
X$5540 26299 27082 25997 26166 26168 gf180mcu_fd_sc_mcu9t5v0__nand2_1
* cell instance $5541 r0 *1 927.92,1391.04
X$5541 25876 26171 26331 26166 26300 gf180mcu_fd_sc_mcu9t5v0__or2_1
* cell instance $5542 r0 *1 958.16,1441.44
X$5542 27784 27816 27807 27666 27631 gf180mcu_fd_sc_mcu9t5v0__xnor2_1
* cell instance $5543 m0 *1 927.36,1401.12
X$5543 26299 26340 26462 26171 26331 26456 26342
+ gf180mcu_fd_sc_mcu9t5v0__aoi211_4
* cell instance $5544 m0 *1 899.36,1401.12
X$5544 26462 26039 26331 26456 27081 gf180mcu_fd_sc_mcu9t5v0__nor2_1
* cell instance $5545 m0 *1 931.28,1391.04
X$5545 26341 17575 26040 25997 26166 25839 gf180mcu_fd_sc_mcu9t5v0__oai21_1
* cell instance $5546 r0 *1 934.08,1401.12
X$5546 26300 26632 26456 26639 gf180mcu_fd_sc_mcu9t5v0__clkinv_1
* cell instance $5547 r0 *1 938.56,1411.2
X$5547 26888 26887 26886 26942 26757 26948 gf180mcu_fd_sc_mcu9t5v0__nand3_1
* cell instance $5548 m0 *1 902.72,1401.12
X$5548 26339 26331 26456 14820 gf180mcu_fd_sc_mcu9t5v0__buf_8
* cell instance $5549 m0 *1 955.36,1401.12
X$5549 26640 23213 26331 26456 26463 gf180mcu_fd_sc_mcu9t5v0__nand2_1
* cell instance $5550 r0 *1 898.24,1391.04
X$5550 26298 26299 26331 26166 27251 gf180mcu_fd_sc_mcu9t5v0__nand2_1
* cell instance $5551 r0 *1 938.56,1421.28
X$5551 4952 27254 27213 27078 26887 gf180mcu_fd_sc_mcu9t5v0__nand2_1
* cell instance $5552 m0 *1 918.4,1391.04
X$5552 19000 25841 25997 26166 26169 gf180mcu_fd_sc_mcu9t5v0__nand2_1
* cell instance $5553 m0 *1 935.76,1391.04
X$5553 25877 25997 26166 26170 gf180mcu_fd_sc_mcu9t5v0__clkinv_1
* cell instance $5554 r0 *1 923.44,1391.04
X$5554 14189 26169 26170 26331 26166 26340 gf180mcu_fd_sc_mcu9t5v0__oai21_1
* cell instance $5555 r0 *1 934.08,1431.36
X$5555 27255 27517 27367 25877 gf180mcu_fd_sc_mcu9t5v0__buf_8
* cell instance $5556 r0 *1 916.16,1441.44
X$5556 27781 18593 27807 27666 27814 gf180mcu_fd_sc_mcu9t5v0__nand2_1
* cell instance $5557 r0 *1 918.96,1441.44
X$5557 27630 27781 27489 27807 27666 27255 gf180mcu_fd_sc_mcu9t5v0__nor3_4
* cell instance $5558 m0 *1 926.24,1441.44
X$5558 19000 27630 27517 27666 26341 gf180mcu_fd_sc_mcu9t5v0__nor2_1
* cell instance $5559 m0 *1 911.68,1441.44
X$5559 27781 27517 27666 19000 gf180mcu_fd_sc_mcu9t5v0__buf_8
* cell instance $5560 r0 *1 952,1441.44
X$5560 27782 27783 27784 27807 27666 27371 gf180mcu_fd_sc_mcu9t5v0__and3_2
* cell instance $5561 m0 *1 930.16,1411.2
X$5561 19000 26632 26757 18594 gf180mcu_fd_sc_mcu9t5v0__clkinv_1
* cell instance $5562 r0 *1 931.84,1411.2
X$5562 18594 26947 15739 26942 26757 26886 gf180mcu_fd_sc_mcu9t5v0__nand3_1
* cell instance $5563 r0 *1 943.6,1411.2
X$5563 19000 19406 26942 26757 26888 gf180mcu_fd_sc_mcu9t5v0__nand2_1
* cell instance $5564 r0 *1 917.84,1411.2
X$5564 25841 26942 26757 26885 gf180mcu_fd_sc_mcu9t5v0__clkinv_1
* cell instance $5565 m0 *1 946.4,1391.04
X$5565 23685 26002 26003 12383 25997 26166 gf180mcu_fd_sc_mcu9t5v0__dffrnq_2
* cell instance $5566 m0 *1 917.84,1421.28
X$5566 25841 27083 15739 26942 27078 26946 gf180mcu_fd_sc_mcu9t5v0__nand3_1
* cell instance $5567 r0 *1 924.56,1421.28
X$5567 19000 26760 27213 27078 27083 gf180mcu_fd_sc_mcu9t5v0__nand2_1
* cell instance $5568 m0 *1 934.64,1411.2
X$5568 26462 26639 26632 26757 26760 gf180mcu_fd_sc_mcu9t5v0__nor2_1
* cell instance $5569 r0 *1 905.52,1421.28
X$5569 27519 27222 25841 12383 27213 27078 gf180mcu_fd_sc_mcu9t5v0__dffrnq_2
* cell instance $5570 m0 *1 918.4,1431.36
X$5570 27254 26946 27213 27367 27222 gf180mcu_fd_sc_mcu9t5v0__nand2_1
* cell instance $5571 m0 *1 949.76,1401.12
X$5571 18614 23213 22450 26463 26331 26456 26464
+ gf180mcu_fd_sc_mcu9t5v0__oai31_1
* cell instance $5572 r0 *1 903.28,1391.04
X$5572 26462 26039 26331 26166 26339 gf180mcu_fd_sc_mcu9t5v0__or2_1
* cell instance $5573 m0 *1 922.32,1411.2
X$5573 25841 16658 19406 26947 26632 26757 26761
+ gf180mcu_fd_sc_mcu9t5v0__aoi211_1
* cell instance $5574 r0 *1 920.08,1411.2
X$5574 26885 26760 26761 26942 26757 18593 gf180mcu_fd_sc_mcu9t5v0__oai21_1
* cell instance $5575 m0 *1 921.2,1391.04
X$5575 14189 26169 17575 26039 25997 26166 26171
+ gf180mcu_fd_sc_mcu9t5v0__oai31_2
* cell instance $5576 m0 *1 963.2,1421.28
X$5576 26040 26639 26942 27078 26949 gf180mcu_fd_sc_mcu9t5v0__nand2_1
* cell instance $5577 m0 *1 936.88,1421.28
X$5577 25164 26948 26947 12383 26942 27078 gf180mcu_fd_sc_mcu9t5v0__dffrnq_2
* cell instance $5578 m0 *1 1033.76,1451.52
X$5578 27992 27957 27807 27945 27819 gf180mcu_fd_sc_mcu9t5v0__nand2_1
* cell instance $5579 m0 *1 998.48,1451.52
X$5579 27490 27817 27668 13331 27807 27945 gf180mcu_fd_sc_mcu9t5v0__dffrnq_2
* cell instance $5580 m0 *1 1028.72,1461.6
X$5580 27374 26342 27992 28103 28239 28639 gf180mcu_fd_sc_mcu9t5v0__and3_4
* cell instance $5581 r0 *1 1020.32,1441.44
X$5581 27490 27818 27374 13331 27807 27666 gf180mcu_fd_sc_mcu9t5v0__dffrnq_2
* cell instance $5582 m0 *1 980.56,1451.52
X$5582 27955 22708 27633 27807 27945 27956 gf180mcu_fd_sc_mcu9t5v0__mux2_1
* cell instance $5583 m0 *1 1027.04,1451.52
X$5583 27958 27957 27807 27945 27818 gf180mcu_fd_sc_mcu9t5v0__nand2_1
* cell instance $5584 r0 *1 1034.32,1471.68
X$5584 20537 28639 28635 28530 28356 gf180mcu_fd_sc_mcu9t5v0__nor2_1
* cell instance $5585 m0 *1 1030.4,1451.52
X$5585 27374 26342 27807 27945 27957 gf180mcu_fd_sc_mcu9t5v0__nand2_1
* cell instance $5586 m0 *1 967.12,1451.52
X$5586 27783 27784 27807 27945 28211 gf180mcu_fd_sc_mcu9t5v0__nor2_1
* cell instance $5587 r0 *1 1030.96,1501.92
X$5587 29127 28669 28921 26962 29146 29062 29067
+ gf180mcu_fd_sc_mcu9t5v0__oai31_1
* cell instance $5588 m0 *1 1034.88,1512
X$5588 29128 29067 29146 29212 29170 gf180mcu_fd_sc_mcu9t5v0__xnor2_1
* cell instance $5589 m0 *1 1032.64,1501.92
X$5589 29127 29047 28989 29062 29048 gf180mcu_fd_sc_mcu9t5v0__xnor2_1
* cell instance $5590 m0 *1 970.48,1451.52
X$5590 27955 27631 27807 27945 27989 gf180mcu_fd_sc_mcu9t5v0__nand2_1
* cell instance $5591 r0 *1 1031.52,1461.6
X$5591 28357 28387 28358 28378 28239 28386 gf180mcu_fd_sc_mcu9t5v0__aoi21_4
* cell instance $5592 m0 *1 1032.64,1431.36
X$5592 27258 26342 27213 27367 27493 gf180mcu_fd_sc_mcu9t5v0__nor2_1
* cell instance $5593 r0 *1 1022.56,1411.2
X$5593 25164 26646 26518 13331 26942 26757 gf180mcu_fd_sc_mcu9t5v0__dffrnq_2
* cell instance $5594 m0 *1 1022,1391.04
X$5594 25164 26008 26043 13331 25997 26166 gf180mcu_fd_sc_mcu9t5v0__dffrnq_2
* cell instance $5595 m0 *1 1028.16,1411.2
X$5595 25164 26765 26647 13331 26632 26757 gf180mcu_fd_sc_mcu9t5v0__dffrnq_2
* cell instance $5596 m0 *1 1035.44,1471.68
X$5596 28639 27109 28508 28378 28530 28533 gf180mcu_fd_sc_mcu9t5v0__oai21_4
* cell instance $5597 m0 *1 1089.2,1451.52
X$5597 27945 27807 gf180mcu_fd_sc_mcu9t5v0__filltie
* cell instance $5598 m0 *1 1086.4,1451.52
X$5598 18614 27960 27807 27945 27495 gf180mcu_fd_sc_mcu9t5v0__nand2_1
* cell instance $5599 m0 *1 1058.96,1451.52
X$5599 27959 27820 27821 13331 27807 27945 gf180mcu_fd_sc_mcu9t5v0__dffrnq_2
* cell instance $5600 r0 *1 1057.28,1461.6
X$5600 28358 28378 28239 28245 gf180mcu_fd_sc_mcu9t5v0__buf_8
* cell instance $5601 r0 *1 1084.16,1491.84
X$5601 18444 25006 28989 28937 28994 gf180mcu_fd_sc_mcu9t5v0__nand2_1
* cell instance $5602 m0 *1 1051.12,1471.68
X$5602 28508 28378 28530 28358 gf180mcu_fd_sc_mcu9t5v0__clkinv_1
* cell instance $5603 r0 *1 1074.64,1501.92
X$5603 27959 29068 29130 13331 29146 29062 gf180mcu_fd_sc_mcu9t5v0__dffrnq_2
* cell instance $5604 r0 *1 1091.44,1461.6
X$5604 28214 28378 28239 28106 28215 gf180mcu_fd_sc_mcu9t5v0__xor2_1
* cell instance $5605 m0 *1 1083.04,1501.92
X$5605 23615 29130 28672 28989 29062 29068 gf180mcu_fd_sc_mcu9t5v0__mux2_1
* cell instance $5606 m0 *1 1072.4,1512
X$5606 29129 29146 29212 29213 gf180mcu_fd_sc_mcu9t5v0__clkinv_1
* cell instance $5607 r0 *1 1071.28,1512
X$5607 29213 29149 29285 29212 29271 gf180mcu_fd_sc_mcu9t5v0__nand2_1
* cell instance $5608 m0 *1 1065.12,1461.6
X$5608 28671 28103 28239 28104 gf180mcu_fd_sc_mcu9t5v0__clkinv_1
* cell instance $5609 m0 *1 1097.04,1512
X$5609 28996 29130 29271 29146 29212 29171 gf180mcu_fd_sc_mcu9t5v0__nor3_1
* cell instance $5610 m0 *1 1081.92,1512
X$5610 29212 29146 gf180mcu_fd_sc_mcu9t5v0__filltie
* cell instance $5611 m0 *1 1039.92,1491.84
X$5611 28921 18444 28874 28937 28923 gf180mcu_fd_sc_mcu9t5v0__nor2_1
* cell instance $5612 m0 *1 1081.92,1501.92
X$5612 29062 28989 gf180mcu_fd_sc_mcu9t5v0__filltie
* cell instance $5613 r0 *1 1067.92,1512
X$5613 27995 29149 29285 29212 29270 gf180mcu_fd_sc_mcu9t5v0__nor2_1
* cell instance $5614 r0 *1 1058.96,1501.92
X$5614 20030 29129 28672 29146 29062 29151 gf180mcu_fd_sc_mcu9t5v0__mux2_1
* cell instance $5615 r0 *1 1039.92,1512
X$5615 28386 29285 29212 29288 gf180mcu_fd_sc_mcu9t5v0__buf_8
* cell instance $5616 m0 *1 1053.36,1512
X$5616 27959 29151 29129 12383 29146 29212 gf180mcu_fd_sc_mcu9t5v0__dffrnq_2
* cell instance $5617 m0 *1 1092.56,1512
X$5617 29130 29271 26962 29146 29212 29152 gf180mcu_fd_sc_mcu9t5v0__oai21_1
* cell instance $5618 m0 *1 1039.92,1461.6
X$5618 27374 26342 27992 28103 28239 28357 gf180mcu_fd_sc_mcu9t5v0__nand3_2
* cell instance $5619 m0 *1 1095.92,1461.6
X$5619 23966 28215 18614 28103 28239 28246 gf180mcu_fd_sc_mcu9t5v0__mux2_1
* cell instance $5620 r0 *1 1099.84,1461.6
X$5620 26004 28246 28359 28378 28239 28388 gf180mcu_fd_sc_mcu9t5v0__oai21_1
* cell instance $5621 r0 *1 1041.04,1471.68
X$5621 28533 28635 28530 30030 gf180mcu_fd_sc_mcu9t5v0__buf_8
* cell instance $5622 m0 *1 1079.68,1461.6
X$5622 26962 28212 28103 28239 28105 gf180mcu_fd_sc_mcu9t5v0__nand2_1
* cell instance $5623 m0 *1 1082.48,1461.6
X$5623 28213 28105 28103 28239 27960 gf180mcu_fd_sc_mcu9t5v0__xnor2_1
* cell instance $5624 m0 *1 1043.84,1491.84
X$5624 29272 28923 22889 28924 28874 28937 28940
+ gf180mcu_fd_sc_mcu9t5v0__oai31_1
* cell instance $5625 m0 *1 1052.8,1491.84
X$5625 28925 29272 28874 28937 28924 gf180mcu_fd_sc_mcu9t5v0__nand2_1
* cell instance $5626 r0 *1 1069.04,1451.52
X$5626 27995 27634 28103 27945 27993 gf180mcu_fd_sc_mcu9t5v0__nor2_1
* cell instance $5627 r0 *1 1062.32,1451.52
X$5627 28671 27993 28103 27945 27994 gf180mcu_fd_sc_mcu9t5v0__xnor2_1
* cell instance $5628 m0 *1 1089.2,1481.76
X$5628 28661 28635 gf180mcu_fd_sc_mcu9t5v0__filltie
* cell instance $5629 r0 *1 1095.92,1471.68
X$5629 22443 28214 26961 28635 28530 28641 gf180mcu_fd_sc_mcu9t5v0__mux2_1
* cell instance $5630 m0 *1 1089.2,1461.6
X$5630 28239 28103 gf180mcu_fd_sc_mcu9t5v0__filltie
* cell instance $5631 m0 *1 1081.92,1491.84
X$5631 28937 28874 gf180mcu_fd_sc_mcu9t5v0__filltie
* cell instance $5632 r0 *1 1057.28,1481.76
X$5632 27959 28670 28671 12383 28874 28661 gf180mcu_fd_sc_mcu9t5v0__dffrnq_2
* cell instance $5633 r0 *1 1075.2,1471.68
X$5633 27959 28640 28213 13331 28635 28530 gf180mcu_fd_sc_mcu9t5v0__dffrnq_2
* cell instance $5634 m0 *1 1060.64,1481.76
X$5634 20030 28671 26961 28635 28661 28670 gf180mcu_fd_sc_mcu9t5v0__mux2_1
* cell instance $5635 m0 *1 1079.68,1481.76
X$5635 23615 28213 26961 28635 28661 28640 gf180mcu_fd_sc_mcu9t5v0__mux2_1
* cell instance $5636 r0 *1 1040.48,1501.92
X$5636 18614 29048 29044 29272 29146 29062 29150
+ gf180mcu_fd_sc_mcu9t5v0__aoi211_1
* cell instance $5637 r0 *1 1096.48,1491.84
X$5637 22443 28996 28672 28989 28937 28995 gf180mcu_fd_sc_mcu9t5v0__mux2_1
* cell instance $5638 m0 *1 1057.84,1471.68
X$5638 28387 28378 28530 20719 gf180mcu_fd_sc_mcu9t5v0__buf_8
* cell instance $5639 m0 *1 1067.36,1461.6
X$5639 28104 27634 28103 28239 28212 gf180mcu_fd_sc_mcu9t5v0__nand2_1
* cell instance $5640 m0 *1 1089.2,1471.68
X$5640 28530 28378 gf180mcu_fd_sc_mcu9t5v0__filltie
* cell instance $5641 r0 *1 1044.96,1461.6
X$5641 20719 28357 28378 28239 28244 gf180mcu_fd_sc_mcu9t5v0__nand2_1
* cell instance $5642 m0 *1 1090.88,1461.6
X$5642 28214 28213 28212 28103 28239 27962 gf180mcu_fd_sc_mcu9t5v0__nor3_1
* cell instance $5643 r0 *1 1087.52,1451.52
X$5643 28213 28212 26962 28103 27945 28106 gf180mcu_fd_sc_mcu9t5v0__oai21_1
* cell instance $5644 r0 *1 1041.6,1451.52
X$5644 28244 28103 27945 17977 gf180mcu_fd_sc_mcu9t5v0__buf_8
* cell instance $5645 r0 *1 1047.2,1491.84
X$5645 27959 28940 28925 12383 28989 28937 gf180mcu_fd_sc_mcu9t5v0__dffrnq_2
* cell instance $5646 m0 *1 977.2,1491.84
X$5646 28920 29046 12383 28992 28874 28937 27633 gf180mcu_fd_sc_mcu9t5v0__and4_1
* cell instance $5647 r0 *1 991.2,1461.6
X$5647 27991 25003 28355 28378 28239 28384 gf180mcu_fd_sc_mcu9t5v0__mux2_1
* cell instance $5648 r0 *1 969.36,1461.6
X$5648 28239 28378 gf180mcu_fd_sc_mcu9t5v0__filltie
* cell instance $5649 r0 *1 969.36,1451.52
X$5649 27945 28103 gf180mcu_fd_sc_mcu9t5v0__filltie
* cell instance $5650 m0 *1 987.28,1491.84
X$5650 27490 28876 28921 12383 28874 28937 gf180mcu_fd_sc_mcu9t5v0__dffrnq_2
* cell instance $5651 m0 *1 1019.76,1491.84
X$5651 28921 26962 28874 28937 28939 gf180mcu_fd_sc_mcu9t5v0__nand2_1
* cell instance $5652 r0 *1 1004.64,1481.76
X$5652 27490 28668 28669 12383 28874 28661 gf180mcu_fd_sc_mcu9t5v0__dffrnq_2
* cell instance $5653 m0 *1 969.92,1512
X$5653 28993 28992 29266 29146 29212 29169 gf180mcu_fd_sc_mcu9t5v0__aoi21_1
* cell instance $5654 r0 *1 1029.84,1451.52
X$5654 27992 28103 27945 27958 gf180mcu_fd_sc_mcu9t5v0__clkinv_1
* cell instance $5655 m0 *1 1022.56,1491.84
X$5655 28922 23010 18444 28874 28937 29269 gf180mcu_fd_sc_mcu9t5v0__mux2_1
* cell instance $5656 r0 *1 978.88,1451.52
X$5656 27490 27956 27955 28103 27945 gf180mcu_fd_sc_mcu9t5v0__dffq_2
* cell instance $5657 r0 *1 1022,1461.6
X$5657 28356 28378 28239 28385 gf180mcu_fd_sc_mcu9t5v0__clkinv_1
* cell instance $5658 m0 *1 1014.72,1471.68
X$5658 27490 28385 27992 12383 28378 28530 gf180mcu_fd_sc_mcu9t5v0__dffrnq_2
* cell instance $5659 m0 *1 976.64,1461.6
X$5659 28354 28211 28103 28239 27990 gf180mcu_fd_sc_mcu9t5v0__nand2_1
* cell instance $5660 r0 *1 1023.12,1491.84
X$5660 28669 28989 28937 28939 28922 gf180mcu_fd_sc_mcu9t5v0__xor2_1
* cell instance $5661 m0 *1 988.96,1471.68
X$5661 27490 28384 27991 28378 28530 gf180mcu_fd_sc_mcu9t5v0__dffq_2
* cell instance $5662 r0 *1 971.04,1471.68
X$5662 27490 28383 28354 28635 28530 gf180mcu_fd_sc_mcu9t5v0__dffq_2
* cell instance $5663 r0 *1 967.68,1512
X$5663 29266 28992 29169 29285 29212 29287 gf180mcu_fd_sc_mcu9t5v0__aoi21_1
* cell instance $5664 r0 *1 997.36,1501.92
X$5664 27490 29065 29127 12383 29146 29062 gf180mcu_fd_sc_mcu9t5v0__dffrnq_2
* cell instance $5665 m0 *1 1008.56,1512
X$5665 27959 29066 29128 12383 29146 29212 gf180mcu_fd_sc_mcu9t5v0__dffrnq_2
* cell instance $5666 m0 *1 978.88,1471.68
X$5666 27490 28378 28530 gf180mcu_fd_sc_mcu9t5v0__clkbuf_4
* cell instance $5667 r0 *1 981.12,1512
X$5667 27490 29267 29268 12383 29285 29212 gf180mcu_fd_sc_mcu9t5v0__dffrnq_2
* cell instance $5668 m0 *1 988.4,1512
X$5668 18614 24533 29146 29212 29355 gf180mcu_fd_sc_mcu9t5v0__nor2_1
* cell instance $5669 r0 *1 1025.36,1501.92
X$5669 29128 29127 28669 28921 29146 29062 29149 gf180mcu_fd_sc_mcu9t5v0__nor4_1
* cell instance $5670 m0 *1 1009.12,1481.76
X$5670 22572 28669 28672 28635 28661 28668 gf180mcu_fd_sc_mcu9t5v0__mux2_1
* cell instance $5671 m0 *1 1011.36,1501.92
X$5671 20826 29128 28672 28989 29062 29066 gf180mcu_fd_sc_mcu9t5v0__mux2_1
* cell instance $5672 m0 *1 1009.12,1461.6
X$5672 28243 28103 28239 13475 gf180mcu_fd_sc_mcu9t5v0__buf_8
* cell instance $5673 r0 *1 977.2,1461.6
X$5673 28354 22708 28355 28378 28239 28383 gf180mcu_fd_sc_mcu9t5v0__mux2_1
* cell instance $5674 m0 *1 975.52,1501.92
X$5674 29266 28989 29062 29046 gf180mcu_fd_sc_mcu9t5v0__clkinv_1
* cell instance $5675 m0 *1 971.04,1501.92
X$5675 29046 28992 28993 28989 29062 29045 gf180mcu_fd_sc_mcu9t5v0__aoi21_1
* cell instance $5676 r0 *1 969.36,1491.84
X$5676 28993 28989 28937 28920 gf180mcu_fd_sc_mcu9t5v0__clkinv_1
* cell instance $5677 r0 *1 971.6,1491.84
X$5677 28920 29266 12383 28992 28989 28937 28507 gf180mcu_fd_sc_mcu9t5v0__and4_1
* cell instance $5678 r0 *1 977.76,1491.84
X$5678 28993 29046 12383 28992 28989 28937 28355 gf180mcu_fd_sc_mcu9t5v0__and4_1
* cell instance $5679 r0 *1 974.96,1451.52
X$5679 27989 27990 27988 28103 27945 25881 gf180mcu_fd_sc_mcu9t5v0__nand3_1
* cell instance $5680 m0 *1 978.88,1481.76
X$5680 19402 28635 28661 27490 gf180mcu_fd_sc_mcu9t5v0__clkbuf_8
* cell instance $5681 m0 *1 1000.16,1501.92
X$5681 21726 29127 28672 28989 29062 29065 gf180mcu_fd_sc_mcu9t5v0__mux2_1
* cell instance $5682 m0 *1 1028.16,1501.92
X$5682 28669 28921 26962 28989 29062 29047 gf180mcu_fd_sc_mcu9t5v0__oai21_1
* cell instance $5683 r0 *1 995.68,1451.52
X$5683 27991 28103 27945 27954 gf180mcu_fd_sc_mcu9t5v0__clkinv_1
* cell instance $5684 r0 *1 1001.84,1461.6
X$5684 30040 28347 28378 28239 28243 gf180mcu_fd_sc_mcu9t5v0__nand2_1
* cell instance $5685 r0 *1 969.36,1471.68
X$5685 28530 28635 gf180mcu_fd_sc_mcu9t5v0__filltie
* cell instance $5686 m0 *1 969.36,1481.76
X$5686 28661 28635 gf180mcu_fd_sc_mcu9t5v0__filltie
* cell instance $5687 r0 *1 990.64,1481.76
X$5687 22441 28921 28672 28874 28661 28876 gf180mcu_fd_sc_mcu9t5v0__mux2_1
* cell instance $5688 r0 *1 1024.8,1421.28
X$5688 27258 26949 27213 27078 27084 gf180mcu_fd_sc_mcu9t5v0__nand2_1
* cell instance $5689 m0 *1 1001.84,1411.2
X$5689 26641 26301 26962 26632 26757 26762 gf180mcu_fd_sc_mcu9t5v0__nand3_1
* cell instance $5690 r0 *1 1006.32,1411.2
X$5690 18614 26762 26942 26757 26642 gf180mcu_fd_sc_mcu9t5v0__nand2_1
* cell instance $5691 r0 *1 1009.68,1421.28
X$5691 26641 26301 26962 27213 27078 27223 gf180mcu_fd_sc_mcu9t5v0__oai21_1
* cell instance $5692 r0 *1 969.36,1391.04
X$5692 26166 26331 gf180mcu_fd_sc_mcu9t5v0__filltie
* cell instance $5693 r0 *1 969.36,1401.12
X$5693 26456 26632 gf180mcu_fd_sc_mcu9t5v0__filltie
* cell instance $5694 m0 *1 995.68,1431.36
X$5694 21726 27373 26961 27213 27367 27372 gf180mcu_fd_sc_mcu9t5v0__mux2_1
* cell instance $5695 m0 *1 1009.68,1431.36
X$5695 27373 27223 27213 27367 26042 gf180mcu_fd_sc_mcu9t5v0__xnor2_1
* cell instance $5696 m0 *1 1029.84,1431.36
X$5696 27374 26949 27213 27367 27259 gf180mcu_fd_sc_mcu9t5v0__nand2_1
* cell instance $5697 m0 *1 1027.6,1431.36
X$5697 27374 27213 27367 27258 gf180mcu_fd_sc_mcu9t5v0__clkinv_1
* cell instance $5698 m0 *1 980,1441.44
X$5698 27632 25003 27633 27517 27666 27491 gf180mcu_fd_sc_mcu9t5v0__mux2_1
* cell instance $5699 m0 *1 1004.08,1431.36
X$5699 27373 26641 26301 26962 27213 27367 27492
+ gf180mcu_fd_sc_mcu9t5v0__oai31_1
* cell instance $5700 m0 *1 983.36,1391.04
X$5700 25877 25881 25997 26166 13173 gf180mcu_fd_sc_mcu9t5v0__and2_1
* cell instance $5701 r0 *1 988.96,1431.36
X$5701 27490 27372 27373 13331 27517 27367 gf180mcu_fd_sc_mcu9t5v0__dffrnq_2
* cell instance $5702 m0 *1 967.68,1401.12
X$5702 18614 23213 23625 26465 26331 26456 26466
+ gf180mcu_fd_sc_mcu9t5v0__oai31_1
* cell instance $5703 r0 *1 969.36,1411.2
X$5703 26757 26942 gf180mcu_fd_sc_mcu9t5v0__filltie
* cell instance $5704 m0 *1 996.24,1391.04
X$5704 25164 26041 26005 13331 25997 26166 gf180mcu_fd_sc_mcu9t5v0__dffrnq_2
* cell instance $5705 r0 *1 969.36,1421.28
X$5705 27078 27213 gf180mcu_fd_sc_mcu9t5v0__filltie
* cell instance $5706 m0 *1 1023.68,1411.2
X$5706 26645 26004 26764 26632 26757 26765 gf180mcu_fd_sc_mcu9t5v0__aoi21_1
* cell instance $5707 m0 *1 994,1411.2
X$5707 22572 26641 26961 26632 26757 26889 gf180mcu_fd_sc_mcu9t5v0__mux2_1
* cell instance $5708 m0 *1 1015.28,1391.04
X$5708 18614 26042 25997 26166 26007 gf180mcu_fd_sc_mcu9t5v0__nand2_1
* cell instance $5709 r0 *1 995.12,1391.04
X$5709 26004 26302 26303 26331 26166 26041 gf180mcu_fd_sc_mcu9t5v0__oai21_1
* cell instance $5710 r0 *1 1012.48,1391.04
X$5710 18614 21587 26331 26166 26304 gf180mcu_fd_sc_mcu9t5v0__nor2_1
* cell instance $5711 m0 *1 1015.84,1411.2
X$5711 18614 26763 26304 26004 26632 26757 26764
+ gf180mcu_fd_sc_mcu9t5v0__aoi211_1
* cell instance $5712 m0 *1 1005.76,1411.2
X$5712 18614 22130 26643 26642 26632 26757 26644
+ gf180mcu_fd_sc_mcu9t5v0__oai22_1
* cell instance $5713 m0 *1 1010.24,1441.44
X$5713 27668 27373 26641 26301 27517 27666 27634 gf180mcu_fd_sc_mcu9t5v0__nor4_1
* cell instance $5714 r0 *1 1011.92,1431.36
X$5714 27668 27492 27517 27367 26763 gf180mcu_fd_sc_mcu9t5v0__xnor2_1
* cell instance $5715 r0 *1 987.28,1411.2
X$5715 25164 26889 26641 13331 26942 26757 gf180mcu_fd_sc_mcu9t5v0__dffrnq_2
* cell instance $5716 r0 *1 969.36,1431.36
X$5716 27367 27517 gf180mcu_fd_sc_mcu9t5v0__filltie
* cell instance $5717 r0 *1 969.36,1441.44
X$5717 27666 27807 gf180mcu_fd_sc_mcu9t5v0__filltie
* cell instance $5718 r0 *1 1006.32,1401.12
X$5718 26301 26962 26641 26632 26456 26643 gf180mcu_fd_sc_mcu9t5v0__aoi21_1
* cell instance $5719 r0 *1 978.88,1411.2
X$5719 22441 26301 26961 26942 26757 26950 gf180mcu_fd_sc_mcu9t5v0__mux2_1
* cell instance $5720 m0 *1 972.16,1421.28
X$5720 25164 26950 26301 13331 26942 27078 gf180mcu_fd_sc_mcu9t5v0__dffrnq_2
* cell instance $5721 r0 *1 970.48,1401.12
X$5721 25164 26466 26517 13331 26632 26456 gf180mcu_fd_sc_mcu9t5v0__dffrnq_2
* cell instance $5722 r0 *1 1026.48,1401.12
X$5722 26518 26644 24836 26632 26456 26646 gf180mcu_fd_sc_mcu9t5v0__mux2_1
* cell instance $5723 r0 *1 972.16,1431.36
X$5723 27490 27491 27632 27517 27367 gf180mcu_fd_sc_mcu9t5v0__dffq_2
* cell instance $5724 m0 *1 976.08,1401.12
X$5724 26517 23213 26331 26456 26465 gf180mcu_fd_sc_mcu9t5v0__nand2_1
* cell instance $5725 r0 *1 985.04,1391.04
X$5725 26301 18444 22581 26331 26166 26302 gf180mcu_fd_sc_mcu9t5v0__oai21_1
* cell instance $5726 r0 *1 1005.2,1441.44
X$5726 20826 27668 26961 27807 27666 27817 gf180mcu_fd_sc_mcu9t5v0__mux2_1
* cell instance $5727 r0 *1 1052.8,1411.2
X$5727 26648 26519 26942 26757 26890 gf180mcu_fd_sc_mcu9t5v0__nor2_1
* cell instance $5728 r0 *1 1056.16,1411.2
X$5728 26172 26942 26757 26890 26952 gf180mcu_fd_sc_mcu9t5v0__xor2_1
* cell instance $5729 r0 *1 1066.24,1421.28
X$5729 26053 26952 27213 27078 27226 gf180mcu_fd_sc_mcu9t5v0__nand2_1
* cell instance $5730 r0 *1 1060.64,1421.28
X$5730 26043 26053 18277 27226 27213 27078 27225
+ gf180mcu_fd_sc_mcu9t5v0__oai211_1
* cell instance $5731 m0 *1 1071.84,1431.36
X$5731 27259 27213 27367 12632 gf180mcu_fd_sc_mcu9t5v0__buf_8
* cell instance $5732 r0 *1 1039.36,1441.44
X$5732 27819 27807 27666 14872 gf180mcu_fd_sc_mcu9t5v0__buf_8
* cell instance $5733 r0 *1 1039.36,1431.36
X$5733 27493 27517 27367 13492 gf180mcu_fd_sc_mcu9t5v0__buf_8
* cell instance $5734 m0 *1 1089.2,1431.36
X$5734 27367 27213 gf180mcu_fd_sc_mcu9t5v0__filltie
* cell instance $5735 r0 *1 1075.2,1411.2
X$5735 26767 26891 26010 26942 26757 27086 gf180mcu_fd_sc_mcu9t5v0__aoi21_1
* cell instance $5736 r0 *1 1084.16,1401.12
X$5736 26647 25434 26632 26456 26520 gf180mcu_fd_sc_mcu9t5v0__nand2_1
* cell instance $5737 m0 *1 1053.36,1411.2
X$5737 26305 26306 26632 26757 26951 gf180mcu_fd_sc_mcu9t5v0__xnor2_1
* cell instance $5738 m0 *1 1054.48,1421.28
X$5738 26053 26951 26942 27078 27085 gf180mcu_fd_sc_mcu9t5v0__nand2_1
* cell instance $5739 m0 *1 1089.2,1391.04
X$5739 26166 25997 gf180mcu_fd_sc_mcu9t5v0__filltie
* cell instance $5740 r0 *1 1055.04,1421.28
X$5740 26518 26053 18277 27085 27213 27078 27224
+ gf180mcu_fd_sc_mcu9t5v0__oai211_1
* cell instance $5741 m0 *1 1043.28,1391.04
X$5741 26043 25844 25997 26166 26172 gf180mcu_fd_sc_mcu9t5v0__xnor2_1
* cell instance $5742 m0 *1 1047.76,1411.2
X$5742 26518 26632 26757 26766 gf180mcu_fd_sc_mcu9t5v0__clkinv_1
* cell instance $5743 r0 *1 1062.88,1441.44
X$5743 27225 27785 27807 27666 27820 gf180mcu_fd_sc_mcu9t5v0__nand2_1
* cell instance $5744 m0 *1 1051.12,1391.04
X$5744 26044 25882 26172 25997 26166 26045 gf180mcu_fd_sc_mcu9t5v0__aoi21_1
* cell instance $5745 m0 *1 1070.16,1411.2
X$5745 26647 26632 26757 26645 gf180mcu_fd_sc_mcu9t5v0__clkinv_1
* cell instance $5746 m0 *1 1097.04,1421.28
X$5746 26343 26953 27086 26942 27078 27088 gf180mcu_fd_sc_mcu9t5v0__or3_1
* cell instance $5747 r0 *1 1067.36,1441.44
X$5747 27821 23921 27807 27666 27785 gf180mcu_fd_sc_mcu9t5v0__nand2_1
* cell instance $5748 m0 *1 1066.24,1391.04
X$5748 26005 25884 26053 25997 26166 26174 gf180mcu_fd_sc_mcu9t5v0__mux2_1
* cell instance $5749 r0 *1 1086.96,1431.36
X$5749 18614 25131 27495 27517 27367 27494 gf180mcu_fd_sc_mcu9t5v0__oai21_1
* cell instance $5750 m0 *1 1050,1411.2
X$5750 26766 26640 26632 26757 26648 gf180mcu_fd_sc_mcu9t5v0__nor2_1
* cell instance $5751 m0 *1 1075.2,1411.2
X$5751 26647 26632 26757 25434 26010 gf180mcu_fd_sc_mcu9t5v0__xor2_1
* cell instance $5752 m0 *1 1058.4,1391.04
X$5752 26305 26009 25997 26166 25883 gf180mcu_fd_sc_mcu9t5v0__xnor2_1
* cell instance $5753 m0 *1 1089.2,1441.44
X$5753 27666 27517 gf180mcu_fd_sc_mcu9t5v0__filltie
* cell instance $5754 m0 *1 1077.44,1391.04
X$5754 26307 26045 26010 25997 26166 26175 gf180mcu_fd_sc_mcu9t5v0__oai21_1
* cell instance $5755 r0 *1 1097.6,1421.28
X$5755 26953 27086 26343 27213 27078 27227 gf180mcu_fd_sc_mcu9t5v0__oai21_1
* cell instance $5756 m0 *1 1089.2,1401.12
X$5756 26456 26331 gf180mcu_fd_sc_mcu9t5v0__filltie
* cell instance $5757 r0 *1 1096.48,1411.2
X$5757 26892 26517 26942 26757 26343 gf180mcu_fd_sc_mcu9t5v0__xnor2_1
* cell instance $5758 r0 *1 1092,1401.12
X$5758 26520 26175 26343 26632 26456 26344 gf180mcu_fd_sc_mcu9t5v0__aoi21_1
* cell instance $5759 r0 *1 1044.4,1401.12
X$5759 26518 26640 26632 26456 26044 gf180mcu_fd_sc_mcu9t5v0__nand2_1
* cell instance $5760 m0 *1 1063.44,1441.44
X$5760 24238 27994 18614 27517 27666 27635 gf180mcu_fd_sc_mcu9t5v0__mux2_1
* cell instance $5761 m0 *1 1090.88,1441.44
X$5761 26892 26004 27517 27666 27637 gf180mcu_fd_sc_mcu9t5v0__nand2_1
* cell instance $5762 m0 *1 1082.48,1441.44
X$5762 26004 27635 27637 27517 27666 27636 gf180mcu_fd_sc_mcu9t5v0__oai21_1
* cell instance $5763 r0 *1 1083.04,1441.44
X$5763 27959 27636 26892 13331 27807 27666 gf180mcu_fd_sc_mcu9t5v0__dffrnq_2
* cell instance $5764 m0 *1 1055.6,1391.04
X$5764 25842 25997 26166 26173 gf180mcu_fd_sc_mcu9t5v0__clkinv_1
* cell instance $5765 r0 *1 1054.48,1391.04
X$5765 26005 26173 26331 26166 26306 gf180mcu_fd_sc_mcu9t5v0__nor2_1
* cell instance $5766 m0 *1 1089.2,1411.2
X$5766 26757 26632 gf180mcu_fd_sc_mcu9t5v0__filltie
* cell instance $5767 r0 *1 1071.84,1391.04
X$5767 26043 25844 26331 26166 26307 gf180mcu_fd_sc_mcu9t5v0__and2_1
* cell instance $5768 m0 *1 1071.84,1401.12
X$5768 25844 26331 26456 26467 gf180mcu_fd_sc_mcu9t5v0__clkinv_1
* cell instance $5769 r0 *1 1055.04,1401.12
X$5769 26305 26306 26632 26456 26519 gf180mcu_fd_sc_mcu9t5v0__nor2_1
* cell instance $5770 m0 *1 1072.4,1411.2
X$5770 26043 26467 26632 26757 26767 gf180mcu_fd_sc_mcu9t5v0__nand2_1
* cell instance $5771 m0 *1 1089.2,1421.28
X$5771 27078 26942 gf180mcu_fd_sc_mcu9t5v0__filltie
* cell instance $5772 r0 *1 1047.2,1401.12
X$5772 26518 26632 26456 26640 26305 gf180mcu_fd_sc_mcu9t5v0__xor2_1
* cell instance $5773 m0 *1 1057.28,1421.28
X$5773 26648 26519 26172 26942 27078 26891 gf180mcu_fd_sc_mcu9t5v0__oai21_1
* cell instance $5774 r0 *1 1050.56,1391.04
X$5774 26005 25842 26305 26331 26166 25882 gf180mcu_fd_sc_mcu9t5v0__nand3_1
* cell instance $5775 r0 *1 1079.68,1411.2
X$5775 26010 26767 26891 26942 26757 26954 gf180mcu_fd_sc_mcu9t5v0__and3_1
* cell instance $5776 m0 *1 1078,1421.28
X$5776 26645 25434 26942 27078 26953 gf180mcu_fd_sc_mcu9t5v0__nor2_1
* cell instance $5777 r0 *1 1091.44,1411.2
X$5777 26647 25282 26942 26757 26955 gf180mcu_fd_sc_mcu9t5v0__nand2_1
* cell instance $5778 m0 *1 1091.44,1421.28
X$5778 25282 27086 26954 26955 26942 27078 27087
+ gf180mcu_fd_sc_mcu9t5v0__oai31_1
* cell instance $5779 m0 *1 1091.44,1401.12
X$5779 26343 26520 26175 26331 26456 26178 gf180mcu_fd_sc_mcu9t5v0__and3_1
* cell instance $5780 r0 *1 1090.32,1391.04
X$5780 26308 23921 26331 26166 26176 gf180mcu_fd_sc_mcu9t5v0__nand2_1
* cell instance $5781 m0 *1 1094.24,1391.04
X$5781 23921 26344 26178 26176 25997 26166 26177
+ gf180mcu_fd_sc_mcu9t5v0__oai31_1
* cell instance $5782 m0 *1 683.76,1421.28
X$5782 26328 27071 25118 11958 26942 27078 gf180mcu_fd_sc_mcu9t5v0__dffrnq_2
* cell instance $5783 m0 *1 682.64,1401.12
X$5783 26328 25995 24946 11958 26456 26331 gf180mcu_fd_sc_mcu9t5v0__dffsnq_2
* cell instance $5784 m0 *1 689.92,1431.36
X$5784 24568 27213 27367 25538 gf180mcu_fd_sc_mcu9t5v0__clkinv_1
* cell instance $5785 m0 *1 675.36,1471.68
X$5785 26328 28497 27366 18834 28378 28530 gf180mcu_fd_sc_mcu9t5v0__dffrnq_2
* cell instance $5786 r0 *1 674.24,1441.44
X$5786 26328 27660 25120 18834 27807 27666 gf180mcu_fd_sc_mcu9t5v0__dffrnq_2
* cell instance $5787 m0 *1 687.68,1481.76
X$5787 26627 28635 28661 29059 gf180mcu_fd_sc_mcu9t5v0__clkinv_4
* cell instance $5788 m0 *1 690.48,1441.44
X$5788 25118 27209 25120 27517 27666 27627 gf180mcu_fd_sc_mcu9t5v0__aoi21_1
* cell instance $5789 m0 *1 672,1461.6
X$5789 26328 28204 28102 18834 28103 28239 gf180mcu_fd_sc_mcu9t5v0__dffrnq_2
* cell instance $5790 m0 *1 614.32,1471.68
X$5790 22168 28496 24702 28378 28530 28495 gf180mcu_fd_sc_mcu9t5v0__mux2_1
* cell instance $5791 m0 *1 593.6,1451.52
X$5791 27625 27624 27623 27621 27807 27945 27513
+ gf180mcu_fd_sc_mcu9t5v0__nand4_1
* cell instance $5792 m0 *1 631.12,1451.52
X$5792 27801 27807 27945 29164 gf180mcu_fd_sc_mcu9t5v0__buf_8
* cell instance $5793 m0 *1 609.84,1451.52
X$5793 27945 27807 gf180mcu_fd_sc_mcu9t5v0__filltie
* cell instance $5794 r0 *1 605.92,1471.68
X$5794 27205 28495 28496 18834 28635 28530 gf180mcu_fd_sc_mcu9t5v0__dffrnq_2
* cell instance $5795 r0 *1 613.76,1441.44
X$5795 26328 27659 27626 18834 27807 27666 gf180mcu_fd_sc_mcu9t5v0__dffrnq_2
* cell instance $5796 m0 *1 614.88,1421.28
X$5796 26328 26935 26937 18834 26942 27078 gf180mcu_fd_sc_mcu9t5v0__dffrnq_2
* cell instance $5797 r0 *1 618.24,1421.28
X$5797 26936 27213 27078 24819 gf180mcu_fd_sc_mcu9t5v0__buf_8
* cell instance $5798 m0 *1 610.96,1401.12
X$5798 26328 26329 26282 18834 26331 26456 gf180mcu_fd_sc_mcu9t5v0__dffrnq_2
* cell instance $5799 r0 *1 621.04,1411.2
X$5799 26937 26875 26942 26757 26936 gf180mcu_fd_sc_mcu9t5v0__nand2_1
* cell instance $5800 m0 *1 616.56,1461.6
X$5800 28496 27625 24819 28103 28239 28236 gf180mcu_fd_sc_mcu9t5v0__mux2_1
* cell instance $5801 m0 *1 563.36,1451.52
X$5801 27205 27941 27622 18834 27807 27945 gf180mcu_fd_sc_mcu9t5v0__dffrnq_2
* cell instance $5802 m0 *1 618.24,1441.44
X$5802 22829 27626 24702 27517 27666 27659 gf180mcu_fd_sc_mcu9t5v0__mux2_1
* cell instance $5803 m0 *1 647.36,1451.52
X$5803 27515 27807 27945 25693 gf180mcu_fd_sc_mcu9t5v0__buf_8
* cell instance $5804 r0 *1 614.32,1461.6
X$5804 26328 28236 27625 18834 28378 28239 gf180mcu_fd_sc_mcu9t5v0__dffrnq_2
* cell instance $5805 r0 *1 646.8,1451.52
X$5805 24408 28103 27945 28101 gf180mcu_fd_sc_mcu9t5v0__clkinv_1
* cell instance $5806 r0 *1 637.28,1461.6
X$5806 28100 28378 28239 28374 gf180mcu_fd_sc_mcu9t5v0__buf_8
* cell instance $5807 m0 *1 627.76,1461.6
X$5807 25264 28103 28239 28202 gf180mcu_fd_sc_mcu9t5v0__clkinv_1
* cell instance $5808 m0 *1 651.84,1461.6
X$5808 25865 28103 28239 28203 gf180mcu_fd_sc_mcu9t5v0__clkinv_2
* cell instance $5809 m0 *1 642.32,1471.68
X$5809 18834 26751 28378 28530 28373 gf180mcu_fd_sc_mcu9t5v0__nand2_4
* cell instance $5810 r0 *1 631.12,1471.68
X$5810 28202 28635 28530 29060 gf180mcu_fd_sc_mcu9t5v0__buf_8
* cell instance $5811 r0 *1 631.68,1451.52
X$5811 24992 28103 27945 28100 gf180mcu_fd_sc_mcu9t5v0__clkinv_1
* cell instance $5812 r0 *1 654.08,1461.6
X$5812 28101 28378 28239 28375 gf180mcu_fd_sc_mcu9t5v0__buf_8
* cell instance $5813 r0 *1 660.24,1451.52
X$5813 27248 28103 27945 24702 gf180mcu_fd_sc_mcu9t5v0__buf_8
* cell instance $5814 r0 *1 652.96,1471.68
X$5814 28203 28635 28530 28633 gf180mcu_fd_sc_mcu9t5v0__buf_8
* cell instance $5815 r0 *1 669.76,1471.68
X$5815 18834 26751 28635 28530 28634 gf180mcu_fd_sc_mcu9t5v0__nand2_4
* cell instance $5816 r0 *1 587.44,1461.6
X$5816 27205 28235 27623 18834 28378 28239 gf180mcu_fd_sc_mcu9t5v0__dffrnq_2
* cell instance $5817 m0 *1 579.04,1471.68
X$5817 27205 28493 28494 18834 28378 28530 gf180mcu_fd_sc_mcu9t5v0__dffrnq_2
* cell instance $5818 r0 *1 587.44,1471.68
X$5818 22832 28494 24702 28635 28530 28493 gf180mcu_fd_sc_mcu9t5v0__mux2_1
* cell instance $5819 m0 *1 609.84,1461.6
X$5819 28239 28103 gf180mcu_fd_sc_mcu9t5v0__filltie
* cell instance $5820 m0 *1 560,1471.68
X$5820 27205 28492 26931 18834 28378 28530 gf180mcu_fd_sc_mcu9t5v0__dffrnq_2
* cell instance $5821 m0 *1 591.92,1461.6
X$5821 28494 27623 24819 28103 28239 28235 gf180mcu_fd_sc_mcu9t5v0__mux2_1
* cell instance $5822 m0 *1 609.84,1481.76
X$5822 28661 28635 gf180mcu_fd_sc_mcu9t5v0__filltie
* cell instance $5823 r0 *1 557.76,1471.68
X$5823 22828 28491 24702 28635 28530 28344 gf180mcu_fd_sc_mcu9t5v0__mux2_1
* cell instance $5824 r0 *1 570.64,1451.52
X$5824 19917 27622 24702 28103 27945 27941 gf180mcu_fd_sc_mcu9t5v0__mux2_1
* cell instance $5825 r0 *1 565.6,1471.68
X$5825 28491 26931 24819 28635 28530 28492 gf180mcu_fd_sc_mcu9t5v0__mux2_1
* cell instance $5826 m0 *1 609.84,1471.68
X$5826 28530 28378 gf180mcu_fd_sc_mcu9t5v0__filltie
* cell instance $5827 r0 *1 562.8,1421.28
X$5827 27205 27069 26930 18834 27213 27078 gf180mcu_fd_sc_mcu9t5v0__dffrnq_2
* cell instance $5828 r0 *1 559.44,1391.04
X$5828 25817 26161 26279 18834 26331 26166 gf180mcu_fd_sc_mcu9t5v0__dffrnq_2
* cell instance $5829 r0 *1 556.08,1401.12
X$5829 25817 26503 26504 18834 26632 26456 gf180mcu_fd_sc_mcu9t5v0__dffrnq_2
* cell instance $5830 m0 *1 576.24,1431.36
X$5830 27070 26931 26930 27068 27213 27367 27244
+ gf180mcu_fd_sc_mcu9t5v0__nand4_1
* cell instance $5831 r0 *1 594.16,1421.28
X$5831 27205 27206 27245 18834 27213 27078 gf180mcu_fd_sc_mcu9t5v0__dffrnq_2
* cell instance $5832 m0 *1 590.24,1401.12
X$5832 26328 26449 26505 18834 26331 26456 gf180mcu_fd_sc_mcu9t5v0__dffrnq_2
* cell instance $5833 m0 *1 593.6,1441.44
X$5833 27625 27624 27623 27621 27517 27666 26932 gf180mcu_fd_sc_mcu9t5v0__nor4_1
* cell instance $5834 m0 *1 582.96,1401.12
X$5834 26505 26281 24819 26331 26456 26280 gf180mcu_fd_sc_mcu9t5v0__mux2_1
* cell instance $5835 m0 *1 563.36,1401.12
X$5835 23314 26504 25693 26331 26456 26503 gf180mcu_fd_sc_mcu9t5v0__mux2_1
* cell instance $5836 m0 *1 567.84,1391.04
X$5836 26504 26279 24702 25997 26166 26161 gf180mcu_fd_sc_mcu9t5v0__mux2_1
* cell instance $5837 r0 *1 594.72,1441.44
X$5837 27205 27658 27624 18834 27807 27666 gf180mcu_fd_sc_mcu9t5v0__dffrnq_2
* cell instance $5838 m0 *1 582.4,1421.28
X$5838 27244 27513 26281 26942 27078 25536 gf180mcu_fd_sc_mcu9t5v0__oai21_1
* cell instance $5839 m0 *1 602.56,1441.44
X$5839 27626 27624 24819 27517 27666 27658 gf180mcu_fd_sc_mcu9t5v0__mux2_1
* cell instance $5840 r0 *1 613.2,1391.04
X$5840 16947 26282 12245 26331 26166 26329 gf180mcu_fd_sc_mcu9t5v0__mux2_1
* cell instance $5841 r0 *1 594.72,1401.12
X$5841 23314 26505 24702 26632 26456 26449 gf180mcu_fd_sc_mcu9t5v0__mux2_1
* cell instance $5842 m0 *1 609.84,1391.04
X$5842 26166 25997 gf180mcu_fd_sc_mcu9t5v0__filltie
* cell instance $5843 m0 *1 579.04,1441.44
X$5843 27622 27621 24819 27517 27666 27657 gf180mcu_fd_sc_mcu9t5v0__mux2_1
* cell instance $5844 m0 *1 609.84,1401.12
X$5844 26456 26331 gf180mcu_fd_sc_mcu9t5v0__filltie
* cell instance $5845 m0 *1 609.84,1411.2
X$5845 26757 26632 gf180mcu_fd_sc_mcu9t5v0__filltie
* cell instance $5846 m0 *1 588.56,1421.28
X$5846 26328 26934 27070 18834 26942 27078 gf180mcu_fd_sc_mcu9t5v0__dffrnq_2
* cell instance $5847 m0 *1 599.76,1431.36
X$5847 22833 27245 24702 27213 27367 27206 gf180mcu_fd_sc_mcu9t5v0__mux2_1
* cell instance $5848 m0 *1 609.84,1431.36
X$5848 27367 27213 gf180mcu_fd_sc_mcu9t5v0__filltie
* cell instance $5849 m0 *1 592.48,1431.36
X$5849 27245 27070 24819 27213 27367 26934 gf180mcu_fd_sc_mcu9t5v0__mux2_1
* cell instance $5850 m0 *1 609.84,1421.28
X$5850 27078 26942 gf180mcu_fd_sc_mcu9t5v0__filltie
* cell instance $5851 m0 *1 576.24,1421.28
X$5851 27070 26931 26930 27068 26942 27078 26933 gf180mcu_fd_sc_mcu9t5v0__nor4_1
* cell instance $5852 m0 *1 566.72,1421.28
X$5852 27364 26930 24819 26942 27078 27069 gf180mcu_fd_sc_mcu9t5v0__mux2_1
* cell instance $5853 r0 *1 554.96,1431.36
X$5853 22830 27364 24702 27517 27367 27243 gf180mcu_fd_sc_mcu9t5v0__mux2_1
* cell instance $5854 r0 *1 553.28,1441.44
X$5854 19567 27807 27666 27205 gf180mcu_fd_sc_mcu9t5v0__clkbuf_8
* cell instance $5855 m0 *1 609.84,1441.44
X$5855 27666 27517 gf180mcu_fd_sc_mcu9t5v0__filltie
* cell instance $5856 r0 *1 575.68,1441.44
X$5856 27205 27657 27621 18834 27807 27666 gf180mcu_fd_sc_mcu9t5v0__dffrnq_2
* cell instance $5857 r0 *1 578.48,1391.04
X$5857 26328 26280 26281 18834 26331 26166 gf180mcu_fd_sc_mcu9t5v0__dffrnq_2
* cell instance $5858 r0 *1 580.16,1411.2
X$5858 26933 26932 26281 26942 26757 24565 gf180mcu_fd_sc_mcu9t5v0__aoi21_1
* cell instance $5859 m0 *1 646.8,1411.2
X$5859 26026 26626 26627 26632 26757 26752 gf180mcu_fd_sc_mcu9t5v0__aoi21_1
* cell instance $5860 m0 *1 644,1411.2
X$5860 26026 26626 26632 26757 26751 gf180mcu_fd_sc_mcu9t5v0__nand2_1
* cell instance $5861 m0 *1 657.44,1421.28
X$5861 19567 26942 27078 26328 gf180mcu_fd_sc_mcu9t5v0__clkbuf_8
* cell instance $5862 m0 *1 686,1441.44
X$5862 27627 27661 27517 27666 27660 gf180mcu_fd_sc_mcu9t5v0__nor2_1
* cell instance $5863 r0 *1 647.36,1421.28
X$5863 27208 27365 27213 27078 27207 gf180mcu_fd_sc_mcu9t5v0__nand2_1
* cell instance $5864 m0 *1 672.56,1391.04
X$5864 24946 25997 26166 25994 gf180mcu_fd_sc_mcu9t5v0__clkinv_1
* cell instance $5865 r0 *1 657.44,1421.28
X$5865 26328 27213 27078 33569 gf180mcu_fd_sc_mcu9t5v0__clkinv_1
* cell instance $5866 r0 *1 632.8,1441.44
X$5866 27514 27807 27666 27801 gf180mcu_fd_sc_mcu9t5v0__clkinv_1
* cell instance $5867 m0 *1 675.36,1401.12
X$5867 24990 26331 26456 26450 gf180mcu_fd_sc_mcu9t5v0__clkinv_1
* cell instance $5868 m0 *1 626.64,1431.36
X$5868 26937 27213 27367 26876 gf180mcu_fd_sc_mcu9t5v0__clkinv_1
* cell instance $5869 r0 *1 644.56,1411.2
X$5869 26328 26752 24568 18834 26942 26757 gf180mcu_fd_sc_mcu9t5v0__dffrnq_2
* cell instance $5870 r0 *1 649.6,1431.36
X$5870 27208 24568 26506 27517 27367 27515 gf180mcu_fd_sc_mcu9t5v0__nand3_1
* cell instance $5871 m0 *1 652.4,1431.36
X$5871 24568 26506 27213 27367 27365 gf180mcu_fd_sc_mcu9t5v0__nand2_1
* cell instance $5872 m0 *1 663.04,1431.36
X$5872 24568 27247 26506 27213 27367 27248 gf180mcu_fd_sc_mcu9t5v0__nand3_1
* cell instance $5873 m0 *1 666.96,1431.36
X$5873 27248 27213 27367 26507 gf180mcu_fd_sc_mcu9t5v0__clkinv_1
* cell instance $5874 m0 *1 630.56,1431.36
X$5874 18577 27207 27213 27367 27246 gf180mcu_fd_sc_mcu9t5v0__nand2_1
* cell instance $5875 m0 *1 678.16,1401.12
X$5875 15575 26286 26450 26331 26456 26451 gf180mcu_fd_sc_mcu9t5v0__oai21_1
* cell instance $5876 r0 *1 664.72,1401.12
X$5876 24946 26507 26506 26632 26456 16499 gf180mcu_fd_sc_mcu9t5v0__oai21_1
* cell instance $5877 m0 *1 672,1411.2
X$5877 25428 26632 26757 26627 gf180mcu_fd_sc_mcu9t5v0__buf_8
* cell instance $5878 m0 *1 633.36,1431.36
X$5878 26328 27246 27208 18834 27213 27367 gf180mcu_fd_sc_mcu9t5v0__dffrnq_2
* cell instance $5879 r0 *1 650.16,1391.04
X$5879 26328 26162 25867 18834 26331 26166 gf180mcu_fd_sc_mcu9t5v0__dffrnq_2
* cell instance $5880 r0 *1 673.12,1391.04
X$5880 25994 26285 26331 26166 26284 gf180mcu_fd_sc_mcu9t5v0__nor2_1
* cell instance $5881 m0 *1 652.4,1391.04
X$5881 27208 25867 25997 26166 26026 gf180mcu_fd_sc_mcu9t5v0__nor2_1
* cell instance $5882 m0 *1 644.56,1401.12
X$5882 25825 13151 26331 26456 26626 gf180mcu_fd_sc_mcu9t5v0__nor2_1
* cell instance $5883 m0 *1 675.36,1431.36
X$5883 26451 27213 27367 29166 gf180mcu_fd_sc_mcu9t5v0__buf_8
* cell instance $5884 r0 *1 653.52,1431.36
X$5884 25693 27485 27517 27367 27486 gf180mcu_fd_sc_mcu9t5v0__nand2_1
* cell instance $5885 m0 *1 653.52,1441.44
X$5885 26328 27486 27247 18834 27517 27666 gf180mcu_fd_sc_mcu9t5v0__dffrnq_2
* cell instance $5886 r0 *1 633.92,1391.04
X$5886 26284 26331 26166 13151 gf180mcu_fd_sc_mcu9t5v0__buf_8
* cell instance $5887 r0 *1 622.72,1401.12
X$5887 25114 26632 26456 25825 gf180mcu_fd_sc_mcu9t5v0__buf_8
* cell instance $5888 m0 *1 641.2,1391.04
X$5888 25114 26284 26026 25997 26166 24990 gf180mcu_fd_sc_mcu9t5v0__nor3_1
* cell instance $5889 r0 *1 661.92,1421.28
X$5889 26328 26507 26875 18834 27213 27078 gf180mcu_fd_sc_mcu9t5v0__dffrnq_2
* cell instance $5890 r0 *1 677.04,1391.04
X$5890 25994 26285 26331 26166 15575 gf180mcu_fd_sc_mcu9t5v0__or2_1
* cell instance $5891 m0 *1 658,1391.04
X$5891 26027 25997 26166 26162 gf180mcu_fd_sc_mcu9t5v0__clkinv_1
* cell instance $5892 r0 *1 657.44,1401.12
X$5892 24946 24568 27247 26632 26456 16503 gf180mcu_fd_sc_mcu9t5v0__mux2_1
* cell instance $5893 r0 *1 624.96,1391.04
X$5893 26282 24990 16947 25825 26283 26331 26166 27514
+ gf180mcu_fd_sc_mcu9t5v0__aoi221_1
* cell instance $5894 r0 *1 623.84,1411.2
X$5894 26876 26875 18577 26942 26757 26935 gf180mcu_fd_sc_mcu9t5v0__oai21_1
* cell instance $5895 r0 *1 656.32,1431.36
X$5895 27247 27365 27517 27367 27485 gf180mcu_fd_sc_mcu9t5v0__nand2_1
* cell instance $5896 m0 *1 796.88,1451.52
X$5896 14820 24234 27944 27771 27807 27945 27946
+ gf180mcu_fd_sc_mcu9t5v0__oai31_1
* cell instance $5897 m0 *1 760.48,1451.52
X$5897 27770 27808 27807 27945 25829 gf180mcu_fd_sc_mcu9t5v0__nor2_1
* cell instance $5898 m0 *1 744.24,1451.52
X$5898 27943 27942 27807 27945 27768 gf180mcu_fd_sc_mcu9t5v0__nand2_1
* cell instance $5899 m0 *1 775.04,1451.52
X$5899 25830 27978 27808 27807 27945 26509 gf180mcu_fd_sc_mcu9t5v0__nor3_1
* cell instance $5900 m0 *1 730.8,1451.52
X$5900 25118 27803 27807 27945 27942 gf180mcu_fd_sc_mcu9t5v0__xnor2_1
* cell instance $5901 r0 *1 758.8,1461.6
X$5901 27770 27808 28378 28239 27629 gf180mcu_fd_sc_mcu9t5v0__nand2_1
* cell instance $5902 m0 *1 767.76,1451.52
X$5902 27808 27807 27945 27806 gf180mcu_fd_sc_mcu9t5v0__clkinv_1
* cell instance $5903 m0 *1 747.6,1451.52
X$5903 25120 27806 27978 27979 27807 27945 27804
+ gf180mcu_fd_sc_mcu9t5v0__aoi211_1
* cell instance $5904 m0 *1 764.96,1451.52
X$5904 27805 25833 27807 27945 27944 gf180mcu_fd_sc_mcu9t5v0__nand2_1
* cell instance $5905 m0 *1 753.2,1451.52
X$5905 27074 27805 27807 27945 27767 gf180mcu_fd_sc_mcu9t5v0__nor2_1
* cell instance $5906 m0 *1 737.52,1451.52
X$5906 28102 26884 27807 27945 27769 gf180mcu_fd_sc_mcu9t5v0__xnor2_1
* cell instance $5907 m0 *1 750.4,1401.12
X$5907 26455 26453 26331 26456 25159 26631 gf180mcu_fd_sc_mcu9t5v0__xnor3_1
* cell instance $5908 m0 *1 754.32,1421.28
X$5908 27074 25833 26881 26941 26942 27078 27075
+ gf180mcu_fd_sc_mcu9t5v0__oai31_1
* cell instance $5909 r0 *1 755.44,1421.28
X$5909 25160 27075 26940 11958 27213 27078 gf180mcu_fd_sc_mcu9t5v0__dffrnq_2
* cell instance $5910 m0 *1 779.52,1451.52
X$5910 25830 27770 27808 27807 27945 26884 gf180mcu_fd_sc_mcu9t5v0__nor3_1
* cell instance $5911 m0 *1 823.76,1451.52
X$5911 27948 27251 27949 27807 27945 27980 gf180mcu_fd_sc_mcu9t5v0__aoi21_1
* cell instance $5912 m0 *1 802.48,1451.52
X$5912 25160 27946 27772 11958 27807 27945 gf180mcu_fd_sc_mcu9t5v0__dffrnq_2
* cell instance $5913 r0 *1 761.6,1461.6
X$5913 27629 27664 28378 28239 28379 gf180mcu_fd_sc_mcu9t5v0__nor2_1
* cell instance $5914 m0 *1 768.88,1471.68
X$5914 25830 28379 28378 28530 28380 gf180mcu_fd_sc_mcu9t5v0__nor2_1
* cell instance $5915 r0 *1 764.96,1461.6
X$5915 27979 27978 27808 28378 28239 28347 gf180mcu_fd_sc_mcu9t5v0__nor3_1
* cell instance $5916 m0 *1 765.52,1471.68
X$5916 27074 28380 28378 28530 28529 gf180mcu_fd_sc_mcu9t5v0__nor2_1
* cell instance $5917 m0 *1 780.08,1471.68
X$5917 27978 28504 28379 27074 28378 28530 28505
+ gf180mcu_fd_sc_mcu9t5v0__aoi211_1
* cell instance $5918 r0 *1 763.28,1471.68
X$5918 28500 28529 25830 18834 28635 28530 gf180mcu_fd_sc_mcu9t5v0__dffrnq_2
* cell instance $5919 m0 *1 804.72,1471.68
X$5919 27808 28348 23621 28378 28530 28349 gf180mcu_fd_sc_mcu9t5v0__oai21_1
* cell instance $5920 r0 *1 803.04,1461.6
X$5920 27808 28348 28349 28378 28239 28381 gf180mcu_fd_sc_mcu9t5v0__aoi21_1
* cell instance $5921 r0 *1 825.44,1451.52
X$5921 27079 28103 27945 27948 gf180mcu_fd_sc_mcu9t5v0__clkinv_1
* cell instance $5922 r0 *1 801.36,1471.68
X$5922 27519 28381 27808 18834 28635 28530 gf180mcu_fd_sc_mcu9t5v0__dffrnq_2
* cell instance $5923 r0 *1 788.48,1471.68
X$5923 27808 28348 28635 28530 28504 gf180mcu_fd_sc_mcu9t5v0__nand2_1
* cell instance $5924 m0 *1 785.68,1471.68
X$5924 25160 28505 27770 18834 28378 28530 gf180mcu_fd_sc_mcu9t5v0__dffrnq_2
* cell instance $5925 r0 *1 781.76,1461.6
X$5925 27770 28378 28239 27978 gf180mcu_fd_sc_mcu9t5v0__clkinv_1
* cell instance $5926 r0 *1 788.48,1461.6
X$5926 28347 27664 28378 28239 28348 gf180mcu_fd_sc_mcu9t5v0__nor2_1
* cell instance $5927 r0 *1 729.68,1471.68
X$5927 28530 28635 gf180mcu_fd_sc_mcu9t5v0__filltie
* cell instance $5928 m0 *1 708.4,1461.6
X$5928 13214 27767 28103 28239 28206 gf180mcu_fd_sc_mcu9t5v0__nand2_1
* cell instance $5929 m0 *1 715.68,1461.6
X$5929 28102 27366 26882 28103 28239 27628 gf180mcu_fd_sc_mcu9t5v0__and3_1
* cell instance $5930 r0 *1 714,1461.6
X$5930 27628 28206 28238 28346 28378 28239 28376
+ gf180mcu_fd_sc_mcu9t5v0__oai31_1
* cell instance $5931 m0 *1 706.16,1471.68
X$5931 27366 27080 28378 28530 28499 gf180mcu_fd_sc_mcu9t5v0__nand2_1
* cell instance $5932 m0 *1 751.52,1471.68
X$5932 26882 28378 28530 27629 28503 gf180mcu_fd_sc_mcu9t5v0__xor2_1
* cell instance $5933 m0 *1 696.08,1461.6
X$5933 28102 27802 28205 28103 28239 28204 gf180mcu_fd_sc_mcu9t5v0__aoi21_1
* cell instance $5934 m0 *1 694.96,1471.68
X$5934 28102 27366 28378 28530 28498 gf180mcu_fd_sc_mcu9t5v0__xnor2_1
* cell instance $5935 m0 *1 735.28,1471.68
X$5935 25830 27366 26882 28378 28530 28501 gf180mcu_fd_sc_mcu9t5v0__and3_1
* cell instance $5936 m0 *1 715.68,1471.68
X$5936 28500 28376 26882 18834 28378 28530 gf180mcu_fd_sc_mcu9t5v0__dffrnq_2
* cell instance $5937 r0 *1 693.28,1461.6
X$5937 28345 25538 26506 28378 28239 28237 gf180mcu_fd_sc_mcu9t5v0__nor3_1
* cell instance $5938 r0 *1 729.68,1461.6
X$5938 28239 28378 gf180mcu_fd_sc_mcu9t5v0__filltie
* cell instance $5939 m0 *1 729.68,1481.76
X$5939 28661 28635 gf180mcu_fd_sc_mcu9t5v0__filltie
* cell instance $5940 r0 *1 739.76,1451.52
X$5940 27979 27978 25120 28103 27945 27943 gf180mcu_fd_sc_mcu9t5v0__oai21_1
* cell instance $5941 m0 *1 746.48,1471.68
X$5941 28502 28503 28501 26455 28378 28530 27663
+ gf180mcu_fd_sc_mcu9t5v0__aoi22_1
* cell instance $5942 m0 *1 732.48,1481.76
X$5942 26627 28635 28661 28660 gf180mcu_fd_sc_mcu9t5v0__clkinv_4
* cell instance $5943 r0 *1 741.44,1461.6
X$5943 27978 27366 27979 28378 28239 28377 gf180mcu_fd_sc_mcu9t5v0__oai21_1
* cell instance $5944 r0 *1 739.2,1461.6
X$5944 25830 28378 28239 27979 gf180mcu_fd_sc_mcu9t5v0__clkinv_1
* cell instance $5945 r0 *1 719.6,1461.6
X$5945 28102 27366 26882 28378 28239 28238 gf180mcu_fd_sc_mcu9t5v0__aoi21_1
* cell instance $5946 m0 *1 703.36,1461.6
X$5946 13214 27767 28102 28103 28239 28205 gf180mcu_fd_sc_mcu9t5v0__aoi21_1
* cell instance $5947 r0 *1 729.68,1451.52
X$5947 27945 28103 gf180mcu_fd_sc_mcu9t5v0__filltie
* cell instance $5948 m0 *1 701.68,1471.68
X$5948 28206 28498 28499 28378 28530 28497 gf180mcu_fd_sc_mcu9t5v0__oai21_1
* cell instance $5949 m0 *1 740.88,1471.68
X$5949 27978 27366 28377 26455 28378 28530 28502
+ gf180mcu_fd_sc_mcu9t5v0__aoi211_1
* cell instance $5950 r0 *1 711.2,1461.6
X$5950 26882 27080 28378 28239 28346 gf180mcu_fd_sc_mcu9t5v0__nand2_1
* cell instance $5951 r0 *1 702.8,1451.52
X$5951 27080 28103 27945 27802 gf180mcu_fd_sc_mcu9t5v0__clkinv_1
* cell instance $5952 r0 *1 721.28,1411.2
X$5952 26029 26452 26938 26942 26757 26628 gf180mcu_fd_sc_mcu9t5v0__nand3_1
* cell instance $5953 r0 *1 734.72,1411.2
X$5953 26879 26878 26942 26757 26755 gf180mcu_fd_sc_mcu9t5v0__nand2_1
* cell instance $5954 r0 *1 693.84,1391.04
X$5954 15399 26287 25701 26331 26166 26285 gf180mcu_fd_sc_mcu9t5v0__nor3_1
* cell instance $5955 m0 *1 724.08,1401.12
X$5955 26508 26452 26330 26331 26456 26289 gf180mcu_fd_sc_mcu9t5v0__aoi21_1
* cell instance $5956 m0 *1 728.56,1401.12
X$5956 26330 26508 26452 26331 26456 26290 gf180mcu_fd_sc_mcu9t5v0__and3_1
* cell instance $5957 r0 *1 725.2,1391.04
X$5957 26289 26290 26029 26331 26166 26030 gf180mcu_fd_sc_mcu9t5v0__oai21_1
* cell instance $5958 r0 *1 748.16,1401.12
X$5958 26455 26631 26632 26456 26454 gf180mcu_fd_sc_mcu9t5v0__nand2_1
* cell instance $5959 m0 *1 711.76,1411.2
X$5959 26629 26628 25542 26632 26757 26753 gf180mcu_fd_sc_mcu9t5v0__aoi21_1
* cell instance $5960 r0 *1 699.44,1411.2
X$5960 26328 26753 26631 11958 26942 26757 gf180mcu_fd_sc_mcu9t5v0__dffrnq_2
* cell instance $5961 m0 *1 709.52,1411.2
X$5961 26029 26632 26757 26877 gf180mcu_fd_sc_mcu9t5v0__clkinv_1
* cell instance $5962 r0 *1 737.52,1431.36
X$5962 26884 26029 27517 27367 27488 gf180mcu_fd_sc_mcu9t5v0__nand2_1
* cell instance $5963 m0 *1 710.08,1391.04
X$5963 25542 26028 25997 26166 26163 gf180mcu_fd_sc_mcu9t5v0__nor2_1
* cell instance $5964 r0 *1 730.8,1391.04
X$5964 24951 25996 26331 26166 26330 gf180mcu_fd_sc_mcu9t5v0__xnor2_1
* cell instance $5965 m0 *1 713.44,1421.28
X$5965 26631 26877 26942 27078 26629 gf180mcu_fd_sc_mcu9t5v0__nand2_1
* cell instance $5966 r0 *1 692.72,1421.28
X$5966 25118 27209 27072 27213 27078 27071 gf180mcu_fd_sc_mcu9t5v0__aoi21_1
* cell instance $5967 r0 *1 744.24,1421.28
X$5967 27212 26884 26939 27213 27078 27073 gf180mcu_fd_sc_mcu9t5v0__aoi21_1
* cell instance $5968 r0 *1 721.84,1441.44
X$5968 27080 27767 27807 27666 26029 gf180mcu_fd_sc_mcu9t5v0__nor2_1
* cell instance $5969 r0 *1 729.68,1431.36
X$5969 27367 27517 gf180mcu_fd_sc_mcu9t5v0__filltie
* cell instance $5970 m0 *1 726.32,1411.2
X$5970 26508 26630 26632 26757 26754 gf180mcu_fd_sc_mcu9t5v0__nand2_1
* cell instance $5971 r0 *1 730.8,1431.36
X$5971 27212 27517 27367 27488 27210 gf180mcu_fd_sc_mcu9t5v0__xor2_1
* cell instance $5972 r0 *1 729.68,1441.44
X$5972 27666 27807 gf180mcu_fd_sc_mcu9t5v0__filltie
* cell instance $5973 r0 *1 729.68,1391.04
X$5973 26166 26331 gf180mcu_fd_sc_mcu9t5v0__filltie
* cell instance $5974 r0 *1 717.36,1391.04
X$5974 24576 15399 23954 13895 26288 26331 26166 26286
+ gf180mcu_fd_sc_mcu9t5v0__aoi221_1
* cell instance $5975 r0 *1 748.72,1391.04
X$5975 26455 26631 26331 26166 26291 gf180mcu_fd_sc_mcu9t5v0__nor2_1
* cell instance $5976 m0 *1 750.96,1421.28
X$5976 26877 27073 26942 27078 26880 gf180mcu_fd_sc_mcu9t5v0__nor2_1
* cell instance $5977 r0 *1 699.44,1421.28
X$5977 25118 27209 26877 27213 27078 27072 gf180mcu_fd_sc_mcu9t5v0__oai21_1
* cell instance $5978 r0 *1 742.56,1441.44
X$5978 27663 27804 27769 27768 27807 27666 27805 gf180mcu_fd_sc_mcu9t5v0__nor4_1
* cell instance $5979 m0 *1 714.56,1391.04
X$5979 24951 26029 26030 25997 26166 26028 gf180mcu_fd_sc_mcu9t5v0__oai21_1
* cell instance $5980 r0 *1 748.72,1421.28
X$5980 26940 27213 27078 26511 26939 gf180mcu_fd_sc_mcu9t5v0__xor2_1
* cell instance $5981 m0 *1 745.92,1401.12
X$5981 26454 26453 26291 26331 26456 24953 gf180mcu_fd_sc_mcu9t5v0__aoi21_1
* cell instance $5982 r0 *1 749.84,1411.2
X$5982 26878 26880 26942 26757 26881 gf180mcu_fd_sc_mcu9t5v0__nand2_1
* cell instance $5983 m0 *1 724.08,1431.36
X$5983 26328 27211 27212 11958 27213 27367 gf180mcu_fd_sc_mcu9t5v0__dffrnq_2
* cell instance $5984 r0 *1 753.76,1411.2
X$5984 26940 26877 26942 26757 26941 gf180mcu_fd_sc_mcu9t5v0__nand2_1
* cell instance $5985 m0 *1 747.04,1421.28
X$5985 27212 26884 26939 26942 27078 26878 gf180mcu_fd_sc_mcu9t5v0__nand3_1
* cell instance $5986 r0 *1 701.12,1441.44
X$5986 26455 27802 27628 27807 27666 27209 gf180mcu_fd_sc_mcu9t5v0__and3_1
* cell instance $5987 r0 *1 706.72,1441.44
X$5987 27802 27628 26455 27807 27666 27487 gf180mcu_fd_sc_mcu9t5v0__aoi21_1
* cell instance $5988 r0 *1 729.68,1401.12
X$5988 26456 26632 gf180mcu_fd_sc_mcu9t5v0__filltie
* cell instance $5989 r0 *1 725.2,1411.2
X$5989 26631 26509 26942 26757 26630 gf180mcu_fd_sc_mcu9t5v0__or2_1
* cell instance $5990 r0 *1 726.32,1421.28
X$5990 25542 27210 27213 27078 27211 gf180mcu_fd_sc_mcu9t5v0__nor2_1
* cell instance $5991 r0 *1 747.04,1411.2
X$5991 26940 26511 26942 26757 26879 gf180mcu_fd_sc_mcu9t5v0__nand2_1
* cell instance $5992 m0 *1 698.88,1441.44
X$5992 26455 25120 25118 27628 27517 27666 27662
+ gf180mcu_fd_sc_mcu9t5v0__nand4_1
* cell instance $5993 r0 *1 729.68,1411.2
X$5993 26757 26942 gf180mcu_fd_sc_mcu9t5v0__filltie
* cell instance $5994 r0 *1 698.32,1391.04
X$5994 26328 26163 24951 11958 26331 26166 gf180mcu_fd_sc_mcu9t5v0__dffrnq_2
* cell instance $5995 m0 *1 707.28,1441.44
X$5995 26328 27516 26455 11958 27517 27666 gf180mcu_fd_sc_mcu9t5v0__dffrnq_2
* cell instance $5996 r0 *1 696.08,1441.44
X$5996 25120 27080 27767 27662 27807 27666 27661
+ gf180mcu_fd_sc_mcu9t5v0__aoi22_1
* cell instance $5997 r0 *1 730.8,1411.2
X$5997 26879 26878 26754 26942 26757 26938 gf180mcu_fd_sc_mcu9t5v0__nand3_1
* cell instance $5998 m0 *1 729.12,1411.2
X$5998 26630 26755 26632 26757 26452 gf180mcu_fd_sc_mcu9t5v0__nand2_1
* cell instance $5999 r0 *1 730.8,1401.12
X$5999 26631 26509 26632 26456 26508 gf180mcu_fd_sc_mcu9t5v0__nand2_1
* cell instance $6000 r0 *1 729.68,1421.28
X$6000 27078 27213 gf180mcu_fd_sc_mcu9t5v0__filltie
* cell instance $6001 r0 *1 705.6,1431.36
X$6001 27209 26029 27487 27517 27367 27516 gf180mcu_fd_sc_mcu9t5v0__nor3_1
* cell instance $6002 r0 *1 737.52,1441.44
X$6002 27979 25829 27807 27666 27803 gf180mcu_fd_sc_mcu9t5v0__nor2_1
* cell instance $6003 m0 *1 796.88,1391.04
X$6003 26165 26033 25998 25997 26166 26034 gf180mcu_fd_sc_mcu9t5v0__oai21_1
* cell instance $6004 r0 *1 766.64,1411.2
X$6004 26940 26882 26942 26757 26883 gf180mcu_fd_sc_mcu9t5v0__and2_1
* cell instance $6005 r0 *1 771.12,1411.2
X$6005 26940 26634 26942 26757 26292 26882 gf180mcu_fd_sc_mcu9t5v0__xnor3_1
* cell instance $6006 m0 *1 797.44,1411.2
X$6006 26512 26756 26632 26757 24235 26511 gf180mcu_fd_sc_mcu9t5v0__xnor3_1
* cell instance $6007 r0 *1 803.04,1401.12
X$6007 26884 26632 26456 25270 25272 gf180mcu_fd_sc_mcu9t5v0__xor2_1
* cell instance $6008 m0 *1 814.24,1401.12
X$6008 26457 23370 15575 26331 26456 26283 gf180mcu_fd_sc_mcu9t5v0__aoi21_1
* cell instance $6009 m0 *1 820.96,1431.36
X$6009 25836 27250 27213 27367 27368 gf180mcu_fd_sc_mcu9t5v0__nand2_1
* cell instance $6010 m0 *1 778.4,1431.36
X$6010 27366 27076 27213 27367 26512 27212 gf180mcu_fd_sc_mcu9t5v0__xnor3_1
* cell instance $6011 m0 *1 775.04,1431.36
X$6011 27366 27212 27213 27367 27249 gf180mcu_fd_sc_mcu9t5v0__nor2_1
* cell instance $6012 m0 *1 823.76,1431.36
X$6012 27251 27217 27213 27367 27250 gf180mcu_fd_sc_mcu9t5v0__nand2_1
* cell instance $6013 m0 *1 804.72,1391.04
X$6013 26287 27947 25431 15399 24997 25997 26166 26031
+ gf180mcu_fd_sc_mcu9t5v0__aoi221_1
* cell instance $6014 m0 *1 796.88,1431.36
X$6014 25160 27215 27216 11958 27213 27367 gf180mcu_fd_sc_mcu9t5v0__dffrnq_2
* cell instance $6015 r0 *1 795.2,1401.12
X$6015 26512 26511 26632 26456 26510 gf180mcu_fd_sc_mcu9t5v0__nor2_1
* cell instance $6016 r0 *1 796.88,1411.2
X$6016 26512 26511 26942 26757 26635 gf180mcu_fd_sc_mcu9t5v0__nand2_1
* cell instance $6017 r0 *1 800.8,1411.2
X$6017 26884 25270 26942 26757 26756 gf180mcu_fd_sc_mcu9t5v0__nand2_1
* cell instance $6018 m0 *1 792.96,1411.2
X$6018 26756 26510 26635 26632 26757 26293 gf180mcu_fd_sc_mcu9t5v0__oai21_1
* cell instance $6019 m0 *1 779.52,1401.12
X$6019 26509 26331 26456 26332 gf180mcu_fd_sc_mcu9t5v0__clkinv_1
* cell instance $6020 m0 *1 781.76,1401.12
X$6020 26292 26509 26331 26456 26333 gf180mcu_fd_sc_mcu9t5v0__xnor2_1
* cell instance $6021 m0 *1 792.4,1391.04
X$6021 13214 26164 25997 26166 26033 gf180mcu_fd_sc_mcu9t5v0__nand2_1
* cell instance $6022 r0 *1 823.76,1421.28
X$6022 27772 27079 13895 27213 27078 27217 gf180mcu_fd_sc_mcu9t5v0__aoi21_1
* cell instance $6023 r0 *1 792.96,1391.04
X$6023 26293 26333 26331 26166 26165 gf180mcu_fd_sc_mcu9t5v0__nor2_1
* cell instance $6024 r0 *1 803.04,1421.28
X$6024 27216 14820 27213 27078 27077 gf180mcu_fd_sc_mcu9t5v0__nand2_1
* cell instance $6025 r0 *1 796.32,1421.28
X$6025 23153 14820 24234 27077 27213 27078 27215
+ gf180mcu_fd_sc_mcu9t5v0__oai31_1
* cell instance $6026 r0 *1 778.96,1421.28
X$6026 27076 27249 27214 27213 27078 26634 gf180mcu_fd_sc_mcu9t5v0__oai21_1
* cell instance $6027 r0 *1 759.92,1441.44
X$6027 27979 27770 27806 27807 27666 24412 gf180mcu_fd_sc_mcu9t5v0__nor3_1
* cell instance $6028 m0 *1 785.12,1441.44
X$6028 27518 24411 27664 27517 27666 27665 gf180mcu_fd_sc_mcu9t5v0__and3_1
* cell instance $6029 r0 *1 809.2,1441.44
X$6029 27772 14820 27807 27666 27771 gf180mcu_fd_sc_mcu9t5v0__nand2_1
* cell instance $6030 m0 *1 763.28,1401.12
X$6030 25830 27629 26331 26456 25996 gf180mcu_fd_sc_mcu9t5v0__nor2_1
* cell instance $6031 m0 *1 769.44,1421.28
X$6031 26940 26882 26942 27078 26633 gf180mcu_fd_sc_mcu9t5v0__or2_1
* cell instance $6032 r0 *1 777.84,1431.36
X$6032 27366 27212 27517 27367 27214 gf180mcu_fd_sc_mcu9t5v0__nand2_1
* cell instance $6033 m0 *1 762.72,1441.44
X$6033 13214 27805 25833 27517 27666 27664 gf180mcu_fd_sc_mcu9t5v0__nand3_1
* cell instance $6034 m0 *1 793.52,1441.44
X$6034 27518 27517 27666 28102 25270 gf180mcu_fd_sc_mcu9t5v0__xor2_1
* cell instance $6035 m0 *1 772.8,1411.2
X$6035 26634 26633 26883 26632 26757 26453 gf180mcu_fd_sc_mcu9t5v0__aoi21_1
* cell instance $6036 r0 *1 790.16,1391.04
X$6036 26293 26333 26331 26166 26164 gf180mcu_fd_sc_mcu9t5v0__nand2_1
* cell instance $6037 m0 *1 766.08,1391.04
X$6037 15575 26031 25864 25997 26166 26032 gf180mcu_fd_sc_mcu9t5v0__oai21_1
* cell instance $6038 r0 *1 766.08,1441.44
X$6038 25830 27770 27806 27807 27666 26511 gf180mcu_fd_sc_mcu9t5v0__nor3_1
* cell instance $6039 m0 *1 823.76,1391.04
X$6039 24576 25999 25836 25997 26166 26000 gf180mcu_fd_sc_mcu9t5v0__oai21_1
* cell instance $6040 m0 *1 782.32,1441.44
X$6040 27518 28102 27517 27666 27076 gf180mcu_fd_sc_mcu9t5v0__nand2_1
* cell instance $6041 r0 *1 767.76,1391.04
X$6041 26032 26331 26166 29165 gf180mcu_fd_sc_mcu9t5v0__buf_8
* cell instance $6042 m0 *1 759.92,1441.44
X$6042 23621 27664 27517 27666 25542 gf180mcu_fd_sc_mcu9t5v0__nand2_1
* cell instance $6043 r0 *1 770.56,1441.44
X$6043 25830 27770 27806 27807 27666 24234 gf180mcu_fd_sc_mcu9t5v0__nand3_1
* cell instance $6044 r0 *1 785.12,1441.44
X$6044 25160 27665 27518 11958 27807 27666 gf180mcu_fd_sc_mcu9t5v0__dffrnq_2
* cell instance $6045 r0 *1 782.32,1391.04
X$6045 26292 26332 26164 26331 26166 24955 gf180mcu_fd_sc_mcu9t5v0__oai21_1
* cell instance $6046 m0 *1 688.8,1370.88
X$6046 25538 25537 24570 25430 25581 25429 gf180mcu_fd_sc_mcu9t5v0__oai21_1
* cell instance $6047 m0 *1 690.48,1239.84
X$6047 21714 21575 21537 21719 21578 gf180mcu_fd_sc_mcu9t5v0__nand2_1
* cell instance $6048 r0 *1 756,1239.84
X$6048 21121 19559 21884 21719 21840 gf180mcu_fd_sc_mcu9t5v0__nand2_1
* cell instance $6049 r0 *1 729.68,1239.84
X$6049 21719 21884 gf180mcu_fd_sc_mcu9t5v0__filltie
* cell instance $6050 r0 *1 811.44,1239.84
X$6050 19402 21884 21719 21409 gf180mcu_fd_sc_mcu9t5v0__clkbuf_8
* cell instance $6051 r0 *1 787.36,1239.84
X$6051 21409 21718 21584 12383 21884 21719 gf180mcu_fd_sc_mcu9t5v0__dffrnq_2
* cell instance $6052 r0 *1 651.84,1239.84
X$6052 21238 21717 21576 11958 21884 21719 gf180mcu_fd_sc_mcu9t5v0__dffrnq_2
* cell instance $6053 r0 *1 684.88,1310.4
X$6053 23037 23902 23677 11958 23957 23797 gf180mcu_fd_sc_mcu9t5v0__dffrnq_2
* cell instance $6054 m0 *1 686,1350.72
X$6054 24569 24570 24524 24828 25000 25827 gf180mcu_fd_sc_mcu9t5v0__or3_2
* cell instance $6055 r0 *1 678.72,1300.32
X$6055 23037 23620 23500 11958 23623 23504 gf180mcu_fd_sc_mcu9t5v0__dffrnq_2
* cell instance $6056 m0 *1 684.88,1360.8
X$6056 22838 23315 25539 11958 25158 25268 gf180mcu_fd_sc_mcu9t5v0__dffrnq_2
* cell instance $6057 r0 *1 689.92,1330.56
X$6057 24571 24528 24414 21236 gf180mcu_fd_sc_mcu9t5v0__buf_8
* cell instance $6058 r0 *1 671.44,1340.64
X$6058 24826 24712 24828 19567 gf180mcu_fd_sc_mcu9t5v0__clkbuf_16
* cell instance $6059 r0 *1 624.4,1239.84
X$6059 21714 21837 21715 21884 21719 14713 gf180mcu_fd_sc_mcu9t5v0__aoi21_1
* cell instance $6060 r0 *1 599.76,1239.84
X$6060 21573 21570 21835 21884 21719 21836 gf180mcu_fd_sc_mcu9t5v0__nand3_1
* cell instance $6061 r0 *1 604.24,1239.84
X$6061 21714 21836 21834 21884 21719 14443 gf180mcu_fd_sc_mcu9t5v0__aoi21_1
* cell instance $6062 r0 *1 635.6,1239.84
X$6062 14809 21882 21716 21884 21719 21838 gf180mcu_fd_sc_mcu9t5v0__mux2_1
* cell instance $6063 r0 *1 688.8,1280.16
X$6063 23037 23006 22883 11958 23038 22885 gf180mcu_fd_sc_mcu9t5v0__dffrnq_2
* cell instance $6064 m0 *1 684.88,1260
X$6064 22168 22166 21236 22124 22295 22291 gf180mcu_fd_sc_mcu9t5v0__mux2_1
* cell instance $6065 r0 *1 683.2,1239.84
X$6065 21714 21577 21713 21884 21719 20375 gf180mcu_fd_sc_mcu9t5v0__aoi21_1
* cell instance $6066 m0 *1 688.8,1280.16
X$6066 22883 18441 20336 22700 22885 22881 gf180mcu_fd_sc_mcu9t5v0__aoi21_1
* cell instance $6067 m0 *1 689.36,1249.92
X$6067 21714 22167 21884 21997 17949 gf180mcu_fd_sc_mcu9t5v0__and2_1
* cell instance $6068 r0 *1 690.48,1290.24
X$6068 23316 22882 23319 23200 23197 gf180mcu_fd_sc_mcu9t5v0__nor2_1
* cell instance $6069 r0 *1 692.72,1239.84
X$6069 20983 21579 21884 21719 21839 gf180mcu_fd_sc_mcu9t5v0__nor2_1
* cell instance $6070 r0 *1 680.4,1260
X$6070 21238 22291 22166 11958 22449 22295 gf180mcu_fd_sc_mcu9t5v0__dffrnq_2
* cell instance $6071 m0 *1 689.92,1169.28
X$6071 18133 19448 19605 gf180mcu_fd_sc_mcu9t5v0__inv_3
* cell instance $6072 m0 *1 689.36,1179.36
X$6072 19898 19897 14999 19729 19901 19896 gf180mcu_fd_sc_mcu9t5v0__oai21_1
* cell instance $6073 r0 *1 684.88,1179.36
X$6073 18133 19896 19855 11958 20028 19901 gf180mcu_fd_sc_mcu9t5v0__dffrnq_2
* cell instance $6074 r0 *1 677.6,1219.68
X$6074 21238 21237 21358 11958 21241 21123 gf180mcu_fd_sc_mcu9t5v0__dffrnq_2
* cell instance $6075 r0 *1 676.48,1189.44
X$6075 20210 20379 20217 16439 gf180mcu_fd_sc_mcu9t5v0__buf_8
* cell instance $6076 m0 *1 684.32,1229.76
X$6076 22830 21358 21236 21241 21412 21237 gf180mcu_fd_sc_mcu9t5v0__mux2_1
* cell instance $6077 m0 *1 673.12,1209.6
X$6077 21238 20635 20636 11958 20637 20822 gf180mcu_fd_sc_mcu9t5v0__dffrnq_2
* cell instance $6078 r0 *1 679.28,1128.96
X$6078 18133 18265 18379 11958 18553 18386 gf180mcu_fd_sc_mcu9t5v0__dffrnq_2
* cell instance $6079 m0 *1 677.04,1149.12
X$6079 18961 18841 18996 18575 gf180mcu_fd_sc_mcu9t5v0__buf_8
* cell instance $6080 m0 *1 682.64,1159.2
X$6080 18961 19171 19282 19170 gf180mcu_fd_sc_mcu9t5v0__buf_8
* cell instance $6081 r0 *1 683.2,1108.8
X$6081 16641 17947 17948 11958 17985 17837 gf180mcu_fd_sc_mcu9t5v0__dffrnq_2
* cell instance $6082 m0 *1 686.56,1118.88
X$6082 17948 17946 12241 17985 18104 17947 gf180mcu_fd_sc_mcu9t5v0__mux2_1
* cell instance $6083 r0 *1 801.92,1310.4
X$6083 22839 23905 16517 11958 23957 23797 gf180mcu_fd_sc_mcu9t5v0__dffrnq_2
* cell instance $6084 r0 *1 798,1310.4
X$6084 16517 14820 23957 23797 23683 gf180mcu_fd_sc_mcu9t5v0__nand2_1
* cell instance $6085 r0 *1 790.72,1310.4
X$6085 16792 16517 23501 23957 23797 23956 gf180mcu_fd_sc_mcu9t5v0__mux2_1
* cell instance $6086 r0 *1 757.68,1350.72
X$6086 25124 25123 25158 25000 23904 gf180mcu_fd_sc_mcu9t5v0__xnor2_1
* cell instance $6087 r0 *1 733.04,1310.4
X$6087 22884 23952 23316 23957 23797 23955 gf180mcu_fd_sc_mcu9t5v0__mux2_1
* cell instance $6088 m0 *1 745.92,1310.4
X$6088 22838 23681 23318 11958 23623 23797 gf180mcu_fd_sc_mcu9t5v0__dffrnq_2
* cell instance $6089 r0 *1 753.2,1310.4
X$6089 23318 23903 13214 23957 23797 23681 gf180mcu_fd_sc_mcu9t5v0__mux2_1
* cell instance $6090 m0 *1 753.76,1330.56
X$6090 24412 24413 24232 24414 23903 23158 gf180mcu_fd_sc_mcu9t5v0__xnor3_1
* cell instance $6091 r0 *1 729.68,1310.4
X$6091 23797 23957 gf180mcu_fd_sc_mcu9t5v0__filltie
* cell instance $6092 r0 *1 770.56,1310.4
X$6092 23502 23904 13214 23957 23797 23958 gf180mcu_fd_sc_mcu9t5v0__mux2_1
* cell instance $6093 r0 *1 757.12,1330.56
X$6093 24413 24526 24527 24528 24414 24233 gf180mcu_fd_sc_mcu9t5v0__oai21_1
* cell instance $6094 r0 *1 749.28,1290.24
X$6094 22838 23199 23159 11958 23319 23200 gf180mcu_fd_sc_mcu9t5v0__dffrnq_2
* cell instance $6095 r0 *1 753.76,1270.08
X$6095 22838 22574 22575 11958 22700 22577 gf180mcu_fd_sc_mcu9t5v0__dffrnq_2
* cell instance $6096 m0 *1 753.2,1290.24
X$6096 23159 23158 13214 23038 23200 23199 gf180mcu_fd_sc_mcu9t5v0__mux2_1
* cell instance $6097 m0 *1 757.68,1249.92
X$6097 19566 21994 21884 21997 21995 gf180mcu_fd_sc_mcu9t5v0__nand2_1
* cell instance $6098 m0 *1 742,1260
X$6098 21238 22122 21994 11958 22124 22295 gf180mcu_fd_sc_mcu9t5v0__dffrnq_2
* cell instance $6099 r0 *1 756,1370.88
X$6099 25124 24412 25705 25581 25704 gf180mcu_fd_sc_mcu9t5v0__xnor2_1
* cell instance $6100 r0 *1 711.76,1310.4
X$6100 22292 23667 23316 23957 23797 23954 gf180mcu_fd_sc_mcu9t5v0__mux2_1
* cell instance $6101 m0 *1 759.36,1370.88
X$6101 25124 26877 25542 25835 25430 25581 25579
+ gf180mcu_fd_sc_mcu9t5v0__aoi211_1
* cell instance $6102 m0 *1 756.56,1300.32
X$6102 23159 23318 23501 23319 23504 23368 gf180mcu_fd_sc_mcu9t5v0__mux2_1
* cell instance $6103 r0 *1 773.36,1350.72
X$6103 25126 25127 24955 25158 25000 24999 gf180mcu_fd_sc_mcu9t5v0__aoi21_1
* cell instance $6104 r0 *1 792.96,1340.64
X$6104 17292 25159 13214 24828 24712 24574 gf180mcu_fd_sc_mcu9t5v0__mux2_1
* cell instance $6105 r0 *1 770.56,1350.72
X$6105 25126 25125 25158 25000 24572 gf180mcu_fd_sc_mcu9t5v0__nand2_1
* cell instance $6106 r0 *1 768.88,1340.64
X$6106 24827 24711 24828 24712 24573 gf180mcu_fd_sc_mcu9t5v0__nand2_1
* cell instance $6107 r0 *1 791.84,1320.48
X$6107 16792 14820 24232 24118 24282 gf180mcu_fd_sc_mcu9t5v0__nand2_1
* cell instance $6108 m0 *1 782.88,1330.56
X$6108 14820 24827 24282 24232 24414 24281 gf180mcu_fd_sc_mcu9t5v0__oai21_1
* cell instance $6109 m0 *1 796.32,1350.72
X$6109 16963 17087 23501 24828 25000 24957 gf180mcu_fd_sc_mcu9t5v0__mux2_1
* cell instance $6110 r0 *1 765.52,1330.56
X$6110 24827 24711 24528 24414 24529 gf180mcu_fd_sc_mcu9t5v0__nor2_1
* cell instance $6111 m0 *1 769.44,1360.8
X$6111 25159 25996 25158 25268 25127 gf180mcu_fd_sc_mcu9t5v0__or2_1
* cell instance $6112 m0 *1 768.88,1330.56
X$6112 22838 24232 24414 gf180mcu_fd_sc_mcu9t5v0__inv_4
* cell instance $6113 m0 *1 766.64,1340.64
X$6113 24573 24572 24529 24528 24712 24413 gf180mcu_fd_sc_mcu9t5v0__aoi21_1
* cell instance $6114 m0 *1 773.92,1360.8
X$6114 25159 25996 25158 25268 25126 gf180mcu_fd_sc_mcu9t5v0__nand2_1
* cell instance $6115 r0 *1 812.56,1330.56
X$6115 20383 26512 13214 24528 24414 24530 gf180mcu_fd_sc_mcu9t5v0__mux2_1
* cell instance $6116 m0 *1 813.12,1360.8
X$6116 25130 25272 13214 25158 25268 25129 gf180mcu_fd_sc_mcu9t5v0__mux2_1
* cell instance $6117 m0 *1 775.6,1350.72
X$6117 25127 24955 24828 25000 25125 gf180mcu_fd_sc_mcu9t5v0__nand2_1
* cell instance $6118 r0 *1 787.36,1350.72
X$6118 25128 24956 25158 25000 25115 gf180mcu_fd_sc_mcu9t5v0__nand2_1
* cell instance $6119 r0 *1 760.48,1320.48
X$6119 24234 23904 24232 24118 23682 24233 gf180mcu_fd_sc_mcu9t5v0__xnor3_1
* cell instance $6120 r0 *1 811.44,1320.48
X$6120 17577 24235 13214 24232 24118 24081 gf180mcu_fd_sc_mcu9t5v0__mux2_1
* cell instance $6121 m0 *1 801.36,1360.8
X$6121 25271 25270 13214 25158 25268 25269 gf180mcu_fd_sc_mcu9t5v0__mux2_1
* cell instance $6122 r0 *1 796.32,1360.8
X$6122 22838 25269 25271 11958 25430 25268 gf180mcu_fd_sc_mcu9t5v0__dffrnq_2
* cell instance $6123 r0 *1 768.88,1330.56
X$6123 19567 24528 24414 22838 gf180mcu_fd_sc_mcu9t5v0__clkbuf_8
* cell instance $6124 m0 *1 809.2,1320.48
X$6124 22839 24081 17577 11958 23957 24118 gf180mcu_fd_sc_mcu9t5v0__dffrnq_2
* cell instance $6125 m0 *1 785.12,1350.72
X$6125 15399 24957 24952 13895 24828 25000 24956
+ gf180mcu_fd_sc_mcu9t5v0__aoi22_1
* cell instance $6126 m0 *1 791.28,1340.64
X$6126 22838 24574 17292 11958 24528 24712 gf180mcu_fd_sc_mcu9t5v0__dffrnq_2
* cell instance $6127 r0 *1 815.36,1360.8
X$6127 25271 25130 23501 25430 25268 25431 gf180mcu_fd_sc_mcu9t5v0__mux2_1
* cell instance $6128 m0 *1 764.96,1370.88
X$6128 25543 25430 25581 25124 gf180mcu_fd_sc_mcu9t5v0__clkinv_1
* cell instance $6129 r0 *1 764.4,1370.88
X$6129 22838 25579 25543 11958 25705 25581 gf180mcu_fd_sc_mcu9t5v0__dffrnq_2
* cell instance $6130 r0 *1 783.44,1370.88
X$6130 22838 25580 16963 11958 25705 25581 gf180mcu_fd_sc_mcu9t5v0__dffrnq_2
* cell instance $6131 m0 *1 786.24,1370.88
X$6131 14820 26292 25544 25430 25581 25580 gf180mcu_fd_sc_mcu9t5v0__oai21_1
* cell instance $6132 m0 *1 792.96,1370.88
X$6132 16963 14820 25430 25581 25544 gf180mcu_fd_sc_mcu9t5v0__nand2_1
* cell instance $6133 m0 *1 768.88,1320.48
X$6133 22838 23958 23502 11958 23957 24118 gf180mcu_fd_sc_mcu9t5v0__dffrnq_2
* cell instance $6134 m0 *1 787.36,1330.56
X$6134 22838 24281 16792 11958 24232 24414 gf180mcu_fd_sc_mcu9t5v0__dffrnq_2
* cell instance $6135 r0 *1 777.84,1350.72
X$6135 25127 24955 24999 25158 25000 23624 gf180mcu_fd_sc_mcu9t5v0__aoi21_1
* cell instance $6136 r0 *1 772.24,1340.64
X$6136 12129 24828 24712 24826 gf180mcu_fd_sc_mcu9t5v0__clkbuf_8
* cell instance $6137 m0 *1 771.12,1340.64
X$6137 24827 24572 24528 24712 24117 24711 gf180mcu_fd_sc_mcu9t5v0__xnor3_1
* cell instance $6138 m0 *1 731.36,1350.72
X$6138 25118 24953 24828 25000 24827 24951 gf180mcu_fd_sc_mcu9t5v0__xnor3_1
* cell instance $6139 r0 *1 729.68,1340.64
X$6139 24712 24828 gf180mcu_fd_sc_mcu9t5v0__filltie
* cell instance $6140 r0 *1 733.04,1350.72
X$6140 25118 24951 25158 25000 24998 gf180mcu_fd_sc_mcu9t5v0__and2_1
* cell instance $6141 r0 *1 753.76,1330.56
X$6141 24412 23158 24528 24414 24526 gf180mcu_fd_sc_mcu9t5v0__nor2_1
* cell instance $6142 m0 *1 756,1340.64
X$6142 24412 23158 24528 24712 24527 gf180mcu_fd_sc_mcu9t5v0__nand2_1
* cell instance $6143 r0 *1 748.16,1350.72
X$6143 25119 25120 25158 25000 25122 gf180mcu_fd_sc_mcu9t5v0__nor2_1
* cell instance $6144 r0 *1 745.36,1350.72
X$6144 25119 25120 25158 25000 25121 gf180mcu_fd_sc_mcu9t5v0__nand2_1
* cell instance $6145 r0 *1 729.68,1360.8
X$6145 25268 25430 gf180mcu_fd_sc_mcu9t5v0__filltie
* cell instance $6146 r0 *1 751.52,1350.72
X$6146 24954 25122 25121 25158 25000 25123 gf180mcu_fd_sc_mcu9t5v0__oai21_1
* cell instance $6147 m0 *1 732.48,1360.8
X$6147 25118 24951 25158 25268 25267 gf180mcu_fd_sc_mcu9t5v0__or2_1
* cell instance $6148 r0 *1 751.52,1370.88
X$6148 25704 25577 25705 25581 25832 gf180mcu_fd_sc_mcu9t5v0__or2_1
* cell instance $6149 r0 *1 723.52,1330.56
X$6149 24525 23364 15575 24528 24414 24409 gf180mcu_fd_sc_mcu9t5v0__aoi21_1
* cell instance $6150 m0 *1 717.36,1370.88
X$6150 25541 25540 25542 25430 25581 25702 gf180mcu_fd_sc_mcu9t5v0__aoi21_1
* cell instance $6151 m0 *1 700,1350.72
X$6151 24947 23196 24828 25000 19897 gf180mcu_fd_sc_mcu9t5v0__nor2_1
* cell instance $6152 r0 *1 709.52,1320.48
X$6152 23316 22573 24232 24118 24948 gf180mcu_fd_sc_mcu9t5v0__nor2_1
* cell instance $6153 m0 *1 692.72,1350.72
X$6153 24946 15269 25827 24828 25000 24523 gf180mcu_fd_sc_mcu9t5v0__nand3_1
* cell instance $6154 m0 *1 708.96,1350.72
X$6154 23316 24947 24828 25000 24949 gf180mcu_fd_sc_mcu9t5v0__nor2_1
* cell instance $6155 r0 *1 712.88,1320.48
X$6155 22883 18990 24232 24118 24231 gf180mcu_fd_sc_mcu9t5v0__nor2_1
* cell instance $6156 r0 *1 739.76,1370.88
X$6156 25703 25576 25578 25705 25581 25577 gf180mcu_fd_sc_mcu9t5v0__oai21_1
* cell instance $6157 r0 *1 701.68,1320.48
X$6157 18990 24232 24118 24114 gf180mcu_fd_sc_mcu9t5v0__clkinv_1
* cell instance $6158 r0 *1 703.92,1320.48
X$6158 19723 24114 23621 22883 24232 24118 24115
+ gf180mcu_fd_sc_mcu9t5v0__aoi211_1
* cell instance $6159 m0 *1 703.36,1350.72
X$6159 23316 23669 24947 24948 24828 25000 24997
+ gf180mcu_fd_sc_mcu9t5v0__aoi211_1
* cell instance $6160 m0 *1 739.2,1330.56
X$6160 24280 24232 24414 23153 gf180mcu_fd_sc_mcu9t5v0__buf_8
* cell instance $6161 m0 *1 694.4,1370.88
X$6161 25539 24947 25430 25581 25537 gf180mcu_fd_sc_mcu9t5v0__or2_2
* cell instance $6162 r0 *1 697.2,1370.88
X$6162 25537 24709 25574 24947 25705 25581 25701
+ gf180mcu_fd_sc_mcu9t5v0__oai22_1
* cell instance $6163 r0 *1 701.12,1350.72
X$6163 25539 25158 25000 23316 gf180mcu_fd_sc_mcu9t5v0__buf_8
* cell instance $6164 r0 *1 691.04,1370.88
X$6164 25537 25827 25705 25581 25866 gf180mcu_fd_sc_mcu9t5v0__or2_1
* cell instance $6165 r0 *1 746.48,1370.88
X$6165 25830 25829 25705 25581 24711 gf180mcu_fd_sc_mcu9t5v0__nand2_1
* cell instance $6166 m0 *1 704.48,1320.48
X$6166 22883 23196 18990 23957 24118 24116 gf180mcu_fd_sc_mcu9t5v0__nor3_1
* cell instance $6167 r0 *1 729.68,1370.88
X$6167 25581 25705 gf180mcu_fd_sc_mcu9t5v0__filltie
* cell instance $6168 m0 *1 720.16,1330.56
X$6168 22838 24278 24280 11958 24232 24414 gf180mcu_fd_sc_mcu9t5v0__dffrnq_2
* cell instance $6169 m0 *1 756.56,1370.88
X$6169 25704 25577 25430 25581 25834 gf180mcu_fd_sc_mcu9t5v0__nand2_1
* cell instance $6170 r0 *1 729.68,1320.48
X$6170 24118 24232 gf180mcu_fd_sc_mcu9t5v0__filltie
* cell instance $6171 m0 *1 739.2,1370.88
X$6171 25119 25430 25581 24711 25576 gf180mcu_fd_sc_mcu9t5v0__xor2_1
* cell instance $6172 r0 *1 734.72,1370.88
X$6172 25703 25576 25705 25581 25868 gf180mcu_fd_sc_mcu9t5v0__nand2_1
* cell instance $6173 r0 *1 739.2,1350.72
X$6173 25267 24953 24998 25158 25000 24954 gf180mcu_fd_sc_mcu9t5v0__aoi21_1
* cell instance $6174 r0 *1 722.4,1320.48
X$6174 23153 24411 24232 24118 24279 gf180mcu_fd_sc_mcu9t5v0__nand2_1
* cell instance $6175 m0 *1 744.24,1350.72
X$6175 25119 24954 24828 25000 23158 25120 gf180mcu_fd_sc_mcu9t5v0__xnor3_1
* cell instance $6176 r0 *1 708.96,1370.88
X$6176 22838 25702 25119 11958 25705 25581 gf180mcu_fd_sc_mcu9t5v0__dffrnq_2
* cell instance $6177 m0 *1 718.48,1360.8
X$6177 25266 23680 15575 25158 25268 25263 gf180mcu_fd_sc_mcu9t5v0__aoi21_1
* cell instance $6178 m0 *1 738.64,1320.48
X$6178 15399 23956 23955 13895 23957 24118 24080
+ gf180mcu_fd_sc_mcu9t5v0__aoi22_1
* cell instance $6179 m0 *1 715.68,1330.56
X$6179 24231 24411 24279 24232 24414 24278 gf180mcu_fd_sc_mcu9t5v0__oai21_1
* cell instance $6180 m0 *1 712.32,1350.72
X$6180 24949 24828 25000 15269 gf180mcu_fd_sc_mcu9t5v0__buf_8
* cell instance $6181 r0 *1 729.68,1330.56
X$6181 24414 24528 gf180mcu_fd_sc_mcu9t5v0__filltie
* cell instance $6182 m0 *1 726.88,1350.72
X$6182 24950 23367 15575 24828 25000 24991 gf180mcu_fd_sc_mcu9t5v0__aoi21_1
* cell instance $6183 r0 *1 729.68,1350.72
X$6183 25000 25158 gf180mcu_fd_sc_mcu9t5v0__filltie
* cell instance $6184 r0 *1 729.68,1260
X$6184 22295 22449 gf180mcu_fd_sc_mcu9t5v0__filltie
* cell instance $6185 r0 *1 737.52,1290.24
X$6185 21240 22824 23316 23319 23200 23198 gf180mcu_fd_sc_mcu9t5v0__mux2_1
* cell instance $6186 r0 *1 701.68,1300.32
X$6186 22883 19277 23621 23623 23504 23363 gf180mcu_fd_sc_mcu9t5v0__mux2_1
* cell instance $6187 r0 *1 717.36,1290.24
X$6187 22698 23195 23316 23319 23200 23317 gf180mcu_fd_sc_mcu9t5v0__mux2_1
* cell instance $6188 r0 *1 733.04,1249.92
X$6188 14809 22121 20986 22124 21997 22120 gf180mcu_fd_sc_mcu9t5v0__mux2_1
* cell instance $6189 r0 *1 733.04,1270.08
X$6189 13159 22884 20986 22700 22577 22699 gf180mcu_fd_sc_mcu9t5v0__mux2_1
* cell instance $6190 m0 *1 696.08,1300.32
X$6190 23037 23363 19277 11958 23319 23504 gf180mcu_fd_sc_mcu9t5v0__dffrnq_2
* cell instance $6191 m0 *1 730.8,1300.32
X$6191 21534 23677 23316 23319 23504 23366 gf180mcu_fd_sc_mcu9t5v0__mux2_1
* cell instance $6192 m0 *1 696.08,1270.08
X$6192 21238 22448 22573 11958 22449 22577 gf180mcu_fd_sc_mcu9t5v0__dffrnq_2
* cell instance $6193 r0 *1 735.84,1300.32
X$6193 22121 23612 23316 23623 23504 24952 gf180mcu_fd_sc_mcu9t5v0__mux2_1
* cell instance $6194 m0 *1 701.12,1249.92
X$6194 21883 21884 21997 19726 gf180mcu_fd_sc_mcu9t5v0__buf_8
* cell instance $6195 m0 *1 722.96,1260
X$6195 21238 22120 22121 11958 22124 22295 gf180mcu_fd_sc_mcu9t5v0__dffrnq_2
* cell instance $6196 r0 *1 729.68,1270.08
X$6196 22577 22700 gf180mcu_fd_sc_mcu9t5v0__filltie
* cell instance $6197 r0 *1 729.68,1300.32
X$6197 23504 23623 gf180mcu_fd_sc_mcu9t5v0__filltie
* cell instance $6198 r0 *1 752.08,1249.92
X$6198 21994 22123 21536 22124 21997 22122 gf180mcu_fd_sc_mcu9t5v0__mux2_1
* cell instance $6199 r0 *1 702.8,1260
X$6199 13874 22573 20986 22449 22295 22448 gf180mcu_fd_sc_mcu9t5v0__mux2_1
* cell instance $6200 m0 *1 725.76,1300.32
X$6200 15399 23368 23366 13895 23319 23504 23367
+ gf180mcu_fd_sc_mcu9t5v0__aoi22_1
* cell instance $6201 m0 *1 716.24,1310.4
X$6201 13895 23622 23679 15399 23623 23797 23680
+ gf180mcu_fd_sc_mcu9t5v0__aoi22_1
* cell instance $6202 r0 *1 715.12,1270.08
X$6202 14856 22698 20986 22700 22577 23007 gf180mcu_fd_sc_mcu9t5v0__mux2_1
* cell instance $6203 m0 *1 694.4,1249.92
X$6203 14019 21714 20689 21839 21884 21997 21883
+ gf180mcu_fd_sc_mcu9t5v0__nand4_1
* cell instance $6204 r0 *1 745.36,1270.08
X$6204 11323 22700 22577 14856 gf180mcu_fd_sc_mcu9t5v0__clkbuf_1
* cell instance $6205 r0 *1 729.68,1290.24
X$6205 23200 23319 gf180mcu_fd_sc_mcu9t5v0__filltie
* cell instance $6206 m0 *1 717.36,1280.16
X$6206 23037 22699 22884 11958 22700 22885 gf180mcu_fd_sc_mcu9t5v0__dffrnq_2
* cell instance $6207 r0 *1 729.68,1280.16
X$6207 22885 23038 gf180mcu_fd_sc_mcu9t5v0__filltie
* cell instance $6208 m0 *1 703.92,1260
X$6208 21238 22119 22292 11958 22124 22295 gf180mcu_fd_sc_mcu9t5v0__dffrnq_2
* cell instance $6209 r0 *1 707.84,1280.16
X$6209 23037 23007 22698 11958 23038 22885 gf180mcu_fd_sc_mcu9t5v0__dffrnq_2
* cell instance $6210 r0 *1 714.56,1249.92
X$6210 14854 22292 20986 22124 21997 22119 gf180mcu_fd_sc_mcu9t5v0__mux2_1
* cell instance $6211 r0 *1 716.8,1300.32
X$6211 21581 23500 23316 23623 23504 23622 gf180mcu_fd_sc_mcu9t5v0__mux2_1
* cell instance $6212 r0 *1 729.68,1249.92
X$6212 21997 22124 gf180mcu_fd_sc_mcu9t5v0__filltie
* cell instance $6213 m0 *1 720.72,1300.32
X$6213 15399 23365 23317 13895 23319 23504 23364
+ gf180mcu_fd_sc_mcu9t5v0__aoi22_1
* cell instance $6214 m0 *1 736.4,1280.16
X$6214 22838 24710 23035 11958 22700 22885 gf180mcu_fd_sc_mcu9t5v0__dffrnq_2
* cell instance $6215 m0 *1 786.24,1280.16
X$6215 22839 22703 22576 11958 22700 22885 gf180mcu_fd_sc_mcu9t5v0__dffrnq_2
* cell instance $6216 m0 *1 805.28,1280.16
X$6216 22839 22704 22705 22700 22885 gf180mcu_fd_sc_mcu9t5v0__dffq_2
* cell instance $6217 r0 *1 774.48,1270.08
X$6217 22575 22702 18585 22700 22577 22701 gf180mcu_fd_sc_mcu9t5v0__mux2_1
* cell instance $6218 r0 *1 782.88,1260
X$6218 21409 22294 22170 22449 22295 gf180mcu_fd_sc_mcu9t5v0__dffq_2
* cell instance $6219 m0 *1 786.24,1260
X$6219 18585 22125 22169 22124 22295 22294 gf180mcu_fd_sc_mcu9t5v0__oai21_1
* cell instance $6220 m0 *1 790.72,1260
X$6220 22170 18585 22124 22295 22169 gf180mcu_fd_sc_mcu9t5v0__nand2_1
* cell instance $6221 r0 *1 792.4,1270.08
X$6221 22576 14850 21536 22700 22577 22703 gf180mcu_fd_sc_mcu9t5v0__mux2_1
* cell instance $6222 r0 *1 779.52,1280.16
X$6222 19566 23038 22885 21121 gf180mcu_fd_sc_mcu9t5v0__clkinv_1
* cell instance $6223 r0 *1 791.28,1290.24
X$6223 17292 23320 23501 23319 23200 23365 gf180mcu_fd_sc_mcu9t5v0__mux2_1
* cell instance $6224 m0 *1 804.72,1260
X$6224 14123 21998 20215 22124 22295 22127 gf180mcu_fd_sc_mcu9t5v0__mux2_1
* cell instance $6225 r0 *1 819.28,1249.92
X$6225 22000 21413 21122 22124 21997 22128 gf180mcu_fd_sc_mcu9t5v0__mux2_1
* cell instance $6226 r0 *1 800.24,1249.92
X$6226 21409 22127 21998 12383 22124 21997 gf180mcu_fd_sc_mcu9t5v0__dffrnq_2
* cell instance $6227 r0 *1 805.84,1280.16
X$6227 14850 22576 19566 23038 22885 22886 gf180mcu_fd_sc_mcu9t5v0__mux2_1
* cell instance $6228 m0 *1 812,1249.92
X$6228 21409 21884 21997 gf180mcu_fd_sc_mcu9t5v0__inv_3
* cell instance $6229 m0 *1 810.32,1300.32
X$6229 15399 23371 23198 13895 23319 23504 23370
+ gf180mcu_fd_sc_mcu9t5v0__aoi22_1
* cell instance $6230 m0 *1 771.12,1310.4
X$6230 19863 23682 13214 23623 23797 23369 gf180mcu_fd_sc_mcu9t5v0__mux2_1
* cell instance $6231 m0 *1 768.88,1300.32
X$6231 22838 23369 19863 11958 23319 23504 gf180mcu_fd_sc_mcu9t5v0__dffrnq_2
* cell instance $6232 m0 *1 759.92,1270.08
X$6232 22575 22123 21122 22449 22577 22574 gf180mcu_fd_sc_mcu9t5v0__mux2_1
* cell instance $6233 m0 *1 815.92,1300.32
X$6233 20383 17577 23501 23319 23504 23371 gf180mcu_fd_sc_mcu9t5v0__mux2_1
* cell instance $6234 m0 *1 792.96,1310.4
X$6234 14820 24117 23683 23623 23797 23905 gf180mcu_fd_sc_mcu9t5v0__oai21_1
* cell instance $6235 r0 *1 774.48,1249.92
X$6235 21996 22293 18585 22124 21997 22126 gf180mcu_fd_sc_mcu9t5v0__mux2_1
* cell instance $6236 r0 *1 771.12,1300.32
X$6236 23502 19863 23501 23623 23504 23679 gf180mcu_fd_sc_mcu9t5v0__mux2_1
* cell instance $6237 r0 *1 770.56,1249.92
X$6237 19566 14123 22124 21997 22125 gf180mcu_fd_sc_mcu9t5v0__nand2_1
* cell instance $6238 m0 *1 761.04,1260
X$6238 21840 22125 22124 22295 22123 gf180mcu_fd_sc_mcu9t5v0__nand2_1
* cell instance $6239 m0 *1 769.44,1260
X$6239 21409 22126 22293 22124 22295 gf180mcu_fd_sc_mcu9t5v0__dffq_2
* cell instance $6240 m0 *1 768.88,1280.16
X$6240 22839 22701 22702 22700 22885 gf180mcu_fd_sc_mcu9t5v0__dffq_2
* cell instance $6241 r0 *1 788.48,1300.32
X$6241 23320 23624 13214 23623 23504 23503 gf180mcu_fd_sc_mcu9t5v0__mux2_1
* cell instance $6242 r0 *1 761.04,1249.92
X$6242 21840 21995 22124 21997 21996 gf180mcu_fd_sc_mcu9t5v0__nand2_1
* cell instance $6243 m0 *1 821.52,1249.92
X$6243 21999 21884 21997 22578 gf180mcu_fd_sc_mcu9t5v0__clkinv_1
* cell instance $6244 r0 *1 809.2,1270.08
X$6244 22886 22705 18585 22700 22577 22704 gf180mcu_fd_sc_mcu9t5v0__mux2_1
* cell instance $6245 m0 *1 791.28,1300.32
X$6245 22839 23503 23320 11958 23319 23504 gf180mcu_fd_sc_mcu9t5v0__dffrnq_2
* cell instance $6246 r0 *1 669.76,1310.4
X$6246 23677 23675 23957 23797 23361 gf180mcu_fd_sc_mcu9t5v0__nand2_1
* cell instance $6247 r0 *1 663.6,1310.4
X$6247 23953 22158 23676 23957 23797 23901 gf180mcu_fd_sc_mcu9t5v0__and3_1
* cell instance $6248 r0 *1 675.36,1310.4
X$6248 22158 23678 23957 23797 23902 gf180mcu_fd_sc_mcu9t5v0__nand2_1
* cell instance $6249 r0 *1 631.12,1310.4
X$6249 23900 23614 23957 23797 23899 gf180mcu_fd_sc_mcu9t5v0__xnor2_1
* cell instance $6250 r0 *1 628.32,1310.4
X$6250 22158 23899 23957 23797 23951 gf180mcu_fd_sc_mcu9t5v0__nand2_1
* cell instance $6251 m0 *1 614.32,1330.56
X$6251 23036 24275 24229 18834 24232 24414 gf180mcu_fd_sc_mcu9t5v0__dffrnq_2
* cell instance $6252 m0 *1 610.96,1350.72
X$6252 23036 24825 24989 18834 24828 25000 gf180mcu_fd_sc_mcu9t5v0__dffrnq_2
* cell instance $6253 r0 *1 614.88,1340.64
X$6253 17943 24989 12245 24828 24712 24825 gf180mcu_fd_sc_mcu9t5v0__mux2_1
* cell instance $6254 r0 *1 641.76,1310.4
X$6254 23952 23957 23797 23900 gf180mcu_fd_sc_mcu9t5v0__clkinv_1
* cell instance $6255 r0 *1 621.04,1350.72
X$6255 17943 25114 24990 24989 24991 25158 25000 24992
+ gf180mcu_fd_sc_mcu9t5v0__aoi221_1
* cell instance $6256 m0 *1 610.96,1310.4
X$6256 23674 23623 23797 21529 gf180mcu_fd_sc_mcu9t5v0__buf_8
* cell instance $6257 m0 *1 617.68,1360.8
X$6257 25157 24990 18572 25114 25263 25158 25268 25264
+ gf180mcu_fd_sc_mcu9t5v0__aoi221_1
* cell instance $6258 m0 *1 619.36,1249.92
X$6258 21571 21993 21881 21884 21997 21837 gf180mcu_fd_sc_mcu9t5v0__nand3_1
* cell instance $6259 r0 *1 605.92,1280.16
X$6259 23037 22878 21572 11958 23038 22885 gf180mcu_fd_sc_mcu9t5v0__dffrnq_2
* cell instance $6260 r0 *1 608.72,1290.24
X$6260 23037 21579 21574 11958 23319 23200 gf180mcu_fd_sc_mcu9t5v0__dffrnq_2
* cell instance $6261 r0 *1 609.84,1260
X$6261 21238 22407 22445 11958 22449 22295 gf180mcu_fd_sc_mcu9t5v0__dffrnq_2
* cell instance $6262 m0 *1 617.12,1270.08
X$6262 20826 22445 21236 22449 22577 22407 gf180mcu_fd_sc_mcu9t5v0__mux2_1
* cell instance $6263 m0 *1 616.56,1370.88
X$6263 25700 25430 25581 18264 gf180mcu_fd_sc_mcu9t5v0__buf_8
* cell instance $6264 m0 *1 671.44,1350.72
X$6264 19567 24828 25000 33576 gf180mcu_fd_sc_mcu9t5v0__clkbuf_8
* cell instance $6265 m0 *1 685.44,1340.64
X$6265 24568 24570 15269 24528 24712 24571 gf180mcu_fd_sc_mcu9t5v0__nand3_1
* cell instance $6266 r0 *1 677.04,1330.56
X$6266 24524 24523 24528 24414 24230 gf180mcu_fd_sc_mcu9t5v0__nand2_1
* cell instance $6267 m0 *1 653.52,1340.64
X$6267 23037 24522 24569 11958 24528 24712 gf180mcu_fd_sc_mcu9t5v0__dffrnq_2
* cell instance $6268 m0 *1 650.72,1360.8
X$6268 24995 25158 25268 25265 gf180mcu_fd_sc_mcu9t5v0__buf_8
* cell instance $6269 m0 *1 648.48,1370.88
X$6269 25825 16503 25430 25581 25573 gf180mcu_fd_sc_mcu9t5v0__nand2_1
* cell instance $6270 r0 *1 633.36,1330.56
X$6270 24229 24990 17832 25114 24409 24528 24414 24408
+ gf180mcu_fd_sc_mcu9t5v0__aoi221_2
* cell instance $6271 r0 *1 627.2,1350.72
X$6271 23036 24993 24944 18834 25158 25000 gf180mcu_fd_sc_mcu9t5v0__dffrnq_2
* cell instance $6272 m0 *1 638.4,1330.56
X$6272 23037 24276 21880 11958 24232 24414 gf180mcu_fd_sc_mcu9t5v0__dffrnq_2
* cell instance $6273 m0 *1 650.16,1320.48
X$6273 23037 23901 23953 11958 23957 24118 gf180mcu_fd_sc_mcu9t5v0__dffrnq_2
* cell instance $6274 r0 *1 679.84,1320.48
X$6274 16439 24230 24232 24118 24277 gf180mcu_fd_sc_mcu9t5v0__nand2_1
* cell instance $6275 r0 *1 663.6,1330.56
X$6275 20985 19891 24523 24569 24528 24414 24410
+ gf180mcu_fd_sc_mcu9t5v0__aoi22_1
* cell instance $6276 m0 *1 642.32,1350.72
X$6276 24944 24990 24828 25000 24945 gf180mcu_fd_sc_mcu9t5v0__nand2_1
* cell instance $6277 m0 *1 643.44,1340.64
X$6277 23316 24568 24528 24712 22163 gf180mcu_fd_sc_mcu9t5v0__nand2_1
* cell instance $6278 r0 *1 622.16,1320.48
X$6278 17832 24229 12245 24232 24118 24275 gf180mcu_fd_sc_mcu9t5v0__mux2_1
* cell instance $6279 m0 *1 633.36,1330.56
X$6279 18577 18578 24232 24414 25114 gf180mcu_fd_sc_mcu9t5v0__nand2_1
* cell instance $6280 m0 *1 645.68,1350.72
X$6280 24945 24994 24828 25000 24995 gf180mcu_fd_sc_mcu9t5v0__nand2_1
* cell instance $6281 m0 *1 634.48,1350.72
X$6281 18098 24944 12245 24828 25000 24993 gf180mcu_fd_sc_mcu9t5v0__mux2_1
* cell instance $6282 r0 *1 659.68,1330.56
X$6282 24410 24528 24414 24522 gf180mcu_fd_sc_mcu9t5v0__clkinv_1
* cell instance $6283 r0 *1 646.24,1350.72
X$6283 25114 18098 25115 13151 25158 25000 24994
+ gf180mcu_fd_sc_mcu9t5v0__aoi22_1
* cell instance $6284 r0 *1 678.72,1350.72
X$6284 24524 15399 15575 25158 25000 24996 gf180mcu_fd_sc_mcu9t5v0__nor3_1
* cell instance $6285 r0 *1 676.48,1360.8
X$6285 25429 25117 25430 25268 25317 gf180mcu_fd_sc_mcu9t5v0__nand2_1
* cell instance $6286 m0 *1 630,1320.48
X$6286 23037 23951 23952 11958 23957 24118 gf180mcu_fd_sc_mcu9t5v0__dffrnq_2
* cell instance $6287 r0 *1 679.84,1330.56
X$6287 24946 24524 15269 24528 24414 24276 gf180mcu_fd_sc_mcu9t5v0__and3_1
* cell instance $6288 r0 *1 654.64,1350.72
X$6288 25116 25158 25000 13193 gf180mcu_fd_sc_mcu9t5v0__buf_8
* cell instance $6289 m0 *1 682.08,1340.64
X$6289 24569 24524 24528 24712 24709 gf180mcu_fd_sc_mcu9t5v0__nor2_1
* cell instance $6290 r0 *1 674.8,1350.72
X$6290 24946 24569 15269 25158 25000 25117 gf180mcu_fd_sc_mcu9t5v0__nand3_1
* cell instance $6291 r0 *1 623.84,1370.88
X$6291 23036 25822 25823 18834 25705 25581 gf180mcu_fd_sc_mcu9t5v0__dffrnq_2
* cell instance $6292 m0 *1 670.32,1330.56
X$6292 23037 24277 24524 11958 24232 24414 gf180mcu_fd_sc_mcu9t5v0__dffrnq_2
* cell instance $6293 r0 *1 644.56,1370.88
X$6293 25573 25705 25581 12245 gf180mcu_fd_sc_mcu9t5v0__buf_8
* cell instance $6294 m0 *1 668.64,1370.88
X$6294 26328 25317 24570 11958 25430 25581 gf180mcu_fd_sc_mcu9t5v0__dffrnq_2
* cell instance $6295 r0 *1 683.2,1370.88
X$6295 25537 25827 25705 25581 26506 gf180mcu_fd_sc_mcu9t5v0__nor2_1
* cell instance $6296 r0 *1 663.04,1360.8
X$6296 13154 13151 25116 25430 25268 25316 gf180mcu_fd_sc_mcu9t5v0__nor3_1
* cell instance $6297 r0 *1 686.56,1370.88
X$6297 25575 25574 25705 25581 21876 gf180mcu_fd_sc_mcu9t5v0__nor2_1
* cell instance $6298 r0 *1 670.88,1360.8
X$6298 24996 25316 25430 25268 25428 gf180mcu_fd_sc_mcu9t5v0__nor2_1
* cell instance $6299 m0 *1 589.68,1350.72
X$6299 23314 24228 21236 24828 25000 25112 gf180mcu_fd_sc_mcu9t5v0__mux2_1
* cell instance $6300 m0 *1 552.72,1320.48
X$6300 20826 22405 23957 24118 24075 gf180mcu_fd_sc_mcu9t5v0__nand2_1
* cell instance $6301 m0 *1 564.48,1320.48
X$6301 24113 23957 24118 24077 gf180mcu_fd_sc_mcu9t5v0__clkinv_1
* cell instance $6302 m0 *1 598.08,1330.56
X$6302 18430 23950 24232 24414 24274 gf180mcu_fd_sc_mcu9t5v0__nor2_1
* cell instance $6303 r0 *1 558.88,1340.64
X$6303 24707 24565 24566 24828 24712 24706 gf180mcu_fd_sc_mcu9t5v0__oai21_1
* cell instance $6304 r0 *1 571.2,1340.64
X$6304 20826 24708 24702 24828 24712 24943 gf180mcu_fd_sc_mcu9t5v0__mux2_1
* cell instance $6305 r0 *1 563.36,1340.64
X$6305 24708 24707 24819 24828 24712 24824 gf180mcu_fd_sc_mcu9t5v0__mux2_1
* cell instance $6306 r0 *1 577.92,1370.88
X$6306 23036 25572 25698 18834 25705 25581 gf180mcu_fd_sc_mcu9t5v0__dffrnq_2
* cell instance $6307 m0 *1 553.84,1340.64
X$6307 21531 24077 24706 24823 23004 24528 24712 21715
+ gf180mcu_fd_sc_mcu9t5v0__aoi221_1
* cell instance $6308 r0 *1 584.64,1340.64
X$6308 23314 24520 22163 24828 24712 24519 gf180mcu_fd_sc_mcu9t5v0__mux2_1
* cell instance $6309 m0 *1 609.84,1350.72
X$6309 25000 24828 gf180mcu_fd_sc_mcu9t5v0__filltie
* cell instance $6310 m0 *1 609.84,1340.64
X$6310 24712 24528 gf180mcu_fd_sc_mcu9t5v0__filltie
* cell instance $6311 r0 *1 597.52,1330.56
X$6311 18430 24521 24274 21531 24528 24414 24407
+ gf180mcu_fd_sc_mcu9t5v0__aoi211_1
* cell instance $6312 r0 *1 596.96,1350.72
X$6312 23036 25113 25157 18834 25158 25000 gf180mcu_fd_sc_mcu9t5v0__dffrnq_2
* cell instance $6313 m0 *1 602,1330.56
X$6313 21531 24520 24407 13904 24232 24414 18439
+ gf180mcu_fd_sc_mcu9t5v0__aoi211_1
* cell instance $6314 m0 *1 565.6,1370.88
X$6314 22443 25570 24702 25430 25581 25571 gf180mcu_fd_sc_mcu9t5v0__mux2_1
* cell instance $6315 m0 *1 609.84,1360.8
X$6315 25268 25158 gf180mcu_fd_sc_mcu9t5v0__filltie
* cell instance $6316 r0 *1 576.8,1330.56
X$6316 23036 24519 24520 18834 24528 24414 gf180mcu_fd_sc_mcu9t5v0__dffrnq_2
* cell instance $6317 r0 *1 612.08,1330.56
X$6317 23316 22114 24528 24414 25574 gf180mcu_fd_sc_mcu9t5v0__nand2_1
* cell instance $6318 m0 *1 609.84,1370.88
X$6318 25581 25430 gf180mcu_fd_sc_mcu9t5v0__filltie
* cell instance $6319 m0 *1 586.32,1330.56
X$6319 23036 24232 24414 gf180mcu_fd_sc_mcu9t5v0__clkbuf_4
* cell instance $6320 m0 *1 602.56,1360.8
X$6320 18572 25157 12245 25158 25268 25113 gf180mcu_fd_sc_mcu9t5v0__mux2_1
* cell instance $6321 r0 *1 553.28,1360.8
X$6321 25315 24565 24566 25430 25268 25314 gf180mcu_fd_sc_mcu9t5v0__oai21_1
* cell instance $6322 m0 *1 609.84,1320.48
X$6322 24118 23957 gf180mcu_fd_sc_mcu9t5v0__filltie
* cell instance $6323 m0 *1 555.52,1320.48
X$6323 24077 22163 22162 24075 23957 24118 24076
+ gf180mcu_fd_sc_mcu9t5v0__aoi22_1
* cell instance $6324 m0 *1 579.04,1370.88
X$6324 18430 25536 25430 25581 24566 gf180mcu_fd_sc_mcu9t5v0__and2_1
* cell instance $6325 r0 *1 595.28,1320.48
X$6325 21579 24228 21353 21880 24232 24118 24078
+ gf180mcu_fd_sc_mcu9t5v0__aoi211_1
* cell instance $6326 m0 *1 566.16,1350.72
X$6326 23036 24943 24708 18834 24828 25000 gf180mcu_fd_sc_mcu9t5v0__dffrnq_2
* cell instance $6327 r0 *1 568.96,1330.56
X$6327 24819 24528 24414 24273 gf180mcu_fd_sc_mcu9t5v0__clkinv_1
* cell instance $6328 m0 *1 581.84,1340.64
X$6328 19567 24528 24712 23036 gf180mcu_fd_sc_mcu9t5v0__clkbuf_8
* cell instance $6329 r0 *1 554.4,1320.48
X$6329 23036 24076 24113 18834 24232 24118 gf180mcu_fd_sc_mcu9t5v0__dffrnq_2
* cell instance $6330 m0 *1 593.04,1370.88
X$6330 26281 25430 25581 24521 gf180mcu_fd_sc_mcu9t5v0__clkinv_1
* cell instance $6331 r0 *1 558.88,1370.88
X$6331 23036 25571 25570 18834 25705 25581 gf180mcu_fd_sc_mcu9t5v0__dffrnq_2
* cell instance $6332 r0 *1 603.12,1370.88
X$6332 17284 25699 12245 25705 25581 25821 gf180mcu_fd_sc_mcu9t5v0__mux2_1
* cell instance $6333 m0 *1 567.28,1330.56
X$6333 23036 24273 21353 18834 24232 24414 gf180mcu_fd_sc_mcu9t5v0__dffrnq_2
* cell instance $6334 m0 *1 595.28,1370.88
X$6334 25698 25430 25581 24079 gf180mcu_fd_sc_mcu9t5v0__clkinv_1
* cell instance $6335 m0 *1 595.84,1320.48
X$6335 24079 21353 23152 24078 23957 24118 23950
+ gf180mcu_fd_sc_mcu9t5v0__aoi22_1
* cell instance $6336 r0 *1 577.92,1350.72
X$6336 23036 25112 24228 18834 25158 25000 gf180mcu_fd_sc_mcu9t5v0__dffrnq_2
* cell instance $6337 m0 *1 609.84,1330.56
X$6337 24414 24232 gf180mcu_fd_sc_mcu9t5v0__filltie
* cell instance $6338 m0 *1 609.84,1260
X$6338 22295 22124 gf180mcu_fd_sc_mcu9t5v0__filltie
* cell instance $6339 m0 *1 570.08,1280.16
X$6339 23036 22695 22696 18834 22700 22885 gf180mcu_fd_sc_mcu9t5v0__dffrnq_2
* cell instance $6340 m0 *1 607.6,1280.16
X$6340 21716 22700 22885 22878 gf180mcu_fd_sc_mcu9t5v0__clkinv_1
* cell instance $6341 m0 *1 575.12,1260
X$6341 21236 22124 22295 22164 gf180mcu_fd_sc_mcu9t5v0__clkinv_1
* cell instance $6342 m0 *1 609.84,1300.32
X$6342 23504 23319 gf180mcu_fd_sc_mcu9t5v0__filltie
* cell instance $6343 m0 *1 610.96,1249.92
X$6343 21880 21572 21574 21884 21997 20689 gf180mcu_fd_sc_mcu9t5v0__nor3_1
* cell instance $6344 m0 *1 609.84,1280.16
X$6344 22885 22700 gf180mcu_fd_sc_mcu9t5v0__filltie
* cell instance $6345 m0 *1 609.84,1290.24
X$6345 23200 23038 gf180mcu_fd_sc_mcu9t5v0__filltie
* cell instance $6346 r0 *1 556.64,1290.24
X$6346 23313 23311 23314 23319 23200 23312 gf180mcu_fd_sc_mcu9t5v0__aoi21_1
* cell instance $6347 m0 *1 616,1290.24
X$6347 23154 23153 23038 23200 19168 gf180mcu_fd_sc_mcu9t5v0__nand2_1
* cell instance $6348 m0 *1 577.36,1260
X$6348 20326 22164 21579 11958 22124 22295 gf180mcu_fd_sc_mcu9t5v0__dffrnq_2
* cell instance $6349 m0 *1 598.64,1260
X$6349 13874 22165 21716 22124 22295 22289 gf180mcu_fd_sc_mcu9t5v0__mux2_1
* cell instance $6350 m0 *1 598.64,1280.16
X$6350 12888 23151 21716 22700 22885 22877 gf180mcu_fd_sc_mcu9t5v0__mux2_1
* cell instance $6351 m0 *1 596.4,1290.24
X$6351 21574 23150 23151 21572 23038 23200 23152
+ gf180mcu_fd_sc_mcu9t5v0__aoi22_1
* cell instance $6352 m0 *1 592.48,1270.08
X$6352 21572 22165 21579 22444 21574 22696 22449 22577 21405
+ gf180mcu_fd_sc_mcu9t5v0__aoi222_1
* cell instance $6353 m0 *1 556.64,1300.32
X$6353 19917 22833 19745 22832 23319 23504 23313 gf180mcu_fd_sc_mcu9t5v0__nor4_1
* cell instance $6354 m0 *1 581.84,1310.4
X$6354 23036 23673 23617 18834 23623 23797 gf180mcu_fd_sc_mcu9t5v0__dffrnq_2
* cell instance $6355 r0 *1 586.88,1280.16
X$6355 23036 22877 23151 11958 23038 22885 gf180mcu_fd_sc_mcu9t5v0__dffrnq_2
* cell instance $6356 r0 *1 596.4,1300.32
X$6356 21579 23672 21574 23617 21880 23623 23504 21835
+ gf180mcu_fd_sc_mcu9t5v0__aoi221_1
* cell instance $6357 r0 *1 612.64,1300.32
X$6357 23316 23618 23623 23504 22158 gf180mcu_fd_sc_mcu9t5v0__or2_1
* cell instance $6358 m0 *1 574.56,1310.4
X$6358 22828 23672 21236 23623 23797 23616 gf180mcu_fd_sc_mcu9t5v0__mux2_1
* cell instance $6359 r0 *1 563.92,1260
X$6359 22820 22406 22444 11958 22449 22295 gf180mcu_fd_sc_mcu9t5v0__dffrnq_2
* cell instance $6360 r0 *1 555.52,1300.32
X$6360 22163 23312 23623 23504 22162 gf180mcu_fd_sc_mcu9t5v0__nor2_1
* cell instance $6361 r0 *1 617.12,1300.32
X$6361 19277 23154 23153 23623 23504 23618 gf180mcu_fd_sc_mcu9t5v0__nand3_1
* cell instance $6362 r0 *1 589.12,1300.32
X$6362 21726 23617 21236 23623 23504 23673 gf180mcu_fd_sc_mcu9t5v0__mux2_1
* cell instance $6363 m0 *1 567.84,1260
X$6363 22694 22124 22295 20685 gf180mcu_fd_sc_mcu9t5v0__clkinv_1
* cell instance $6364 r0 *1 564.48,1270.08
X$6364 22694 23035 22700 22577 20633 gf180mcu_fd_sc_mcu9t5v0__nand2_1
* cell instance $6365 m0 *1 565.6,1290.24
X$6365 23036 23149 23150 18834 23038 23200 gf180mcu_fd_sc_mcu9t5v0__dffrnq_2
* cell instance $6366 m0 *1 571.76,1270.08
X$6366 22832 22444 21236 22449 22577 22406 gf180mcu_fd_sc_mcu9t5v0__mux2_1
* cell instance $6367 m0 *1 609.84,1249.92
X$6367 21997 21884 gf180mcu_fd_sc_mcu9t5v0__filltie
* cell instance $6368 m0 *1 609.84,1270.08
X$6368 22577 22449 gf180mcu_fd_sc_mcu9t5v0__filltie
* cell instance $6369 r0 *1 576.8,1270.08
X$6369 22572 22696 21236 22700 22577 22695 gf180mcu_fd_sc_mcu9t5v0__mux2_1
* cell instance $6370 r0 *1 573.44,1280.16
X$6370 19917 23150 21236 23038 22885 23149 gf180mcu_fd_sc_mcu9t5v0__mux2_1
* cell instance $6371 r0 *1 589.12,1260
X$6371 21238 22289 22165 11958 22449 22295 gf180mcu_fd_sc_mcu9t5v0__dffrnq_2
* cell instance $6372 m0 *1 554.4,1280.16
X$6372 19917 22833 19745 22832 22700 22885 22834
+ gf180mcu_fd_sc_mcu9t5v0__nand4_1
* cell instance $6373 m0 *1 606.48,1310.4
X$6373 23316 23618 23623 23797 23674 gf180mcu_fd_sc_mcu9t5v0__nor2_1
* cell instance $6374 m0 *1 609.84,1310.4
X$6374 23797 23623 gf180mcu_fd_sc_mcu9t5v0__filltie
* cell instance $6375 m0 *1 559.44,1280.16
X$6375 22834 22831 23314 22700 22885 22405 gf180mcu_fd_sc_mcu9t5v0__oai21_1
* cell instance $6376 r0 *1 568.4,1300.32
X$6376 23036 23616 23672 18834 23623 23504 gf180mcu_fd_sc_mcu9t5v0__dffrnq_2
* cell instance $6377 m0 *1 624.96,1260
X$6377 21579 22290 21574 22445 22124 22295 21993
+ gf180mcu_fd_sc_mcu9t5v0__aoi22_1
* cell instance $6378 m0 *1 657.44,1280.16
X$6378 21714 22837 22835 22700 22885 18992 gf180mcu_fd_sc_mcu9t5v0__aoi21_1
* cell instance $6379 r0 *1 631.68,1260
X$6379 19745 22290 21236 22449 22295 22446 gf180mcu_fd_sc_mcu9t5v0__mux2_1
* cell instance $6380 m0 *1 623.28,1249.92
X$6380 21572 21882 21880 21884 21997 21881 gf180mcu_fd_sc_mcu9t5v0__aoi21_1
* cell instance $6381 r0 *1 687.12,1290.24
X$6381 23197 20692 23319 23200 23315 gf180mcu_fd_sc_mcu9t5v0__nor2_1
* cell instance $6382 r0 *1 661.36,1260
X$6382 21238 22408 22447 11958 22449 22295 gf180mcu_fd_sc_mcu9t5v0__dffrnq_2
* cell instance $6383 r0 *1 681.52,1290.24
X$6383 19277 23154 23153 23319 23200 22882 gf180mcu_fd_sc_mcu9t5v0__and3_1
* cell instance $6384 m0 *1 649.04,1300.32
X$6384 23615 23360 21236 23319 23504 23619 gf180mcu_fd_sc_mcu9t5v0__mux2_1
* cell instance $6385 m0 *1 631.12,1290.24
X$6385 23156 14999 23154 23038 23200 23155 gf180mcu_fd_sc_mcu9t5v0__aoi21_1
* cell instance $6386 r0 *1 685.44,1280.16
X$6386 22882 22881 23038 22885 23006 gf180mcu_fd_sc_mcu9t5v0__nor2_1
* cell instance $6387 r0 *1 664.16,1300.32
X$6387 19567 23623 23504 23037 gf180mcu_fd_sc_mcu9t5v0__clkbuf_8
* cell instance $6388 m0 *1 670.32,1249.92
X$6388 21238 21884 21997 33561 gf180mcu_fd_sc_mcu9t5v0__clkinv_1
* cell instance $6389 m0 *1 635.6,1290.24
X$6389 23196 19721 23038 23200 23156 gf180mcu_fd_sc_mcu9t5v0__nand2_1
* cell instance $6390 m0 *1 668.64,1270.08
X$6390 22441 22447 21236 22449 22577 22408 gf180mcu_fd_sc_mcu9t5v0__mux2_1
* cell instance $6391 r0 *1 653.52,1290.24
X$6391 21574 23360 21880 23319 23200 23157 gf180mcu_fd_sc_mcu9t5v0__aoi21_1
* cell instance $6392 m0 *1 676.48,1300.32
X$6392 22158 23362 23319 23504 23620 gf180mcu_fd_sc_mcu9t5v0__nand2_1
* cell instance $6393 r0 *1 655.76,1280.16
X$6393 21572 22879 21579 22836 23038 22885 23005
+ gf180mcu_fd_sc_mcu9t5v0__aoi22_1
* cell instance $6394 m0 *1 675.36,1260
X$6394 21572 22118 21579 22166 21574 22447 22124 22295 22167
+ gf180mcu_fd_sc_mcu9t5v0__aoi222_1
* cell instance $6395 m0 *1 655.76,1290.24
X$6395 23157 23005 23038 23200 22837 gf180mcu_fd_sc_mcu9t5v0__nand2_1
* cell instance $6396 m0 *1 672.56,1249.92
X$6396 19567 21884 21997 21238 gf180mcu_fd_sc_mcu9t5v0__clkbuf_8
* cell instance $6397 r0 *1 661.92,1280.16
X$6397 23037 22880 22879 11958 23038 22885 gf180mcu_fd_sc_mcu9t5v0__dffrnq_2
* cell instance $6398 r0 *1 656.88,1249.92
X$6398 14854 22118 21716 22124 21997 22117 gf180mcu_fd_sc_mcu9t5v0__mux2_1
* cell instance $6399 m0 *1 664.16,1300.32
X$6399 23037 23319 23504 gf180mcu_fd_sc_mcu9t5v0__inv_4
* cell instance $6400 r0 *1 645.12,1270.08
X$6400 22829 22836 21236 22700 22577 22697 gf180mcu_fd_sc_mcu9t5v0__mux2_1
* cell instance $6401 m0 *1 637.84,1280.16
X$6401 23037 22697 22836 11958 22700 22885 gf180mcu_fd_sc_mcu9t5v0__dffrnq_2
* cell instance $6402 m0 *1 626.08,1270.08
X$6402 21238 22446 22290 11958 22449 22577 gf180mcu_fd_sc_mcu9t5v0__dffrnq_2
* cell instance $6403 m0 *1 627.76,1249.92
X$6403 21238 21838 21882 11958 21884 21997 gf180mcu_fd_sc_mcu9t5v0__dffrnq_2
* cell instance $6404 m0 *1 669.2,1310.4
X$6404 23677 23675 23623 23797 23678 gf180mcu_fd_sc_mcu9t5v0__xnor2_1
* cell instance $6405 m0 *1 669.76,1300.32
X$6405 23500 23319 23504 23361 23362 gf180mcu_fd_sc_mcu9t5v0__xor2_1
* cell instance $6406 r0 *1 627.76,1290.24
X$6406 23037 23155 23196 11958 23319 23200 gf180mcu_fd_sc_mcu9t5v0__dffrnq_2
* cell instance $6407 r0 *1 641.76,1300.32
X$6407 23037 23619 23360 11958 23623 23504 gf180mcu_fd_sc_mcu9t5v0__dffrnq_2
* cell instance $6408 m0 *1 665.28,1310.4
X$6408 23677 23500 23675 23623 23797 23676 gf180mcu_fd_sc_mcu9t5v0__nand3_1
* cell instance $6409 m0 *1 636.16,1310.4
X$6409 23900 23614 23623 23797 23675 gf180mcu_fd_sc_mcu9t5v0__nor2_1
* cell instance $6410 m0 *1 645.68,1260
X$6410 21238 22117 22118 11958 22124 22295 gf180mcu_fd_sc_mcu9t5v0__dffrnq_2
* cell instance $6411 m0 *1 669.76,1280.16
X$6411 13159 22879 21716 22700 22885 22880 gf180mcu_fd_sc_mcu9t5v0__mux2_1
* cell instance $6412 m0 *1 586.32,1179.36
X$6412 19850 19846 19729 19901 19894 gf180mcu_fd_sc_mcu9t5v0__nand2_1
* cell instance $6413 r0 *1 614.32,1229.76
X$6413 21238 21407 21355 11958 21537 21412 gf180mcu_fd_sc_mcu9t5v0__dffrnq_2
* cell instance $6414 r0 *1 636.16,1169.28
X$6414 19723 19721 19729 19605 19854 gf180mcu_fd_sc_mcu9t5v0__nand2_1
* cell instance $6415 m0 *1 637.28,1179.36
X$6415 20326 19853 19723 11958 19729 19901 gf180mcu_fd_sc_mcu9t5v0__dffrnq_2
* cell instance $6416 r0 *1 666.4,1169.28
X$6416 18133 19725 19566 11958 19729 19605 gf180mcu_fd_sc_mcu9t5v0__dffrnq_2
* cell instance $6417 r0 *1 609.84,1169.28
X$6417 12888 13692 19446 19729 19605 19722 gf180mcu_fd_sc_mcu9t5v0__oai21_1
* cell instance $6418 r0 *1 655.2,1169.28
X$6418 19279 19720 19724 19600 19729 19605 19847
+ gf180mcu_fd_sc_mcu9t5v0__oai211_1
* cell instance $6419 r0 *1 590.24,1169.28
X$6419 14153 19729 19605 19721 gf180mcu_fd_sc_mcu9t5v0__buf_8
* cell instance $6420 r0 *1 614.32,1169.28
X$6420 9539 19120 19729 19605 19563 gf180mcu_fd_sc_mcu9t5v0__nand2_1
* cell instance $6421 r0 *1 660.8,1169.28
X$6421 19274 19564 19601 19565 19729 19605 19725
+ gf180mcu_fd_sc_mcu9t5v0__oai31_1
* cell instance $6422 m0 *1 685.44,1179.36
X$6422 12888 19729 19901 15401 gf180mcu_fd_sc_mcu9t5v0__clkbuf_1
* cell instance $6423 m0 *1 577.92,1179.36
X$6423 18421 19889 19729 19901 19720 gf180mcu_fd_sc_mcu9t5v0__nor2_1
* cell instance $6424 r0 *1 619.36,1199.52
X$6424 20501 20637 20507 20333 gf180mcu_fd_sc_mcu9t5v0__dlyc_1
* cell instance $6425 r0 *1 617.68,1189.44
X$6425 20072 20379 20217 20334 gf180mcu_fd_sc_mcu9t5v0__dlyc_1
* cell instance $6426 m0 *1 609.84,1179.36
X$6426 19901 19729 gf180mcu_fd_sc_mcu9t5v0__filltie
* cell instance $6427 m0 *1 618.8,1209.6
X$6427 19893 20333 20205 20815 20637 20822 20816
+ gf180mcu_fd_sc_mcu9t5v0__oai31_1
* cell instance $6428 m0 *1 623.28,1179.36
X$6428 9539 19852 19729 19901 19851 gf180mcu_fd_sc_mcu9t5v0__nand2_1
* cell instance $6429 m0 *1 605.36,1179.36
X$6429 19119 19851 19722 19729 19901 19850 gf180mcu_fd_sc_mcu9t5v0__oai21_1
* cell instance $6430 m0 *1 632.24,1179.36
X$6430 19895 19562 19854 19729 19901 19853 gf180mcu_fd_sc_mcu9t5v0__oai21_1
* cell instance $6431 r0 *1 603.12,1209.6
X$6431 20326 20935 20983 11958 20936 20822 gf180mcu_fd_sc_mcu9t5v0__dffrnq_2
* cell instance $6432 m0 *1 620.48,1189.44
X$6432 19893 19895 20028 20217 19559 gf180mcu_fd_sc_mcu9t5v0__nand2_1
* cell instance $6433 m0 *1 616.56,1128.96
X$6433 18264 18268 18386 12779 gf180mcu_fd_sc_mcu9t5v0__buf_8
* cell instance $6434 r0 *1 619.92,1118.88
X$6434 18263 18575 18268 18104 17513 gf180mcu_fd_sc_mcu9t5v0__nand2_2
* cell instance $6435 m0 *1 621.04,1139.04
X$6435 17117 12779 18553 18731 18577 gf180mcu_fd_sc_mcu9t5v0__nand2_1
* cell instance $6436 r0 *1 620.48,1149.12
X$6436 9539 19171 18996 18991 gf180mcu_fd_sc_mcu9t5v0__clkinv_1
* cell instance $6437 r0 *1 657.44,1209.6
X$6437 20502 20985 20691 20936 20822 19600 gf180mcu_fd_sc_mcu9t5v0__nor3_1
* cell instance $6438 r0 *1 663.04,1199.52
X$6438 20502 19891 20637 20507 16141 gf180mcu_fd_sc_mcu9t5v0__nand2_1
* cell instance $6439 m0 *1 658.56,1219.68
X$6439 20985 20691 19891 20936 21123 20986 gf180mcu_fd_sc_mcu9t5v0__oai21_1
* cell instance $6440 r0 *1 687.12,1199.52
X$6440 13692 20637 20507 14166 gf180mcu_fd_sc_mcu9t5v0__clkbuf_1
* cell instance $6441 r0 *1 654.64,1189.44
X$6441 16141 20335 20379 20217 20209 gf180mcu_fd_sc_mcu9t5v0__nand2_1
* cell instance $6442 r0 *1 654.64,1199.52
X$6442 20502 20691 19891 20637 20507 20634 gf180mcu_fd_sc_mcu9t5v0__mux2_1
* cell instance $6443 m0 *1 660.24,1229.76
X$6443 21238 21235 21357 11958 21241 21412 gf180mcu_fd_sc_mcu9t5v0__dffrnq_2
* cell instance $6444 r0 *1 640.08,1229.76
X$6444 21238 21408 21356 11958 21537 21412 gf180mcu_fd_sc_mcu9t5v0__dffrnq_2
* cell instance $6445 m0 *1 665.28,1239.84
X$6445 14166 21576 21716 21537 21719 21717 gf180mcu_fd_sc_mcu9t5v0__mux2_1
* cell instance $6446 m0 *1 676.48,1239.84
X$6446 21572 20636 21579 21358 21574 21357 21537 21719 21577
+ gf180mcu_fd_sc_mcu9t5v0__aoi222_1
* cell instance $6447 r0 *1 623.28,1209.6
X$6447 20326 20816 20691 11958 20936 20822 gf180mcu_fd_sc_mcu9t5v0__dffrnq_2
* cell instance $6448 m0 *1 650.16,1199.52
X$6448 19891 20379 20507 20074 gf180mcu_fd_sc_mcu9t5v0__clkinv_1
* cell instance $6449 m0 *1 623.28,1189.44
X$6449 20374 19895 20205 20073 20028 20217 20208
+ gf180mcu_fd_sc_mcu9t5v0__oai31_1
* cell instance $6450 r0 *1 625.52,1179.36
X$6450 19276 14123 20028 19901 19895 gf180mcu_fd_sc_mcu9t5v0__nand2_1
* cell instance $6451 m0 *1 642.88,1189.44
X$6451 20075 20074 20028 20217 20073 gf180mcu_fd_sc_mcu9t5v0__nand2_1
* cell instance $6452 m0 *1 649.6,1209.6
X$6452 21238 20634 20502 11958 20637 20822 gf180mcu_fd_sc_mcu9t5v0__dffrnq_2
* cell instance $6453 r0 *1 651.84,1189.44
X$6453 20076 20074 20379 20217 20335 gf180mcu_fd_sc_mcu9t5v0__nand2_1
* cell instance $6454 m0 *1 623.84,1229.76
X$6454 13010 21355 21716 21241 21412 21407 gf180mcu_fd_sc_mcu9t5v0__mux2_1
* cell instance $6455 m0 *1 646.8,1229.76
X$6455 22443 21356 21236 21241 21412 21408 gf180mcu_fd_sc_mcu9t5v0__mux2_1
* cell instance $6456 m0 *1 647.36,1199.52
X$6456 20075 19891 20379 20507 21716 gf180mcu_fd_sc_mcu9t5v0__nand2_1
* cell instance $6457 m0 *1 654.64,1189.44
X$6457 20076 20075 20028 20217 19724 gf180mcu_fd_sc_mcu9t5v0__nor2_1
* cell instance $6458 m0 *1 641.76,1209.6
X$6458 20985 20074 20637 20822 20690 gf180mcu_fd_sc_mcu9t5v0__nand2_1
* cell instance $6459 m0 *1 624.4,1209.6
X$6459 19564 20333 20205 20690 20637 20822 20817
+ gf180mcu_fd_sc_mcu9t5v0__oai31_1
* cell instance $6460 m0 *1 638.96,1209.6
X$6460 20691 20074 20637 20822 20815 gf180mcu_fd_sc_mcu9t5v0__nand2_1
* cell instance $6461 r0 *1 628.88,1189.44
X$6461 20326 20208 20075 11958 20379 20217 gf180mcu_fd_sc_mcu9t5v0__dffrnq_2
* cell instance $6462 m0 *1 622.72,1199.52
X$6462 13826 19564 20379 20507 20027 gf180mcu_fd_sc_mcu9t5v0__nand2_1
* cell instance $6463 m0 *1 629.44,1219.68
X$6463 20326 20817 20985 11958 20936 21123 gf180mcu_fd_sc_mcu9t5v0__dffrnq_2
* cell instance $6464 r0 *1 677.6,1199.52
X$6464 14856 20636 21716 20637 20507 20635 gf180mcu_fd_sc_mcu9t5v0__mux2_1
* cell instance $6465 m0 *1 660.24,1239.84
X$6465 21576 21572 21356 21574 21537 21719 21575
+ gf180mcu_fd_sc_mcu9t5v0__aoi22_1
* cell instance $6466 r0 *1 657.44,1189.44
X$6466 20326 20209 20076 11958 20379 20217 gf180mcu_fd_sc_mcu9t5v0__dffrnq_2
* cell instance $6467 m0 *1 669.2,1189.44
X$6467 20076 19891 20028 20217 20210 gf180mcu_fd_sc_mcu9t5v0__nand2_1
* cell instance $6468 r0 *1 667.52,1219.68
X$6468 20030 21357 21236 21241 21123 21235 gf180mcu_fd_sc_mcu9t5v0__mux2_1
* cell instance $6469 r0 *1 578.48,1219.68
X$6469 20981 20932 21241 21123 20933 gf180mcu_fd_sc_mcu9t5v0__nor2_1
* cell instance $6470 r0 *1 591.92,1229.76
X$6470 21404 20984 21537 21412 21532 gf180mcu_fd_sc_mcu9t5v0__nor2_1
* cell instance $6471 r0 *1 613.76,1189.44
X$6471 13826 14298 19120 20379 20217 20501 gf180mcu_fd_sc_mcu9t5v0__nand3_1
* cell instance $6472 r0 *1 600.88,1189.44
X$6472 14123 20334 20025 20379 20217 20206 gf180mcu_fd_sc_mcu9t5v0__aoi21_1
* cell instance $6473 r0 *1 595.28,1189.44
X$6473 13874 20333 20206 20332 20379 20217 20331
+ gf180mcu_fd_sc_mcu9t5v0__oai211_1
* cell instance $6474 m0 *1 589.12,1229.76
X$6474 21403 21404 21241 21412 20982 gf180mcu_fd_sc_mcu9t5v0__nand2_1
* cell instance $6475 r0 *1 608.72,1179.36
X$6475 19119 20027 19722 19563 20028 19901 20026
+ gf180mcu_fd_sc_mcu9t5v0__oai211_1
* cell instance $6476 m0 *1 588.56,1219.68
X$6476 20981 20983 20982 20936 21123 20931 gf180mcu_fd_sc_mcu9t5v0__nand3_1
* cell instance $6477 m0 *1 609.84,1189.44
X$6477 20217 20028 gf180mcu_fd_sc_mcu9t5v0__filltie
* cell instance $6478 r0 *1 594.72,1209.6
X$6478 20983 20934 20936 20822 20688 gf180mcu_fd_sc_mcu9t5v0__nand2_1
* cell instance $6479 m0 *1 595.28,1239.84
X$6479 21533 21403 21532 21537 21719 21571 gf180mcu_fd_sc_mcu9t5v0__nand3_1
* cell instance $6480 r0 *1 575.12,1209.6
X$6480 20932 20931 20933 20936 20822 20930 gf180mcu_fd_sc_mcu9t5v0__aoi21_1
* cell instance $6481 r0 *1 576.8,1179.36
X$6481 19891 19847 20028 19901 20024 gf180mcu_fd_sc_mcu9t5v0__nand2_1
* cell instance $6482 m0 *1 595.84,1209.6
X$6482 20688 20689 20637 20822 20686 gf180mcu_fd_sc_mcu9t5v0__nand2_1
* cell instance $6483 r0 *1 586.88,1199.52
X$6483 19567 20637 20507 20326 gf180mcu_fd_sc_mcu9t5v0__clkbuf_8
* cell instance $6484 m0 *1 604.24,1239.84
X$6484 21714 21406 21568 13904 21537 21719 15745
+ gf180mcu_fd_sc_mcu9t5v0__aoi211_1
* cell instance $6485 m0 *1 561.68,1209.6
X$6485 19889 20024 20813 20365 20686 20637 20822 20330
+ gf180mcu_fd_sc_mcu9t5v0__aoi221_1
* cell instance $6486 m0 *1 609.84,1229.76
X$6486 21412 21241 gf180mcu_fd_sc_mcu9t5v0__filltie
* cell instance $6487 m0 *1 609.84,1219.68
X$6487 21123 20936 gf180mcu_fd_sc_mcu9t5v0__filltie
* cell instance $6488 m0 *1 609.84,1199.52
X$6488 20507 20379 gf180mcu_fd_sc_mcu9t5v0__filltie
* cell instance $6489 m0 *1 614.32,1189.44
X$6489 13826 19563 20028 20217 20072 gf180mcu_fd_sc_mcu9t5v0__nor2_1
* cell instance $6490 m0 *1 567.84,1189.44
X$6490 19560 20071 20028 20217 20204 gf180mcu_fd_sc_mcu9t5v0__nand2_1
* cell instance $6491 m0 *1 598.08,1189.44
X$6491 3795 14123 20072 20028 20217 20207 gf180mcu_fd_sc_mcu9t5v0__nand3_1
* cell instance $6492 m0 *1 593.6,1199.52
X$6492 19889 20373 20379 20507 20500 gf180mcu_fd_sc_mcu9t5v0__nand2_1
* cell instance $6493 r0 *1 585.76,1189.44
X$6493 20204 20024 20379 20217 20332 gf180mcu_fd_sc_mcu9t5v0__nor2_1
* cell instance $6494 r0 *1 585.2,1179.36
X$6494 19274 19893 20026 19894 20028 19901 20071
+ gf180mcu_fd_sc_mcu9t5v0__oai211_1
* cell instance $6495 r0 *1 567.84,1189.44
X$6495 20331 20330 20379 20217 20372 gf180mcu_fd_sc_mcu9t5v0__nand2_1
* cell instance $6496 m0 *1 565.6,1189.44
X$6496 20204 20028 20217 20023 gf180mcu_fd_sc_mcu9t5v0__clkinv_1
* cell instance $6497 m0 *1 609.84,1209.6
X$6497 20822 20637 gf180mcu_fd_sc_mcu9t5v0__filltie
* cell instance $6498 m0 *1 571.76,1189.44
X$6498 19889 20028 20217 20025 gf180mcu_fd_sc_mcu9t5v0__clkinv_1
* cell instance $6499 r0 *1 592.48,1189.44
X$6499 19889 20332 20379 20217 20205 gf180mcu_fd_sc_mcu9t5v0__nand2_1
* cell instance $6500 m0 *1 552.72,1209.6
X$6500 20365 19560 19849 20684 20685 20637 20822 20814
+ gf180mcu_fd_sc_mcu9t5v0__oai32_1
* cell instance $6501 m0 *1 598.08,1219.68
X$6501 20983 20936 21123 20984 gf180mcu_fd_sc_mcu9t5v0__clkinv_1
* cell instance $6502 m0 *1 593.6,1219.68
X$6502 20981 20982 20936 21123 20934 gf180mcu_fd_sc_mcu9t5v0__nor2_1
* cell instance $6503 r0 *1 597.52,1209.6
X$6503 20984 20934 20205 20373 20936 20822 20935
+ gf180mcu_fd_sc_mcu9t5v0__oai22_1
* cell instance $6504 r0 *1 601.44,1199.52
X$6504 20207 20637 20507 20373 gf180mcu_fd_sc_mcu9t5v0__dlyc_1
* cell instance $6505 r0 *1 597.52,1229.76
X$6505 20981 21403 20984 21405 21537 21412 21406
+ gf180mcu_fd_sc_mcu9t5v0__oai31_1
* cell instance $6506 r0 *1 595.28,1229.76
X$6506 20981 21537 21412 21533 gf180mcu_fd_sc_mcu9t5v0__clkinv_1
* cell instance $6507 m0 *1 618.8,1199.52
X$6507 20334 20379 20507 20374 gf180mcu_fd_sc_mcu9t5v0__clkinv_1
* cell instance $6508 m0 *1 581.84,1209.6
X$6508 19889 20024 20687 20637 20822 20932 gf180mcu_fd_sc_mcu9t5v0__aoi21_1
* cell instance $6509 m0 *1 590.24,1209.6
X$6509 20983 19889 20500 20688 20637 20822 20687
+ gf180mcu_fd_sc_mcu9t5v0__oai211_1
* cell instance $6510 r0 *1 566.72,1179.36
X$6510 20025 20023 20028 19901 20022 gf180mcu_fd_sc_mcu9t5v0__nor2_1
* cell instance $6511 m0 *1 599.2,1239.84
X$6511 20981 20983 21572 21355 21537 21719 21573
+ gf180mcu_fd_sc_mcu9t5v0__aoi22_1
* cell instance $6512 m0 *1 589.12,1239.84
X$6512 21403 21404 20983 21537 21719 21570 gf180mcu_fd_sc_mcu9t5v0__oai21_1
* cell instance $6513 m0 *1 609.84,1239.84
X$6513 21719 21537 gf180mcu_fd_sc_mcu9t5v0__filltie
* cell instance $6514 m0 *1 565.6,1199.52
X$6514 20326 20372 19889 11958 20507 20379 gf180mcu_fd_sc_mcu9t5v0__dffsnq_2
* cell instance $6515 m0 *1 564.48,1219.68
X$6515 20326 20930 20981 11958 20936 21123 gf180mcu_fd_sc_mcu9t5v0__dffrnq_2
* cell instance $6516 m0 *1 571.2,1229.76
X$6516 21403 21354 20932 21241 21412 21402 gf180mcu_fd_sc_mcu9t5v0__mux2_1
* cell instance $6517 r0 *1 575.68,1229.76
X$6517 21404 21532 20932 21537 21412 21569 gf180mcu_fd_sc_mcu9t5v0__mux2_1
* cell instance $6518 r0 *1 582.96,1229.76
X$6518 21403 21404 21570 21537 21412 21354 gf180mcu_fd_sc_mcu9t5v0__aoi21_1
* cell instance $6519 m0 *1 565.6,1239.84
X$6519 20326 21569 21404 11958 21537 21719 gf180mcu_fd_sc_mcu9t5v0__dffrnq_2
* cell instance $6520 r0 *1 553.84,1229.76
X$6520 20326 21402 21403 11958 21537 21412 gf180mcu_fd_sc_mcu9t5v0__dffrnq_2
* cell instance $6521 r0 *1 562.24,1179.36
X$6521 19889 20023 20024 20028 19901 19888 gf180mcu_fd_sc_mcu9t5v0__aoi21_1
* cell instance $6522 r0 *1 556.64,1209.6
X$6522 20365 20071 20936 20822 20927 gf180mcu_fd_sc_mcu9t5v0__nor2_1
* cell instance $6523 r0 *1 582.4,1199.52
X$6523 20326 20637 20507 gf180mcu_fd_sc_mcu9t5v0__clkinv_3
* cell instance $6524 r0 *1 576.8,1149.12
X$6524 20326 19118 18990 11958 19171 18996 gf180mcu_fd_sc_mcu9t5v0__dffrnq_2
* cell instance $6525 r0 *1 568.96,1108.8
X$6525 18094 17117 17985 17837 17827 gf180mcu_fd_sc_mcu9t5v0__nand2_1
* cell instance $6526 r0 *1 572.88,1159.2
X$6526 5662 19274 19448 19282 19444 gf180mcu_fd_sc_mcu9t5v0__nor2_1
* cell instance $6527 m0 *1 574,1128.96
X$6527 17117 18268 18386 15263 gf180mcu_fd_sc_mcu9t5v0__clkinv_1
* cell instance $6528 m0 *1 568.96,1169.28
X$6528 19560 19559 19448 19605 18427 gf180mcu_fd_sc_mcu9t5v0__nor2_1
* cell instance $6529 r0 *1 584.08,1118.88
X$6529 20326 18096 17567 11958 18268 18104 gf180mcu_fd_sc_mcu9t5v0__dffrnq_2
* cell instance $6530 r0 *1 605.92,1149.12
X$6530 15388 17829 19171 18996 19119 gf180mcu_fd_sc_mcu9t5v0__nand2_1
* cell instance $6531 m0 *1 593.04,1128.96
X$6531 17567 18268 18386 18097 gf180mcu_fd_sc_mcu9t5v0__clkinv_1
* cell instance $6532 m0 *1 566.72,1128.96
X$6532 15263 12779 18376 18431 18268 18386 18262
+ gf180mcu_fd_sc_mcu9t5v0__oai211_1
* cell instance $6533 r0 *1 609.28,1159.2
X$6533 7549 14298 19119 19448 19282 19561 gf180mcu_fd_sc_mcu9t5v0__nor3_1
* cell instance $6534 m0 *1 556.64,1139.04
X$6534 18430 18956 18435 18553 18731 17227 gf180mcu_fd_sc_mcu9t5v0__nand3_1
* cell instance $6535 m0 *1 596.96,1118.88
X$6535 17981 14997 17985 18104 18098 gf180mcu_fd_sc_mcu9t5v0__nand2_1
* cell instance $6536 m0 *1 609.84,1159.2
X$6536 19282 19171 gf180mcu_fd_sc_mcu9t5v0__filltie
* cell instance $6537 m0 *1 588.56,1149.12
X$6537 18990 17982 17828 18841 18996 18958 gf180mcu_fd_sc_mcu9t5v0__aoi21_1
* cell instance $6538 m0 *1 556.08,1118.88
X$6538 18094 17941 17283 17985 18104 18433 gf180mcu_fd_sc_mcu9t5v0__nand3_1
* cell instance $6539 r0 *1 608.72,1149.12
X$6539 15388 17829 19171 18996 19120 gf180mcu_fd_sc_mcu9t5v0__and2_1
* cell instance $6540 m0 *1 609.84,1139.04
X$6540 18731 18553 gf180mcu_fd_sc_mcu9t5v0__filltie
* cell instance $6541 r0 *1 604.24,1118.88
X$6541 18132 18268 18104 15565 gf180mcu_fd_sc_mcu9t5v0__buf_8
* cell instance $6542 m0 *1 609.84,1128.96
X$6542 18386 18268 gf180mcu_fd_sc_mcu9t5v0__filltie
* cell instance $6543 m0 *1 567.28,1149.12
X$6543 19117 18957 18841 18996 18431 gf180mcu_fd_sc_mcu9t5v0__nand2_1
* cell instance $6544 m0 *1 595.28,1149.12
X$6544 18727 18841 18996 19445 gf180mcu_fd_sc_mcu9t5v0__buf_8
* cell instance $6545 r0 *1 593.6,1159.2
X$6545 19445 18427 19448 19282 19278 gf180mcu_fd_sc_mcu9t5v0__nand2_1
* cell instance $6546 m0 *1 588.56,1159.2
X$6546 19274 19893 19171 19282 19115 gf180mcu_fd_sc_mcu9t5v0__nor2_1
* cell instance $6547 r0 *1 595.84,1128.96
X$6547 17117 18428 18553 18386 18436 gf180mcu_fd_sc_mcu9t5v0__nand2_1
* cell instance $6548 m0 *1 595.28,1139.04
X$6548 17567 17828 18553 18731 18574 gf180mcu_fd_sc_mcu9t5v0__nand2_1
* cell instance $6549 m0 *1 609.84,1118.88
X$6549 18104 17985 gf180mcu_fd_sc_mcu9t5v0__filltie
* cell instance $6550 r0 *1 601.44,1128.96
X$6550 18436 14998 18553 18386 18551 gf180mcu_fd_sc_mcu9t5v0__nand2_1
* cell instance $6551 m0 *1 609.84,1149.12
X$6551 18996 18841 gf180mcu_fd_sc_mcu9t5v0__filltie
* cell instance $6552 r0 *1 596.4,1139.04
X$6552 19115 19445 18841 18731 17572 gf180mcu_fd_sc_mcu9t5v0__nand2_1
* cell instance $6553 r0 *1 616.56,1149.12
X$6553 7549 18991 19120 19171 18996 19121 gf180mcu_fd_sc_mcu9t5v0__nand3_1
* cell instance $6554 r0 *1 593.6,1139.04
X$6554 18727 18573 18841 18731 17982 gf180mcu_fd_sc_mcu9t5v0__nand2_1
* cell instance $6555 r0 *1 611.52,1108.8
X$6555 17117 15570 17830 17942 17985 17837 17943
+ gf180mcu_fd_sc_mcu9t5v0__oai31_1
* cell instance $6556 m0 *1 614.32,1139.04
X$6556 18576 18575 18573 18377 18553 18731 18132
+ gf180mcu_fd_sc_mcu9t5v0__nand4_1
* cell instance $6557 r0 *1 607.04,1159.2
X$6557 17829 19448 19282 19446 gf180mcu_fd_sc_mcu9t5v0__clkinv_1
* cell instance $6558 m0 *1 589.12,1118.88
X$6558 18097 17828 17982 17985 18104 18096 gf180mcu_fd_sc_mcu9t5v0__oai21_1
* cell instance $6559 r0 *1 561.68,1128.96
X$6559 18430 18435 18553 18386 18376 gf180mcu_fd_sc_mcu9t5v0__nand2_1
* cell instance $6560 m0 *1 576.8,1169.28
X$6560 19444 19561 19448 19605 19560 gf180mcu_fd_sc_mcu9t5v0__nor2_1
* cell instance $6561 m0 *1 570.64,1159.2
X$6561 19277 19168 19171 19282 18957 gf180mcu_fd_sc_mcu9t5v0__nor2_1
* cell instance $6562 m0 *1 606.48,1169.28
X$6562 19561 19445 19448 19605 19562 gf180mcu_fd_sc_mcu9t5v0__nand2_1
* cell instance $6563 m0 *1 568.4,1118.88
X$6563 17941 17117 17985 18104 17981 gf180mcu_fd_sc_mcu9t5v0__nand2_1
* cell instance $6564 r0 *1 554.4,1149.12
X$6564 18093 18989 19169 11958 19171 18996 gf180mcu_fd_sc_mcu9t5v0__dffrnq_2
* cell instance $6565 m0 *1 616,1169.28
X$6565 5662 7549 19563 19448 19605 19114 gf180mcu_fd_sc_mcu9t5v0__nor3_1
* cell instance $6566 m0 *1 564.48,1159.2
X$6566 19277 19168 19117 19171 19282 18956 gf180mcu_fd_sc_mcu9t5v0__oai21_1
* cell instance $6567 m0 *1 572.32,1169.28
X$6567 19561 19559 18421 19448 19605 19443 gf180mcu_fd_sc_mcu9t5v0__aoi21_1
* cell instance $6568 r0 *1 573.44,1149.12
X$6568 18957 18958 19171 18996 19118 gf180mcu_fd_sc_mcu9t5v0__nor2_1
* cell instance $6569 m0 *1 575.68,1139.04
X$6569 17117 18434 18553 18731 18571 gf180mcu_fd_sc_mcu9t5v0__nand2_1
* cell instance $6570 m0 *1 581.84,1139.04
X$6570 18571 15569 18553 18731 18572 gf180mcu_fd_sc_mcu9t5v0__nand2_1
* cell instance $6571 r0 *1 566.72,1128.96
X$6571 18093 18262 17117 11958 18553 18386 gf180mcu_fd_sc_mcu9t5v0__dffrnq_2
* cell instance $6572 r0 *1 568.96,1118.88
X$6572 18432 17117 18268 18104 17942 gf180mcu_fd_sc_mcu9t5v0__nand2_1
* cell instance $6573 m0 *1 609.84,1169.28
X$6573 19605 19448 gf180mcu_fd_sc_mcu9t5v0__filltie
* cell instance $6574 m0 *1 593.6,1169.28
X$6574 19561 19445 19559 19448 19605 14153 gf180mcu_fd_sc_mcu9t5v0__nand3_1
* cell instance $6575 m0 *1 649.04,1128.96
X$6575 18133 18437 18263 11958 18268 18386 gf180mcu_fd_sc_mcu9t5v0__dffrnq_2
* cell instance $6576 r0 *1 636.16,1128.96
X$6576 16501 18553 18386 13154 gf180mcu_fd_sc_mcu9t5v0__buf_8
* cell instance $6577 r0 *1 636.16,1149.12
X$6577 19169 18959 19171 18996 19122 gf180mcu_fd_sc_mcu9t5v0__nand2_1
* cell instance $6578 r0 *1 624.96,1118.88
X$6578 18263 18264 18268 18104 17705 gf180mcu_fd_sc_mcu9t5v0__nand2_1
* cell instance $6579 m0 *1 641.76,1169.28
X$6579 19121 19448 19605 19274 gf180mcu_fd_sc_mcu9t5v0__dlyc_1
* cell instance $6580 m0 *1 631.68,1118.88
X$6580 20326 17983 17945 11958 17985 18104 gf180mcu_fd_sc_mcu9t5v0__dffrnq_2
* cell instance $6581 m0 *1 657.44,1139.04
X$6581 19114 18727 18553 18731 18440 gf180mcu_fd_sc_mcu9t5v0__nand2_1
* cell instance $6582 m0 *1 654.64,1149.12
X$6582 18960 18841 18996 13002 gf180mcu_fd_sc_mcu9t5v0__buf_8
* cell instance $6583 r0 *1 665.28,1149.12
X$6583 18133 13001 20336 11958 19171 18996 gf180mcu_fd_sc_mcu9t5v0__dffrnq_2
* cell instance $6584 r0 *1 632.24,1139.04
X$6584 18959 18841 18731 18837 gf180mcu_fd_sc_mcu9t5v0__clkinv_1
* cell instance $6585 m0 *1 682.64,1128.96
X$6585 18379 18268 18386 18378 gf180mcu_fd_sc_mcu9t5v0__clkinv_1
* cell instance $6586 m0 *1 681.52,1139.04
X$6586 18379 18575 18553 18731 13825 gf180mcu_fd_sc_mcu9t5v0__nand2_1
* cell instance $6587 r0 *1 675.92,1108.8
X$6587 13159 17946 14702 17985 17837 17707 gf180mcu_fd_sc_mcu9t5v0__mux2_1
* cell instance $6588 r0 *1 664.72,1128.96
X$6588 18440 18553 18386 18441 gf180mcu_fd_sc_mcu9t5v0__buf_8
* cell instance $6589 m0 *1 678.16,1128.96
X$6589 18378 18575 15518 18268 18386 18265 gf180mcu_fd_sc_mcu9t5v0__oai21_1
* cell instance $6590 r0 *1 656.32,1128.96
X$6590 18438 18575 13825 18553 18386 18437 gf180mcu_fd_sc_mcu9t5v0__oai21_1
* cell instance $6591 m0 *1 670.32,1169.28
X$6591 19566 19278 19448 19605 19565 gf180mcu_fd_sc_mcu9t5v0__nand2_1
* cell instance $6592 r0 *1 653.52,1108.8
X$6592 16641 17834 17706 11958 17985 17837 gf180mcu_fd_sc_mcu9t5v0__dffrnq_2
* cell instance $6593 m0 *1 622.72,1159.2
X$6593 3795 19275 19171 19282 19893 gf180mcu_fd_sc_mcu9t5v0__nand2_1
* cell instance $6594 r0 *1 627.2,1159.2
X$6594 19276 19275 19448 19282 19564 gf180mcu_fd_sc_mcu9t5v0__nand2_1
* cell instance $6595 m0 *1 672.56,1159.2
X$6595 15529 19279 19171 19282 18961 gf180mcu_fd_sc_mcu9t5v0__nor2_4
* cell instance $6596 r0 *1 660.8,1128.96
X$6596 18263 18553 18386 18438 gf180mcu_fd_sc_mcu9t5v0__clkinv_1
* cell instance $6597 r0 *1 657.44,1149.12
X$6597 18438 15529 19279 19171 18996 18960 gf180mcu_fd_sc_mcu9t5v0__nor3_2
* cell instance $6598 r0 *1 626.64,1139.04
X$6598 19169 18837 18574 18841 18731 18838 gf180mcu_fd_sc_mcu9t5v0__oai21_1
* cell instance $6599 r0 *1 637.28,1159.2
X$6599 19396 19278 19448 19282 19394 gf180mcu_fd_sc_mcu9t5v0__nand2_1
* cell instance $6600 r0 *1 637.84,1108.8
X$6600 13010 17080 14702 17945 17985 17837 17944
+ gf180mcu_fd_sc_mcu9t5v0__aoi22_1
* cell instance $6601 r0 *1 642.88,1149.12
X$6601 17393 19171 18996 19113 gf180mcu_fd_sc_mcu9t5v0__buf_8
* cell instance $6602 m0 *1 634.48,1128.96
X$6602 5662 18268 18386 14123 gf180mcu_fd_sc_mcu9t5v0__buf_1
* cell instance $6603 r0 *1 640.08,1159.2
X$6603 18133 19395 19396 11958 19448 19282 gf180mcu_fd_sc_mcu9t5v0__dffrnq_2
* cell instance $6604 m0 *1 624.4,1149.12
X$6604 18133 18838 18959 11958 18841 18996 gf180mcu_fd_sc_mcu9t5v0__dffrnq_2
* cell instance $6605 m0 *1 623.84,1169.28
X$6605 7549 19564 19448 19605 19852 gf180mcu_fd_sc_mcu9t5v0__or2_1
* cell instance $6606 r0 *1 647.36,1139.04
X$6606 18576 18575 18841 18731 18727 gf180mcu_fd_sc_mcu9t5v0__and2_1
* cell instance $6607 m0 *1 629.44,1139.04
X$6607 16501 18553 18731 18578 gf180mcu_fd_sc_mcu9t5v0__clkinv_1
* cell instance $6608 r0 *1 635.6,1108.8
X$6608 17944 17985 17837 17983 gf180mcu_fd_sc_mcu9t5v0__clkinv_1
* cell instance $6609 r0 *1 630.56,1159.2
X$6609 19276 19275 19562 19394 19448 19282 19395
+ gf180mcu_fd_sc_mcu9t5v0__oai31_1
* cell instance $6610 r0 *1 692.72,1169.28
X$6610 18576 19170 19729 19605 19601 gf180mcu_fd_sc_mcu9t5v0__nand2_1
* cell instance $6611 r0 *1 729.68,1169.28
X$6611 19605 19729 gf180mcu_fd_sc_mcu9t5v0__filltie
* cell instance $6612 r0 *1 784,1169.28
X$6612 19567 19729 19605 18581 gf180mcu_fd_sc_mcu9t5v0__clkbuf_8
* cell instance $6613 r0 *1 739.2,1169.28
X$6613 19857 15529 19279 19729 19605 21535 gf180mcu_fd_sc_mcu9t5v0__nor3_1
* cell instance $6614 r0 *1 781.76,1169.28
X$6614 18581 19729 19605 33574 gf180mcu_fd_sc_mcu9t5v0__clkinv_1
* cell instance $6615 r0 *1 748.72,1169.28
X$6615 18581 19728 19730 12383 19729 19605 gf180mcu_fd_sc_mcu9t5v0__dffrnq_2
* cell instance $6616 m0 *1 784,1179.36
X$6616 19281 19604 18585 19729 19901 19603 gf180mcu_fd_sc_mcu9t5v0__mux2_1
* cell instance $6617 m0 *1 708.4,1179.36
X$6617 20693 19856 19897 19855 19285 19729 19901 19899
+ gf180mcu_fd_sc_mcu9t5v0__aoi221_1
* cell instance $6618 m0 *1 757.68,1239.84
X$6618 21409 21583 21359 12383 21537 21719 gf180mcu_fd_sc_mcu9t5v0__dffrnq_2
* cell instance $6619 m0 *1 757.68,1219.68
X$6619 20077 20936 21123 21122 gf180mcu_fd_sc_mcu9t5v0__buf_8
* cell instance $6620 m0 *1 719.04,1179.36
X$6620 19170 19729 19901 19900 gf180mcu_fd_sc_mcu9t5v0__buf_8
* cell instance $6621 m0 *1 757.12,1179.36
X$6621 19730 19900 19729 19901 19858 gf180mcu_fd_sc_mcu9t5v0__nor2_1
* cell instance $6622 m0 *1 750.96,1179.36
X$6622 19397 19900 19858 19729 19901 19728 gf180mcu_fd_sc_mcu9t5v0__aoi21_1
* cell instance $6623 m0 *1 737.52,1179.36
X$6623 20338 19857 19729 19901 19727 gf180mcu_fd_sc_mcu9t5v0__nand2_1
* cell instance $6624 m0 *1 758.8,1189.44
X$6624 19730 19900 20028 20217 20215 gf180mcu_fd_sc_mcu9t5v0__nand2_1
* cell instance $6625 r0 *1 757.12,1189.44
X$6625 18581 20216 19399 12383 20379 20217 gf180mcu_fd_sc_mcu9t5v0__dffrnq_2
* cell instance $6626 r0 *1 755.44,1128.96
X$6626 18581 18384 18443 12383 18553 18386 gf180mcu_fd_sc_mcu9t5v0__dffrnq_2
* cell instance $6627 r0 *1 758.24,1139.04
X$6627 18995 18841 18731 18730 gf180mcu_fd_sc_mcu9t5v0__clkinv_1
* cell instance $6628 r0 *1 754.88,1159.2
X$6628 19126 19398 19397 18729 19448 19282 19447
+ gf180mcu_fd_sc_mcu9t5v0__nand4_1
* cell instance $6629 m0 *1 749.28,1149.12
X$6629 18581 18839 18995 12383 18841 18996 gf180mcu_fd_sc_mcu9t5v0__dffrnq_2
* cell instance $6630 r0 *1 754.88,1149.12
X$6630 18385 19124 18576 18995 19171 18996 19126 gf180mcu_fd_sc_mcu9t5v0__nor4_1
* cell instance $6631 m0 *1 758.24,1128.96
X$6631 18269 18136 18268 18386 18384 gf180mcu_fd_sc_mcu9t5v0__nand2_1
* cell instance $6632 r0 *1 746.48,1229.76
X$6632 21535 21537 21412 21536 gf180mcu_fd_sc_mcu9t5v0__buf_8
* cell instance $6633 m0 *1 696.08,1179.36
X$6633 19855 19729 19901 19898 gf180mcu_fd_sc_mcu9t5v0__clkinv_1
* cell instance $6634 m0 *1 714.56,1179.36
X$6634 19856 19729 19901 19568 gf180mcu_fd_sc_mcu9t5v0__clkinv_1
* cell instance $6635 r0 *1 698.88,1169.28
X$6635 18133 19602 19856 11958 19729 19605 gf180mcu_fd_sc_mcu9t5v0__dffrnq_2
* cell instance $6636 m0 *1 813.68,1219.68
X$6636 18585 20937 20989 20936 21123 20988 gf180mcu_fd_sc_mcu9t5v0__oai21_1
* cell instance $6637 r0 *1 811.44,1209.6
X$6637 19566 13826 20936 20822 20937 gf180mcu_fd_sc_mcu9t5v0__nand2_1
* cell instance $6638 m0 *1 793.52,1189.44
X$6638 18581 20079 20080 20028 20217 gf180mcu_fd_sc_mcu9t5v0__dffq_2
* cell instance $6639 r0 *1 788.48,1229.76
X$6639 21409 21411 21361 12383 21537 21412 gf180mcu_fd_sc_mcu9t5v0__dffrnq_2
* cell instance $6640 m0 *1 819.28,1219.68
X$6640 20990 18585 20936 21123 20989 gf180mcu_fd_sc_mcu9t5v0__nand2_1
* cell instance $6641 m0 *1 809.2,1239.84
X$6641 21409 21585 21414 12383 21537 21719 gf180mcu_fd_sc_mcu9t5v0__dffrnq_2
* cell instance $6642 m0 *1 795.76,1209.6
X$6642 13159 20508 19284 20637 20822 20821 gf180mcu_fd_sc_mcu9t5v0__mux2_1
* cell instance $6643 r0 *1 789.6,1209.6
X$6643 18581 20821 20508 12383 20936 20822 gf180mcu_fd_sc_mcu9t5v0__dffrnq_2
* cell instance $6644 m0 *1 795.76,1239.84
X$6644 14854 21584 20215 21537 21719 21718 gf180mcu_fd_sc_mcu9t5v0__mux2_1
* cell instance $6645 m0 *1 774.48,1189.44
X$6645 18581 20078 20029 12383 20028 20217 gf180mcu_fd_sc_mcu9t5v0__dffrnq_2
* cell instance $6646 m0 *1 766.08,1189.44
X$6646 19399 19900 20028 20217 20214 gf180mcu_fd_sc_mcu9t5v0__nand2_1
* cell instance $6647 m0 *1 768.88,1189.44
X$6647 19399 20028 20217 19570 gf180mcu_fd_sc_mcu9t5v0__clkinv_1
* cell instance $6648 r0 *1 781.2,1179.36
X$6648 14809 20029 19284 20028 19901 20078 gf180mcu_fd_sc_mcu9t5v0__mux2_1
* cell instance $6649 r0 *1 780.08,1199.52
X$6649 20506 20639 18585 20637 20507 20638 gf180mcu_fd_sc_mcu9t5v0__mux2_1
* cell instance $6650 r0 *1 763.84,1209.6
X$6650 18581 20820 20506 12383 20936 20822 gf180mcu_fd_sc_mcu9t5v0__dffrnq_2
* cell instance $6651 m0 *1 761.6,1189.44
X$6651 19570 19900 19284 20028 20217 20216 gf180mcu_fd_sc_mcu9t5v0__oai21_1
* cell instance $6652 m0 *1 768.88,1209.6
X$6652 13010 20506 19284 20637 20822 20820 gf180mcu_fd_sc_mcu9t5v0__mux2_1
* cell instance $6653 m0 *1 776.16,1229.76
X$6653 21359 21360 18585 21241 21412 21410 gf180mcu_fd_sc_mcu9t5v0__mux2_1
* cell instance $6654 m0 *1 776.16,1209.6
X$6654 18581 20638 20639 20637 20822 gf180mcu_fd_sc_mcu9t5v0__dffq_2
* cell instance $6655 r0 *1 815.92,1229.76
X$6655 21414 21413 21536 21537 21412 21585 gf180mcu_fd_sc_mcu9t5v0__mux2_1
* cell instance $6656 r0 *1 764.4,1229.76
X$6656 13874 21359 19284 21537 21412 21583 gf180mcu_fd_sc_mcu9t5v0__mux2_1
* cell instance $6657 m0 *1 803.6,1199.52
X$6657 14854 20380 18840 20379 20507 20339 gf180mcu_fd_sc_mcu9t5v0__mux2_1
* cell instance $6658 r0 *1 799.68,1189.44
X$6658 18581 20339 20380 12383 20379 20217 gf180mcu_fd_sc_mcu9t5v0__dffrnq_2
* cell instance $6659 r0 *1 815.92,1199.52
X$6659 20508 20510 18585 20637 20507 20509 gf180mcu_fd_sc_mcu9t5v0__mux2_1
* cell instance $6660 r0 *1 809.76,1219.68
X$6660 21409 20988 20990 21241 21123 gf180mcu_fd_sc_mcu9t5v0__dffq_2
* cell instance $6661 m0 *1 815.36,1229.76
X$6661 20819 20937 21241 21412 21413 gf180mcu_fd_sc_mcu9t5v0__nand2_1
* cell instance $6662 r0 *1 792.96,1179.36
X$6662 20029 20080 18585 20028 19901 20079 gf180mcu_fd_sc_mcu9t5v0__mux2_1
* cell instance $6663 r0 *1 771.68,1229.76
X$6663 21409 21410 21360 21537 21412 gf180mcu_fd_sc_mcu9t5v0__dffq_2
* cell instance $6664 m0 *1 793.52,1229.76
X$6664 13010 21361 20215 21241 21412 21411 gf180mcu_fd_sc_mcu9t5v0__mux2_1
* cell instance $6665 r0 *1 698.88,1189.44
X$6665 20204 19170 20379 20217 20211 gf180mcu_fd_sc_mcu9t5v0__nand2_1
* cell instance $6666 m0 *1 731.92,1199.52
X$6666 19566 20504 19899 20337 20379 20507 20378
+ gf180mcu_fd_sc_mcu9t5v0__oai211_1
* cell instance $6667 r0 *1 714,1189.44
X$6667 20503 19170 20211 18576 20379 20217 20337
+ gf180mcu_fd_sc_mcu9t5v0__aoi22_1
* cell instance $6668 m0 *1 722.96,1199.52
X$6668 20212 19170 20379 20507 20504 gf180mcu_fd_sc_mcu9t5v0__nand2_1
* cell instance $6669 m0 *1 720.72,1219.68
X$6669 21120 20936 21123 15267 gf180mcu_fd_sc_mcu9t5v0__buf_8
* cell instance $6670 m0 *1 698.88,1219.68
X$6670 22833 21117 21236 20936 21123 21119 gf180mcu_fd_sc_mcu9t5v0__mux2_1
* cell instance $6671 r0 *1 729.68,1199.52
X$6671 20507 20637 gf180mcu_fd_sc_mcu9t5v0__filltie
* cell instance $6672 m0 *1 733.04,1209.6
X$6672 18133 20378 18576 11958 20822 20637 gf180mcu_fd_sc_mcu9t5v0__dffsnq_2
* cell instance $6673 r0 *1 736.4,1219.68
X$6673 13010 21240 20986 21241 21123 21239 gf180mcu_fd_sc_mcu9t5v0__mux2_1
* cell instance $6674 r0 *1 732.48,1229.76
X$6674 14166 21534 20986 21537 21412 21582 gf180mcu_fd_sc_mcu9t5v0__mux2_1
* cell instance $6675 m0 *1 707.28,1239.84
X$6675 21238 21580 21581 11958 21537 21719 gf180mcu_fd_sc_mcu9t5v0__dffrnq_2
* cell instance $6676 r0 *1 729.68,1219.68
X$6676 21123 21241 gf180mcu_fd_sc_mcu9t5v0__filltie
* cell instance $6677 r0 *1 720.72,1199.52
X$6677 20503 20637 20507 20338 gf180mcu_fd_sc_mcu9t5v0__clkinv_1
* cell instance $6678 m0 *1 736.4,1189.44
X$6678 20212 20028 20217 19857 gf180mcu_fd_sc_mcu9t5v0__clkinv_1
* cell instance $6679 m0 *1 726.32,1199.52
X$6679 19566 20504 20377 20338 20379 20507 20505
+ gf180mcu_fd_sc_mcu9t5v0__oai22_1
* cell instance $6680 m0 *1 753.76,1219.68
X$6680 21121 19851 20818 20936 21123 20987 gf180mcu_fd_sc_mcu9t5v0__nand3_1
* cell instance $6681 r0 *1 747.6,1179.36
X$6681 19566 20212 20028 19901 19397 gf180mcu_fd_sc_mcu9t5v0__nand2_1
* cell instance $6682 r0 *1 696.64,1219.68
X$6682 21238 21119 21117 11958 21241 21123 gf180mcu_fd_sc_mcu9t5v0__dffrnq_2
* cell instance $6683 r0 *1 729.68,1189.44
X$6683 20217 20379 gf180mcu_fd_sc_mcu9t5v0__filltie
* cell instance $6684 r0 *1 729.68,1229.76
X$6684 21412 21537 gf180mcu_fd_sc_mcu9t5v0__filltie
* cell instance $6685 r0 *1 730.8,1209.6
X$6685 13868 20936 20822 13159 gf180mcu_fd_sc_mcu9t5v0__clkbuf_1
* cell instance $6686 r0 *1 715.68,1229.76
X$6686 15401 21581 20986 21537 21412 21580 gf180mcu_fd_sc_mcu9t5v0__mux2_1
* cell instance $6687 r0 *1 755.44,1209.6
X$6687 21121 20027 19852 20936 20822 20819 gf180mcu_fd_sc_mcu9t5v0__nand3_1
* cell instance $6688 r0 *1 733.04,1189.44
X$6688 18133 20213 20212 11958 20379 20217 gf180mcu_fd_sc_mcu9t5v0__dffrnq_2
* cell instance $6689 r0 *1 750.96,1209.6
X$6689 14298 19852 20936 20822 20818 gf180mcu_fd_sc_mcu9t5v0__or2_1
* cell instance $6690 m0 *1 738.64,1189.44
X$6690 19857 19900 20214 20028 20217 20213 gf180mcu_fd_sc_mcu9t5v0__oai21_1
* cell instance $6691 m0 *1 692.16,1199.52
X$6691 13904 20375 20379 20507 14964 gf180mcu_fd_sc_mcu9t5v0__nor2_1
* cell instance $6692 m0 *1 692.16,1209.6
X$6692 18133 20692 20693 11958 20637 20822 gf180mcu_fd_sc_mcu9t5v0__dffrnq_2
* cell instance $6693 m0 *1 710.64,1219.68
X$6693 13904 20980 21118 14445 20936 21123 21120
+ gf180mcu_fd_sc_mcu9t5v0__oai31_2
* cell instance $6694 m0 *1 703.36,1199.52
X$6694 18133 20376 20503 11958 20379 20507 gf180mcu_fd_sc_mcu9t5v0__dffrnq_2
* cell instance $6695 m0 *1 731.36,1229.76
X$6695 18133 21239 21240 11958 21241 21412 gf180mcu_fd_sc_mcu9t5v0__dffrnq_2
* cell instance $6696 r0 *1 729.68,1209.6
X$6696 20822 20936 gf180mcu_fd_sc_mcu9t5v0__filltie
* cell instance $6697 m0 *1 726.32,1239.84
X$6697 21238 21582 21534 11958 21537 21719 gf180mcu_fd_sc_mcu9t5v0__dffrnq_2
* cell instance $6698 r0 *1 694.4,1229.76
X$6698 21117 21579 21578 20983 21537 21412 21118
+ gf180mcu_fd_sc_mcu9t5v0__aoi211_1
* cell instance $6699 r0 *1 719.04,1189.44
X$6699 20338 19170 20215 20379 20217 20376 gf180mcu_fd_sc_mcu9t5v0__oai21_1
* cell instance $6700 r0 *1 729.68,1179.36
X$6700 19901 20028 gf180mcu_fd_sc_mcu9t5v0__filltie
* cell instance $6701 r0 *1 723.52,1189.44
X$6701 19566 19170 20379 20217 20377 gf180mcu_fd_sc_mcu9t5v0__nand2_1
* cell instance $6702 m0 *1 714.56,1128.96
X$6702 18099 13193 13151 18268 18386 18381 gf180mcu_fd_sc_mcu9t5v0__aoi21_1
* cell instance $6703 m0 *1 715.68,1159.2
X$6703 19170 19171 19282 17986 gf180mcu_fd_sc_mcu9t5v0__buf_8
* cell instance $6704 m0 *1 702.8,1159.2
X$6704 19124 19171 19282 19280 gf180mcu_fd_sc_mcu9t5v0__clkinv_1
* cell instance $6705 m0 *1 708.96,1118.88
X$6705 18099 12245 17985 18104 17984 gf180mcu_fd_sc_mcu9t5v0__nand2_1
* cell instance $6706 m0 *1 697.2,1159.2
X$6706 19280 19170 19278 19171 19282 19123 gf180mcu_fd_sc_mcu9t5v0__oai21_1
* cell instance $6707 m0 *1 756.56,1118.88
X$6707 12898 18101 17985 18104 18136 gf180mcu_fd_sc_mcu9t5v0__nand2_1
* cell instance $6708 r0 *1 729.68,1128.96
X$6708 18386 18553 gf180mcu_fd_sc_mcu9t5v0__filltie
* cell instance $6709 r0 *1 695.52,1149.12
X$6709 18133 19123 19124 11958 19171 18996 gf180mcu_fd_sc_mcu9t5v0__dffrnq_2
* cell instance $6710 m0 *1 736.4,1139.04
X$6710 18576 19114 17986 18552 18553 18731 16917
+ gf180mcu_fd_sc_mcu9t5v0__nand4_1
* cell instance $6711 r0 *1 729.68,1139.04
X$6711 18731 18841 gf180mcu_fd_sc_mcu9t5v0__filltie
* cell instance $6712 m0 *1 705.04,1118.88
X$6712 17984 16916 17985 18104 18134 gf180mcu_fd_sc_mcu9t5v0__nand2_1
* cell instance $6713 m0 *1 715.68,1139.04
X$6713 18580 15269 15399 18380 18553 18731 18442
+ gf180mcu_fd_sc_mcu9t5v0__aoi22_1
* cell instance $6714 r0 *1 744.8,1118.88
X$6714 18266 18136 15400 18268 18104 18135 gf180mcu_fd_sc_mcu9t5v0__aoi21_1
* cell instance $6715 r0 *1 729.68,1159.2
X$6715 19282 19448 gf180mcu_fd_sc_mcu9t5v0__filltie
* cell instance $6716 r0 *1 729.68,1149.12
X$6716 18996 19171 gf180mcu_fd_sc_mcu9t5v0__filltie
* cell instance $6717 r0 *1 735.28,1149.12
X$6717 18994 19171 18996 18728 gf180mcu_fd_sc_mcu9t5v0__clkinv_1
* cell instance $6718 r0 *1 729.68,1118.88
X$6718 18104 18268 gf180mcu_fd_sc_mcu9t5v0__filltie
* cell instance $6719 r0 *1 730.8,1118.88
X$6719 18135 18268 18104 18382 gf180mcu_fd_sc_mcu9t5v0__clkinv_1
* cell instance $6720 m0 *1 706.72,1139.04
X$6720 13159 18580 16439 18553 18731 18579 gf180mcu_fd_sc_mcu9t5v0__mux2_1
* cell instance $6721 m0 *1 725.2,1149.12
X$6721 18133 18962 18994 12383 18841 18996 gf180mcu_fd_sc_mcu9t5v0__dffrnq_2
* cell instance $6722 r0 *1 743.12,1139.04
X$6722 18994 18266 18841 18731 18729 gf180mcu_fd_sc_mcu9t5v0__nand2_1
* cell instance $6723 r0 *1 731.36,1139.04
X$6723 18728 18383 18441 18841 18731 18962 gf180mcu_fd_sc_mcu9t5v0__oai21_1
* cell instance $6724 r0 *1 732.48,1149.12
X$6724 18994 18383 19171 18996 19125 gf180mcu_fd_sc_mcu9t5v0__nand2_1
* cell instance $6725 r0 *1 737.52,1128.96
X$6725 18266 18443 18440 18553 18386 18267 gf180mcu_fd_sc_mcu9t5v0__nor3_1
* cell instance $6726 m0 *1 694.4,1169.28
X$6726 19567 19448 19605 18133 gf180mcu_fd_sc_mcu9t5v0__clkbuf_8
* cell instance $6727 r0 *1 729.68,1108.8
X$6727 17837 17985 gf180mcu_fd_sc_mcu9t5v0__filltie
* cell instance $6728 m0 *1 741.44,1128.96
X$6728 18267 18268 18386 15400 gf180mcu_fd_sc_mcu9t5v0__buf_8
* cell instance $6729 r0 *1 718.48,1128.96
X$6729 18100 18381 18442 13151 18553 18386 18993
+ gf180mcu_fd_sc_mcu9t5v0__aoi22_1
* cell instance $6730 r0 *1 753.76,1139.04
X$6730 18730 17986 18840 18841 18731 18839 gf180mcu_fd_sc_mcu9t5v0__oai21_1
* cell instance $6731 r0 *1 752.64,1108.8
X$6731 15529 18729 17985 17837 17397 gf180mcu_fd_sc_mcu9t5v0__nor2_1
* cell instance $6732 r0 *1 752.08,1149.12
X$6732 19124 17986 19171 18996 18840 gf180mcu_fd_sc_mcu9t5v0__nand2_1
* cell instance $6733 m0 *1 729.12,1169.28
X$6733 18993 19448 19605 19569 gf180mcu_fd_sc_mcu9t5v0__buf_8
* cell instance $6734 r0 *1 734.16,1128.96
X$6734 18266 18443 18553 18386 18552 gf180mcu_fd_sc_mcu9t5v0__nor2_1
* cell instance $6735 m0 *1 722.4,1128.96
X$6735 18133 18382 18266 12383 18268 18386 gf180mcu_fd_sc_mcu9t5v0__dffrnq_2
* cell instance $6736 r0 *1 698.32,1139.04
X$6736 18133 18579 18580 11958 18841 18731 gf180mcu_fd_sc_mcu9t5v0__dffrnq_2
* cell instance $6737 r0 *1 697.76,1118.88
X$6737 18133 18134 18099 11958 18268 18104 gf180mcu_fd_sc_mcu9t5v0__dffrnq_2
* cell instance $6738 m0 *1 711.76,1169.28
X$6738 20693 19568 19125 19448 19605 19602 gf180mcu_fd_sc_mcu9t5v0__oai21_1
* cell instance $6739 r0 *1 694.4,1139.04
X$6739 14123 18841 18731 13874 gf180mcu_fd_sc_mcu9t5v0__clkbuf_1
* cell instance $6740 m0 *1 777.28,1169.28
X$6740 18581 19603 19604 19448 19605 gf180mcu_fd_sc_mcu9t5v0__dffq_2
* cell instance $6741 m0 *1 761.04,1169.28
X$6741 19570 15529 19279 19448 19605 20077 gf180mcu_fd_sc_mcu9t5v0__nor3_1
* cell instance $6742 r0 *1 770,1118.88
X$6742 15857 12898 18443 18268 18104 18269 gf180mcu_fd_sc_mcu9t5v0__oai21_1
* cell instance $6743 r0 *1 777.28,1139.04
X$6743 13874 18582 18840 18841 18731 18842 gf180mcu_fd_sc_mcu9t5v0__mux2_1
* cell instance $6744 m0 *1 775.6,1128.96
X$6744 18581 18138 18383 12383 18268 18386 gf180mcu_fd_sc_mcu9t5v0__dffrnq_2
* cell instance $6745 m0 *1 797.44,1169.28
X$6745 18581 19449 19401 12383 19448 19605 gf180mcu_fd_sc_mcu9t5v0__dffrnq_2
* cell instance $6746 r0 *1 761.6,1159.2
X$6746 17839 18379 19730 19399 19448 19282 19398 gf180mcu_fd_sc_mcu9t5v0__nor4_1
* cell instance $6747 m0 *1 771.68,1149.12
X$6747 18581 18842 18582 12383 18841 18996 gf180mcu_fd_sc_mcu9t5v0__dffrnq_2
* cell instance $6748 m0 *1 781.2,1159.2
X$6748 13010 19281 18840 19171 19282 19400 gf180mcu_fd_sc_mcu9t5v0__mux2_1
* cell instance $6749 m0 *1 773.36,1128.96
X$6749 18443 18268 18386 18137 gf180mcu_fd_sc_mcu9t5v0__clkinv_1
* cell instance $6750 r0 *1 775.04,1118.88
X$6750 15857 18137 12898 18268 18104 18138 gf180mcu_fd_sc_mcu9t5v0__nor3_1
* cell instance $6751 m0 *1 761.6,1118.88
X$6751 13904 17980 17949 17522 17985 18104 18102
+ gf180mcu_fd_sc_mcu9t5v0__oai31_2
* cell instance $6752 m0 *1 795.76,1139.04
X$6752 18582 18584 18585 18553 18731 18583 gf180mcu_fd_sc_mcu9t5v0__mux2_1
* cell instance $6753 m0 *1 798.56,1128.96
X$6753 18385 18268 18386 17987 gf180mcu_fd_sc_mcu9t5v0__clkinv_1
* cell instance $6754 m0 *1 796.88,1118.88
X$6754 17987 17986 17572 17950 17985 18104 18103
+ gf180mcu_fd_sc_mcu9t5v0__oai211_1
* cell instance $6755 m0 *1 796.88,1149.12
X$6755 18581 18963 18997 12383 18841 18996 gf180mcu_fd_sc_mcu9t5v0__dffrnq_2
* cell instance $6756 m0 *1 802.48,1118.88
X$6756 18385 17986 17985 18104 13427 gf180mcu_fd_sc_mcu9t5v0__nand2_1
* cell instance $6757 r0 *1 764.4,1149.12
X$6757 18995 17986 19171 18996 19284 gf180mcu_fd_sc_mcu9t5v0__nand2_1
* cell instance $6758 r0 *1 773.92,1159.2
X$6758 18581 19400 19281 12383 19448 19282 gf180mcu_fd_sc_mcu9t5v0__dffrnq_2
* cell instance $6759 r0 *1 803.04,1159.2
X$6759 14856 19401 19284 19448 19282 19449 gf180mcu_fd_sc_mcu9t5v0__mux2_1
* cell instance $6760 r0 *1 818.72,1139.04
X$6760 18997 18586 18585 18841 18731 18843 gf180mcu_fd_sc_mcu9t5v0__mux2_1
* cell instance $6761 r0 *1 791.84,1118.88
X$6761 18581 18103 18385 12383 18268 18104 gf180mcu_fd_sc_mcu9t5v0__dffrnq_2
* cell instance $6762 r0 *1 817.6,1128.96
X$6762 13159 18388 16141 18553 18386 18387 gf180mcu_fd_sc_mcu9t5v0__mux2_1
* cell instance $6763 r0 *1 778.96,1128.96
X$6763 14298 18553 18386 14809 gf180mcu_fd_sc_mcu9t5v0__clkbuf_1
* cell instance $6764 r0 *1 810.88,1118.88
X$6764 17399 18268 18104 18139 gf180mcu_fd_sc_mcu9t5v0__buf_8
* cell instance $6765 r0 *1 801.92,1149.12
X$6765 14854 18997 19284 19171 18996 18963 gf180mcu_fd_sc_mcu9t5v0__mux2_1
* cell instance $6766 r0 *1 792.4,1139.04
X$6766 18581 18583 18584 18841 18731 gf180mcu_fd_sc_mcu9t5v0__dffq_2
* cell instance $6767 r0 *1 771.12,1108.8
X$6767 18102 17985 17837 3797 gf180mcu_fd_sc_mcu9t5v0__buf_8
* cell instance $6768 m0 *1 948.64,1370.88
X$6768 23685 25433 25434 12383 25430 25581 gf180mcu_fd_sc_mcu9t5v0__dffrnq_2
* cell instance $6769 m0 *1 960.4,1300.32
X$6769 20944 23377 23509 13331 23319 23504 gf180mcu_fd_sc_mcu9t5v0__dffrnq_2
* cell instance $6770 m0 *1 966,1360.8
X$6770 23685 24831 25003 25158 25268 gf180mcu_fd_sc_mcu9t5v0__dffq_2
* cell instance $6771 m0 *1 960.4,1330.56
X$6771 23685 24416 24284 24232 24414 gf180mcu_fd_sc_mcu9t5v0__dffq_2
* cell instance $6772 m0 *1 964.88,1229.76
X$6772 19407 21246 21420 21241 21412 gf180mcu_fd_sc_mcu9t5v0__dffq_2
* cell instance $6773 m0 *1 962.08,1239.84
X$6773 20944 21724 21725 21537 21719 gf180mcu_fd_sc_mcu9t5v0__dffq_2
* cell instance $6774 m0 *1 957.6,1189.44
X$6774 19407 20084 20085 13331 20028 20217 gf180mcu_fd_sc_mcu9t5v0__dffrnq_2
* cell instance $6775 m0 *1 960.4,1270.08
X$6775 20944 22455 22412 13331 22449 22577 gf180mcu_fd_sc_mcu9t5v0__dffrnq_2
* cell instance $6776 r0 *1 987.84,1239.84
X$6776 21726 21843 19910 21884 21719 21844 gf180mcu_fd_sc_mcu9t5v0__mux2_1
* cell instance $6777 r0 *1 1005.2,1239.84
X$6777 20944 21845 21846 13331 21884 21719 gf180mcu_fd_sc_mcu9t5v0__dffrnq_2
* cell instance $6778 r0 *1 995.12,1239.84
X$6778 20944 21884 21719 gf180mcu_fd_sc_mcu9t5v0__clkbuf_4
* cell instance $6779 r0 *1 984.48,1239.84
X$6779 21843 18444 21884 21719 21132 gf180mcu_fd_sc_mcu9t5v0__nor2_1
* cell instance $6780 r0 *1 1098.16,1239.84
X$6780 22014 21849 21884 21719 21848 gf180mcu_fd_sc_mcu9t5v0__or2_1
* cell instance $6781 r0 *1 1093.68,1239.84
X$6781 21727 21847 21848 21884 21719 21594 gf180mcu_fd_sc_mcu9t5v0__oai21_1
* cell instance $6782 r0 *1 962.08,1300.32
X$6782 23509 23376 21122 23623 23504 23377 gf180mcu_fd_sc_mcu9t5v0__mux2_1
* cell instance $6783 r0 *1 962.08,1330.56
X$6783 24088 24284 19862 24528 24414 24416 gf180mcu_fd_sc_mcu9t5v0__mux2_1
* cell instance $6784 m0 *1 962.64,1350.72
X$6784 24961 18966 18394 24828 25000 16198 gf180mcu_fd_sc_mcu9t5v0__nor3_1
* cell instance $6785 r0 *1 878.08,1239.84
X$6785 21721 18590 21126 4669 21884 21719 21841 gf180mcu_fd_sc_mcu9t5v0__aoi22_1
* cell instance $6786 r0 *1 892.64,1239.84
X$6786 16789 20824 21884 21719 21842 gf180mcu_fd_sc_mcu9t5v0__nor2_1
* cell instance $6787 r0 *1 865.76,1239.84
X$6787 21722 21245 21884 21719 21723 gf180mcu_fd_sc_mcu9t5v0__nand2_1
* cell instance $6788 r0 *1 858.48,1239.84
X$6788 21722 22004 21536 21884 21719 21885 gf180mcu_fd_sc_mcu9t5v0__mux2_1
* cell instance $6789 r0 *1 969.36,1239.84
X$6789 21719 21884 gf180mcu_fd_sc_mcu9t5v0__filltie
* cell instance $6790 r0 *1 952,1239.84
X$6790 21725 19862 21245 21887 21884 21719 22008
+ gf180mcu_fd_sc_mcu9t5v0__aoi22_1
* cell instance $6791 m0 *1 963.76,1290.24
X$6791 23014 18590 21126 11861 23038 23200 23162
+ gf180mcu_fd_sc_mcu9t5v0__aoi22_1
* cell instance $6792 m0 *1 958.72,1260
X$6792 20944 21592 22299 22124 22295 gf180mcu_fd_sc_mcu9t5v0__dffq_2
* cell instance $6793 m0 *1 949.2,1169.28
X$6793 17247 19452 19409 13331 19448 19605 gf180mcu_fd_sc_mcu9t5v0__dffrnq_2
* cell instance $6794 r0 *1 952.56,1219.68
X$6794 19407 21366 21130 21241 21123 gf180mcu_fd_sc_mcu9t5v0__dffq_2
* cell instance $6795 m0 *1 952.56,1209.6
X$6795 19407 20645 20694 13331 20637 20822 gf180mcu_fd_sc_mcu9t5v0__dffrnq_2
* cell instance $6796 r0 *1 953.68,1209.6
X$6796 19402 20936 20822 19407 gf180mcu_fd_sc_mcu9t5v0__clkbuf_8
* cell instance $6797 r0 *1 964.32,1159.2
X$6797 18597 19408 18847 19410 19448 19282 19453
+ gf180mcu_fd_sc_mcu9t5v0__aoi22_1
* cell instance $6798 m0 *1 953.68,1118.88
X$6798 17247 18108 18109 13331 17985 18104 gf180mcu_fd_sc_mcu9t5v0__dffrnq_2
* cell instance $6799 r0 *1 965.44,1139.04
X$6799 18148 18735 18596 18841 18731 18849 gf180mcu_fd_sc_mcu9t5v0__nand3_1
* cell instance $6800 m0 *1 965.44,1128.96
X$6800 18148 17989 18268 18386 18394 gf180mcu_fd_sc_mcu9t5v0__nand2_1
* cell instance $6801 r0 *1 963.2,1118.88
X$6801 18148 18146 18147 18268 18104 18108 gf180mcu_fd_sc_mcu9t5v0__aoi21_1
* cell instance $6802 m0 *1 962.64,1149.12
X$6802 18848 18847 19408 18841 18996 18147 gf180mcu_fd_sc_mcu9t5v0__aoi21_1
* cell instance $6803 m0 *1 1024.24,1290.24
X$6803 23164 23044 22893 13331 23038 23200 gf180mcu_fd_sc_mcu9t5v0__dffrnq_2
* cell instance $6804 r0 *1 1035.44,1320.48
X$6804 23509 24241 19862 24232 24118 24286 gf180mcu_fd_sc_mcu9t5v0__mux2_1
* cell instance $6805 m0 *1 1027.6,1330.56
X$6805 23164 24286 24241 24232 24414 gf180mcu_fd_sc_mcu9t5v0__dffq_2
* cell instance $6806 m0 *1 1023.12,1360.8
X$6806 25164 25277 25165 13331 25158 25268 gf180mcu_fd_sc_mcu9t5v0__dffrnq_2
* cell instance $6807 m0 *1 1035.44,1310.4
X$6807 23164 23511 23512 13331 23623 23797 gf180mcu_fd_sc_mcu9t5v0__dffrnq_2
* cell instance $6808 m0 *1 1033.2,1270.08
X$6808 22457 22449 22577 22420 gf180mcu_fd_sc_mcu9t5v0__buf_8
* cell instance $6809 r0 *1 1028.72,1270.08
X$6809 22457 22700 22577 21126 gf180mcu_fd_sc_mcu9t5v0__buf_8
* cell instance $6810 r0 *1 1069.6,1310.4
X$6810 23164 23913 24092 13331 23957 23797 gf180mcu_fd_sc_mcu9t5v0__dffrnq_2
* cell instance $6811 r0 *1 1099.84,1310.4
X$6811 18604 12632 23957 23797 23640 gf180mcu_fd_sc_mcu9t5v0__nand2_1
* cell instance $6812 r0 *1 1061.2,1310.4
X$6812 23639 18590 4952 22458 18614 23957 23797 23912
+ gf180mcu_fd_sc_mcu9t5v0__aoi221_1
* cell instance $6813 r0 *1 1007.44,1310.4
X$6813 19862 23632 23957 23797 23911 gf180mcu_fd_sc_mcu9t5v0__or2_1
* cell instance $6814 r0 *1 1011.92,1310.4
X$6814 23910 23692 23957 23797 23965 gf180mcu_fd_sc_mcu9t5v0__nand2_1
* cell instance $6815 r0 *1 987.28,1310.4
X$6815 23164 23798 23910 13331 23957 23797 gf180mcu_fd_sc_mcu9t5v0__dffrnq_2
* cell instance $6816 r0 *1 1033.2,1310.4
X$6816 23690 18590 4952 22301 23957 23797 23966 gf180mcu_fd_sc_mcu9t5v0__aoi22_1
* cell instance $6817 m0 *1 1018.64,1249.92
X$6817 20944 21888 22009 13331 21884 21997 gf180mcu_fd_sc_mcu9t5v0__dffrnq_2
* cell instance $6818 r0 *1 969.36,1310.4
X$6818 23797 23957 gf180mcu_fd_sc_mcu9t5v0__filltie
* cell instance $6819 r0 *1 970.48,1310.4
X$6819 23685 23909 23690 23957 23797 gf180mcu_fd_sc_mcu9t5v0__dffq_2
* cell instance $6820 m0 *1 1051.12,1340.64
X$6820 23164 24583 23379 13331 24528 24712 gf180mcu_fd_sc_mcu9t5v0__dffrnq_2
* cell instance $6821 r0 *1 1048.88,1320.48
X$6821 23512 24287 14872 24232 24118 24242 gf180mcu_fd_sc_mcu9t5v0__mux2_1
* cell instance $6822 r0 *1 1057.28,1340.64
X$6822 25005 23379 14872 24828 24712 24583 gf180mcu_fd_sc_mcu9t5v0__mux2_1
* cell instance $6823 m0 *1 1090.32,1350.72
X$6823 24965 24585 14872 24828 25000 25007 gf180mcu_fd_sc_mcu9t5v0__mux2_1
* cell instance $6824 r0 *1 1083.6,1330.56
X$6824 24093 23921 24528 24414 24537 gf180mcu_fd_sc_mcu9t5v0__nand2_1
* cell instance $6825 m0 *1 1089.2,1340.64
X$6825 24712 24528 gf180mcu_fd_sc_mcu9t5v0__filltie
* cell instance $6826 r0 *1 1098.16,1330.56
X$6826 24127 24538 24528 24414 24419 gf180mcu_fd_sc_mcu9t5v0__nor2_1
* cell instance $6827 m0 *1 1097.04,1330.56
X$6827 18603 12632 24232 24414 24126 gf180mcu_fd_sc_mcu9t5v0__nand2_1
* cell instance $6828 r0 *1 1079.12,1330.56
X$6828 23921 24536 24537 24528 24414 24584 gf180mcu_fd_sc_mcu9t5v0__oai21_1
* cell instance $6829 m0 *1 1044.4,1330.56
X$6829 23164 24242 24287 13331 24232 24414 gf180mcu_fd_sc_mcu9t5v0__dffrnq_2
* cell instance $6830 r0 *1 1072.4,1320.48
X$6830 20996 22712 24285 24232 24118 25006 gf180mcu_fd_sc_mcu9t5v0__oai21_1
* cell instance $6831 r0 *1 1066.24,1320.48
X$6831 24091 18590 4952 22895 18614 24232 24118 24125
+ gf180mcu_fd_sc_mcu9t5v0__aoi221_1
* cell instance $6832 m0 *1 1089.2,1350.72
X$6832 25000 24828 gf180mcu_fd_sc_mcu9t5v0__filltie
* cell instance $6833 m0 *1 1089.2,1320.48
X$6833 24118 23957 gf180mcu_fd_sc_mcu9t5v0__filltie
* cell instance $6834 m0 *1 1089.2,1330.56
X$6834 24414 24232 gf180mcu_fd_sc_mcu9t5v0__filltie
* cell instance $6835 r0 *1 1081.92,1350.72
X$6835 25164 25007 24585 13331 25158 25000 gf180mcu_fd_sc_mcu9t5v0__dffrnq_2
* cell instance $6836 m0 *1 1053.36,1360.8
X$6836 24964 23921 25158 25268 25550 gf180mcu_fd_sc_mcu9t5v0__nand2_1
* cell instance $6837 m0 *1 1079.12,1320.48
X$6837 24093 24092 17977 23957 24118 23913 gf180mcu_fd_sc_mcu9t5v0__mux2_1
* cell instance $6838 m0 *1 1051.12,1350.72
X$6838 24964 25005 17977 24828 25000 25133 gf180mcu_fd_sc_mcu9t5v0__mux2_1
* cell instance $6839 m0 *1 1072.96,1360.8
X$6839 25324 24965 17977 25158 25268 25166 gf180mcu_fd_sc_mcu9t5v0__mux2_1
* cell instance $6840 r0 *1 1099.28,1320.48
X$6840 12632 24094 24419 24126 24232 24118 24243
+ gf180mcu_fd_sc_mcu9t5v0__oai31_1
* cell instance $6841 m0 *1 1089.2,1360.8
X$6841 25268 25158 gf180mcu_fd_sc_mcu9t5v0__filltie
* cell instance $6842 r0 *1 1062.88,1350.72
X$6842 25164 25166 24965 13331 25158 25000 gf180mcu_fd_sc_mcu9t5v0__dffrnq_2
* cell instance $6843 r0 *1 1083.04,1370.88
X$6843 25164 25586 25552 13331 25705 25581 gf180mcu_fd_sc_mcu9t5v0__dffrnq_2
* cell instance $6844 m0 *1 1089.2,1370.88
X$6844 25581 25430 gf180mcu_fd_sc_mcu9t5v0__filltie
* cell instance $6845 m0 *1 1051.12,1370.88
X$6845 23921 26045 25551 25550 25430 25581 25323
+ gf180mcu_fd_sc_mcu9t5v0__oai31_1
* cell instance $6846 r0 *1 1068.48,1360.8
X$6846 25324 25884 18277 25430 25268 25436 gf180mcu_fd_sc_mcu9t5v0__mux2_1
* cell instance $6847 m0 *1 1091.44,1370.88
X$6847 26308 25552 17977 25430 25581 25586 gf180mcu_fd_sc_mcu9t5v0__mux2_1
* cell instance $6848 r0 *1 1041.04,1350.72
X$6848 25164 25133 25005 13331 25158 25000 gf180mcu_fd_sc_mcu9t5v0__dffrnq_2
* cell instance $6849 m0 *1 1063.44,1370.88
X$6849 25164 25436 25324 13331 25430 25581 gf180mcu_fd_sc_mcu9t5v0__dffrnq_2
* cell instance $6850 m0 *1 1070.16,1340.64
X$6850 23164 24584 24093 13331 24528 24712 gf180mcu_fd_sc_mcu9t5v0__dffrnq_2
* cell instance $6851 r0 *1 1042.72,1360.8
X$6851 25164 25323 24964 13331 25430 25268 gf180mcu_fd_sc_mcu9t5v0__dffrnq_2
* cell instance $6852 m0 *1 1036,1350.72
X$6852 24833 18590 18614 24828 25000 24963 gf180mcu_fd_sc_mcu9t5v0__aoi21_1
* cell instance $6853 r0 *1 1029.28,1340.64
X$6853 24833 19862 24828 24712 24418 gf180mcu_fd_sc_mcu9t5v0__nand2_1
* cell instance $6854 m0 *1 1010.24,1340.64
X$6854 24962 23692 24528 24712 24581 gf180mcu_fd_sc_mcu9t5v0__nand2_1
* cell instance $6855 m0 *1 1010.24,1330.56
X$6855 24284 18590 24232 24414 24285 gf180mcu_fd_sc_mcu9t5v0__nand2_1
* cell instance $6856 r0 *1 982.8,1330.56
X$6856 24415 18590 4952 23015 24528 24414 24533 gf180mcu_fd_sc_mcu9t5v0__aoi22_1
* cell instance $6857 m0 *1 987.28,1320.48
X$6857 24089 23691 21536 23957 24118 24123 gf180mcu_fd_sc_mcu9t5v0__mux2_1
* cell instance $6858 m0 *1 982.8,1340.64
X$6858 23685 24532 24417 13331 24528 24712 gf180mcu_fd_sc_mcu9t5v0__dffrnq_2
* cell instance $6859 m0 *1 987.28,1360.8
X$6859 23685 25004 24962 13331 25158 25268 gf180mcu_fd_sc_mcu9t5v0__dffrnq_2
* cell instance $6860 r0 *1 1015.84,1330.56
X$6860 24418 24581 23911 24528 24414 24535 gf180mcu_fd_sc_mcu9t5v0__nand3_1
* cell instance $6861 m0 *1 1017.52,1340.64
X$6861 24582 19862 24528 24712 24717 gf180mcu_fd_sc_mcu9t5v0__nand2_1
* cell instance $6862 r0 *1 1001.28,1330.56
X$6862 24417 23692 24528 24414 24534 gf180mcu_fd_sc_mcu9t5v0__nand2_1
* cell instance $6863 m0 *1 991.2,1350.72
X$6863 24962 23691 21536 24828 25000 25004 gf180mcu_fd_sc_mcu9t5v0__mux2_1
* cell instance $6864 r0 *1 1011.92,1320.48
X$6864 23164 24124 24091 24232 24118 gf180mcu_fd_sc_mcu9t5v0__dffq_2
* cell instance $6865 r0 *1 1004.64,1340.64
X$6865 23911 24717 24534 24828 24712 24832 gf180mcu_fd_sc_mcu9t5v0__nand3_1
* cell instance $6866 m0 *1 1023.68,1320.48
X$6866 24091 19862 23957 24118 24090 gf180mcu_fd_sc_mcu9t5v0__nand2_1
* cell instance $6867 r0 *1 988.4,1330.56
X$6867 24417 23691 21536 24528 24414 24532 gf180mcu_fd_sc_mcu9t5v0__mux2_1
* cell instance $6868 r0 *1 1008.56,1340.64
X$6868 23164 24832 24582 24828 24712 gf180mcu_fd_sc_mcu9t5v0__dffq_2
* cell instance $6869 r0 *1 1008,1320.48
X$6869 23911 24090 23965 24232 24118 24124 gf180mcu_fd_sc_mcu9t5v0__nand3_1
* cell instance $6870 r0 *1 969.36,1360.8
X$6870 25268 25430 gf180mcu_fd_sc_mcu9t5v0__filltie
* cell instance $6871 m0 *1 1016.4,1350.72
X$6871 25164 24535 24833 24828 25000 gf180mcu_fd_sc_mcu9t5v0__dffq_2
* cell instance $6872 r0 *1 992.88,1360.8
X$6872 25274 18590 4952 22892 25430 25268 25435 gf180mcu_fd_sc_mcu9t5v0__aoi22_1
* cell instance $6873 r0 *1 969.36,1320.48
X$6873 24118 24232 gf180mcu_fd_sc_mcu9t5v0__filltie
* cell instance $6874 r0 *1 969.36,1330.56
X$6874 24414 24528 gf180mcu_fd_sc_mcu9t5v0__filltie
* cell instance $6875 r0 *1 970.48,1340.64
X$6875 25003 19862 23692 24828 24712 24716 gf180mcu_fd_sc_mcu9t5v0__aoi21_1
* cell instance $6876 r0 *1 972.16,1360.8
X$6876 23685 25321 25322 13331 25430 25268 gf180mcu_fd_sc_mcu9t5v0__dffrnq_2
* cell instance $6877 r0 *1 969.36,1340.64
X$6877 24712 24828 gf180mcu_fd_sc_mcu9t5v0__filltie
* cell instance $6878 r0 *1 969.36,1350.72
X$6878 25000 25158 gf180mcu_fd_sc_mcu9t5v0__filltie
* cell instance $6879 r0 *1 1002.96,1360.8
X$6879 25164 25275 25276 13331 25430 25268 gf180mcu_fd_sc_mcu9t5v0__dffrnq_2
* cell instance $6880 r0 *1 1026.48,1360.8
X$6880 25276 25165 17977 25430 25268 25277 gf180mcu_fd_sc_mcu9t5v0__mux2_1
* cell instance $6881 r0 *1 1027.6,1370.88
X$6881 25844 23213 25705 25581 25584 gf180mcu_fd_sc_mcu9t5v0__nand2_1
* cell instance $6882 r0 *1 1018.64,1370.88
X$6882 18614 23213 21242 25584 25705 25581 25585
+ gf180mcu_fd_sc_mcu9t5v0__oai31_1
* cell instance $6883 m0 *1 977.76,1370.88
X$6883 25322 18272 25430 25581 25549 gf180mcu_fd_sc_mcu9t5v0__nand2_1
* cell instance $6884 r0 *1 969.36,1370.88
X$6884 25581 25705 gf180mcu_fd_sc_mcu9t5v0__filltie
* cell instance $6885 m0 *1 972.16,1370.88
X$6885 25432 25549 25430 25581 25321 gf180mcu_fd_sc_mcu9t5v0__nand2_1
* cell instance $6886 m0 *1 1006.32,1360.8
X$6886 25276 25322 18277 25158 25268 25275 gf180mcu_fd_sc_mcu9t5v0__mux2_1
* cell instance $6887 r0 *1 980,1320.48
X$6887 23685 24123 24089 13331 24232 24118 gf180mcu_fd_sc_mcu9t5v0__dffrnq_2
* cell instance $6888 m0 *1 1019.2,1320.48
X$6888 23911 23635 23799 23957 24118 23693 gf180mcu_fd_sc_mcu9t5v0__nand3_1
* cell instance $6889 r0 *1 986.72,1340.64
X$6889 21122 23691 24828 24712 24718 gf180mcu_fd_sc_mcu9t5v0__nand2_1
* cell instance $6890 m0 *1 1010.8,1310.4
X$6890 23164 23693 23636 23623 23797 gf180mcu_fd_sc_mcu9t5v0__dffq_2
* cell instance $6891 r0 *1 1008,1270.08
X$6891 23164 22588 22589 13331 22700 22577 gf180mcu_fd_sc_mcu9t5v0__dffrnq_2
* cell instance $6892 r0 *1 986.16,1270.08
X$6892 22582 22586 22700 22577 22841 gf180mcu_fd_sc_mcu9t5v0__and2_1
* cell instance $6893 m0 *1 1011.36,1270.08
X$6893 22589 22456 18277 22449 22577 22588 gf180mcu_fd_sc_mcu9t5v0__mux2_1
* cell instance $6894 m0 *1 987.28,1280.16
X$6894 22842 22841 22700 22885 22891 gf180mcu_fd_sc_mcu9t5v0__nand2_1
* cell instance $6895 r0 *1 989.52,1280.16
X$6895 4776 23038 22885 22891 23015 gf180mcu_fd_sc_mcu9t5v0__xor2_1
* cell instance $6896 r0 *1 1002.96,1290.24
X$6896 23164 23203 23165 13331 23319 23200 gf180mcu_fd_sc_mcu9t5v0__dffrnq_2
* cell instance $6897 m0 *1 983.36,1249.92
X$6897 20944 21844 21843 13331 21884 21997 gf180mcu_fd_sc_mcu9t5v0__dffrnq_2
* cell instance $6898 m0 *1 1008.56,1249.92
X$6898 21846 20694 18277 21884 21997 21845 gf180mcu_fd_sc_mcu9t5v0__mux2_1
* cell instance $6899 m0 *1 1028.72,1260
X$6899 14305 22173 22124 22295 22301 gf180mcu_fd_sc_mcu9t5v0__xnor2_1
* cell instance $6900 r0 *1 995.12,1249.92
X$6900 19402 22124 21997 20944 gf180mcu_fd_sc_mcu9t5v0__clkbuf_8
* cell instance $6901 m0 *1 991.2,1310.4
X$6901 23910 23691 21536 23623 23797 23798 gf180mcu_fd_sc_mcu9t5v0__mux2_1
* cell instance $6902 r0 *1 990.64,1270.08
X$6902 22711 22842 22582 22700 22577 22586 22587
+ gf180mcu_fd_sc_mcu9t5v0__nand4_2
* cell instance $6903 r0 *1 980,1260
X$6903 22412 18444 22449 22295 22413 gf180mcu_fd_sc_mcu9t5v0__nor2_1
* cell instance $6904 m0 *1 1000.16,1310.4
X$6904 24089 23692 23623 23797 23799 gf180mcu_fd_sc_mcu9t5v0__nand2_1
* cell instance $6905 m0 *1 1002.4,1260
X$6905 22456 19292 22124 22295 22300 gf180mcu_fd_sc_mcu9t5v0__nand2_1
* cell instance $6906 m0 *1 996.8,1280.16
X$6906 16443 4776 22700 22885 22711 gf180mcu_fd_sc_mcu9t5v0__nand2_1
* cell instance $6907 r0 *1 969.36,1300.32
X$6907 23504 23623 gf180mcu_fd_sc_mcu9t5v0__filltie
* cell instance $6908 m0 *1 999.6,1280.16
X$6908 16443 5773 22700 22885 22842 gf180mcu_fd_sc_mcu9t5v0__nand2_1
* cell instance $6909 r0 *1 978.32,1270.08
X$6909 16443 5771 22700 22577 22586 gf180mcu_fd_sc_mcu9t5v0__nand2_1
* cell instance $6910 r0 *1 986.72,1260
X$6910 19292 22413 20513 22300 22449 22295 22414
+ gf180mcu_fd_sc_mcu9t5v0__oai31_1
* cell instance $6911 r0 *1 1027.6,1280.16
X$6911 22893 23042 18277 23038 22885 23044 gf180mcu_fd_sc_mcu9t5v0__mux2_1
* cell instance $6912 m0 *1 1031.52,1310.4
X$6912 23636 18590 23623 23797 23637 gf180mcu_fd_sc_mcu9t5v0__nand2_1
* cell instance $6913 m0 *1 987.84,1290.24
X$6913 23163 23323 18277 23038 23200 23202 gf180mcu_fd_sc_mcu9t5v0__mux2_1
* cell instance $6914 m0 *1 990.08,1280.16
X$6914 5773 22841 22700 22885 22892 gf180mcu_fd_sc_mcu9t5v0__xnor2_1
* cell instance $6915 r0 *1 1020.32,1300.32
X$6915 23636 19862 23623 23504 23635 gf180mcu_fd_sc_mcu9t5v0__nand2_1
* cell instance $6916 m0 *1 1025.36,1260
X$6916 16789 21886 22124 22295 22173 gf180mcu_fd_sc_mcu9t5v0__nor2_1
* cell instance $6917 r0 *1 969.36,1270.08
X$6917 22577 22700 gf180mcu_fd_sc_mcu9t5v0__filltie
* cell instance $6918 m0 *1 970.48,1249.92
X$6918 22006 18590 21126 4521 21884 21997 22411 gf180mcu_fd_sc_mcu9t5v0__aoi22_1
* cell instance $6919 r0 *1 969.36,1280.16
X$6919 22885 23038 gf180mcu_fd_sc_mcu9t5v0__filltie
* cell instance $6920 r0 *1 969.36,1290.24
X$6920 23200 23319 gf180mcu_fd_sc_mcu9t5v0__filltie
* cell instance $6921 r0 *1 969.36,1260
X$6921 22295 22449 gf180mcu_fd_sc_mcu9t5v0__filltie
* cell instance $6922 m0 *1 969.92,1280.16
X$6922 22582 22700 22885 5771 22709 gf180mcu_fd_sc_mcu9t5v0__xor2_1
* cell instance $6923 r0 *1 971.6,1270.08
X$6923 20996 22709 22585 22700 22577 22710 gf180mcu_fd_sc_mcu9t5v0__oai21_1
* cell instance $6924 r0 *1 970.48,1260
X$6924 22441 22412 19910 22449 22295 22455 gf180mcu_fd_sc_mcu9t5v0__mux2_1
* cell instance $6925 m0 *1 971.04,1310.4
X$6925 23688 23690 19862 23623 23797 23909 gf180mcu_fd_sc_mcu9t5v0__mux2_1
* cell instance $6926 r0 *1 969.36,1249.92
X$6926 21997 22124 gf180mcu_fd_sc_mcu9t5v0__filltie
* cell instance $6927 r0 *1 988.96,1300.32
X$6927 23632 23510 23623 23504 23691 gf180mcu_fd_sc_mcu9t5v0__nand2_1
* cell instance $6928 r0 *1 980.56,1290.24
X$6928 23164 23202 23163 13331 23319 23200 gf180mcu_fd_sc_mcu9t5v0__dffrnq_2
* cell instance $6929 r0 *1 992.32,1260
X$6929 20944 22414 22456 13331 22449 22295 gf180mcu_fd_sc_mcu9t5v0__dffrnq_2
* cell instance $6930 m0 *1 1008.56,1290.24
X$6930 22572 23165 19910 23038 23200 23203 gf180mcu_fd_sc_mcu9t5v0__mux2_1
* cell instance $6931 m0 *1 1022,1270.08
X$6931 15583 20996 22449 22577 22457 gf180mcu_fd_sc_mcu9t5v0__nor2_1
* cell instance $6932 m0 *1 1013.6,1300.32
X$6932 23165 18444 22721 18554 23319 23504 23378
+ gf180mcu_fd_sc_mcu9t5v0__oai211_1
* cell instance $6933 r0 *1 1023.68,1249.92
X$6933 21846 22009 17977 22124 21997 21888 gf180mcu_fd_sc_mcu9t5v0__mux2_1
* cell instance $6934 r0 *1 1063.44,1249.92
X$6934 8092 22013 22124 21997 22895 gf180mcu_fd_sc_mcu9t5v0__xnor2_1
* cell instance $6935 r0 *1 1097.6,1300.32
X$6935 12632 23967 23640 23623 23504 23514 gf180mcu_fd_sc_mcu9t5v0__oai21_1
* cell instance $6936 r0 *1 1056.72,1300.32
X$6936 23689 23639 19862 23623 23504 23638 gf180mcu_fd_sc_mcu9t5v0__mux2_1
* cell instance $6937 r0 *1 1083.6,1260
X$6937 22299 18590 22420 4042 22449 22295 22459 gf180mcu_fd_sc_mcu9t5v0__aoi22_1
* cell instance $6938 r0 *1 1100.96,1249.92
X$6938 22014 22124 21997 22174 gf180mcu_fd_sc_mcu9t5v0__clkinv_1
* cell instance $6939 r0 *1 1079.68,1249.92
X$6939 14663 22133 13492 22124 21997 22132 gf180mcu_fd_sc_mcu9t5v0__mux2_1
* cell instance $6940 m0 *1 1090.32,1280.16
X$6940 18556 22844 13492 22700 22885 22714 gf180mcu_fd_sc_mcu9t5v0__mux2_1
* cell instance $6941 m0 *1 1054.48,1310.4
X$6941 23164 23638 23639 23623 23797 gf180mcu_fd_sc_mcu9t5v0__dffq_2
* cell instance $6942 m0 *1 1089.2,1310.4
X$6942 23797 23623 gf180mcu_fd_sc_mcu9t5v0__filltie
* cell instance $6943 r0 *1 1072.96,1300.32
X$6943 23164 23513 22416 13331 23623 23504 gf180mcu_fd_sc_mcu9t5v0__dffrnq_2
* cell instance $6944 r0 *1 1039.36,1249.92
X$6944 20944 22010 22014 13331 22124 21997 gf180mcu_fd_sc_mcu9t5v0__dffrnq_2
* cell instance $6945 m0 *1 1038.8,1300.32
X$6945 23163 23512 17977 23319 23504 23511 gf180mcu_fd_sc_mcu9t5v0__mux2_1
* cell instance $6946 r0 *1 1071.84,1270.08
X$6946 16443 5166 22700 22577 22713 gf180mcu_fd_sc_mcu9t5v0__nand2_1
* cell instance $6947 m0 *1 1079.12,1280.16
X$6947 22713 22700 22885 22846 gf180mcu_fd_sc_mcu9t5v0__clkinv_1
* cell instance $6948 m0 *1 1089.2,1249.92
X$6948 21997 21884 gf180mcu_fd_sc_mcu9t5v0__filltie
* cell instance $6949 r0 *1 1064.56,1270.08
X$6949 5166 22587 22700 22577 22712 gf180mcu_fd_sc_mcu9t5v0__xnor2_1
* cell instance $6950 r0 *1 1066.8,1260
X$6950 8092 22449 22295 22415 gf180mcu_fd_sc_mcu9t5v0__clkinv_1
* cell instance $6951 m0 *1 1056.16,1260
X$6951 21889 22124 22295 22302 gf180mcu_fd_sc_mcu9t5v0__clkinv_1
* cell instance $6952 m0 *1 1051.68,1280.16
X$6952 23164 22843 22894 13331 22700 22885 gf180mcu_fd_sc_mcu9t5v0__dffrnq_2
* cell instance $6953 r0 *1 1052.8,1290.24
X$6953 22304 19862 23319 23200 23204 gf180mcu_fd_sc_mcu9t5v0__nand2_1
* cell instance $6954 r0 *1 1058.96,1249.92
X$6954 14305 21886 16789 22124 21997 22012 gf180mcu_fd_sc_mcu9t5v0__aoi21_1
* cell instance $6955 m0 *1 1089.2,1270.08
X$6955 22577 22449 gf180mcu_fd_sc_mcu9t5v0__filltie
* cell instance $6956 r0 *1 1043.28,1280.16
X$6956 19862 23510 23204 23038 22885 23045 gf180mcu_fd_sc_mcu9t5v0__oai21_1
* cell instance $6957 m0 *1 1089.2,1260
X$6957 22295 22124 gf180mcu_fd_sc_mcu9t5v0__filltie
* cell instance $6958 m0 *1 1058.4,1260
X$6958 22415 22302 14305 22124 22295 21886 22422
+ gf180mcu_fd_sc_mcu9t5v0__nand4_2
* cell instance $6959 r0 *1 1082.48,1270.08
X$6959 23164 22714 18556 13331 22700 22577 gf180mcu_fd_sc_mcu9t5v0__dffrnq_2
* cell instance $6960 m0 *1 1070.16,1260
X$6960 19174 22132 14663 13331 22124 22295 gf180mcu_fd_sc_mcu9t5v0__dffrnq_2
* cell instance $6961 m0 *1 1069.04,1290.24
X$6961 23164 23046 22896 13331 23038 23200 gf180mcu_fd_sc_mcu9t5v0__dffrnq_2
* cell instance $6962 r0 *1 1059.52,1260
X$6962 22302 22012 22449 22295 22458 gf180mcu_fd_sc_mcu9t5v0__xnor2_1
* cell instance $6963 m0 *1 1089.2,1290.24
X$6963 23200 23038 gf180mcu_fd_sc_mcu9t5v0__filltie
* cell instance $6964 m0 *1 1098.72,1249.92
X$6964 22014 21849 21884 21997 21727 gf180mcu_fd_sc_mcu9t5v0__and2_1
* cell instance $6965 m0 *1 1064,1249.92
X$6965 16443 21889 22012 21884 21997 22013 gf180mcu_fd_sc_mcu9t5v0__aoi21_1
* cell instance $6966 m0 *1 1043.28,1249.92
X$6966 22009 22014 14872 21884 21997 22010 gf180mcu_fd_sc_mcu9t5v0__mux2_1
* cell instance $6967 r0 *1 1054.48,1280.16
X$6967 22893 22894 17977 23038 22885 22843 gf180mcu_fd_sc_mcu9t5v0__mux2_1
* cell instance $6968 m0 *1 1043.28,1290.24
X$6968 23164 23045 22304 23038 23200 gf180mcu_fd_sc_mcu9t5v0__dffq_2
* cell instance $6969 r0 *1 1071.84,1280.16
X$6969 22894 22896 14872 23038 22885 23046 gf180mcu_fd_sc_mcu9t5v0__mux2_1
* cell instance $6970 m0 *1 1089.2,1280.16
X$6970 22885 22700 gf180mcu_fd_sc_mcu9t5v0__filltie
* cell instance $6971 r0 *1 1101.52,1290.24
X$6971 22896 23205 23319 23200 23167 gf180mcu_fd_sc_mcu9t5v0__nor2_1
* cell instance $6972 m0 *1 1078.56,1300.32
X$6972 24092 22416 14872 23319 23504 23513 gf180mcu_fd_sc_mcu9t5v0__mux2_1
* cell instance $6973 r0 *1 1039.36,1300.32
X$6973 19402 23623 23504 23164 gf180mcu_fd_sc_mcu9t5v0__clkbuf_8
* cell instance $6974 m0 *1 1089.2,1300.32
X$6974 23504 23319 gf180mcu_fd_sc_mcu9t5v0__filltie
* cell instance $6975 m0 *1 892.64,1290.24
X$6975 22839 23039 23011 13331 23038 23200 gf180mcu_fd_sc_mcu9t5v0__dffrnq_2
* cell instance $6976 m0 *1 896,1330.56
X$6976 23685 24239 24120 24232 24414 gf180mcu_fd_sc_mcu9t5v0__dffq_2
* cell instance $6977 r0 *1 930.72,1310.4
X$6977 23687 23324 23957 23797 24086 gf180mcu_fd_sc_mcu9t5v0__nand2_1
* cell instance $6978 r0 *1 933.52,1310.4
X$6978 23687 23908 23957 23797 23688 gf180mcu_fd_sc_mcu9t5v0__nand2_1
* cell instance $6979 r0 *1 887.6,1310.4
X$6979 19566 13868 23957 23797 23684 gf180mcu_fd_sc_mcu9t5v0__nand2_1
* cell instance $6980 r0 *1 907.76,1310.4
X$6980 23686 19862 23957 23797 23628 gf180mcu_fd_sc_mcu9t5v0__nand2_1
* cell instance $6981 r0 *1 883.12,1310.4
X$6981 13868 23505 19566 23957 23797 23907 gf180mcu_fd_sc_mcu9t5v0__aoi21_1
* cell instance $6982 r0 *1 893.2,1340.64
X$6982 16661 16658 27082 24715 24828 24712 24710
+ gf180mcu_fd_sc_mcu9t5v0__aoi211_1
* cell instance $6983 r0 *1 878.64,1310.4
X$6983 13868 23505 23907 23957 23797 23964 gf180mcu_fd_sc_mcu9t5v0__oai21_1
* cell instance $6984 r0 *1 855.12,1310.4
X$6984 23963 18585 23957 23797 23962 gf180mcu_fd_sc_mcu9t5v0__nand2_1
* cell instance $6985 r0 *1 887.04,1350.72
X$6985 26459 25158 25000 14189 gf180mcu_fd_sc_mcu9t5v0__buf_8
* cell instance $6986 m0 *1 893.76,1249.92
X$6986 8087 21842 21884 21997 22005 gf180mcu_fd_sc_mcu9t5v0__xnor2_1
* cell instance $6987 m0 *1 897.12,1270.08
X$6987 20996 22453 22449 22577 22583 gf180mcu_fd_sc_mcu9t5v0__nor2_1
* cell instance $6988 r0 *1 896,1270.08
X$6988 22580 18590 22452 22583 22700 22577 22706
+ gf180mcu_fd_sc_mcu9t5v0__aoi22_1
* cell instance $6989 r0 *1 894.88,1370.88
X$6989 25160 25709 25547 12383 25705 25581 gf180mcu_fd_sc_mcu9t5v0__dffrnq_2
* cell instance $6990 r0 *1 833.28,1310.4
X$6990 23505 23906 23957 23797 23959 gf180mcu_fd_sc_mcu9t5v0__nand2_1
* cell instance $6991 r0 *1 836.08,1310.4
X$6991 23959 23372 23957 23797 23960 gf180mcu_fd_sc_mcu9t5v0__nand2_1
* cell instance $6992 r0 *1 892.08,1360.8
X$6992 25160 25319 25274 25430 25268 gf180mcu_fd_sc_mcu9t5v0__dffq_2
* cell instance $6993 m0 *1 946.4,1350.72
X$6993 18145 25001 24828 25000 25002 gf180mcu_fd_sc_mcu9t5v0__or2_1
* cell instance $6994 m0 *1 922.88,1360.8
X$6994 14189 18594 25158 25268 25163 gf180mcu_fd_sc_mcu9t5v0__nor2_1
* cell instance $6995 m0 *1 949.2,1320.48
X$6995 24088 24086 21122 23957 24118 24122 gf180mcu_fd_sc_mcu9t5v0__mux2_1
* cell instance $6996 m0 *1 946.4,1340.64
X$6996 19402 24528 24712 23685 gf180mcu_fd_sc_mcu9t5v0__clkbuf_8
* cell instance $6997 m0 *1 954.24,1350.72
X$6997 18270 18849 24961 24828 25000 25001 gf180mcu_fd_sc_mcu9t5v0__mux2_2
* cell instance $6998 r0 *1 929.6,1350.72
X$6998 25001 24830 18846 22694 25158 25000 26299
+ gf180mcu_fd_sc_mcu9t5v0__oai31_4
* cell instance $6999 m0 *1 950.88,1350.72
X$6999 25002 24828 25000 19572 gf180mcu_fd_sc_mcu9t5v0__clkinv_1
* cell instance $7000 m0 *1 913.92,1340.64
X$7000 23685 24531 24415 24528 24712 gf180mcu_fd_sc_mcu9t5v0__dffq_2
* cell instance $7001 r0 *1 920.64,1320.48
X$7001 23685 24121 24087 13331 24232 24118 gf180mcu_fd_sc_mcu9t5v0__dffrnq_2
* cell instance $7002 r0 *1 910.56,1350.72
X$7002 22694 25132 25158 25000 24960 gf180mcu_fd_sc_mcu9t5v0__nand2_1
* cell instance $7003 r0 *1 919.52,1360.8
X$7003 25163 25430 25268 16661 gf180mcu_fd_sc_mcu9t5v0__buf_8
* cell instance $7004 r0 *1 910,1340.64
X$7004 24715 19571 24828 24712 24829 gf180mcu_fd_sc_mcu9t5v0__and2_1
* cell instance $7005 r0 *1 905.52,1330.56
X$7005 24120 19862 24528 24414 24240 gf180mcu_fd_sc_mcu9t5v0__nand2_1
* cell instance $7006 m0 *1 911.68,1350.72
X$7006 14019 24960 24828 25000 19571 gf180mcu_fd_sc_mcu9t5v0__nand2_1
* cell instance $7007 r0 *1 898.8,1340.64
X$7007 13904 19572 24828 24712 24715 gf180mcu_fd_sc_mcu9t5v0__nand2_1
* cell instance $7008 r0 *1 899.92,1320.48
X$7008 19862 24237 24240 24232 24118 24239 gf180mcu_fd_sc_mcu9t5v0__oai21_1
* cell instance $7009 m0 *1 899.92,1360.8
X$7009 24575 25274 19862 25158 25268 25319 gf180mcu_fd_sc_mcu9t5v0__mux2_1
* cell instance $7010 m0 *1 935.76,1320.48
X$7010 19566 24087 23957 24118 23908 gf180mcu_fd_sc_mcu9t5v0__nand2_1
* cell instance $7011 r0 *1 916.72,1340.64
X$7011 23685 24829 24580 13331 24828 24712 gf180mcu_fd_sc_mcu9t5v0__dffrnq_2
* cell instance $7012 r0 *1 904.4,1320.48
X$7012 24120 18590 4952 22005 24232 24118 25131 gf180mcu_fd_sc_mcu9t5v0__aoi22_1
* cell instance $7013 r0 *1 946.4,1320.48
X$7013 23685 24122 24088 13331 24232 24118 gf180mcu_fd_sc_mcu9t5v0__dffrnq_2
* cell instance $7014 m0 *1 928.48,1320.48
X$7014 24087 24086 21536 23957 24118 24121 gf180mcu_fd_sc_mcu9t5v0__mux2_1
* cell instance $7015 r0 *1 936.88,1340.64
X$7015 24580 24828 24712 24830 gf180mcu_fd_sc_mcu9t5v0__inv_1
* cell instance $7016 r0 *1 917.28,1330.56
X$7016 24578 24415 19862 24528 24414 24531 gf180mcu_fd_sc_mcu9t5v0__mux2_1
* cell instance $7017 m0 *1 914.48,1370.88
X$7017 25547 18444 25548 18555 25430 25581 25432
+ gf180mcu_fd_sc_mcu9t5v0__oai211_1
* cell instance $7018 m0 *1 902.16,1370.88
X$7018 25547 22441 19287 25430 25581 25709 gf180mcu_fd_sc_mcu9t5v0__mux2_1
* cell instance $7019 r0 *1 931.84,1370.88
X$7019 25710 25705 25581 12393 gf180mcu_fd_sc_mcu9t5v0__buf_8
* cell instance $7020 r0 *1 962.64,1340.64
X$7020 24716 24828 24712 24831 gf180mcu_fd_sc_mcu9t5v0__clkinv_1
* cell instance $7021 r0 *1 946.4,1330.56
X$7021 23685 24528 24414 gf180mcu_fd_sc_mcu9t5v0__inv_3
* cell instance $7022 r0 *1 940.24,1340.64
X$7022 24830 24828 24712 14019 gf180mcu_fd_sc_mcu9t5v0__buf_8
* cell instance $7023 m0 *1 931.84,1340.64
X$7023 24580 24528 24712 13904 gf180mcu_fd_sc_mcu9t5v0__buf_8
* cell instance $7024 r0 *1 955.36,1360.8
X$7024 25434 23213 25430 25268 25320 gf180mcu_fd_sc_mcu9t5v0__nand2_1
* cell instance $7025 r0 *1 948.64,1360.8
X$7025 18614 23213 20823 25320 25430 25268 25433
+ gf180mcu_fd_sc_mcu9t5v0__oai31_1
* cell instance $7026 m0 *1 851.76,1340.64
X$7026 24576 23501 24528 24712 24577 gf180mcu_fd_sc_mcu9t5v0__nor2_1
* cell instance $7027 m0 *1 858.48,1350.72
X$7027 24959 24828 25000 14825 gf180mcu_fd_sc_mcu9t5v0__buf_8
* cell instance $7028 m0 *1 875.84,1340.64
X$7028 24578 24083 21122 24528 24712 24714 gf180mcu_fd_sc_mcu9t5v0__mux2_1
* cell instance $7029 m0 *1 855.12,1340.64
X$7029 24577 24528 24712 16153 gf180mcu_fd_sc_mcu9t5v0__buf_8
* cell instance $7030 m0 *1 849.52,1360.8
X$7030 25268 25158 gf180mcu_fd_sc_mcu9t5v0__filltie
* cell instance $7031 m0 *1 850.64,1320.48
X$7031 22839 24082 23963 23957 24118 gf180mcu_fd_sc_mcu9t5v0__dffq_2
* cell instance $7032 m0 *1 849.52,1320.48
X$7032 24118 23957 gf180mcu_fd_sc_mcu9t5v0__filltie
* cell instance $7033 m0 *1 868.56,1360.8
X$7033 25162 25158 25268 14865 gf180mcu_fd_sc_mcu9t5v0__buf_8
* cell instance $7034 m0 *1 849.52,1370.88
X$7034 25581 25430 gf180mcu_fd_sc_mcu9t5v0__filltie
* cell instance $7035 m0 *1 870.24,1320.48
X$7035 24084 24083 21536 23957 24118 24236 gf180mcu_fd_sc_mcu9t5v0__mux2_1
* cell instance $7036 m0 *1 854,1350.72
X$7036 24958 23501 24828 25000 24959 gf180mcu_fd_sc_mcu9t5v0__nor2_1
* cell instance $7037 r0 *1 859.04,1320.48
X$7037 22839 24236 24084 12383 24232 24118 gf180mcu_fd_sc_mcu9t5v0__dffrnq_2
* cell instance $7038 m0 *1 849.52,1340.64
X$7038 24712 24528 gf180mcu_fd_sc_mcu9t5v0__filltie
* cell instance $7039 m0 *1 845.6,1370.88
X$7039 25546 25545 25430 25581 23501 gf180mcu_fd_sc_mcu9t5v0__nand2_1
* cell instance $7040 m0 *1 845.04,1320.48
X$7040 18585 23961 23962 23957 24118 24082 gf180mcu_fd_sc_mcu9t5v0__oai21_1
* cell instance $7041 r0 *1 874.72,1360.8
X$7041 25318 25430 25268 16921 gf180mcu_fd_sc_mcu9t5v0__buf_8
* cell instance $7042 r0 *1 888.16,1320.48
X$7042 23963 18590 4952 21128 24232 24118 24238 gf180mcu_fd_sc_mcu9t5v0__aoi22_1
* cell instance $7043 m0 *1 886.48,1340.64
X$7043 13904 19572 20685 24528 24712 24579 gf180mcu_fd_sc_mcu9t5v0__aoi21_1
* cell instance $7044 r0 *1 843.36,1370.88
X$7044 25707 25705 25581 25545 gf180mcu_fd_sc_mcu9t5v0__clkinv_1
* cell instance $7045 m0 *1 849.52,1330.56
X$7045 24414 24232 gf180mcu_fd_sc_mcu9t5v0__filltie
* cell instance $7046 m0 *1 879.2,1320.48
X$7046 19566 24084 23957 24118 24085 gf180mcu_fd_sc_mcu9t5v0__nand2_1
* cell instance $7047 r0 *1 883.12,1320.48
X$7047 23964 24085 24232 24118 24237 gf180mcu_fd_sc_mcu9t5v0__and2_1
* cell instance $7048 r0 *1 845.6,1370.88
X$7048 25546 25707 25705 25581 25582 gf180mcu_fd_sc_mcu9t5v0__nand2_1
* cell instance $7049 r0 *1 844.48,1350.72
X$7049 25273 25158 25000 24576 gf180mcu_fd_sc_mcu9t5v0__buf_8
* cell instance $7050 r0 *1 855.12,1370.88
X$7050 24958 25582 23621 25583 25705 25581 26036
+ gf180mcu_fd_sc_mcu9t5v0__oai211_1
* cell instance $7051 r0 *1 832.16,1340.64
X$7051 22838 24713 24575 12383 24828 24712 gf180mcu_fd_sc_mcu9t5v0__dffrnq_2
* cell instance $7052 r0 *1 852.32,1360.8
X$7052 24576 25430 25268 24958 gf180mcu_fd_sc_mcu9t5v0__clkinv_1
* cell instance $7053 m0 *1 856.8,1360.8
X$7053 24576 25582 25158 25268 25162 gf180mcu_fd_sc_mcu9t5v0__nor2_1
* cell instance $7054 m0 *1 850.64,1370.88
X$7054 25545 24958 25546 25430 25581 25318 gf180mcu_fd_sc_mcu9t5v0__oai21_1
* cell instance $7055 r0 *1 833.28,1320.48
X$7055 24119 23960 21536 24232 24118 24283 gf180mcu_fd_sc_mcu9t5v0__mux2_1
* cell instance $7056 m0 *1 836.64,1340.64
X$7056 24575 23960 21122 24528 24712 24713 gf180mcu_fd_sc_mcu9t5v0__mux2_1
* cell instance $7057 r0 *1 848.4,1370.88
X$7057 25546 25707 25273 25705 25581 25708 gf180mcu_fd_sc_mcu9t5v0__and3_1
* cell instance $7058 m0 *1 882,1320.48
X$7058 23964 23684 23957 24118 24083 gf180mcu_fd_sc_mcu9t5v0__nand2_1
* cell instance $7059 r0 *1 869.68,1340.64
X$7059 25160 24714 24578 12383 24828 24712 gf180mcu_fd_sc_mcu9t5v0__dffrnq_2
* cell instance $7060 m0 *1 836.08,1320.48
X$7060 19566 24119 23505 23906 23957 24118 23961
+ gf180mcu_fd_sc_mcu9t5v0__aoi22_1
* cell instance $7061 m0 *1 849.52,1350.72
X$7061 25000 24828 gf180mcu_fd_sc_mcu9t5v0__filltie
* cell instance $7062 r0 *1 870.24,1290.24
X$7062 18272 23161 21415 23321 23319 23200 23322
+ gf180mcu_fd_sc_mcu9t5v0__oai31_1
* cell instance $7063 m0 *1 880.32,1270.08
X$7063 22451 6151 22449 22577 22890 gf180mcu_fd_sc_mcu9t5v0__xnor2_1
* cell instance $7064 m0 *1 855.12,1270.08
X$7064 22000 22580 18585 22449 22577 22579 gf180mcu_fd_sc_mcu9t5v0__mux2_1
* cell instance $7065 r0 *1 850.64,1290.24
X$7065 22839 23201 23160 12383 23319 23200 gf180mcu_fd_sc_mcu9t5v0__dffrnq_2
* cell instance $7066 r0 *1 886.48,1260
X$7066 22451 22409 22449 22295 22410 gf180mcu_fd_sc_mcu9t5v0__nand2_1
* cell instance $7067 m0 *1 874.16,1260
X$7067 22296 18590 21126 5923 22124 22295 22129 gf180mcu_fd_sc_mcu9t5v0__aoi22_1
* cell instance $7068 m0 *1 850.64,1300.32
X$7068 23506 18585 23319 23504 23374 gf180mcu_fd_sc_mcu9t5v0__nand2_1
* cell instance $7069 r0 *1 883.12,1280.16
X$7069 22702 18590 4952 22890 23038 22885 23010 gf180mcu_fd_sc_mcu9t5v0__aoi22_1
* cell instance $7070 m0 *1 849.52,1260
X$7070 22295 22124 gf180mcu_fd_sc_mcu9t5v0__filltie
* cell instance $7071 m0 *1 856.8,1280.16
X$7071 22705 18590 22700 22885 22840 gf180mcu_fd_sc_mcu9t5v0__nand2_1
* cell instance $7072 m0 *1 887.04,1270.08
X$7072 4907 6151 4909 16443 22449 22577 22582 gf180mcu_fd_sc_mcu9t5v0__oai31_2
* cell instance $7073 m0 *1 850.64,1260
X$7073 21586 22124 22295 21720 gf180mcu_fd_sc_mcu9t5v0__clkinv_1
* cell instance $7074 r0 *1 871.92,1270.08
X$7074 18444 16511 22840 22700 22577 22581 gf180mcu_fd_sc_mcu9t5v0__nand3_1
* cell instance $7075 r0 *1 889.84,1260
X$7075 22410 4909 22449 22295 22452 gf180mcu_fd_sc_mcu9t5v0__nand2_1
* cell instance $7076 r0 *1 876.4,1249.92
X$7076 22293 18590 4952 16788 22124 21997 22130 gf180mcu_fd_sc_mcu9t5v0__aoi22_1
* cell instance $7077 r0 *1 868,1260
X$7077 22170 18590 21126 12749 22449 22295 22450
+ gf180mcu_fd_sc_mcu9t5v0__aoi22_1
* cell instance $7078 r0 *1 892.64,1260
X$7078 22410 4909 22449 22295 22453 gf180mcu_fd_sc_mcu9t5v0__nor2_1
* cell instance $7079 m0 *1 849.52,1280.16
X$7079 22885 22700 gf180mcu_fd_sc_mcu9t5v0__filltie
* cell instance $7080 m0 *1 849.52,1249.92
X$7080 21997 21884 gf180mcu_fd_sc_mcu9t5v0__filltie
* cell instance $7081 r0 *1 850.64,1270.08
X$7081 22839 22579 22580 22700 22577 gf180mcu_fd_sc_mcu9t5v0__dffq_2
* cell instance $7082 m0 *1 849.52,1290.24
X$7082 23200 23038 gf180mcu_fd_sc_mcu9t5v0__filltie
* cell instance $7083 m0 *1 889.28,1249.92
X$7083 8087 20824 21884 21997 21886 gf180mcu_fd_sc_mcu9t5v0__and2_1
* cell instance $7084 r0 *1 836.08,1290.24
X$7084 19402 23319 23200 22839 gf180mcu_fd_sc_mcu9t5v0__clkbuf_8
* cell instance $7085 m0 *1 857.92,1290.24
X$7085 23160 22572 19287 23038 23200 23201 gf180mcu_fd_sc_mcu9t5v0__mux2_1
* cell instance $7086 m0 *1 837.76,1290.24
X$7086 22839 23038 23200 gf180mcu_fd_sc_mcu9t5v0__clkbuf_4
* cell instance $7087 m0 *1 849.52,1310.4
X$7087 23797 23623 gf180mcu_fd_sc_mcu9t5v0__filltie
* cell instance $7088 m0 *1 850.64,1249.92
X$7088 21409 21885 21722 12383 21884 21997 gf180mcu_fd_sc_mcu9t5v0__dffrnq_2
* cell instance $7089 r0 *1 891.52,1300.32
X$7089 13868 23505 13692 23623 23504 23626 gf180mcu_fd_sc_mcu9t5v0__oai21_1
* cell instance $7090 r0 *1 876.96,1290.24
X$7090 23323 18272 23319 23200 23321 gf180mcu_fd_sc_mcu9t5v0__nand2_1
* cell instance $7091 r0 *1 861.84,1249.92
X$7091 22001 22124 21997 22003 gf180mcu_fd_sc_mcu9t5v0__clkinv_1
* cell instance $7092 r0 *1 876.96,1300.32
X$7092 23506 18590 21126 6949 23623 23504 23625 gf180mcu_fd_sc_mcu9t5v0__aoi22_1
* cell instance $7093 r0 *1 887.04,1300.32
X$7093 13868 13692 23505 23623 23504 23507 gf180mcu_fd_sc_mcu9t5v0__nor3_1
* cell instance $7094 m0 *1 831.6,1280.16
X$7094 22839 22887 22888 22700 22885 gf180mcu_fd_sc_mcu9t5v0__dffq_2
* cell instance $7095 r0 *1 839.44,1300.32
X$7095 22839 23373 23506 23623 23504 gf180mcu_fd_sc_mcu9t5v0__dffq_2
* cell instance $7096 r0 *1 838.88,1280.16
X$7096 23009 22888 18585 23038 22885 22887 gf180mcu_fd_sc_mcu9t5v0__mux2_1
* cell instance $7097 m0 *1 843.36,1249.92
X$7097 22296 18585 21245 21998 21884 21997 21999
+ gf180mcu_fd_sc_mcu9t5v0__aoi22_1
* cell instance $7098 m0 *1 831.04,1270.08
X$7098 22839 22578 22296 22449 22577 gf180mcu_fd_sc_mcu9t5v0__dffq_2
* cell instance $7099 m0 *1 849.52,1300.32
X$7099 23504 23319 gf180mcu_fd_sc_mcu9t5v0__filltie
* cell instance $7100 m0 *1 869.68,1300.32
X$7100 22839 23322 23323 12383 23319 23504 gf180mcu_fd_sc_mcu9t5v0__dffrnq_2
* cell instance $7101 r0 *1 840,1249.92
X$7101 21409 22003 22002 22124 21997 gf180mcu_fd_sc_mcu9t5v0__dffq_2
* cell instance $7102 m0 *1 841.12,1300.32
X$7102 18585 23372 23374 23319 23504 23373 gf180mcu_fd_sc_mcu9t5v0__oai21_1
* cell instance $7103 m0 *1 878.08,1280.16
X$7103 22888 18590 4952 4907 18614 22700 22885 22889
+ gf180mcu_fd_sc_mcu9t5v0__aoi221_1
* cell instance $7104 m0 *1 877.52,1270.08
X$7104 16443 4907 22449 22577 22451 gf180mcu_fd_sc_mcu9t5v0__nand2_1
* cell instance $7105 r0 *1 881.44,1249.92
X$7105 22002 18590 21126 11567 22124 21997 22131
+ gf180mcu_fd_sc_mcu9t5v0__aoi22_1
* cell instance $7106 m0 *1 869.68,1290.24
X$7106 23160 18444 23038 23200 23161 gf180mcu_fd_sc_mcu9t5v0__nor2_1
* cell instance $7107 r0 *1 883.68,1260
X$7107 16443 6151 22449 22295 22409 gf180mcu_fd_sc_mcu9t5v0__nand2_1
* cell instance $7108 m0 *1 849.52,1270.08
X$7108 22577 22449 gf180mcu_fd_sc_mcu9t5v0__filltie
* cell instance $7109 m0 *1 838.32,1249.92
X$7109 22002 18585 21245 14850 21884 21997 22001
+ gf180mcu_fd_sc_mcu9t5v0__aoi22_1
* cell instance $7110 r0 *1 829.92,1300.32
X$7110 11323 20818 19566 23623 23504 23906 gf180mcu_fd_sc_mcu9t5v0__aoi21_1
* cell instance $7111 r0 *1 836.08,1300.32
X$7111 19566 11323 23623 23504 23372 gf180mcu_fd_sc_mcu9t5v0__nand2_1
* cell instance $7112 r0 *1 937.44,1249.92
X$7112 19407 22007 21887 13331 22124 21997 gf180mcu_fd_sc_mcu9t5v0__dffrnq_2
* cell instance $7113 m0 *1 907.2,1260
X$7113 22171 22004 21122 22124 22295 22297 gf180mcu_fd_sc_mcu9t5v0__mux2_1
* cell instance $7114 m0 *1 953.68,1260
X$7114 22299 19862 21245 22298 22124 22295 21591
+ gf180mcu_fd_sc_mcu9t5v0__aoi22_1
* cell instance $7115 m0 *1 921.76,1290.24
X$7115 23685 23041 23042 13331 23038 23200 gf180mcu_fd_sc_mcu9t5v0__dffrnq_2
* cell instance $7116 m0 *1 913.36,1249.92
X$7116 22006 18585 21245 21588 21884 21997 21589
+ gf180mcu_fd_sc_mcu9t5v0__aoi22_1
* cell instance $7117 m0 *1 946.4,1310.4
X$7117 23632 23375 23510 23623 23797 23376 gf180mcu_fd_sc_mcu9t5v0__nand3_1
* cell instance $7118 m0 *1 911.68,1290.24
X$7118 23011 18444 23038 23200 23040 gf180mcu_fd_sc_mcu9t5v0__nor2_1
* cell instance $7119 m0 *1 942.48,1249.92
X$7119 15401 21887 20215 21884 21997 22007 gf180mcu_fd_sc_mcu9t5v0__mux2_1
* cell instance $7120 r0 *1 902.72,1300.32
X$7120 19862 23684 23628 23623 23504 23627 gf180mcu_fd_sc_mcu9t5v0__oai21_1
* cell instance $7121 m0 *1 921.2,1260
X$7121 19407 22172 22298 13331 22124 22295 gf180mcu_fd_sc_mcu9t5v0__dffrnq_2
* cell instance $7122 r0 *1 913.92,1249.92
X$7122 19407 21590 22006 22124 21997 gf180mcu_fd_sc_mcu9t5v0__dffq_2
* cell instance $7123 r0 *1 935.76,1270.08
X$7123 20944 22584 22454 22700 22577 gf180mcu_fd_sc_mcu9t5v0__dffq_2
* cell instance $7124 r0 *1 930.72,1280.16
X$7124 23042 18272 23038 22885 23012 gf180mcu_fd_sc_mcu9t5v0__nand2_1
* cell instance $7125 m0 *1 946.4,1300.32
X$7125 23508 23376 21536 23319 23504 23633 gf180mcu_fd_sc_mcu9t5v0__mux2_1
* cell instance $7126 m0 *1 927.36,1300.32
X$7126 19566 13692 23319 23504 23324 gf180mcu_fd_sc_mcu9t5v0__nand2_1
* cell instance $7127 r0 *1 931.84,1300.32
X$7127 12888 23623 23504 23631 gf180mcu_fd_sc_mcu9t5v0__clkinv_1
* cell instance $7128 r0 *1 955.92,1280.16
X$7128 23014 19862 23038 22885 23013 gf180mcu_fd_sc_mcu9t5v0__nand2_1
* cell instance $7129 r0 *1 948.08,1280.16
X$7129 19862 23324 23013 23038 22885 23043 gf180mcu_fd_sc_mcu9t5v0__oai21_1
* cell instance $7130 m0 *1 946.96,1290.24
X$7130 20944 23043 23014 23038 23200 gf180mcu_fd_sc_mcu9t5v0__dffq_2
* cell instance $7131 r0 *1 913.36,1270.08
X$7131 19396 22708 19862 22700 22577 22707 gf180mcu_fd_sc_mcu9t5v0__mux2_1
* cell instance $7132 r0 *1 927.92,1260
X$7132 13159 22298 20215 22449 22295 22172 gf180mcu_fd_sc_mcu9t5v0__mux2_1
* cell instance $7133 r0 *1 952.56,1270.08
X$7133 22454 18590 22700 22577 22585 gf180mcu_fd_sc_mcu9t5v0__nand2_1
* cell instance $7134 r0 *1 915.6,1280.16
X$7134 18272 23040 20514 23012 23038 22885 23041
+ gf180mcu_fd_sc_mcu9t5v0__oai31_1
* cell instance $7135 m0 *1 935.76,1270.08
X$7135 22171 22454 18585 22449 22577 22584 gf180mcu_fd_sc_mcu9t5v0__mux2_1
* cell instance $7136 r0 *1 921.2,1300.32
X$7136 19566 23507 23623 23504 23630 gf180mcu_fd_sc_mcu9t5v0__nor2_1
* cell instance $7137 r0 *1 936.88,1300.32
X$7137 23685 23633 23508 13331 23623 23504 gf180mcu_fd_sc_mcu9t5v0__dffrnq_2
* cell instance $7138 r0 *1 955.92,1300.32
X$7138 19566 23508 23623 23504 23634 gf180mcu_fd_sc_mcu9t5v0__nand2_1
* cell instance $7139 m0 *1 934.08,1300.32
X$7139 12888 19566 23319 23504 23510 gf180mcu_fd_sc_mcu9t5v0__nand2_1
* cell instance $7140 r0 *1 898.24,1280.16
X$7140 23011 21726 19287 23038 22885 23039 gf180mcu_fd_sc_mcu9t5v0__mux2_1
* cell instance $7141 r0 *1 909.44,1300.32
X$7141 23686 18590 21126 7678 23623 23504 23629 gf180mcu_fd_sc_mcu9t5v0__aoi22_1
* cell instance $7142 m0 *1 916.16,1300.32
X$7142 12888 21121 23507 23319 23504 23375 gf180mcu_fd_sc_mcu9t5v0__nand3_1
* cell instance $7143 m0 *1 925.12,1310.4
X$7143 23630 23626 23623 23797 23687 gf180mcu_fd_sc_mcu9t5v0__nand2_1
* cell instance $7144 r0 *1 903.28,1260
X$7144 22839 22297 22171 13331 22449 22295 gf180mcu_fd_sc_mcu9t5v0__dffrnq_2
* cell instance $7145 m0 *1 950.32,1310.4
X$7145 23632 23634 23375 23623 23797 23689 gf180mcu_fd_sc_mcu9t5v0__nand3_1
* cell instance $7146 m0 *1 909.44,1280.16
X$7146 22839 22707 22708 22700 22885 gf180mcu_fd_sc_mcu9t5v0__dffq_2
* cell instance $7147 m0 *1 898.8,1310.4
X$7147 23685 23627 23686 23623 23797 gf180mcu_fd_sc_mcu9t5v0__dffq_2
* cell instance $7148 r0 *1 929.04,1300.32
X$7148 23631 23630 23623 23504 23632 gf180mcu_fd_sc_mcu9t5v0__nand2_1
* cell instance $7149 m0 *1 944.16,1270.08
X$7149 22008 22449 22577 21724 gf180mcu_fd_sc_mcu9t5v0__clkinv_1
* cell instance $7150 m0 *1 841.12,1179.36
X$7150 19903 19905 18585 19729 19901 19904 gf180mcu_fd_sc_mcu9t5v0__mux2_1
* cell instance $7151 m0 *1 894.88,1239.84
X$7151 19283 21539 21588 13331 21537 21719 gf180mcu_fd_sc_mcu9t5v0__dffrnq_2
* cell instance $7152 r0 *1 850.64,1169.28
X$7152 19727 19732 19447 17831 19729 19605 15693
+ gf180mcu_fd_sc_mcu9t5v0__aoi211_4
* cell instance $7153 r0 *1 898.24,1169.28
X$7153 19734 18272 19729 19605 19733 gf180mcu_fd_sc_mcu9t5v0__nand2_1
* cell instance $7154 m0 *1 887.04,1169.28
X$7154 19283 19404 19451 13331 19448 19605 gf180mcu_fd_sc_mcu9t5v0__dffrnq_2
* cell instance $7155 r0 *1 913.92,1169.28
X$7155 19129 18445 19736 19729 19605 19735 gf180mcu_fd_sc_mcu9t5v0__oai21_1
* cell instance $7156 m0 *1 896,1149.12
X$7156 19283 18733 19129 13331 18841 18996 gf180mcu_fd_sc_mcu9t5v0__dffrnq_2
* cell instance $7157 m0 *1 943.04,1179.36
X$7157 13159 19861 18840 19729 19901 19907 gf180mcu_fd_sc_mcu9t5v0__mux2_1
* cell instance $7158 r0 *1 882.56,1189.44
X$7158 19283 20340 20082 13331 20379 20217 gf180mcu_fd_sc_mcu9t5v0__dffrnq_2
* cell instance $7159 m0 *1 889.84,1179.36
X$7159 19283 19860 19734 13331 19729 19901 gf180mcu_fd_sc_mcu9t5v0__dffrnq_2
* cell instance $7160 m0 *1 881.44,1179.36
X$7160 18272 19906 19731 19733 19729 19901 19860
+ gf180mcu_fd_sc_mcu9t5v0__oai31_1
* cell instance $7161 m0 *1 849.52,1179.36
X$7161 19901 19729 gf180mcu_fd_sc_mcu9t5v0__filltie
* cell instance $7162 m0 *1 896,1219.68
X$7162 20996 20938 20936 21123 20994 gf180mcu_fd_sc_mcu9t5v0__nor2_1
* cell instance $7163 r0 *1 894.88,1108.8
X$7163 17711 17842 17713 17574 17985 17837 17955
+ gf180mcu_fd_sc_mcu9t5v0__aoi22_1
* cell instance $7164 r0 *1 894.88,1118.88
X$7164 17711 17954 18268 18104 18141 gf180mcu_fd_sc_mcu9t5v0__or2_1
* cell instance $7165 r0 *1 843.36,1169.28
X$7165 19607 18590 4952 6946 18614 19729 19605 19731
+ gf180mcu_fd_sc_mcu9t5v0__aoi221_1
* cell instance $7166 r0 *1 912.8,1219.68
X$7166 21121 20940 21241 21123 21244 gf180mcu_fd_sc_mcu9t5v0__nor2_1
* cell instance $7167 r0 *1 929.04,1189.44
X$7167 14166 20220 18840 20379 20217 20083 gf180mcu_fd_sc_mcu9t5v0__mux2_1
* cell instance $7168 r0 *1 940.24,1179.36
X$7168 19407 19907 19861 13331 20028 19901 gf180mcu_fd_sc_mcu9t5v0__dffrnq_2
* cell instance $7169 m0 *1 924.56,1189.44
X$7169 19407 20083 20220 13331 20028 20217 gf180mcu_fd_sc_mcu9t5v0__dffrnq_2
* cell instance $7170 r0 *1 936.32,1229.76
X$7170 19407 21419 21365 13331 21537 21412 gf180mcu_fd_sc_mcu9t5v0__dffrnq_2
* cell instance $7171 m0 *1 944.72,1209.6
X$7171 19407 20637 20822 gf180mcu_fd_sc_mcu9t5v0__clkbuf_4
* cell instance $7172 r0 *1 939.12,1199.52
X$7172 19407 20644 20943 13331 20637 20507 gf180mcu_fd_sc_mcu9t5v0__dffrnq_2
* cell instance $7173 r0 *1 941.92,1219.68
X$7173 21130 19862 21245 20942 21241 21123 21129
+ gf180mcu_fd_sc_mcu9t5v0__aoi22_1
* cell instance $7174 r0 *1 963.76,1199.52
X$7174 20694 18272 20637 20507 20515 gf180mcu_fd_sc_mcu9t5v0__nand2_1
* cell instance $7175 m0 *1 926.24,1219.68
X$7175 19407 20941 20942 13331 20936 21123 gf180mcu_fd_sc_mcu9t5v0__dffrnq_2
* cell instance $7176 m0 *1 950.32,1189.44
X$7176 14856 20085 18840 20028 20217 20084 gf180mcu_fd_sc_mcu9t5v0__mux2_1
* cell instance $7177 m0 *1 915.6,1229.76
X$7177 21244 21241 21412 21245 gf180mcu_fd_sc_mcu9t5v0__buf_8
* cell instance $7178 r0 *1 930.72,1209.6
X$7178 14166 20942 20215 20936 20822 20941 gf180mcu_fd_sc_mcu9t5v0__mux2_1
* cell instance $7179 m0 *1 911.68,1199.52
X$7179 19283 20382 20342 13331 20379 20507 gf180mcu_fd_sc_mcu9t5v0__dffrnq_2
* cell instance $7180 r0 *1 945.28,1209.6
X$7180 20943 20826 19287 20936 20822 20644 gf180mcu_fd_sc_mcu9t5v0__mux2_1
* cell instance $7181 m0 *1 962.64,1229.76
X$7181 21129 21241 21412 21366 gf180mcu_fd_sc_mcu9t5v0__clkinv_1
* cell instance $7182 r0 *1 913.36,1189.44
X$7182 20342 18272 20379 20217 20219 gf180mcu_fd_sc_mcu9t5v0__nand2_1
* cell instance $7183 m0 *1 943.04,1229.76
X$7183 14856 21365 20215 21241 21412 21419 gf180mcu_fd_sc_mcu9t5v0__mux2_1
* cell instance $7184 r0 *1 958.16,1199.52
X$7184 18272 20997 20381 20515 20637 20507 20645
+ gf180mcu_fd_sc_mcu9t5v0__oai31_1
* cell instance $7185 m0 *1 953.12,1219.68
X$7185 20943 18444 20936 21123 20997 gf180mcu_fd_sc_mcu9t5v0__nor2_1
* cell instance $7186 r0 *1 921.2,1179.36
X$7186 20032 20028 19901 18612 gf180mcu_fd_sc_mcu9t5v0__buf_8
* cell instance $7187 r0 *1 913.36,1179.36
X$7187 19905 18590 18614 20028 19901 20032 gf180mcu_fd_sc_mcu9t5v0__aoi21_1
* cell instance $7188 r0 *1 919.52,1229.76
X$7188 21244 21537 21412 23692 gf180mcu_fd_sc_mcu9t5v0__buf_8
* cell instance $7189 r0 *1 903.28,1209.6
X$7189 13331 20505 20936 20822 20940 gf180mcu_fd_sc_mcu9t5v0__nand2_1
* cell instance $7190 m0 *1 899.92,1229.76
X$7190 21363 18590 21126 4391 21241 21412 21418 gf180mcu_fd_sc_mcu9t5v0__aoi22_1
* cell instance $7191 m0 *1 958.72,1239.84
X$7191 21591 21537 21719 21592 gf180mcu_fd_sc_mcu9t5v0__clkinv_1
* cell instance $7192 r0 *1 955.36,1229.76
X$7192 21420 19862 21245 21365 21537 21412 21367
+ gf180mcu_fd_sc_mcu9t5v0__aoi22_1
* cell instance $7193 r0 *1 903.84,1189.44
X$7193 20082 18444 20379 20217 20341 gf180mcu_fd_sc_mcu9t5v0__nor2_1
* cell instance $7194 r0 *1 898.8,1229.76
X$7194 14809 21588 20215 21537 21412 21539 gf180mcu_fd_sc_mcu9t5v0__mux2_1
* cell instance $7195 r0 *1 934.08,1229.76
X$7195 21589 21537 21412 21590 gf180mcu_fd_sc_mcu9t5v0__clkinv_1
* cell instance $7196 m0 *1 899.92,1209.6
X$7196 19732 20505 20637 20822 20825 gf180mcu_fd_sc_mcu9t5v0__xnor2_1
* cell instance $7197 r0 *1 907.2,1189.44
X$7197 18272 20341 20218 20219 20379 20217 20382
+ gf180mcu_fd_sc_mcu9t5v0__oai31_1
* cell instance $7198 m0 *1 907.2,1209.6
X$7198 20940 20637 20822 19862 gf180mcu_fd_sc_mcu9t5v0__buf_8
* cell instance $7199 r0 *1 907.76,1209.6
X$7199 20940 20936 20822 18585 gf180mcu_fd_sc_mcu9t5v0__buf_8
* cell instance $7200 m0 *1 885.36,1239.84
X$7200 21538 18590 4952 21243 21537 21719 21587 gf180mcu_fd_sc_mcu9t5v0__aoi22_1
* cell instance $7201 r0 *1 878.08,1229.76
X$7201 21538 18585 21537 21412 21364 gf180mcu_fd_sc_mcu9t5v0__nand2_1
* cell instance $7202 m0 *1 849.52,1199.52
X$7202 20507 20379 gf180mcu_fd_sc_mcu9t5v0__filltie
* cell instance $7203 r0 *1 837.76,1179.36
X$7203 19283 19904 19905 20028 19901 gf180mcu_fd_sc_mcu9t5v0__dffq_2
* cell instance $7204 r0 *1 834.4,1229.76
X$7204 21414 21245 21537 21412 20991 gf180mcu_fd_sc_mcu9t5v0__nand2_1
* cell instance $7205 r0 *1 869.12,1219.68
X$7205 20990 18590 21126 8701 21241 21123 21242 gf180mcu_fd_sc_mcu9t5v0__aoi22_1
* cell instance $7206 m0 *1 850.64,1229.76
X$7206 21363 18585 21245 21361 21241 21412 21416
+ gf180mcu_fd_sc_mcu9t5v0__aoi22_1
* cell instance $7207 r0 *1 884.8,1199.52
X$7207 16790 6951 8820 9694 20637 20507 20824 gf180mcu_fd_sc_mcu9t5v0__nor4_1
* cell instance $7208 r0 *1 856.24,1229.76
X$7208 21416 21537 21412 21125 gf180mcu_fd_sc_mcu9t5v0__clkinv_1
* cell instance $7209 m0 *1 834.4,1239.84
X$7209 21721 18585 21245 21584 21537 21719 21586
+ gf180mcu_fd_sc_mcu9t5v0__aoi22_1
* cell instance $7210 m0 *1 860.16,1209.6
X$7210 19283 20641 20643 20637 20822 gf180mcu_fd_sc_mcu9t5v0__dffq_2
* cell instance $7211 r0 *1 848.96,1219.68
X$7211 21409 21125 21363 21241 21123 gf180mcu_fd_sc_mcu9t5v0__dffq_2
* cell instance $7212 m0 *1 849.52,1189.44
X$7212 20217 20028 gf180mcu_fd_sc_mcu9t5v0__filltie
* cell instance $7213 r0 *1 873.04,1209.6
X$7213 20643 18590 21126 9544 20936 20822 20823 gf180mcu_fd_sc_mcu9t5v0__aoi22_1
* cell instance $7214 r0 *1 876.96,1179.36
X$7214 20031 18444 20028 19901 19906 gf180mcu_fd_sc_mcu9t5v0__nor2_1
* cell instance $7215 m0 *1 849.52,1209.6
X$7215 20822 20637 gf180mcu_fd_sc_mcu9t5v0__filltie
* cell instance $7216 r0 *1 887.6,1209.6
X$7216 16789 20938 20936 20822 20939 gf180mcu_fd_sc_mcu9t5v0__nor2_1
* cell instance $7217 r0 *1 843.92,1189.44
X$7217 20510 18590 4952 7815 18614 20379 20217 20218
+ gf180mcu_fd_sc_mcu9t5v0__aoi221_1
* cell instance $7218 m0 *1 885.36,1219.68
X$7218 16443 9694 20939 20936 21123 20993 gf180mcu_fd_sc_mcu9t5v0__aoi21_1
* cell instance $7219 r0 *1 865.2,1179.36
X$7219 20031 20030 19287 20028 19901 20081 gf180mcu_fd_sc_mcu9t5v0__mux2_1
* cell instance $7220 r0 *1 878.64,1219.68
X$7220 20939 21241 21123 9694 21243 gf180mcu_fd_sc_mcu9t5v0__xor2_1
* cell instance $7221 r0 *1 885.36,1219.68
X$7221 6951 20993 21241 21123 21128 gf180mcu_fd_sc_mcu9t5v0__xnor2_1
* cell instance $7222 m0 *1 888.72,1189.44
X$7222 20082 23615 19287 20028 20217 20340 gf180mcu_fd_sc_mcu9t5v0__mux2_1
* cell instance $7223 m0 *1 857.36,1209.6
X$7223 19566 14298 20637 20822 20640 gf180mcu_fd_sc_mcu9t5v0__nand2_1
* cell instance $7224 m0 *1 849.52,1229.76
X$7224 21412 21241 gf180mcu_fd_sc_mcu9t5v0__filltie
* cell instance $7225 m0 *1 861.28,1219.68
X$7225 20987 20640 20936 21123 22004 gf180mcu_fd_sc_mcu9t5v0__nand2_1
* cell instance $7226 r0 *1 843.92,1199.52
X$7226 20639 18590 4952 8700 18614 20637 20507 20514
+ gf180mcu_fd_sc_mcu9t5v0__aoi221_1
* cell instance $7227 r0 *1 869.12,1199.52
X$7227 20643 18585 20637 20507 20642 gf180mcu_fd_sc_mcu9t5v0__nand2_1
* cell instance $7228 r0 *1 864.08,1199.52
X$7228 18585 20640 20642 20637 20507 20641 gf180mcu_fd_sc_mcu9t5v0__oai21_1
* cell instance $7229 m0 *1 849.52,1219.68
X$7229 21123 20936 gf180mcu_fd_sc_mcu9t5v0__filltie
* cell instance $7230 r0 *1 831.04,1219.68
X$7230 21409 21124 21362 21241 21123 gf180mcu_fd_sc_mcu9t5v0__dffq_2
* cell instance $7231 m0 *1 859.04,1189.44
X$7231 19283 20081 20031 13331 20028 20217 gf180mcu_fd_sc_mcu9t5v0__dffrnq_2
* cell instance $7232 m0 *1 890.96,1219.68
X$7232 21362 18590 21127 20994 20936 21123 20995
+ gf180mcu_fd_sc_mcu9t5v0__aoi22_1
* cell instance $7233 r0 *1 890.4,1199.52
X$7233 16790 8820 20637 20507 20938 gf180mcu_fd_sc_mcu9t5v0__nor2_1
* cell instance $7234 m0 *1 887.6,1199.52
X$7234 16790 8820 20379 20507 21127 gf180mcu_fd_sc_mcu9t5v0__nand2_1
* cell instance $7235 m0 *1 869.68,1229.76
X$7235 18585 20987 21364 21723 21241 21412 21417
+ gf180mcu_fd_sc_mcu9t5v0__oai211_1
* cell instance $7236 m0 *1 837.76,1219.68
X$7236 18585 20819 20992 20991 20936 21123 21124
+ gf180mcu_fd_sc_mcu9t5v0__oai211_1
* cell instance $7237 m0 *1 866.32,1239.84
X$7237 21409 21417 21538 21537 21719 gf180mcu_fd_sc_mcu9t5v0__dffq_2
* cell instance $7238 m0 *1 837.2,1229.76
X$7238 21362 18585 21241 21412 20992 gf180mcu_fd_sc_mcu9t5v0__nand2_1
* cell instance $7239 m0 *1 840,1229.76
X$7239 21360 18590 4952 12647 18614 21241 21412 21415
+ gf180mcu_fd_sc_mcu9t5v0__aoi221_1
* cell instance $7240 m0 *1 849.52,1239.84
X$7240 21719 21537 gf180mcu_fd_sc_mcu9t5v0__filltie
* cell instance $7241 m0 *1 843.36,1189.44
X$7241 20080 18590 4952 9437 18614 20028 20217 20381
+ gf180mcu_fd_sc_mcu9t5v0__aoi221_1
* cell instance $7242 m0 *1 843.36,1199.52
X$7242 20512 18590 4952 4797 18614 20379 20507 20513
+ gf180mcu_fd_sc_mcu9t5v0__aoi221_1
* cell instance $7243 m0 *1 849.52,1169.28
X$7243 19605 19448 gf180mcu_fd_sc_mcu9t5v0__filltie
* cell instance $7244 r0 *1 886.48,1108.8
X$7244 17954 17526 17985 17837 17712 gf180mcu_fd_sc_mcu9t5v0__nor2_1
* cell instance $7245 m0 *1 849.52,1149.12
X$7245 18996 18841 gf180mcu_fd_sc_mcu9t5v0__filltie
* cell instance $7246 r0 *1 888.16,1139.04
X$7246 18586 18590 18841 18731 18732 gf180mcu_fd_sc_mcu9t5v0__nand2_1
* cell instance $7247 m0 *1 853.44,1118.88
X$7247 17839 17986 17954 17985 18104 17950 gf180mcu_fd_sc_mcu9t5v0__nand3_1
* cell instance $7248 m0 *1 861.84,1118.88
X$7248 17951 17572 17711 17985 18104 18106 gf180mcu_fd_sc_mcu9t5v0__nand3_1
* cell instance $7249 r0 *1 872.48,1108.8
X$7249 17524 17951 12622 17985 17837 17953 gf180mcu_fd_sc_mcu9t5v0__and3_1
* cell instance $7250 m0 *1 849.52,1159.2
X$7250 19282 19171 gf180mcu_fd_sc_mcu9t5v0__filltie
* cell instance $7251 r0 *1 884.24,1159.2
X$7251 18272 19403 18999 19288 19448 19282 19404
+ gf180mcu_fd_sc_mcu9t5v0__oai31_1
* cell instance $7252 r0 *1 861.28,1139.04
X$7252 19283 18588 18589 13331 18841 18731 gf180mcu_fd_sc_mcu9t5v0__dffrnq_2
* cell instance $7253 m0 *1 849.52,1118.88
X$7253 18104 17985 gf180mcu_fd_sc_mcu9t5v0__filltie
* cell instance $7254 m0 *1 849.52,1139.04
X$7254 18731 18553 gf180mcu_fd_sc_mcu9t5v0__filltie
* cell instance $7255 m0 *1 850.64,1149.12
X$7255 18964 18590 4952 12255 18614 18841 18996 18999
+ gf180mcu_fd_sc_mcu9t5v0__aoi221_1
* cell instance $7256 m0 *1 868.56,1139.04
X$7256 14809 18589 18840 18553 18731 18588 gf180mcu_fd_sc_mcu9t5v0__mux2_1
* cell instance $7257 r0 *1 893.2,1159.2
X$7257 19451 18272 19448 19282 19288 gf180mcu_fd_sc_mcu9t5v0__nand2_1
* cell instance $7258 m0 *1 850.64,1139.04
X$7258 18105 18553 18731 18587 gf180mcu_fd_sc_mcu9t5v0__buf_8
* cell instance $7259 r0 *1 868,1108.8
X$7259 17524 12622 17951 17985 17837 17952 gf180mcu_fd_sc_mcu9t5v0__aoi21_1
* cell instance $7260 r0 *1 880.88,1159.2
X$7260 19286 18444 19448 19282 19403 gf180mcu_fd_sc_mcu9t5v0__nor2_1
* cell instance $7261 m0 *1 875.84,1139.04
X$7261 18584 18590 18553 18731 18591 gf180mcu_fd_sc_mcu9t5v0__nand2_1
* cell instance $7262 r0 *1 865.2,1118.88
X$7262 19283 18107 17951 13331 18268 18104 gf180mcu_fd_sc_mcu9t5v0__dffrnq_2
* cell instance $7263 m0 *1 866.32,1169.28
X$7263 19283 19450 19286 13331 19448 19605 gf180mcu_fd_sc_mcu9t5v0__dffrnq_2
* cell instance $7264 r0 *1 866.32,1159.2
X$7264 19402 19448 19282 19283 gf180mcu_fd_sc_mcu9t5v0__clkbuf_8
* cell instance $7265 m0 *1 857.36,1118.88
X$7265 17839 17986 17985 18104 17711 gf180mcu_fd_sc_mcu9t5v0__nand2_1
* cell instance $7266 m0 *1 865.76,1118.88
X$7266 17950 17953 17952 18106 17985 18104 18107
+ gf180mcu_fd_sc_mcu9t5v0__oai31_1
* cell instance $7267 m0 *1 842.24,1149.12
X$7267 19128 18964 18585 18841 18996 18998 gf180mcu_fd_sc_mcu9t5v0__mux2_1
* cell instance $7268 r0 *1 850.64,1159.2
X$7268 15693 19448 19282 19279 gf180mcu_fd_sc_mcu9t5v0__buf_8
* cell instance $7269 r0 *1 890.4,1108.8
X$7269 17951 17840 17985 17837 17954 gf180mcu_fd_sc_mcu9t5v0__or2_1
* cell instance $7270 r0 *1 882,1128.96
X$7270 14011 6149 18591 18444 18553 18386 18554
+ gf180mcu_fd_sc_mcu9t5v0__oai211_1
* cell instance $7271 m0 *1 876.96,1149.12
X$7271 19283 18844 18592 18841 18996 gf180mcu_fd_sc_mcu9t5v0__dffq_2
* cell instance $7272 r0 *1 880.88,1139.04
X$7272 18589 18592 18585 18841 18731 18844 gf180mcu_fd_sc_mcu9t5v0__mux2_1
* cell instance $7273 m0 *1 872.48,1159.2
X$7273 19286 22443 19287 19171 19282 19450 gf180mcu_fd_sc_mcu9t5v0__mux2_1
* cell instance $7274 m0 *1 849.52,1128.96
X$7274 18386 18268 gf180mcu_fd_sc_mcu9t5v0__filltie
* cell instance $7275 r0 *1 892.08,1128.96
X$7275 15140 13198 18732 18444 18553 18386 18555
+ gf180mcu_fd_sc_mcu9t5v0__oai211_1
* cell instance $7276 m0 *1 831.04,1128.96
X$7276 18388 18390 16439 18268 18386 18389 gf180mcu_fd_sc_mcu9t5v0__mux2_1
* cell instance $7277 r0 *1 844.48,1118.88
X$7277 18140 13830 18268 18104 18105 gf180mcu_fd_sc_mcu9t5v0__nor2_1
* cell instance $7278 m0 *1 858.48,1169.28
X$7278 19283 19448 19605 gf180mcu_fd_sc_mcu9t5v0__clkbuf_4
* cell instance $7279 r0 *1 839.44,1149.12
X$7279 19283 18998 18964 19171 18996 gf180mcu_fd_sc_mcu9t5v0__dffq_2
* cell instance $7280 r0 *1 839.44,1108.8
X$7280 16142 17838 17839 13331 17985 17837 gf180mcu_fd_sc_mcu9t5v0__dffrnq_2
* cell instance $7281 m0 *1 841.12,1128.96
X$7281 18390 15269 15399 17988 15575 18268 18386 18140
+ gf180mcu_fd_sc_mcu9t5v0__aoi221_1
* cell instance $7282 r0 *1 904.4,1108.8
X$7282 14975 17955 17841 13331 17985 17837 gf180mcu_fd_sc_mcu9t5v0__dffrnq_2
* cell instance $7283 m0 *1 908.88,1128.96
X$7283 17293 18392 18391 18268 18386 18393 gf180mcu_fd_sc_mcu9t5v0__aoi21_1
* cell instance $7284 m0 *1 916.16,1169.28
X$7284 19604 18590 4952 3807 18614 19448 19605 19608
+ gf180mcu_fd_sc_mcu9t5v0__aoi221_1
* cell instance $7285 r0 *1 901.6,1149.12
X$7285 19129 17572 19171 18996 18845 gf180mcu_fd_sc_mcu9t5v0__nand2_1
* cell instance $7286 r0 *1 899.92,1108.8
X$7286 17524 17841 12622 17985 17837 17840 gf180mcu_fd_sc_mcu9t5v0__nand3_1
* cell instance $7287 r0 *1 906.64,1128.96
X$7287 17247 18393 18445 13331 18553 18386 gf180mcu_fd_sc_mcu9t5v0__dffrnq_2
* cell instance $7288 m0 *1 904.96,1128.96
X$7288 18445 16010 18268 18386 12886 gf180mcu_fd_sc_mcu9t5v0__nand2_1
* cell instance $7289 r0 *1 950.88,1159.2
X$7289 15401 19409 18840 19448 19282 19452 gf180mcu_fd_sc_mcu9t5v0__mux2_1
* cell instance $7290 r0 *1 957.6,1118.88
X$7290 18145 18147 18146 17990 18268 18104 18144
+ gf180mcu_fd_sc_mcu9t5v0__oai22_1
* cell instance $7291 m0 *1 941.36,1139.04
X$7291 18592 18590 4952 3810 18614 18553 18731 18595
+ gf180mcu_fd_sc_mcu9t5v0__aoi221_1
* cell instance $7292 r0 *1 934.64,1139.04
X$7292 18846 18841 18731 18145 gf180mcu_fd_sc_mcu9t5v0__buf_8
* cell instance $7293 m0 *1 941.36,1149.12
X$7293 17247 18965 18596 13331 18841 18996 gf180mcu_fd_sc_mcu9t5v0__dffrnq_2
* cell instance $7294 m0 *1 943.6,1169.28
X$7294 19571 19448 19605 19408 gf180mcu_fd_sc_mcu9t5v0__clkinv_1
* cell instance $7295 r0 *1 927.92,1159.2
X$7295 19407 19172 19406 13331 19448 19282 gf180mcu_fd_sc_mcu9t5v0__dffrnq_2
* cell instance $7296 r0 *1 902.16,1139.04
X$7296 18141 18845 18392 18841 18731 18733 gf180mcu_fd_sc_mcu9t5v0__aoi21_1
* cell instance $7297 r0 *1 925.12,1159.2
X$7297 18594 19406 19448 19282 19289 gf180mcu_fd_sc_mcu9t5v0__nand2_1
* cell instance $7298 m0 *1 915.04,1149.12
X$7298 18141 19130 18841 18996 19001 gf180mcu_fd_sc_mcu9t5v0__nand2_1
* cell instance $7299 r0 *1 907.76,1159.2
X$7299 19000 19129 19405 19122 19448 19282 19285
+ gf180mcu_fd_sc_mcu9t5v0__oai31_1
* cell instance $7300 m0 *1 927.36,1159.2
X$7300 12393 16011 15739 19289 19171 19282 19172
+ gf180mcu_fd_sc_mcu9t5v0__oai211_1
* cell instance $7301 r0 *1 901.04,1128.96
X$7301 18445 18441 18383 18553 18386 18391 gf180mcu_fd_sc_mcu9t5v0__aoi21_1
* cell instance $7302 r0 *1 920.64,1118.88
X$7302 12886 18142 18268 18104 18143 gf180mcu_fd_sc_mcu9t5v0__nand2_1
* cell instance $7303 r0 *1 915.04,1149.12
X$7303 17247 19001 19131 13331 19171 18996 gf180mcu_fd_sc_mcu9t5v0__dffrnq_2
* cell instance $7304 m0 *1 922.32,1118.88
X$7304 19283 18143 17293 13331 17985 18104 gf180mcu_fd_sc_mcu9t5v0__dffrnq_2
* cell instance $7305 m0 *1 960.4,1139.04
X$7305 18597 18596 13904 18553 18731 18146 gf180mcu_fd_sc_mcu9t5v0__nand3_1
* cell instance $7306 r0 *1 929.04,1118.88
X$7306 17247 18144 18446 13331 18268 18104 gf180mcu_fd_sc_mcu9t5v0__dffrnq_2
* cell instance $7307 m0 *1 945.84,1169.28
X$7307 14019 19572 19448 19605 18847 gf180mcu_fd_sc_mcu9t5v0__nor2_1
* cell instance $7308 r0 *1 940.8,1108.8
X$7308 18446 17985 17837 17989 gf180mcu_fd_sc_mcu9t5v0__buf_8
* cell instance $7309 r0 *1 910.56,1149.12
X$7309 19000 19129 19131 19171 18996 19130 gf180mcu_fd_sc_mcu9t5v0__oai21_1
* cell instance $7310 r0 *1 939.68,1128.96
X$7310 18446 18553 18386 18846 gf180mcu_fd_sc_mcu9t5v0__clkinv_1
* cell instance $7311 m0 *1 918.4,1139.04
X$7311 12393 16658 18553 18731 18392 gf180mcu_fd_sc_mcu9t5v0__nor2_1
* cell instance $7312 r0 *1 949.76,1139.04
X$7312 19408 18847 18734 18841 18731 18965 gf180mcu_fd_sc_mcu9t5v0__mux2_1
* cell instance $7313 m0 *1 921.76,1139.04
X$7313 18594 18593 15739 17293 18553 18731 18142
+ gf180mcu_fd_sc_mcu9t5v0__oai211_1
* cell instance $7314 m0 *1 915.04,1159.2
X$7314 19131 19171 19282 19405 gf180mcu_fd_sc_mcu9t5v0__clkinv_1
* cell instance $7315 r0 *1 961.52,1139.04
X$7315 18596 18841 18731 18734 gf180mcu_fd_sc_mcu9t5v0__clkinv_1
* cell instance $7316 r0 *1 970.48,1169.28
X$7316 19453 19729 19605 19573 gf180mcu_fd_sc_mcu9t5v0__clkinv_1
* cell instance $7317 r0 *1 969.36,1169.28
X$7317 19605 19729 gf180mcu_fd_sc_mcu9t5v0__filltie
* cell instance $7318 m0 *1 1029.84,1239.84
X$7318 20944 21540 21424 13331 21537 21719 gf180mcu_fd_sc_mcu9t5v0__dffrnq_2
* cell instance $7319 r0 *1 1035.44,1229.76
X$7319 21133 21424 17977 21537 21412 21540 gf180mcu_fd_sc_mcu9t5v0__mux2_1
* cell instance $7320 r0 *1 1064,1169.28
X$7320 19174 19738 19133 13331 19729 19605 gf180mcu_fd_sc_mcu9t5v0__dffrnq_2
* cell instance $7321 r0 *1 983.36,1169.28
X$7321 19407 19609 19610 19729 19605 gf180mcu_fd_sc_mcu9t5v0__dffq_2
* cell instance $7322 r0 *1 1025.92,1209.6
X$7322 20944 20829 20695 13331 20936 20822 gf180mcu_fd_sc_mcu9t5v0__dffrnq_2
* cell instance $7323 r0 *1 1013.6,1169.28
X$7323 19611 19451 18277 19729 19605 19737 gf180mcu_fd_sc_mcu9t5v0__mux2_1
* cell instance $7324 r0 *1 1034.88,1139.04
X$7324 19292 18737 18739 18738 18841 18731 18740
+ gf180mcu_fd_sc_mcu9t5v0__oai31_1
* cell instance $7325 m0 *1 1034.32,1199.52
X$7325 19174 20385 20344 13331 20379 20507 gf180mcu_fd_sc_mcu9t5v0__dffrnq_2
* cell instance $7326 m0 *1 1053.36,1179.36
X$7326 19913 18590 18614 19729 19901 18412 gf180mcu_fd_sc_mcu9t5v0__aoi21_1
* cell instance $7327 m0 *1 1042.72,1179.36
X$7327 19409 19913 19862 19729 19901 19912 gf180mcu_fd_sc_mcu9t5v0__mux2_1
* cell instance $7328 m0 *1 1089.2,1179.36
X$7328 19901 19729 gf180mcu_fd_sc_mcu9t5v0__filltie
* cell instance $7329 m0 *1 1100.4,1179.36
X$7329 19918 19729 19901 19612 gf180mcu_fd_sc_mcu9t5v0__clkinv_1
* cell instance $7330 m0 *1 1068.48,1179.36
X$7330 19292 19915 19864 19914 19729 19901 19738
+ gf180mcu_fd_sc_mcu9t5v0__oai31_1
* cell instance $7331 m0 *1 1090.88,1179.36
X$7331 19918 19917 19287 19729 19901 19916 gf180mcu_fd_sc_mcu9t5v0__mux2_1
* cell instance $7332 m0 *1 1010.8,1179.36
X$7332 17247 19737 19611 13331 19729 19901 gf180mcu_fd_sc_mcu9t5v0__dffrnq_2
* cell instance $7333 m0 *1 1000.72,1179.36
X$7333 19909 18444 19729 19901 19294 gf180mcu_fd_sc_mcu9t5v0__nor2_1
* cell instance $7334 r0 *1 1020.88,1179.36
X$7334 17247 20034 19911 20028 19901 gf180mcu_fd_sc_mcu9t5v0__dffq_2
* cell instance $7335 m0 *1 1029.28,1209.6
X$7335 20343 20695 17977 20637 20822 20829 gf180mcu_fd_sc_mcu9t5v0__mux2_1
* cell instance $7336 m0 *1 987.84,1179.36
X$7336 19861 19610 19862 19729 19901 19609 gf180mcu_fd_sc_mcu9t5v0__mux2_1
* cell instance $7337 m0 *1 1019.2,1229.76
X$7337 20944 21248 21133 13331 21241 21412 gf180mcu_fd_sc_mcu9t5v0__dffrnq_2
* cell instance $7338 r0 *1 1020.32,1108.8
X$7338 17247 17844 17956 13331 17985 17837 gf180mcu_fd_sc_mcu9t5v0__dffrnq_2
* cell instance $7339 r0 *1 1034.88,1128.96
X$7339 18448 14825 14865 18149 18553 18386 18447
+ gf180mcu_fd_sc_mcu9t5v0__aoi22_1
* cell instance $7340 m0 *1 1032.08,1149.12
X$7340 19911 18590 4952 3682 18614 18841 18996 18739
+ gf180mcu_fd_sc_mcu9t5v0__aoi221_1
* cell instance $7341 m0 *1 1047.76,1219.68
X$7341 19174 20945 20998 13331 20936 21123 gf180mcu_fd_sc_mcu9t5v0__dffrnq_2
* cell instance $7342 r0 *1 1048.88,1199.52
X$7342 19174 20650 20651 13331 20637 20507 gf180mcu_fd_sc_mcu9t5v0__dffrnq_2
* cell instance $7343 r0 *1 1061.76,1209.6
X$7343 19174 20946 20696 13331 20936 20822 gf180mcu_fd_sc_mcu9t5v0__dffrnq_2
* cell instance $7344 r0 *1 1068.48,1179.36
X$7344 23615 20035 19910 20028 19901 20087 gf180mcu_fd_sc_mcu9t5v0__mux2_1
* cell instance $7345 m0 *1 1089.2,1229.76
X$7345 21412 21241 gf180mcu_fd_sc_mcu9t5v0__filltie
* cell instance $7346 m0 *1 1073.52,1209.6
X$7346 20652 20696 18272 20637 20822 20946 gf180mcu_fd_sc_mcu9t5v0__mux2_1
* cell instance $7347 r0 *1 1075.76,1179.36
X$7347 20035 18444 20028 19901 19915 gf180mcu_fd_sc_mcu9t5v0__nor2_1
* cell instance $7348 r0 *1 1084.72,1179.36
X$7348 19174 19916 19918 13331 20028 19901 gf180mcu_fd_sc_mcu9t5v0__dffrnq_2
* cell instance $7349 r0 *1 1078.56,1189.44
X$7349 3816 20379 20217 19174 gf180mcu_fd_sc_mcu9t5v0__clkbuf_8
* cell instance $7350 m0 *1 1062.88,1229.76
X$7350 19174 21369 21425 13331 21241 21412 gf180mcu_fd_sc_mcu9t5v0__dffrnq_2
* cell instance $7351 m0 *1 1061.76,1189.44
X$7351 19174 20087 20035 13331 20028 20217 gf180mcu_fd_sc_mcu9t5v0__dffrnq_2
* cell instance $7352 m0 *1 1051.68,1209.6
X$7352 20344 20651 14872 20637 20822 20650 gf180mcu_fd_sc_mcu9t5v0__mux2_1
* cell instance $7353 m0 *1 1081.92,1209.6
X$7353 20697 20696 18277 20637 20822 20830 gf180mcu_fd_sc_mcu9t5v0__mux2_1
* cell instance $7354 m0 *1 1089.2,1199.52
X$7354 20507 20379 gf180mcu_fd_sc_mcu9t5v0__filltie
* cell instance $7355 m0 *1 1089.2,1219.68
X$7355 21123 20936 gf180mcu_fd_sc_mcu9t5v0__filltie
* cell instance $7356 r0 *1 1097.04,1189.44
X$7356 14132 20221 13492 20379 20217 20386 gf180mcu_fd_sc_mcu9t5v0__mux2_1
* cell instance $7357 m0 *1 1041.6,1229.76
X$7357 21130 18590 21126 4525 21241 21412 22011 gf180mcu_fd_sc_mcu9t5v0__aoi22_1
* cell instance $7358 m0 *1 1089.2,1209.6
X$7358 20822 20637 gf180mcu_fd_sc_mcu9t5v0__filltie
* cell instance $7359 r0 *1 1078.56,1219.68
X$7359 21425 21241 21123 20518 gf180mcu_fd_sc_mcu9t5v0__clkinv_1
* cell instance $7360 r0 *1 1080.8,1209.6
X$7360 19174 20830 20697 13331 20936 20822 gf180mcu_fd_sc_mcu9t5v0__dffrnq_2
* cell instance $7361 r0 *1 1076.32,1229.76
X$7361 19174 21542 14418 13331 21537 21412 gf180mcu_fd_sc_mcu9t5v0__dffrnq_2
* cell instance $7362 m0 *1 1048.88,1239.84
X$7362 20944 21541 21597 13331 21537 21719 gf180mcu_fd_sc_mcu9t5v0__dffrnq_2
* cell instance $7363 m0 *1 1089.2,1189.44
X$7363 20217 20028 gf180mcu_fd_sc_mcu9t5v0__filltie
* cell instance $7364 r0 *1 1051.12,1229.76
X$7364 21424 21597 14872 21537 21412 21541 gf180mcu_fd_sc_mcu9t5v0__mux2_1
* cell instance $7365 m0 *1 1089.2,1239.84
X$7365 21719 21537 gf180mcu_fd_sc_mcu9t5v0__filltie
* cell instance $7366 r0 *1 1038.24,1179.36
X$7366 19174 19912 19913 20028 19901 gf180mcu_fd_sc_mcu9t5v0__dffq_2
* cell instance $7367 r0 *1 1069.04,1229.76
X$7367 21425 22168 19287 21537 21412 21369 gf180mcu_fd_sc_mcu9t5v0__mux2_1
* cell instance $7368 r0 *1 1038.24,1189.44
X$7368 19611 20344 17977 20379 20217 20385 gf180mcu_fd_sc_mcu9t5v0__mux2_1
* cell instance $7369 m0 *1 1095.36,1239.84
X$7369 21728 21594 21537 21719 21593 gf180mcu_fd_sc_mcu9t5v0__xnor2_1
* cell instance $7370 r0 *1 1078,1199.52
X$7370 20518 18614 18612 7682 20637 20507 20652 gf180mcu_fd_sc_mcu9t5v0__aoi22_1
* cell instance $7371 m0 *1 1081.92,1239.84
X$7371 14418 21593 13492 21537 21719 21542 gf180mcu_fd_sc_mcu9t5v0__mux2_1
* cell instance $7372 r0 *1 1049.44,1209.6
X$7372 20695 20998 14872 20936 20822 20945 gf180mcu_fd_sc_mcu9t5v0__mux2_1
* cell instance $7373 m0 *1 971.6,1209.6
X$7373 19407 20646 20647 13331 20637 20822 gf180mcu_fd_sc_mcu9t5v0__dffrnq_2
* cell instance $7374 r0 *1 969.36,1219.68
X$7374 21123 21241 gf180mcu_fd_sc_mcu9t5v0__filltie
* cell instance $7375 r0 *1 999.6,1229.76
X$7375 20944 21421 21422 13331 21537 21412 gf180mcu_fd_sc_mcu9t5v0__dffrnq_2
* cell instance $7376 r0 *1 990.08,1229.76
X$7376 21368 19292 21537 21412 21131 gf180mcu_fd_sc_mcu9t5v0__nand2_1
* cell instance $7377 r0 *1 969.36,1189.44
X$7377 20217 20379 gf180mcu_fd_sc_mcu9t5v0__filltie
* cell instance $7378 r0 *1 998.48,1199.52
X$7378 20648 19292 20637 20507 20516 gf180mcu_fd_sc_mcu9t5v0__nand2_1
* cell instance $7379 r0 *1 1006.88,1209.6
X$7379 20944 20828 20649 13331 20936 20822 gf180mcu_fd_sc_mcu9t5v0__dffrnq_2
* cell instance $7380 r0 *1 979.44,1199.52
X$7380 20826 20647 19910 20637 20507 20646 gf180mcu_fd_sc_mcu9t5v0__mux2_1
* cell instance $7381 r0 *1 1022,1219.68
X$7381 21133 19734 18277 21241 21123 21248 gf180mcu_fd_sc_mcu9t5v0__mux2_1
* cell instance $7382 m0 *1 976.64,1189.44
X$7382 20085 19908 19862 20028 20217 20033 gf180mcu_fd_sc_mcu9t5v0__mux2_1
* cell instance $7383 m0 *1 1009.68,1209.6
X$7383 20649 20648 18277 20637 20822 20828 gf180mcu_fd_sc_mcu9t5v0__mux2_1
* cell instance $7384 m0 *1 1025.36,1189.44
X$7384 20220 19911 19862 20028 20217 20034 gf180mcu_fd_sc_mcu9t5v0__mux2_1
* cell instance $7385 m0 *1 1001.28,1229.76
X$7385 21422 21368 18277 21241 21412 21421 gf180mcu_fd_sc_mcu9t5v0__mux2_1
* cell instance $7386 r0 *1 969.36,1209.6
X$7386 20822 20936 gf180mcu_fd_sc_mcu9t5v0__filltie
* cell instance $7387 r0 *1 1013.6,1189.44
X$7387 20343 20342 18277 20379 20217 20384 gf180mcu_fd_sc_mcu9t5v0__mux2_1
* cell instance $7388 r0 *1 986.72,1209.6
X$7388 20647 18444 20936 20822 20827 gf180mcu_fd_sc_mcu9t5v0__nor2_1
* cell instance $7389 r0 *1 985.6,1219.68
X$7389 19292 21132 19608 21131 21241 21123 21247
+ gf180mcu_fd_sc_mcu9t5v0__oai31_1
* cell instance $7390 m0 *1 1010.8,1199.52
X$7390 20944 20384 20343 13331 20379 20507 gf180mcu_fd_sc_mcu9t5v0__dffrnq_2
* cell instance $7391 r0 *1 969.36,1229.76
X$7391 21412 21537 gf180mcu_fd_sc_mcu9t5v0__filltie
* cell instance $7392 m0 *1 990.64,1189.44
X$7392 19407 20086 19909 13331 20028 20217 gf180mcu_fd_sc_mcu9t5v0__dffrnq_2
* cell instance $7393 r0 *1 988.4,1199.52
X$7393 19292 20827 18595 20516 20637 20507 20517
+ gf180mcu_fd_sc_mcu9t5v0__oai31_1
* cell instance $7394 m0 *1 981.68,1229.76
X$7394 20944 21247 21368 13331 21241 21412 gf180mcu_fd_sc_mcu9t5v0__dffrnq_2
* cell instance $7395 r0 *1 969.36,1199.52
X$7395 20507 20637 gf180mcu_fd_sc_mcu9t5v0__filltie
* cell instance $7396 m0 *1 1008.56,1229.76
X$7396 21420 18590 21126 4033 21241 21412 21423 gf180mcu_fd_sc_mcu9t5v0__aoi22_1
* cell instance $7397 m0 *1 990.64,1209.6
X$7397 19407 20517 20648 13331 20637 20822 gf180mcu_fd_sc_mcu9t5v0__dffrnq_2
* cell instance $7398 r0 *1 997.92,1179.36
X$7398 20030 19909 19910 20028 19901 20086 gf180mcu_fd_sc_mcu9t5v0__mux2_1
* cell instance $7399 r0 *1 970.48,1219.68
X$7399 21367 21241 21123 21246 gf180mcu_fd_sc_mcu9t5v0__clkinv_1
* cell instance $7400 r0 *1 971.6,1179.36
X$7400 19407 20033 19908 20028 19901 gf180mcu_fd_sc_mcu9t5v0__dffq_2
* cell instance $7401 r0 *1 969.36,1179.36
X$7401 19901 20028 gf180mcu_fd_sc_mcu9t5v0__filltie
* cell instance $7402 r0 *1 972.72,1118.88
X$7402 18148 18145 18268 18104 17579 gf180mcu_fd_sc_mcu9t5v0__nand2_1
* cell instance $7403 m0 *1 969.92,1149.12
X$7403 18735 18734 18841 18996 17578 gf180mcu_fd_sc_mcu9t5v0__nand2_1
* cell instance $7404 r0 *1 970.48,1139.04
X$7404 18109 18597 18734 18841 18731 18270 gf180mcu_fd_sc_mcu9t5v0__nand3_1
* cell instance $7405 m0 *1 972.16,1139.04
X$7405 18735 18596 18553 18731 17529 gf180mcu_fd_sc_mcu9t5v0__nand2_1
* cell instance $7406 r0 *1 969.36,1139.04
X$7406 18731 18841 gf180mcu_fd_sc_mcu9t5v0__filltie
* cell instance $7407 m0 *1 967.12,1149.12
X$7407 18597 18734 18841 18996 18966 gf180mcu_fd_sc_mcu9t5v0__nand2_1
* cell instance $7408 r0 *1 969.36,1128.96
X$7408 18386 18553 gf180mcu_fd_sc_mcu9t5v0__filltie
* cell instance $7409 r0 *1 972.72,1128.96
X$7409 18109 18553 18386 18148 gf180mcu_fd_sc_mcu9t5v0__clkinv_1
* cell instance $7410 r0 *1 974.96,1139.04
X$7410 18109 18597 18596 18841 18731 18848 gf180mcu_fd_sc_mcu9t5v0__nand3_1
* cell instance $7411 r0 *1 969.36,1118.88
X$7411 18104 18268 gf180mcu_fd_sc_mcu9t5v0__filltie
* cell instance $7412 m0 *1 973.84,1118.88
X$7412 18109 18145 17985 18104 17990 gf180mcu_fd_sc_mcu9t5v0__nand2_1
* cell instance $7413 r0 *1 969.36,1108.8
X$7413 17837 17985 gf180mcu_fd_sc_mcu9t5v0__filltie
* cell instance $7414 r0 *1 970.48,1159.2
X$7414 18966 17529 19448 19282 19410 gf180mcu_fd_sc_mcu9t5v0__nand2_1
* cell instance $7415 m0 *1 972.72,1149.12
X$7415 18597 18841 18996 18735 gf180mcu_fd_sc_mcu9t5v0__clkinv_1
* cell instance $7416 m0 *1 968.8,1169.28
X$7416 19407 19573 18597 13331 19448 19605 gf180mcu_fd_sc_mcu9t5v0__dffrnq_2
* cell instance $7417 m0 *1 998.48,1159.2
X$7417 19292 19294 19290 19291 19171 19282 19293
+ gf180mcu_fd_sc_mcu9t5v0__oai31_1
* cell instance $7418 r0 *1 981.68,1149.12
X$7418 18145 18849 19171 18996 18967 gf180mcu_fd_sc_mcu9t5v0__nor2_1
* cell instance $7419 r0 *1 981.12,1118.88
X$7419 18966 17579 18268 18104 17991 gf180mcu_fd_sc_mcu9t5v0__nor2_1
* cell instance $7420 r0 *1 992.32,1159.2
X$7420 19908 18590 4952 3811 18614 19448 19282 19290
+ gf180mcu_fd_sc_mcu9t5v0__aoi221_1
* cell instance $7421 m0 *1 986.16,1118.88
X$7421 17991 17985 18104 13591 gf180mcu_fd_sc_mcu9t5v0__buf_8
* cell instance $7422 m0 *1 985.6,1149.12
X$7422 18967 18841 18996 13465 gf180mcu_fd_sc_mcu9t5v0__buf_8
* cell instance $7423 m0 *1 981.68,1139.04
X$7423 18597 18596 18553 18731 17580 gf180mcu_fd_sc_mcu9t5v0__nand2_1
* cell instance $7424 m0 *1 1013.6,1118.88
X$7424 17956 13465 17714 23159 17985 18104 17992
+ gf180mcu_fd_sc_mcu9t5v0__aoi22_1
* cell instance $7425 r0 *1 1023.12,1118.88
X$7425 18150 13208 13461 18149 16515 23318 18268 18104 18110
+ gf180mcu_fd_sc_mcu9t5v0__aoi222_1
* cell instance $7426 m0 *1 1004.08,1149.12
X$7426 17247 18841 18996 gf180mcu_fd_sc_mcu9t5v0__clkbuf_4
* cell instance $7427 m0 *1 1012.48,1159.2
X$7427 17247 19173 19412 13331 19171 19282 gf180mcu_fd_sc_mcu9t5v0__dffrnq_2
* cell instance $7428 m0 *1 995.12,1128.96
X$7428 18271 18268 18386 13208 gf180mcu_fd_sc_mcu9t5v0__buf_8
* cell instance $7429 m0 *1 1001.28,1139.04
X$7429 18598 18553 18731 13464 gf180mcu_fd_sc_mcu9t5v0__buf_8
* cell instance $7430 m0 *1 1003.52,1169.28
X$7430 19411 19292 19448 19605 19291 gf180mcu_fd_sc_mcu9t5v0__nand2_1
* cell instance $7431 r0 *1 998.48,1159.2
X$7431 17247 19293 19411 13331 19448 19282 gf180mcu_fd_sc_mcu9t5v0__dffrnq_2
* cell instance $7432 r0 *1 969.36,1149.12
X$7432 18996 19171 gf180mcu_fd_sc_mcu9t5v0__filltie
* cell instance $7433 m0 *1 1005.76,1118.88
X$7433 17588 13461 16515 19863 17714 23502 17985 18104 17843
+ gf180mcu_fd_sc_mcu9t5v0__aoi222_1
* cell instance $7434 r0 *1 1004.08,1139.04
X$7434 19402 18841 18731 17247 gf180mcu_fd_sc_mcu9t5v0__clkbuf_8
* cell instance $7435 r0 *1 1032.08,1128.96
X$7435 17957 18447 18553 18386 18380 gf180mcu_fd_sc_mcu9t5v0__nand2_1
* cell instance $7436 r0 *1 995.12,1128.96
X$7436 18736 18553 18386 13461 gf180mcu_fd_sc_mcu9t5v0__buf_8
* cell instance $7437 r0 *1 1020.32,1159.2
X$7437 22443 19412 19910 19448 19282 19173 gf180mcu_fd_sc_mcu9t5v0__mux2_1
* cell instance $7438 m0 *1 980,1118.88
X$7438 18109 17989 17985 18104 17530 gf180mcu_fd_sc_mcu9t5v0__nand2_1
* cell instance $7439 m0 *1 976.64,1118.88
X$7439 18145 18270 17985 18104 17245 gf180mcu_fd_sc_mcu9t5v0__nor2_1
* cell instance $7440 r0 *1 969.36,1159.2
X$7440 19282 19448 gf180mcu_fd_sc_mcu9t5v0__filltie
* cell instance $7441 m0 *1 986.16,1139.04
X$7441 17989 18849 18553 18731 18598 gf180mcu_fd_sc_mcu9t5v0__nor2_1
* cell instance $7442 m0 *1 984.48,1128.96
X$7442 17989 18270 18268 18386 18271 gf180mcu_fd_sc_mcu9t5v0__nor2_1
* cell instance $7443 r0 *1 1024.8,1128.96
X$7443 18149 17582 13214 18553 18386 18599 gf180mcu_fd_sc_mcu9t5v0__mux2_1
* cell instance $7444 r0 *1 985.6,1139.04
X$7444 17989 18848 18841 18731 18736 gf180mcu_fd_sc_mcu9t5v0__nor2_1
* cell instance $7445 r0 *1 1028.16,1149.12
X$7445 19412 18444 19171 18996 18737 gf180mcu_fd_sc_mcu9t5v0__nor2_1
* cell instance $7446 m0 *1 1015.84,1139.04
X$7446 17247 18599 18149 13331 18553 18731 gf180mcu_fd_sc_mcu9t5v0__dffrnq_2
* cell instance $7447 m0 *1 1038.24,1149.12
X$7447 17247 18740 18741 13331 18841 18996 gf180mcu_fd_sc_mcu9t5v0__dffrnq_2
* cell instance $7448 m0 *1 1071.84,1169.28
X$7448 19610 18590 4952 3814 18614 19448 19605 19864
+ gf180mcu_fd_sc_mcu9t5v0__aoi221_1
* cell instance $7449 m0 *1 1068.48,1169.28
X$7449 19133 19292 19448 19605 19914 gf180mcu_fd_sc_mcu9t5v0__nand2_1
* cell instance $7450 r0 *1 1038.8,1159.2
X$7450 19301 19411 18277 19448 19282 19454 gf180mcu_fd_sc_mcu9t5v0__mux2_1
* cell instance $7451 m0 *1 1036.56,1169.28
X$7451 17247 19454 19301 13331 19448 19605 gf180mcu_fd_sc_mcu9t5v0__dffrnq_2
* cell instance $7452 m0 *1 1094.24,1169.28
X$7452 19574 19455 18272 19448 19605 19413 gf180mcu_fd_sc_mcu9t5v0__mux2_1
* cell instance $7453 r0 *1 1039.36,1108.8
X$7453 17531 16153 16921 17956 17985 17837 17957
+ gf180mcu_fd_sc_mcu9t5v0__aoi22_1
* cell instance $7454 m0 *1 1089.2,1169.28
X$7454 19605 19448 gf180mcu_fd_sc_mcu9t5v0__filltie
* cell instance $7455 r0 *1 1042.72,1128.96
X$7455 17247 18395 18448 13331 18553 18386 gf180mcu_fd_sc_mcu9t5v0__dffrnq_2
* cell instance $7456 r0 *1 1065.12,1149.12
X$7456 19002 19133 18277 19171 18996 19132 gf180mcu_fd_sc_mcu9t5v0__mux2_1
* cell instance $7457 m0 *1 1089.2,1128.96
X$7457 18386 18268 gf180mcu_fd_sc_mcu9t5v0__filltie
* cell instance $7458 r0 *1 1081.36,1159.2
X$7458 19174 19413 19455 13331 19448 19282 gf180mcu_fd_sc_mcu9t5v0__dffrnq_2
* cell instance $7459 m0 *1 1053.92,1159.2
X$7459 19174 19132 19002 13331 19171 19282 gf180mcu_fd_sc_mcu9t5v0__dffrnq_2
* cell instance $7460 m0 *1 1048.88,1128.96
X$7460 18448 18396 13214 18268 18386 18395 gf180mcu_fd_sc_mcu9t5v0__mux2_1
* cell instance $7461 m0 *1 1081.92,1139.04
X$7461 17586 18602 13214 18553 18731 18601 gf180mcu_fd_sc_mcu9t5v0__mux2_1
* cell instance $7462 r0 *1 1044.96,1108.8
X$7462 17718 17985 17837 13434 gf180mcu_fd_sc_mcu9t5v0__buf_8
* cell instance $7463 m0 *1 1068.48,1118.88
X$7463 18113 18112 17985 18104 17988 gf180mcu_fd_sc_mcu9t5v0__nand2_1
* cell instance $7464 m0 *1 1090.32,1139.04
X$7464 14663 18556 13024 18553 18731 13884 gf180mcu_fd_sc_mcu9t5v0__mux2_1
* cell instance $7465 r0 *1 1071.28,1118.88
X$7465 18151 16153 16921 17958 18268 18104 18113
+ gf180mcu_fd_sc_mcu9t5v0__aoi22_1
* cell instance $7466 r0 *1 1066.24,1108.8
X$7466 17958 13212 13433 18152 17531 13591 17985 17837 17994
+ gf180mcu_fd_sc_mcu9t5v0__aoi222_1
* cell instance $7467 m0 *1 1086.4,1118.88
X$7467 18150 14820 17985 18104 18114 gf180mcu_fd_sc_mcu9t5v0__nand2_1
* cell instance $7468 m0 *1 1058.96,1118.88
X$7468 17994 17992 18111 18110 17985 18104 17993
+ gf180mcu_fd_sc_mcu9t5v0__nand4_1
* cell instance $7469 m0 *1 1089.2,1118.88
X$7469 18104 17985 gf180mcu_fd_sc_mcu9t5v0__filltie
* cell instance $7470 r0 *1 1078.56,1108.8
X$7470 15275 17995 18150 13331 17985 17837 gf180mcu_fd_sc_mcu9t5v0__dffrnq_2
* cell instance $7471 r0 *1 1066.24,1118.88
X$7471 18152 14825 14865 18150 18268 18104 18112
+ gf180mcu_fd_sc_mcu9t5v0__aoi22_1
* cell instance $7472 r0 *1 1097.04,1139.04
X$7472 15869 18556 13475 18841 18731 18602 gf180mcu_fd_sc_mcu9t5v0__mux2_1
* cell instance $7473 m0 *1 1089.2,1149.12
X$7473 18996 18841 gf180mcu_fd_sc_mcu9t5v0__filltie
* cell instance $7474 m0 *1 1067.92,1149.12
X$7474 19002 18600 17977 18841 18996 18850 gf180mcu_fd_sc_mcu9t5v0__mux2_1
* cell instance $7475 r0 *1 1058.4,1118.88
X$7475 18151 13464 13434 18448 18268 18104 18111
+ gf180mcu_fd_sc_mcu9t5v0__aoi22_1
* cell instance $7476 m0 *1 1089.2,1139.04
X$7476 18731 18553 gf180mcu_fd_sc_mcu9t5v0__filltie
* cell instance $7477 m0 *1 1089.2,1159.2
X$7477 19282 19171 gf180mcu_fd_sc_mcu9t5v0__filltie
* cell instance $7478 m0 *1 1069.04,1128.96
X$7478 14310 14179 13475 18268 18386 18396 gf180mcu_fd_sc_mcu9t5v0__mux2_1
* cell instance $7479 m0 *1 1090.32,1118.88
X$7479 14820 15902 18114 17985 18104 17995 gf180mcu_fd_sc_mcu9t5v0__oai21_1
* cell instance $7480 r0 *1 1044.4,1139.04
X$7480 18741 19292 18841 18731 18738 gf180mcu_fd_sc_mcu9t5v0__nand2_1
* cell instance $7481 r0 *1 1076.32,1139.04
X$7481 19174 18601 17586 13331 18841 18731 gf180mcu_fd_sc_mcu9t5v0__dffrnq_2
* cell instance $7482 r0 *1 1057.28,1139.04
X$7482 17247 18850 18600 13331 18841 18731 gf180mcu_fd_sc_mcu9t5v0__dffrnq_2
* cell instance $7483 r0 *1 1097.04,1128.96
X$7483 18556 18604 13024 18553 18386 14307 gf180mcu_fd_sc_mcu9t5v0__mux2_1
* cell instance $7484 r0 *1 549.92,1038.24
X$7484 15734 15682 12241 15898 15737 15683 gf180mcu_fd_sc_mcu9t5v0__mux2_1
* cell instance $7485 r0 *1 550.48,1058.4
X$7485 15131 16301 16302 11958 16506 16309 gf180mcu_fd_sc_mcu9t5v0__dffrnq_2
* cell instance $7486 m0 *1 538.16,1068.48
X$7486 15131 16496 16497 11958 16506 16653 gf180mcu_fd_sc_mcu9t5v0__dffrnq_2
* cell instance $7487 r0 *1 548.24,1078.56
X$7487 15131 17282 17230 11958 17123 16956 gf180mcu_fd_sc_mcu9t5v0__dffrnq_2
* cell instance $7488 r0 *1 552.16,1088.64
X$7488 17231 17283 17227 17228 17078 17398 17289 17282
+ gf180mcu_fd_sc_mcu9t5v0__oai32_1
* cell instance $7489 r0 *1 551.6,997.92
X$7489 15131 14440 14701 11958 14708 14448 gf180mcu_fd_sc_mcu9t5v0__dffrnq_2
* cell instance $7490 r0 *1 538.72,1018.08
X$7490 15131 15133 15134 11958 15271 15138 gf180mcu_fd_sc_mcu9t5v0__dffrnq_2
* cell instance $7491 m0 *1 542.64,1038.24
X$7491 15131 15683 15734 11958 15576 15737 gf180mcu_fd_sc_mcu9t5v0__dffrnq_2
* cell instance $7492 m0 *1 546,1028.16
X$7492 15134 15391 12241 15271 15402 15133 gf180mcu_fd_sc_mcu9t5v0__mux2_1
* cell instance $7493 m0 *1 550.48,947.52
X$7493 10448 12882 12777 11958 13054 13160 gf180mcu_fd_sc_mcu9t5v0__dffrnq_2
* cell instance $7494 m0 *1 543.2,927.36
X$7494 10448 12606 12608 11958 12508 12646 gf180mcu_fd_sc_mcu9t5v0__dffrnq_2
* cell instance $7495 m0 *1 549.36,907.2
X$7495 10448 11859 12001 11958 11971 12019 gf180mcu_fd_sc_mcu9t5v0__dffrnq_2
* cell instance $7496 m45 *1 0,505
X$7496 2980 33813 33811 33809 33807 33805 33803 33801 33799 33797 33795 33793
+ 33791 33789 33787 33785 33783 33781 33779 33777 33775 33773 33771 33769 33767
+ 33765 33763 33761 33759 33757 33755 33753 33751 33749 33747 33745 33743 33741
+ 33739 33737 33735 33733 33731 33729 33727 33725 33723 33721 33719 33717 33715
+ 33713 33711 33709 33707 33705 33703 33701 33699 33697 33695 33693 33691 33689
+ 33687 33685 33683 33681 33679 33677 33675 33673 33671 2242 33669 33667 33665
+ 33663 33661 33659 2242 2981 gf180mcu_fd_io__in_c
* cell instance $7497 m0 *1 370.16,554.4
X$7497 3227 3215 gf180mcu_fd_sc_mcu9t5v0__endcap
* cell instance $7498 m0 *1 972.16,554.4
X$7498 3232 2990 3233 3215 3227 3231 gf180mcu_fd_sc_mcu9t5v0__mux2_1
* cell instance $7499 m0 *1 1090.32,554.4
X$7499 3346 3237 2891 3215 3227 3112 gf180mcu_fd_sc_mcu9t5v0__mux2_1
* cell instance $7500 m0 *1 1043.84,554.4
X$7500 2884 2367 2677 2998 3337 3109 3215 3227 3236
+ gf180mcu_fd_sc_mcu9t5v0__mux4_1
* cell instance $7501 m0 *1 1089.2,554.4
X$7501 3227 3215 gf180mcu_fd_sc_mcu9t5v0__filltie
* cell instance $7502 m0 *1 1012.48,554.4
X$7502 3235 3108 2891 3215 3227 2991 gf180mcu_fd_sc_mcu9t5v0__mux2_1
* cell instance $7503 m0 *1 1019.76,554.4
X$7503 3235 3108 2251 2785 2987 3106 3215 3227 3234
+ gf180mcu_fd_sc_mcu9t5v0__mux4_1
* cell instance $7504 m0 *1 853.44,554.4
X$7504 3230 3229 2986 3215 3227 3228 gf180mcu_fd_sc_mcu9t5v0__mux2_1
* cell instance $7505 m0 *1 861.28,554.4
X$7505 2776 3216 3099 3215 3227 gf180mcu_fd_sc_mcu9t5v0__dffq_2
* cell instance $7506 m0 *1 900.48,554.4
X$7506 2776 3219 2985 3215 3227 gf180mcu_fd_sc_mcu9t5v0__dffq_2
* cell instance $7507 m0 *1 925.68,554.4
X$7507 3679 3215 3227 3109 gf180mcu_fd_sc_mcu9t5v0__buf_8
* cell instance $7508 m0 *1 849.52,554.4
X$7508 3227 3215 gf180mcu_fd_sc_mcu9t5v0__filltie
* cell instance $7509 m0 *1 609.84,554.4
X$7509 3227 3215 gf180mcu_fd_sc_mcu9t5v0__filltie
* cell instance $7510 m0 *1 827.68,1038.24
X$7510 16142 15580 15526 13331 15576 15737 gf180mcu_fd_sc_mcu9t5v0__dffrnq_2
* cell instance $7511 m0 *1 827.68,1058.4
X$7511 16142 16147 16148 13331 16194 16309 gf180mcu_fd_sc_mcu9t5v0__dffrnq_2
* cell instance $7512 r0 *1 840,826.56
X$7512 10306 10079 11562 10188 10078 gf180mcu_fd_sc_mcu9t5v0__dffq_2
* cell instance $7513 m0 *1 826,977.76
X$7513 13831 13877 13835 13331 13832 14009 gf180mcu_fd_sc_mcu9t5v0__dffrnq_2
* cell instance $7514 r0 *1 826.56,1098.72
X$7514 16142 17523 16958 13331 17709 17521 gf180mcu_fd_sc_mcu9t5v0__dffrnq_2
* cell instance $7515 r0 *1 812,1078.56
X$7515 16142 17083 17239 13331 17123 16956 gf180mcu_fd_sc_mcu9t5v0__dffrnq_2
* cell instance $7516 r0 *1 825.44,1018.08
X$7516 15010 15577 12898 15271 15138 15009 gf180mcu_fd_sc_mcu9t5v0__mux2_1
* cell instance $7517 m0 *1 823.2,1018.08
X$7517 13831 15009 15010 13331 14967 15138 gf180mcu_fd_sc_mcu9t5v0__dffrnq_2
* cell instance $7518 r0 *1 813.12,1008
X$7518 13831 14858 14813 13331 14967 14857 gf180mcu_fd_sc_mcu9t5v0__dffrnq_2
* cell instance $7519 r0 *1 818.16,907.2
X$7519 11563 11721 11975 10679 2987 3106 12128 12019 12388
+ gf180mcu_fd_sc_mcu9t5v0__mux4_1
* cell instance $7520 r0 *1 821.52,957.6
X$7520 13720 13314 13197 13586 13428 13446 gf180mcu_fd_sc_mcu9t5v0__mux2_1
* cell instance $7521 r0 *1 823.76,937.44
X$7521 12748 13162 13197 13054 12900 12902 gf180mcu_fd_sc_mcu9t5v0__mux2_1
* cell instance $7522 m0 *1 822.08,947.52
X$7522 13159 13162 13427 13054 13160 13161 gf180mcu_fd_sc_mcu9t5v0__mux2_1
* cell instance $7523 r0 *1 814.24,947.52
X$7523 12018 13161 13162 13331 13318 13160 gf180mcu_fd_sc_mcu9t5v0__dffrnq_2
* cell instance $7524 m0 *1 828.24,856.8
X$7524 10573 10683 10457 10676 10714 10572 gf180mcu_fd_sc_mcu9t5v0__mux2_1
* cell instance $7525 r0 *1 823.76,876.96
X$7525 10040 4765 4949 9441 11464 2983 11461 11294 11340
+ gf180mcu_fd_sc_mcu9t5v0__aoi222_1
* cell instance $7526 r0 *1 824.32,846.72
X$7526 10306 10572 10683 10676 10570 gf180mcu_fd_sc_mcu9t5v0__dffq_2
* cell instance $7527 m0 *1 814.8,866.88
X$7527 12018 10837 10684 10833 11079 gf180mcu_fd_sc_mcu9t5v0__dffq_2
* cell instance $7528 r0 *1 827.68,715.68
X$7528 7197 7196 7074 6942 2987 3106 7316 7195 7323
+ gf180mcu_fd_sc_mcu9t5v0__mux4_1
* cell instance $7529 r0 *1 716.8,826.56
X$7529 4529 4497 10188 10078 10186 gf180mcu_fd_sc_mcu9t5v0__nand2_1
* cell instance $7530 r0 *1 777.28,826.56
X$7530 10077 10305 2573 10188 10078 10190 gf180mcu_fd_sc_mcu9t5v0__mux2_2
* cell instance $7531 r0 *1 823.2,826.56
X$7531 10306 10039 10040 10188 10078 gf180mcu_fd_sc_mcu9t5v0__dffq_2
* cell instance $7532 r0 *1 799.68,826.56
X$7532 9204 8816 2564 10188 10078 10191 gf180mcu_fd_sc_mcu9t5v0__mux2_2
* cell instance $7533 r0 *1 809.76,826.56
X$7533 9844 10038 4024 10188 10078 10037 gf180mcu_fd_sc_mcu9t5v0__mux2_1
* cell instance $7534 m0 *1 812,806.4
X$7534 9574 9693 9543 9542 6775 3121 9432 9575 9317
+ gf180mcu_fd_sc_mcu9t5v0__mux4_1
* cell instance $7535 m0 *1 827.12,826.56
X$7535 10041 10040 2573 9841 10078 10039 gf180mcu_fd_sc_mcu9t5v0__mux2_2
* cell instance $7536 r0 *1 824.88,806.4
X$7536 9543 9542 9574 9693 2987 3106 9691 9575 9576
+ gf180mcu_fd_sc_mcu9t5v0__mux4_1
* cell instance $7537 r0 *1 738.08,826.56
X$7537 10074 10075 10035 10188 10078 gf180mcu_fd_sc_mcu9t5v0__dffq_2
* cell instance $7538 r0 *1 756,826.56
X$7538 10074 10076 9843 10188 10078 gf180mcu_fd_sc_mcu9t5v0__dffq_2
* cell instance $7539 r0 *1 719.6,826.56
X$7539 3103 2992 10186 10188 10078 8579 gf180mcu_fd_sc_mcu9t5v0__nor3_1
* cell instance $7540 r0 *1 729.68,826.56
X$7540 10078 10188 gf180mcu_fd_sc_mcu9t5v0__filltie
* cell instance $7541 m0 *1 823.2,756
X$7541 8083 8205 2891 8078 8204 8545 gf180mcu_fd_sc_mcu9t5v0__mux2_1
* cell instance $7542 m0 *1 817.04,776.16
X$7542 8696 8318 8695 8698 6775 3679 8693 8818 8819
+ gf180mcu_fd_sc_mcu9t5v0__mux4_1
* cell instance $7543 r0 *1 824.32,745.92
X$7543 8203 8082 8083 8205 6775 3679 8078 7948 8084
+ gf180mcu_fd_sc_mcu9t5v0__mux4_1
* cell instance $7544 m0 *1 812.56,735.84
X$7544 7194 7554 7783 7673 6775 3679 7671 7814 7784
+ gf180mcu_fd_sc_mcu9t5v0__mux4_1
* cell instance $7545 r0 *1 823.2,725.76
X$7545 7198 7784 4764 7671 7558 7675 gf180mcu_fd_sc_mcu9t5v0__mux2_1
* cell instance $7546 r0 *1 826.56,766.08
X$7546 8084 8819 4764 8693 8582 8699 gf180mcu_fd_sc_mcu9t5v0__mux2_1
* cell instance $7547 r0 *1 655.2,826.56
X$7547 10183 10182 9837 4900 10188 10078 10184 gf180mcu_fd_sc_mcu9t5v0__oai211_1
* cell instance $7548 r0 *1 697.76,826.56
X$7548 9112 10185 4923 10188 10078 10303 gf180mcu_fd_sc_mcu9t5v0__mux2_1
* cell instance $7549 r0 *1 613.76,826.56
X$7549 10180 10188 10078 2880 gf180mcu_fd_sc_mcu9t5v0__buf_8
* cell instance $7550 r0 *1 635.04,826.56
X$7550 8197 10071 10072 10188 10078 gf180mcu_fd_sc_mcu9t5v0__dffq_2
* cell instance $7551 m0 *1 818.16,715.68
X$7551 7074 6942 7197 7196 6775 3679 7071 7195 7198
+ gf180mcu_fd_sc_mcu9t5v0__mux4_1
* cell instance $7552 r0 *1 823.2,665.28
X$7552 6256 6147 2891 6144 6034 6255 gf180mcu_fd_sc_mcu9t5v0__mux2_1
* cell instance $7553 m0 *1 825.44,675.36
X$7553 6018 6293 6256 6147 6775 3679 6144 6292 6257
+ gf180mcu_fd_sc_mcu9t5v0__mux4_1
* cell instance $7554 m0 *1 827.68,695.52
X$7554 6807 6666 6252 6774 6775 3679 6664 6805 6776
+ gf180mcu_fd_sc_mcu9t5v0__mux4_1
* cell instance $7555 r0 *1 816.48,695.52
X$7555 6252 6774 6807 6666 2987 3106 6909 6805 6911
+ gf180mcu_fd_sc_mcu9t5v0__mux4_1
* cell instance $7556 m0 *1 827.12,624.96
X$7556 4933 4932 2573 4903 5056 4931 gf180mcu_fd_sc_mcu9t5v0__mux2_2
* cell instance $7557 r0 *1 818.16,624.96
X$7557 3808 5183 5056 3559 gf180mcu_fd_sc_mcu9t5v0__clkbuf_8
* cell instance $7558 m0 *1 822.08,635.04
X$7558 3559 4931 4932 5183 5297 gf180mcu_fd_sc_mcu9t5v0__dffq_2
* cell instance $7559 m0 *1 827.68,604.8
X$7559 4486 4488 3911 4022 2987 3106 4389 4512 4515
+ gf180mcu_fd_sc_mcu9t5v0__mux4_1
* cell instance $7560 r0 *1 827.12,594.72
X$7560 3911 2786 4389 4266 4390 gf180mcu_fd_sc_mcu9t5v0__nand2_1
* cell instance $7561 r0 *1 970.48,826.56
X$7561 10197 6261 6042 10188 10078 10198 gf180mcu_fd_sc_mcu9t5v0__and3_1
* cell instance $7562 r0 *1 1033.2,826.56
X$7562 10204 10188 10078 6022 gf180mcu_fd_sc_mcu9t5v0__clkbuf_8
* cell instance $7563 r0 *1 1070.16,826.56
X$7563 8974 10083 5667 10188 10078 9857 10084 gf180mcu_fd_sc_mcu9t5v0__aoi22_4
* cell instance $7564 r0 *1 984.48,826.56
X$7564 5911 10188 10078 4024 gf180mcu_fd_sc_mcu9t5v0__buf_8
* cell instance $7565 r0 *1 1019.2,826.56
X$7565 10201 10202 10199 10188 10078 9581 gf180mcu_fd_sc_mcu9t5v0__nor3_1
* cell instance $7566 r0 *1 1013.6,826.56
X$7566 10201 10199 10188 10078 10083 gf180mcu_fd_sc_mcu9t5v0__nor2_2
* cell instance $7567 r0 *1 969.36,826.56
X$7567 10078 10188 gf180mcu_fd_sc_mcu9t5v0__filltie
* cell instance $7568 r0 *1 967.12,826.56
X$7568 10339 10188 10078 10197 gf180mcu_fd_sc_mcu9t5v0__clkinv_1
* cell instance $7569 r0 *1 952,826.56
X$7569 10194 6557 7685 6669 10188 10078 9851 gf180mcu_fd_sc_mcu9t5v0__oai31_1
* cell instance $7570 r0 *1 942.48,826.56
X$7570 10194 10688 5767 10188 10078 10196 gf180mcu_fd_sc_mcu9t5v0__and3_1
* cell instance $7571 r0 *1 935.2,826.56
X$7571 10315 10342 8706 10188 10078 10195 gf180mcu_fd_sc_mcu9t5v0__mux2_1
* cell instance $7572 r0 *1 884.8,826.56
X$7572 3103 10192 10082 4930 10188 10078 10183 gf180mcu_fd_sc_mcu9t5v0__aoi211_1
* cell instance $7573 r0 *1 860.16,826.56
X$7573 10306 10080 11721 10188 10078 gf180mcu_fd_sc_mcu9t5v0__dffq_2
* cell instance $7574 m0 *1 828.24,574.56
X$7574 3801 3800 3678 3799 2987 3106 3558 3781 3909
+ gf180mcu_fd_sc_mcu9t5v0__mux4_1
* cell instance $7575 m0 *1 822.08,564.48
X$7575 4247 3678 3446 3334 3444 3445 gf180mcu_fd_sc_mcu9t5v0__mux2_1
* cell instance $7576 r0 *1 818.16,564.48
X$7576 3559 3445 3678 3558 3444 gf180mcu_fd_sc_mcu9t5v0__dffq_2
* cell instance $7577 m0 *1 967.12,967.68
X$7577 13325 13586 13719 12260 gf180mcu_fd_sc_mcu9t5v0__clkbuf_8
* cell instance $7578 m0 *1 964.88,977.76
X$7578 13884 12789 13885 13832 14009 8589 gf180mcu_fd_sc_mcu9t5v0__oai21_1
* cell instance $7579 r0 *1 952.56,1038.24
X$7579 15697 15898 15737 4545 gf180mcu_fd_sc_mcu9t5v0__buf_8
* cell instance $7580 m0 *1 964.88,1068.48
X$7580 12904 4258 16515 16661 16506 16653 16450
+ gf180mcu_fd_sc_mcu9t5v0__oai211_1
* cell instance $7581 r0 *1 962.08,1058.4
X$7581 11835 4254 11983 16506 16309 16514 gf180mcu_fd_sc_mcu9t5v0__mux2_1
* cell instance $7582 m0 *1 962.64,1058.4
X$7582 16314 16198 16154 16194 16309 15740 gf180mcu_fd_sc_mcu9t5v0__nor3_1
* cell instance $7583 m0 *1 959.84,1038.24
X$7583 15698 15576 15737 4258 gf180mcu_fd_sc_mcu9t5v0__buf_8
* cell instance $7584 r0 *1 964.88,987.84
X$7584 14307 12789 14415 14406 14304 10690 gf180mcu_fd_sc_mcu9t5v0__oai21_1
* cell instance $7585 r0 *1 964.88,997.92
X$7585 14654 14653 14656 14708 14448 13839 gf180mcu_fd_sc_mcu9t5v0__nor3_1
* cell instance $7586 r0 *1 950.32,1008
X$7586 14975 14977 14656 13331 14967 14857 gf180mcu_fd_sc_mcu9t5v0__dffrnq_2
* cell instance $7587 r0 *1 959.84,927.36
X$7587 12625 12750 11986 12649 12785 12646 12751
+ gf180mcu_fd_sc_mcu9t5v0__aoi211_2
* cell instance $7588 m0 *1 955.92,937.44
X$7588 12393 12260 13203 12785 12900 12903 gf180mcu_fd_sc_mcu9t5v0__nor3_4
* cell instance $7589 m0 *1 963.2,927.36
X$7589 11835 12515 12625 12508 12646 12394 gf180mcu_fd_sc_mcu9t5v0__mux2_2
* cell instance $7590 r0 *1 963.76,937.44
X$7590 12625 13014 13016 12649 13054 12900 12787
+ gf180mcu_fd_sc_mcu9t5v0__aoi211_1
* cell instance $7591 m0 *1 931.28,967.68
X$7591 13167 13721 13586 13719 13725 gf180mcu_fd_sc_mcu9t5v0__or2_1
* cell instance $7592 m0 *1 849.52,967.68
X$7592 13719 13586 gf180mcu_fd_sc_mcu9t5v0__filltie
* cell instance $7593 m0 *1 879.2,967.68
X$7593 4908 12390 13586 13719 13724 gf180mcu_fd_sc_mcu9t5v0__nor2_1
* cell instance $7594 m0 *1 882.56,967.68
X$7594 13723 13692 13197 13586 13719 13450 gf180mcu_fd_sc_mcu9t5v0__mux2_1
* cell instance $7595 m0 *1 870.8,967.68
X$7595 13723 13692 12898 13586 13719 13722 gf180mcu_fd_sc_mcu9t5v0__mux2_1
* cell instance $7596 r0 *1 950.32,856.8
X$7596 9816 10719 10721 10833 10714 gf180mcu_fd_sc_mcu9t5v0__dffq_2
* cell instance $7597 r0 *1 964.88,846.72
X$7597 6919 6916 10690 10676 10570 10966 gf180mcu_fd_sc_mcu9t5v0__aoi21_1
* cell instance $7598 r0 *1 953.68,897.12
X$7598 11981 11971 11860 11982 gf180mcu_fd_sc_mcu9t5v0__buf_8
* cell instance $7599 m0 *1 962.64,887.04
X$7599 6399 11350 11352 11461 11600 11300 gf180mcu_fd_sc_mcu9t5v0__aoi21_1
* cell instance $7600 m0 *1 963.2,856.8
X$7600 9816 10676 10714 gf180mcu_fd_sc_mcu9t5v0__inv_3
* cell instance $7601 r0 *1 962.64,876.96
X$7601 11351 6261 6042 11461 11294 11352 gf180mcu_fd_sc_mcu9t5v0__and3_1
* cell instance $7602 m0 *1 1067.36,967.68
X$7602 13170 14015 13475 13586 13719 13455 gf180mcu_fd_sc_mcu9t5v0__mux2_1
* cell instance $7603 m0 *1 1089.2,967.68
X$7603 13719 13586 gf180mcu_fd_sc_mcu9t5v0__filltie
* cell instance $7604 m0 *1 1093.68,967.68
X$7604 13480 13693 13475 13586 13719 13457 gf180mcu_fd_sc_mcu9t5v0__mux2_1
* cell instance $7605 m0 *1 1003.52,967.68
X$7605 13726 13586 13719 11572 gf180mcu_fd_sc_mcu9t5v0__buf_8
* cell instance $7606 m0 *1 987.84,967.68
X$7606 13169 13586 13719 14129 gf180mcu_fd_sc_mcu9t5v0__buf_8
* cell instance $7607 m0 *1 959.28,876.96
X$7607 9816 11300 11565 11181 11294 gf180mcu_fd_sc_mcu9t5v0__dffq_2
* cell instance $7608 m0 *1 964.32,836.64
X$7608 9816 10316 10339 10188 10308 gf180mcu_fd_sc_mcu9t5v0__dffq_2
* cell instance $7609 m0 *1 964.88,957.6
X$7609 13325 13318 13428 13204 gf180mcu_fd_sc_mcu9t5v0__buf_8
* cell instance $7610 m0 *1 955.92,1018.08
X$7610 15014 14967 15138 2987 gf180mcu_fd_sc_mcu9t5v0__buf_20
* cell instance $7611 m0 *1 1031.52,1048.32
X$7611 13484 13897 13475 15898 16008 17582 gf180mcu_fd_sc_mcu9t5v0__mux2_1
* cell instance $7612 m0 *1 1018.08,1088.64
X$7612 17247 17128 16668 13331 17123 17289 gf180mcu_fd_sc_mcu9t5v0__dffrnq_2
* cell instance $7613 r0 *1 1034.32,1058.4
X$7613 14820 16451 16452 16506 16309 16520 gf180mcu_fd_sc_mcu9t5v0__oai21_1
* cell instance $7614 m0 *1 997.36,1038.24
X$7614 14975 15699 15741 13331 15576 15737 gf180mcu_fd_sc_mcu9t5v0__dffrnq_2
* cell instance $7615 m0 *1 978.32,1038.24
X$7615 14975 15585 15532 13331 15576 15737 gf180mcu_fd_sc_mcu9t5v0__dffrnq_2
* cell instance $7616 m0 *1 1022,1008
X$7616 14815 14708 14857 4275 gf180mcu_fd_sc_mcu9t5v0__buf_8
* cell instance $7617 r0 *1 1033.76,1018.08
X$7617 15277 14820 15271 15138 15146 gf180mcu_fd_sc_mcu9t5v0__nand2_1
* cell instance $7618 m0 *1 1062.32,1038.24
X$7618 5901 15576 15737 15275 gf180mcu_fd_sc_mcu9t5v0__clkbuf_8
* cell instance $7619 m0 *1 1043.28,1038.24
X$7619 13020 13475 15534 15576 15737 15700 gf180mcu_fd_sc_mcu9t5v0__aoi21_1
* cell instance $7620 m0 *1 1089.2,1038.24
X$7620 15737 15576 gf180mcu_fd_sc_mcu9t5v0__filltie
* cell instance $7621 m0 *1 1076.88,1038.24
X$7621 15901 14820 15576 15737 15743 gf180mcu_fd_sc_mcu9t5v0__nand2_1
* cell instance $7622 m0 *1 1032.64,977.76
X$7622 13897 13888 13024 13832 14009 2365 gf180mcu_fd_sc_mcu9t5v0__mux2_1
* cell instance $7623 m0 *1 1023.12,1028.16
X$7623 15275 15276 15277 13331 15271 15402 gf180mcu_fd_sc_mcu9t5v0__dffrnq_2
* cell instance $7624 m0 *1 1028.16,1068.48
X$7624 15275 16520 16794 13331 16506 16653 gf180mcu_fd_sc_mcu9t5v0__dffrnq_2
* cell instance $7625 r0 *1 1034.88,1098.72
X$7625 13059 14131 13475 17709 17521 17717 gf180mcu_fd_sc_mcu9t5v0__mux2_1
* cell instance $7626 r0 *1 1033.76,1048.32
X$7626 13020 14132 13475 16194 16008 16151 gf180mcu_fd_sc_mcu9t5v0__mux2_1
* cell instance $7627 r0 *1 1034.88,977.76
X$7627 14131 14132 13024 14126 14009 6146 gf180mcu_fd_sc_mcu9t5v0__mux2_1
* cell instance $7628 m0 *1 1089.2,1068.48
X$7628 16653 16506 gf180mcu_fd_sc_mcu9t5v0__filltie
* cell instance $7629 m0 *1 1066.8,1098.72
X$7629 17531 17405 13214 17398 17521 17584 gf180mcu_fd_sc_mcu9t5v0__mux2_1
* cell instance $7630 r0 *1 1052.8,1088.64
X$7630 16920 14820 17398 17289 17295 gf180mcu_fd_sc_mcu9t5v0__nand2_1
* cell instance $7631 m0 *1 1074.08,1088.64
X$7631 14310 13475 15744 17123 17289 17088 gf180mcu_fd_sc_mcu9t5v0__aoi21_1
* cell instance $7632 r0 *1 1036,1068.48
X$7632 16794 14820 16784 16653 16452 gf180mcu_fd_sc_mcu9t5v0__nand2_1
* cell instance $7633 m0 *1 1084.16,1088.64
X$7633 17585 13465 13591 16971 17123 17289 16457
+ gf180mcu_fd_sc_mcu9t5v0__aoi22_1
* cell instance $7634 r0 *1 1075.76,1058.4
X$7634 16455 13212 13433 15901 16506 16309 16456
+ gf180mcu_fd_sc_mcu9t5v0__aoi22_1
* cell instance $7635 m0 *1 1083.04,1068.48
X$7635 16158 13208 13461 15542 16318 16506 16653 16524
+ gf180mcu_fd_sc_mcu9t5v0__aoi221_1
* cell instance $7636 r0 *1 1083.6,1058.4
X$7636 16457 16456 16524 16506 16309 16669 gf180mcu_fd_sc_mcu9t5v0__nand3_1
* cell instance $7637 r0 *1 1083.6,1068.48
X$7637 14189 16669 16784 16653 16523 gf180mcu_fd_sc_mcu9t5v0__nand2_1
* cell instance $7638 m0 *1 1078,1068.48
X$7638 16523 16662 16516 14979 16506 16653 16317
+ gf180mcu_fd_sc_mcu9t5v0__nand4_1
* cell instance $7639 m0 *1 1083.04,1058.4
X$7639 13464 16157 16318 13884 16317 16194 16309 14453
+ gf180mcu_fd_sc_mcu9t5v0__aoi221_1
* cell instance $7640 m0 *1 1089.2,1088.64
X$7640 17289 17123 gf180mcu_fd_sc_mcu9t5v0__filltie
* cell instance $7641 r0 *1 1098.72,1068.48
X$7641 14189 14711 16784 16653 16797 gf180mcu_fd_sc_mcu9t5v0__nor2_1
* cell instance $7642 m0 *1 1066.24,1048.32
X$7642 15275 15861 15901 13331 15898 16008 gf180mcu_fd_sc_mcu9t5v0__dffrnq_2
* cell instance $7643 m0 *1 1047.2,1048.32
X$7643 15742 14820 15898 16008 15860 gf180mcu_fd_sc_mcu9t5v0__nand2_1
* cell instance $7644 m0 *1 1089.2,1098.72
X$7644 17521 17398 gf180mcu_fd_sc_mcu9t5v0__filltie
* cell instance $7645 r0 *1 1042.16,1038.24
X$7645 14820 15700 15860 15898 15737 15859 gf180mcu_fd_sc_mcu9t5v0__oai21_1
* cell instance $7646 r0 *1 1077.44,1038.24
X$7646 15406 13475 15744 15898 15737 15862 gf180mcu_fd_sc_mcu9t5v0__aoi21_1
* cell instance $7647 r0 *1 1072.96,1038.24
X$7647 14820 15862 15743 15898 15737 15861 gf180mcu_fd_sc_mcu9t5v0__oai21_1
* cell instance $7648 r0 *1 1093.68,1038.24
X$7648 14820 15586 15864 15898 15737 15863 gf180mcu_fd_sc_mcu9t5v0__oai21_1
* cell instance $7649 m0 *1 1056.72,1058.4
X$7649 13170 13475 15534 16194 16309 16316 gf180mcu_fd_sc_mcu9t5v0__aoi21_1
* cell instance $7650 m0 *1 1058.96,1068.48
X$7650 16455 14820 16506 16653 16521 gf180mcu_fd_sc_mcu9t5v0__nand2_1
* cell instance $7651 m0 *1 1054.48,1068.48
X$7651 14820 16316 16521 16506 16653 16454 gf180mcu_fd_sc_mcu9t5v0__oai21_1
* cell instance $7652 r0 *1 1049.44,1078.56
X$7652 13171 13475 15534 17123 16956 17404 gf180mcu_fd_sc_mcu9t5v0__aoi21_1
* cell instance $7653 r0 *1 1038.8,1058.4
X$7653 13895 4489 16506 16309 16453 gf180mcu_fd_sc_mcu9t5v0__nand2_1
* cell instance $7654 m0 *1 1089.2,1058.4
X$7654 16309 16194 gf180mcu_fd_sc_mcu9t5v0__filltie
* cell instance $7655 r0 *1 1046.64,1038.24
X$7655 15275 15859 15742 13331 15898 15737 gf180mcu_fd_sc_mcu9t5v0__dffrnq_2
* cell instance $7656 m0 *1 1037.12,1088.64
X$7656 13059 13475 15534 17123 17289 17129 gf180mcu_fd_sc_mcu9t5v0__aoi21_1
* cell instance $7657 r0 *1 1047.76,1088.64
X$7657 14820 17404 17295 17398 17289 17248 gf180mcu_fd_sc_mcu9t5v0__oai21_1
* cell instance $7658 m0 *1 1089.2,1048.32
X$7658 16008 15898 gf180mcu_fd_sc_mcu9t5v0__filltie
* cell instance $7659 r0 *1 1059.52,1098.72
X$7659 17247 17584 17531 13331 17709 17521 gf180mcu_fd_sc_mcu9t5v0__dffrnq_2
* cell instance $7660 m0 *1 1089.2,1078.56
X$7660 16956 16784 gf180mcu_fd_sc_mcu9t5v0__filltie
* cell instance $7661 m0 *1 1041.6,1088.64
X$7661 17247 17248 16920 13331 17123 17289 gf180mcu_fd_sc_mcu9t5v0__dffrnq_2
* cell instance $7662 r0 *1 1063.44,1068.48
X$7662 13895 7454 16784 16653 16795 gf180mcu_fd_sc_mcu9t5v0__nand2_1
* cell instance $7663 m0 *1 1094.8,1098.72
X$7663 17585 17533 13214 17398 17521 17587 gf180mcu_fd_sc_mcu9t5v0__mux2_1
* cell instance $7664 r0 *1 1070.72,1058.4
X$7664 15901 14825 16921 16455 16506 16309 16522
+ gf180mcu_fd_sc_mcu9t5v0__aoi22_1
* cell instance $7665 r0 *1 1067.92,1058.4
X$7665 16522 16156 16506 16309 16507 gf180mcu_fd_sc_mcu9t5v0__nand2_1
* cell instance $7666 r0 *1 1067.36,1078.56
X$7666 16970 16153 16921 16920 17123 16956 17090
+ gf180mcu_fd_sc_mcu9t5v0__aoi22_1
* cell instance $7667 m0 *1 1069.04,1088.64
X$7667 17090 17130 17123 17289 17238 gf180mcu_fd_sc_mcu9t5v0__nand2_1
* cell instance $7668 r0 *1 1081.36,1098.72
X$7668 17586 14825 16921 17585 17709 17521 17532
+ gf180mcu_fd_sc_mcu9t5v0__aoi22_1
* cell instance $7669 r0 *1 1084.72,1078.56
X$7669 16971 16153 14865 15542 17123 16956 17249
+ gf180mcu_fd_sc_mcu9t5v0__aoi22_1
* cell instance $7670 m0 *1 1084.16,1098.72
X$7670 17532 17249 17398 17521 17515 gf180mcu_fd_sc_mcu9t5v0__nand2_1
* cell instance $7671 m0 *1 1057.28,1078.56
X$7671 13895 16920 13212 16795 16784 16956 16968
+ gf180mcu_fd_sc_mcu9t5v0__oai211_1
* cell instance $7672 r0 *1 1095.92,1048.32
X$7672 16158 14820 16194 16008 15864 gf180mcu_fd_sc_mcu9t5v0__nand2_1
* cell instance $7673 r0 *1 1048.32,1058.4
X$7673 15275 16454 16455 13331 16506 16309 gf180mcu_fd_sc_mcu9t5v0__dffrnq_2
* cell instance $7674 m0 *1 1066.24,1078.56
X$7674 16796 16969 16966 13904 16784 16956 17522
+ gf180mcu_fd_sc_mcu9t5v0__oai31_1
* cell instance $7675 r0 *1 1046.08,1098.72
X$7675 17578 17990 17583 17709 17521 16318 gf180mcu_fd_sc_mcu9t5v0__nor3_1
* cell instance $7676 r0 *1 1025.92,1088.64
X$7676 16668 14820 17398 17289 17089 gf180mcu_fd_sc_mcu9t5v0__nand2_1
* cell instance $7677 m0 *1 1013.6,1068.48
X$7677 16519 16667 16506 16653 16508 gf180mcu_fd_sc_mcu9t5v0__nand2_1
* cell instance $7678 r0 *1 969.36,1038.24
X$7678 15737 15898 gf180mcu_fd_sc_mcu9t5v0__filltie
* cell instance $7679 r0 *1 970.48,1098.72
X$7679 17578 17579 17709 17521 17126 gf180mcu_fd_sc_mcu9t5v0__or2_1
* cell instance $7680 r0 *1 969.36,1068.48
X$7680 16653 16784 gf180mcu_fd_sc_mcu9t5v0__filltie
* cell instance $7681 m0 *1 1001.28,1058.4
X$7681 16199 13208 13591 15532 13895 16194 16309 16315
+ gf180mcu_fd_sc_mcu9t5v0__aoi221_1
* cell instance $7682 r0 *1 1024.8,1078.56
X$7682 14820 17129 17089 17123 16956 17128 gf180mcu_fd_sc_mcu9t5v0__oai21_1
* cell instance $7683 r0 *1 983.36,1048.32
X$7683 16152 16151 13214 16194 16008 16150 gf180mcu_fd_sc_mcu9t5v0__mux2_1
* cell instance $7684 r0 *1 969.36,1058.4
X$7684 16309 16506 gf180mcu_fd_sc_mcu9t5v0__filltie
* cell instance $7685 r0 *1 969.36,1078.56
X$7685 16956 17123 gf180mcu_fd_sc_mcu9t5v0__filltie
* cell instance $7686 r0 *1 969.36,1088.64
X$7686 17289 17398 gf180mcu_fd_sc_mcu9t5v0__filltie
* cell instance $7687 r0 *1 969.36,1098.72
X$7687 17521 17709 gf180mcu_fd_sc_mcu9t5v0__filltie
* cell instance $7688 r0 *1 969.36,1048.32
X$7688 16008 16194 gf180mcu_fd_sc_mcu9t5v0__filltie
* cell instance $7689 r0 *1 972.72,1058.4
X$7689 16450 16506 16309 15274 gf180mcu_fd_sc_mcu9t5v0__clkinv_1
* cell instance $7690 m0 *1 967.12,1088.64
X$7690 9090 17245 17127 23320 17244 17123 17289 14416
+ gf180mcu_fd_sc_mcu9t5v0__aoi221_1
* cell instance $7691 m0 *1 971.04,1098.72
X$7691 13895 17529 17990 17398 17521 17127 gf180mcu_fd_sc_mcu9t5v0__nor3_1
* cell instance $7692 r0 *1 993.44,1098.72
X$7692 17581 17709 17521 13433 gf180mcu_fd_sc_mcu9t5v0__buf_8
* cell instance $7693 r0 *1 1008,1098.72
X$7693 17715 17709 17521 13212 gf180mcu_fd_sc_mcu9t5v0__buf_8
* cell instance $7694 m0 *1 994.56,1088.64
X$7694 14975 17246 16793 13331 17123 17289 gf180mcu_fd_sc_mcu9t5v0__dffrnq_2
* cell instance $7695 r0 *1 1005.76,1088.64
X$7695 16793 14820 17398 17289 16967 gf180mcu_fd_sc_mcu9t5v0__nand2_1
* cell instance $7696 r0 *1 1002.4,1078.56
X$7696 14820 17088 16967 17123 16956 17246 gf180mcu_fd_sc_mcu9t5v0__oai21_1
* cell instance $7697 r0 *1 990.64,1048.32
X$7697 15532 16153 16921 16152 16194 16008 16015
+ gf180mcu_fd_sc_mcu9t5v0__aoi22_1
* cell instance $7698 m0 *1 1004.64,1068.48
X$7698 16518 16666 16665 16315 16506 16653 14861
+ gf180mcu_fd_sc_mcu9t5v0__nand4_1
* cell instance $7699 m0 *1 1027.04,1048.32
X$7699 13484 13475 15147 15898 16008 16017 gf180mcu_fd_sc_mcu9t5v0__aoi21_1
* cell instance $7700 m0 *1 1002.4,1048.32
X$7700 14417 14825 14865 15741 15898 16008 16014
+ gf180mcu_fd_sc_mcu9t5v0__aoi22_1
* cell instance $7701 m0 *1 988.96,1048.32
X$7701 16015 16014 15898 16008 16007 gf180mcu_fd_sc_mcu9t5v0__nand2_1
* cell instance $7702 r0 *1 990.08,1098.72
X$7702 17578 17579 17709 17521 17714 gf180mcu_fd_sc_mcu9t5v0__nor2_1
* cell instance $7703 m0 *1 982.8,1098.72
X$7703 17578 17530 17398 17521 13891 gf180mcu_fd_sc_mcu9t5v0__nor2_1
* cell instance $7704 m0 *1 978.88,1098.72
X$7704 17529 17530 17398 17521 14014 gf180mcu_fd_sc_mcu9t5v0__nor2_1
* cell instance $7705 r0 *1 986.72,1098.72
X$7705 18394 17580 17709 17521 13907 gf180mcu_fd_sc_mcu9t5v0__nor2_1
* cell instance $7706 m0 *1 1020.88,1058.4
X$7706 16199 14820 16194 16309 16018 gf180mcu_fd_sc_mcu9t5v0__nand2_1
* cell instance $7707 m0 *1 987.28,1068.48
X$7707 16152 13465 16515 16517 16506 16653 16518
+ gf180mcu_fd_sc_mcu9t5v0__aoi22_1
* cell instance $7708 r0 *1 1012.48,1068.48
X$7708 16668 13212 13464 16794 16784 16653 16666
+ gf180mcu_fd_sc_mcu9t5v0__aoi22_1
* cell instance $7709 m0 *1 1008.56,1048.32
X$7709 13895 14417 13434 15898 16008 16016 gf180mcu_fd_sc_mcu9t5v0__oai21_1
* cell instance $7710 m0 *1 1006.32,1078.56
X$7710 16793 13433 16784 16956 16663 gf180mcu_fd_sc_mcu9t5v0__nand2_1
* cell instance $7711 m0 *1 1001.84,1068.48
X$7711 16016 16663 16506 16653 16664 gf180mcu_fd_sc_mcu9t5v0__nand2_1
* cell instance $7712 r0 *1 1000.72,1068.48
X$7712 15741 13461 17714 16792 16664 16784 16653 16665
+ gf180mcu_fd_sc_mcu9t5v0__aoi221_1
* cell instance $7713 r0 *1 986.16,1078.56
X$7713 17085 16965 16964 16968 17123 16956 16966
+ gf180mcu_fd_sc_mcu9t5v0__nand4_1
* cell instance $7714 m0 *1 984.48,1078.56
X$7714 4939 13891 13907 10979 16962 16784 16956 16965
+ gf180mcu_fd_sc_mcu9t5v0__aoi221_1
* cell instance $7715 r0 *1 1017.52,1068.48
X$7715 16199 14865 16921 16668 16784 16653 16519
+ gf180mcu_fd_sc_mcu9t5v0__aoi22_1
* cell instance $7716 m0 *1 974.96,1058.4
X$7716 14975 16150 16152 13331 16194 16309 gf180mcu_fd_sc_mcu9t5v0__dffrnq_2
* cell instance $7717 r0 *1 974.96,1098.72
X$7717 17529 17990 17709 17521 16515 gf180mcu_fd_sc_mcu9t5v0__nor2_1
* cell instance $7718 r0 *1 970.48,1078.56
X$7718 8553 17245 17127 17087 17086 17123 16956 16662
+ gf180mcu_fd_sc_mcu9t5v0__aoi221_1
* cell instance $7719 r0 *1 978.32,1078.56
X$7719 10046 17245 14014 7963 25130 17127 17123 16956 16964
+ gf180mcu_fd_sc_mcu9t5v0__aoi222_1
* cell instance $7720 m0 *1 1020.32,1048.32
X$7720 14820 16017 16018 15898 16008 16155 gf180mcu_fd_sc_mcu9t5v0__oai21_1
* cell instance $7721 r0 *1 1009.68,1048.32
X$7721 14975 16155 16199 13331 16194 16008 gf180mcu_fd_sc_mcu9t5v0__dffrnq_2
* cell instance $7722 r0 *1 1007.44,1068.48
X$7722 16794 16153 14825 16793 16784 16653 16667
+ gf180mcu_fd_sc_mcu9t5v0__aoi22_1
* cell instance $7723 r0 *1 970.48,987.84
X$7723 14654 12624 14406 14304 13056 gf180mcu_fd_sc_mcu9t5v0__nand2_1
* cell instance $7724 r0 *1 969.36,1028.16
X$7724 15402 15576 gf180mcu_fd_sc_mcu9t5v0__filltie
* cell instance $7725 r0 *1 969.36,1018.08
X$7725 15138 15271 gf180mcu_fd_sc_mcu9t5v0__filltie
* cell instance $7726 r0 *1 969.36,977.76
X$7726 14009 14126 gf180mcu_fd_sc_mcu9t5v0__filltie
* cell instance $7727 r0 *1 970.48,997.92
X$7727 14656 14655 14708 14448 13203 gf180mcu_fd_sc_mcu9t5v0__nand2_1
* cell instance $7728 m0 *1 983.92,997.92
X$7728 14657 12789 14450 14406 14448 6918 gf180mcu_fd_sc_mcu9t5v0__oai21_1
* cell instance $7729 r0 *1 1013.04,987.84
X$7729 13895 14417 13434 13837 14406 14304 14174
+ gf180mcu_fd_sc_mcu9t5v0__oai211_1
* cell instance $7730 r0 *1 969.36,987.84
X$7730 14304 14406 gf180mcu_fd_sc_mcu9t5v0__filltie
* cell instance $7731 m0 *1 1019.2,987.84
X$7731 13886 14174 13588 14126 14304 14659 gf180mcu_fd_sc_mcu9t5v0__nand3_1
* cell instance $7732 r0 *1 1009.68,1008
X$7732 6956 17245 14861 14659 14021 14967 14857 15015
+ gf180mcu_fd_sc_mcu9t5v0__aoi221_1
* cell instance $7733 r0 *1 1022.56,977.76
X$7733 8452 14013 14126 14009 13887 gf180mcu_fd_sc_mcu9t5v0__or2_1
* cell instance $7734 r0 *1 978.88,997.92
X$7734 14658 14657 13167 14708 14448 4247 gf180mcu_fd_sc_mcu9t5v0__mux2_1
* cell instance $7735 r0 *1 969.36,967.68
X$7735 13719 13832 gf180mcu_fd_sc_mcu9t5v0__filltie
* cell instance $7736 m0 *1 1002.96,1018.08
X$7736 15016 14967 15138 11319 gf180mcu_fd_sc_mcu9t5v0__buf_8
* cell instance $7737 r0 *1 1005.76,1028.16
X$7737 15741 15533 13214 15576 15402 15699 gf180mcu_fd_sc_mcu9t5v0__mux2_1
* cell instance $7738 m0 *1 999.6,1008
X$7738 14417 14860 13214 14708 14857 14978 gf180mcu_fd_sc_mcu9t5v0__mux2_1
* cell instance $7739 r0 *1 1005.2,987.84
X$7739 8452 14170 14406 14304 14130 gf180mcu_fd_sc_mcu9t5v0__or2_1
* cell instance $7740 r0 *1 1028.16,1018.08
X$7740 13481 13475 15147 15271 15138 15145 gf180mcu_fd_sc_mcu9t5v0__aoi21_1
* cell instance $7741 r0 *1 1008,977.76
X$7741 14012 12789 14130 14126 14009 7084 gf180mcu_fd_sc_mcu9t5v0__oai21_1
* cell instance $7742 r0 *1 1023.68,1018.08
X$7742 14820 15145 15146 15271 15138 15276 gf180mcu_fd_sc_mcu9t5v0__oai21_1
* cell instance $7743 r0 *1 987.84,1008
X$7743 15275 14978 14417 13331 14967 14857 gf180mcu_fd_sc_mcu9t5v0__dffrnq_2
* cell instance $7744 r0 *1 1027.04,977.76
X$7744 14013 13727 8452 14126 14009 2366 gf180mcu_fd_sc_mcu9t5v0__mux2_1
* cell instance $7745 m0 *1 1018.64,1008
X$7745 4545 13882 14708 14857 14815 gf180mcu_fd_sc_mcu9t5v0__nor2_1
* cell instance $7746 m0 *1 1007.44,987.84
X$7746 14170 14012 8452 14126 14304 2140 gf180mcu_fd_sc_mcu9t5v0__mux2_1
* cell instance $7747 r0 *1 988.4,1028.16
X$7747 15532 15144 13214 15576 15402 15585 gf180mcu_fd_sc_mcu9t5v0__mux2_1
* cell instance $7748 r0 *1 1022.56,1028.16
X$7748 13481 13888 13475 15576 15402 15533 gf180mcu_fd_sc_mcu9t5v0__mux2_1
* cell instance $7749 m0 *1 992.88,987.84
X$7749 14129 14126 14304 8452 gf180mcu_fd_sc_mcu9t5v0__buf_8
* cell instance $7750 r0 *1 983.36,977.76
X$7750 14129 14126 14009 13167 gf180mcu_fd_sc_mcu9t5v0__buf_8
* cell instance $7751 r0 *1 986.16,997.92
X$7751 13167 14658 14708 14448 14450 gf180mcu_fd_sc_mcu9t5v0__or2_1
* cell instance $7752 r0 *1 995.68,967.68
X$7752 13204 12393 13452 13832 13719 13726 gf180mcu_fd_sc_mcu9t5v0__nor3_2
* cell instance $7753 m0 *1 999.6,1018.08
X$7753 15015 14964 14967 15138 15016 gf180mcu_fd_sc_mcu9t5v0__nor2_1
* cell instance $7754 r0 *1 1020.88,997.92
X$7754 14815 14708 14448 4154 gf180mcu_fd_sc_mcu9t5v0__buf_8
* cell instance $7755 r0 *1 999.6,997.92
X$7755 12259 12904 11835 14708 14448 13453 gf180mcu_fd_sc_mcu9t5v0__aoi21_1
* cell instance $7756 m0 *1 1028.16,977.76
X$7756 13727 12789 13887 13832 14009 6920 gf180mcu_fd_sc_mcu9t5v0__oai21_1
* cell instance $7757 m0 *1 996.8,977.76
X$7757 13204 12393 13839 13832 14009 13587 gf180mcu_fd_sc_mcu9t5v0__nor3_1
* cell instance $7758 r0 *1 973.84,1028.16
X$7758 15531 15576 15402 4254 gf180mcu_fd_sc_mcu9t5v0__buf_8
* cell instance $7759 m0 *1 1022,977.76
X$7759 13461 2365 6146 13465 13832 14009 13886 gf180mcu_fd_sc_mcu9t5v0__aoi22_1
* cell instance $7760 r0 *1 972.72,967.68
X$7760 13839 13452 13204 12393 13832 13719 13169
+ gf180mcu_fd_sc_mcu9t5v0__aoi211_4
* cell instance $7761 r0 *1 969.36,997.92
X$7761 14448 14708 gf180mcu_fd_sc_mcu9t5v0__filltie
* cell instance $7762 r0 *1 970.48,1028.16
X$7762 12259 11835 15576 15402 15531 gf180mcu_fd_sc_mcu9t5v0__nor2_1
* cell instance $7763 r0 *1 969.36,1008
X$7763 14857 14967 gf180mcu_fd_sc_mcu9t5v0__filltie
* cell instance $7764 r0 *1 977.76,987.84
X$7764 17293 13839 14406 14304 13452 gf180mcu_fd_sc_mcu9t5v0__nand2_1
* cell instance $7765 m0 *1 1080.24,1008
X$7765 14454 13475 15744 14708 14857 14818 gf180mcu_fd_sc_mcu9t5v0__aoi21_1
* cell instance $7766 r0 *1 1068.48,1008
X$7766 14454 14418 13475 14967 14857 14860 gf180mcu_fd_sc_mcu9t5v0__mux2_1
* cell instance $7767 m0 *1 1054.48,1018.08
X$7767 14662 15017 13214 14967 15138 15149 gf180mcu_fd_sc_mcu9t5v0__mux2_1
* cell instance $7768 m0 *1 1089.2,1018.08
X$7768 15138 14967 gf180mcu_fd_sc_mcu9t5v0__filltie
* cell instance $7769 r0 *1 1048.32,987.84
X$7769 13904 14176 14175 14416 14406 14304 14308
+ gf180mcu_fd_sc_mcu9t5v0__nand4_1
* cell instance $7770 r0 *1 1044.4,997.92
X$7770 13453 15274 14660 14189 14308 14708 14448 14452
+ gf180mcu_fd_sc_mcu9t5v0__aoi221_1
* cell instance $7771 m0 *1 1089.2,1028.16
X$7771 15402 15271 gf180mcu_fd_sc_mcu9t5v0__filltie
* cell instance $7772 m0 *1 1070.16,1008
X$7772 13894 14865 16921 13430 14708 14857 14817
+ gf180mcu_fd_sc_mcu9t5v0__aoi22_1
* cell instance $7773 m0 *1 1046.08,997.92
X$7773 14451 13840 14661 14452 14406 14448 14309
+ gf180mcu_fd_sc_mcu9t5v0__oai211_1
* cell instance $7774 r0 *1 1089.76,987.84
X$7774 13433 14419 14309 14406 14304 14018 gf180mcu_fd_sc_mcu9t5v0__aoi21_1
* cell instance $7775 r0 *1 1062.32,1028.16
X$7775 15275 15576 15402 gf180mcu_fd_sc_mcu9t5v0__inv_4
* cell instance $7776 m0 *1 1090.32,987.84
X$7776 15150 14012 13895 14126 14304 14133 gf180mcu_fd_sc_mcu9t5v0__mux2_1
* cell instance $7777 r0 *1 1067.92,987.84
X$7777 14179 14418 13024 14406 14304 13837 gf180mcu_fd_sc_mcu9t5v0__mux2_1
* cell instance $7778 r0 *1 1089.2,977.76
X$7778 14019 14713 14018 14017 14126 14009 13458
+ gf180mcu_fd_sc_mcu9t5v0__aoi22_1
* cell instance $7779 r0 *1 1067.92,1028.16
X$7779 13895 15742 13212 15576 15402 14177 gf180mcu_fd_sc_mcu9t5v0__oai21_1
* cell instance $7780 r0 *1 1066.8,977.76
X$7780 14132 14015 13024 14126 14009 8816 gf180mcu_fd_sc_mcu9t5v0__mux2_1
* cell instance $7781 m0 *1 1067.36,987.84
X$7781 13464 14178 8816 13465 14126 14304 13892 gf180mcu_fd_sc_mcu9t5v0__aoi22_1
* cell instance $7782 m0 *1 1069.04,1028.16
X$7782 15279 14817 15271 15402 15268 gf180mcu_fd_sc_mcu9t5v0__nand2_1
* cell instance $7783 r0 *1 1082.48,977.76
X$7783 13591 14133 14016 13461 13893 14126 14009 14017
+ gf180mcu_fd_sc_mcu9t5v0__aoi221_1
* cell instance $7784 r0 *1 1046.08,1018.08
X$7784 15275 15149 14662 13331 15271 15138 gf180mcu_fd_sc_mcu9t5v0__dffrnq_2
* cell instance $7785 r0 *1 1094.8,1028.16
X$7785 13480 13475 15147 15576 15402 15586 gf180mcu_fd_sc_mcu9t5v0__aoi21_1
* cell instance $7786 m0 *1 1042.72,1028.16
X$7786 15277 14865 16921 15742 15271 15402 15278
+ gf180mcu_fd_sc_mcu9t5v0__aoi22_1
* cell instance $7787 m0 *1 1084.16,1018.08
X$7787 14862 16153 14825 14821 14967 15138 15148
+ gf180mcu_fd_sc_mcu9t5v0__aoi22_1
* cell instance $7788 m0 *1 1047.76,1028.16
X$7788 15278 15148 15271 15402 15527 gf180mcu_fd_sc_mcu9t5v0__nand2_1
* cell instance $7789 r0 *1 1047.76,967.68
X$7789 13841 12789 13890 13832 13719 6921 gf180mcu_fd_sc_mcu9t5v0__oai21_1
* cell instance $7790 r0 *1 1091.44,967.68
X$7790 13888 13693 13024 13832 13719 2244 gf180mcu_fd_sc_mcu9t5v0__mux2_1
* cell instance $7791 r0 *1 1043.28,967.68
X$7791 14189 9709 13208 13832 13719 13840 gf180mcu_fd_sc_mcu9t5v0__oai21_1
* cell instance $7792 r0 *1 1094.8,987.84
X$7792 14821 8093 13895 14406 14304 14419 gf180mcu_fd_sc_mcu9t5v0__mux2_1
* cell instance $7793 m0 *1 1090.32,1008
X$7793 14821 14820 14708 14857 14819 gf180mcu_fd_sc_mcu9t5v0__nand2_1
* cell instance $7794 m0 *1 1043.28,1008
X$7794 13895 15277 14708 14857 14451 gf180mcu_fd_sc_mcu9t5v0__nor2_1
* cell instance $7795 m0 *1 1089.2,987.84
X$7795 14304 14126 gf180mcu_fd_sc_mcu9t5v0__filltie
* cell instance $7796 r0 *1 1068.48,997.92
X$7796 14418 14663 13024 14708 14448 14306 gf180mcu_fd_sc_mcu9t5v0__mux2_1
* cell instance $7797 r0 *1 1050.56,997.92
X$7797 13895 14662 13434 14306 14708 14448 14661
+ gf180mcu_fd_sc_mcu9t5v0__oai211_1
* cell instance $7798 m0 *1 1089.2,997.92
X$7798 14448 14406 gf180mcu_fd_sc_mcu9t5v0__filltie
* cell instance $7799 m0 *1 1084.72,1008
X$7799 14820 14818 14819 14708 14857 14664 gf180mcu_fd_sc_mcu9t5v0__oai21_1
* cell instance $7800 r0 *1 1084.72,997.92
X$7800 15275 14664 14821 13331 14708 14448 gf180mcu_fd_sc_mcu9t5v0__dffrnq_2
* cell instance $7801 m0 *1 1053.36,1008
X$7801 13895 14662 13434 14708 14857 14816 gf180mcu_fd_sc_mcu9t5v0__oai21_1
* cell instance $7802 m0 *1 1089.2,1008
X$7802 14857 14708 gf180mcu_fd_sc_mcu9t5v0__filltie
* cell instance $7803 m0 *1 1065.12,1008
X$7803 14862 13464 13465 13430 14708 14857 14712
+ gf180mcu_fd_sc_mcu9t5v0__aoi22_1
* cell instance $7804 r0 *1 1056.16,997.92
X$7804 14816 14712 14708 14448 14660 gf180mcu_fd_sc_mcu9t5v0__nand2_1
* cell instance $7805 m0 *1 1089.2,977.76
X$7805 14009 13832 gf180mcu_fd_sc_mcu9t5v0__filltie
* cell instance $7806 m0 *1 1043.84,977.76
X$7806 8452 13889 13832 14009 13890 gf180mcu_fd_sc_mcu9t5v0__or2_1
* cell instance $7807 m0 *1 1048.32,977.76
X$7807 13889 13841 8452 13832 14009 2252 gf180mcu_fd_sc_mcu9t5v0__mux2_1
* cell instance $7808 m0 *1 1081.92,977.76
X$7808 13894 2244 13895 13832 14009 14016 gf180mcu_fd_sc_mcu9t5v0__mux2_1
* cell instance $7809 m0 *1 1067.92,977.76
X$7809 13589 14177 13892 14189 13832 14009 13893
+ gf180mcu_fd_sc_mcu9t5v0__oai22_1
* cell instance $7810 r0 *1 1058.96,977.76
X$7810 12273 13907 14126 14009 14176 gf180mcu_fd_sc_mcu9t5v0__nand2_1
* cell instance $7811 m0 *1 1056.16,987.84
X$7811 4914 13891 14014 4961 14126 14304 14175 gf180mcu_fd_sc_mcu9t5v0__aoi22_1
* cell instance $7812 m0 *1 1074.64,1028.16
X$7812 15406 14663 13475 15271 15402 15017 gf180mcu_fd_sc_mcu9t5v0__mux2_1
* cell instance $7813 r0 *1 1068.48,1018.08
X$7813 15150 16153 14825 14662 15271 15138 15279
+ gf180mcu_fd_sc_mcu9t5v0__aoi22_1
* cell instance $7814 m0 *1 896,1048.32
X$7814 11835 15900 15898 16008 16009 gf180mcu_fd_sc_mcu9t5v0__nand2_1
* cell instance $7815 m0 *1 879.2,1088.64
X$7815 16142 17243 12622 13331 17123 17289 gf180mcu_fd_sc_mcu9t5v0__dffrnq_2
* cell instance $7816 r0 *1 889.84,1058.4
X$7816 14975 16444 16446 13331 16506 16309 gf180mcu_fd_sc_mcu9t5v0__dffrnq_2
* cell instance $7817 r0 *1 893.76,1088.64
X$7817 14189 17292 16661 11835 17398 17289 17291
+ gf180mcu_fd_sc_mcu9t5v0__aoi22_1
* cell instance $7818 m0 *1 849.52,1038.24
X$7818 15737 15576 gf180mcu_fd_sc_mcu9t5v0__filltie
* cell instance $7819 r0 *1 886.48,1028.16
X$7819 14975 15530 15141 13331 15576 15402 gf180mcu_fd_sc_mcu9t5v0__dffrnq_2
* cell instance $7820 m0 *1 903.84,1038.24
X$7820 4545 15900 15695 15576 15737 15530 gf180mcu_fd_sc_mcu9t5v0__aoi21_1
* cell instance $7821 r0 *1 893.76,977.76
X$7821 14128 14126 14009 4252 gf180mcu_fd_sc_mcu9t5v0__buf_8
* cell instance $7822 m0 *1 856.24,1038.24
X$7822 15738 15694 15693 15576 15737 15139 15529 gf180mcu_fd_sc_mcu9t5v0__nor4_4
* cell instance $7823 m0 *1 892.08,1008
X$7823 14710 14973 12623 14708 14857 12258 gf180mcu_fd_sc_mcu9t5v0__mux2_1
* cell instance $7824 r0 *1 889.84,1018.08
X$7824 15141 15271 15138 12259 gf180mcu_fd_sc_mcu9t5v0__buf_8
* cell instance $7825 m0 *1 890.96,1038.24
X$7825 15141 15858 15576 15737 15582 gf180mcu_fd_sc_mcu9t5v0__xnor2_1
* cell instance $7826 m0 *1 944.16,1038.24
X$7826 13882 15584 15576 15737 8086 gf180mcu_fd_sc_mcu9t5v0__nor2_1
* cell instance $7827 m0 *1 948.64,1038.24
X$7827 15697 15583 15576 15737 15584 gf180mcu_fd_sc_mcu9t5v0__nor2_1
* cell instance $7828 m0 *1 912.24,1038.24
X$7828 13882 15583 15576 15737 13880 gf180mcu_fd_sc_mcu9t5v0__nor2_1
* cell instance $7829 m0 *1 924,1038.24
X$7829 15013 16312 15696 15576 15737 15143 gf180mcu_fd_sc_mcu9t5v0__oai21_1
* cell instance $7830 m0 *1 942.48,1098.72
X$7830 14189 25271 16661 12904 17398 17521 17403
+ gf180mcu_fd_sc_mcu9t5v0__aoi22_1
* cell instance $7831 m0 *1 917.28,1048.32
X$7831 15141 13882 16311 15898 16008 16011 gf180mcu_fd_sc_mcu9t5v0__nor3_1
* cell instance $7832 r0 *1 929.6,1078.56
X$7832 16960 16660 16196 17123 16956 17294 gf180mcu_fd_sc_mcu9t5v0__nand3_1
* cell instance $7833 r0 *1 900.48,1068.48
X$7833 16657 16313 16659 16010 16784 16653 16791
+ gf180mcu_fd_sc_mcu9t5v0__aoi211_1
* cell instance $7834 m0 *1 960.96,1068.48
X$7834 16661 16515 16514 16506 16653 16516 gf180mcu_fd_sc_mcu9t5v0__nand3_1
* cell instance $7835 m0 *1 900.48,1068.48
X$7835 16446 16789 14128 16506 16653 16658 gf180mcu_fd_sc_mcu9t5v0__nand3_1
* cell instance $7836 r0 *1 913.36,1058.4
X$7836 16446 16310 16506 16309 16311 gf180mcu_fd_sc_mcu9t5v0__nand2_1
* cell instance $7837 m0 *1 898.8,1048.32
X$7837 16010 15900 15582 16009 15898 16008 15899
+ gf180mcu_fd_sc_mcu9t5v0__oai31_1
* cell instance $7838 m0 *1 920.64,1058.4
X$7838 16196 15696 16194 16309 14414 gf180mcu_fd_sc_mcu9t5v0__nand2_1
* cell instance $7839 r0 *1 918.96,1088.64
X$7839 17294 16311 17293 17398 17289 17575 gf180mcu_fd_sc_mcu9t5v0__aoi21_2
* cell instance $7840 m0 *1 904.4,1068.48
X$7840 16657 16446 16313 16506 16653 16659 gf180mcu_fd_sc_mcu9t5v0__nor3_1
* cell instance $7841 r0 *1 934.08,1058.4
X$7841 11983 15739 16506 16309 16449 gf180mcu_fd_sc_mcu9t5v0__nand2_1
* cell instance $7842 r0 *1 916.16,1058.4
X$7842 16657 16447 16446 16506 16309 16312 gf180mcu_fd_sc_mcu9t5v0__nor3_1
* cell instance $7843 m0 *1 934.64,1048.32
X$7843 14975 15898 16008 33577 gf180mcu_fd_sc_mcu9t5v0__clkbuf_8
* cell instance $7844 r0 *1 920.64,1058.4
X$7844 16449 16313 16448 16196 16506 16309 16444
+ gf180mcu_fd_sc_mcu9t5v0__oai22_1
* cell instance $7845 r0 *1 916.72,1098.72
X$7845 17402 17709 17521 16443 gf180mcu_fd_sc_mcu9t5v0__buf_8
* cell instance $7846 r0 *1 944.16,1058.4
X$7846 16312 16506 16309 11983 gf180mcu_fd_sc_mcu9t5v0__buf_8
* cell instance $7847 r0 *1 928.48,1088.64
X$7847 17294 17398 17289 12904 gf180mcu_fd_sc_mcu9t5v0__buf_8
* cell instance $7848 m0 *1 936.88,1078.56
X$7848 16310 16784 16956 16789 gf180mcu_fd_sc_mcu9t5v0__buf_8
* cell instance $7849 r0 *1 937.44,1098.72
X$7849 17841 17709 17521 13201 gf180mcu_fd_sc_mcu9t5v0__clkinv_1
* cell instance $7850 m0 *1 960.4,1048.32
X$7850 4545 11835 15898 16008 15698 gf180mcu_fd_sc_mcu9t5v0__nor2_1
* cell instance $7851 m0 *1 924,1078.56
X$7851 16960 13323 16784 16956 14976 gf180mcu_fd_sc_mcu9t5v0__and2_1
* cell instance $7852 m0 *1 926.24,1048.32
X$7852 16013 16012 15898 16008 15900 gf180mcu_fd_sc_mcu9t5v0__nand2_1
* cell instance $7853 m0 *1 960.96,1088.64
X$7853 17126 17291 17123 17289 17244 gf180mcu_fd_sc_mcu9t5v0__nor2_1
* cell instance $7854 r0 *1 959.84,1078.56
X$7854 16515 17125 17123 16956 17085 gf180mcu_fd_sc_mcu9t5v0__nand2_1
* cell instance $7855 r0 *1 916.16,1068.48
X$7855 16660 16446 16784 16653 13323 gf180mcu_fd_sc_mcu9t5v0__nor2_1
* cell instance $7856 r0 *1 934.64,1048.32
X$7856 5901 16194 16008 14975 gf180mcu_fd_sc_mcu9t5v0__clkbuf_8
* cell instance $7857 m0 *1 922.88,1088.64
X$7857 16657 16447 17123 17289 17402 gf180mcu_fd_sc_mcu9t5v0__nand2_1
* cell instance $7858 m0 *1 914.48,1068.48
X$7858 16446 16506 16653 16196 gf180mcu_fd_sc_mcu9t5v0__inv_1
* cell instance $7859 r0 *1 940.8,1058.4
X$7859 12393 16011 16506 16309 16197 gf180mcu_fd_sc_mcu9t5v0__nor2_1
* cell instance $7860 m0 *1 945.28,1058.4
X$7860 15583 4275 16197 16194 16309 16313 gf180mcu_fd_sc_mcu9t5v0__oai21_1
* cell instance $7861 r0 *1 931.84,1038.24
X$7861 11835 15013 15898 15737 15696 gf180mcu_fd_sc_mcu9t5v0__nand2_1
* cell instance $7862 m0 *1 907.76,1058.4
X$7862 16446 13880 16194 16309 14449 gf180mcu_fd_sc_mcu9t5v0__nor2_1
* cell instance $7863 m0 *1 928.48,1058.4
X$7863 15739 16313 16194 16309 16448 gf180mcu_fd_sc_mcu9t5v0__nand2_1
* cell instance $7864 r0 *1 926.24,1058.4
X$7864 16013 16313 16448 16447 16506 16309 16513
+ gf180mcu_fd_sc_mcu9t5v0__oai22_1
* cell instance $7865 m0 *1 948.08,1088.64
X$7865 19000 11983 14189 17123 17289 17125 gf180mcu_fd_sc_mcu9t5v0__aoi21_1
* cell instance $7866 r0 *1 953.68,1098.72
X$7866 17577 13895 16515 17709 17521 17528 gf180mcu_fd_sc_mcu9t5v0__oai21_1
* cell instance $7867 m0 *1 903.84,1088.64
X$7867 14975 16513 16660 13331 17123 17289 gf180mcu_fd_sc_mcu9t5v0__dffrnq_2
* cell instance $7868 r0 *1 898.24,1078.56
X$7868 14975 16791 16960 13331 17123 16956 gf180mcu_fd_sc_mcu9t5v0__dffrnq_2
* cell instance $7869 r0 *1 941.36,1098.72
X$7869 14189 20383 16661 12904 17709 17521 17576
+ gf180mcu_fd_sc_mcu9t5v0__aoi22_1
* cell instance $7870 m0 *1 951.44,1098.72
X$7870 17125 17528 17576 17126 13895 17527 17398 17521 16314
+ gf180mcu_fd_sc_mcu9t5v0__oai222_1
* cell instance $7871 r0 *1 934.64,1038.24
X$7871 11983 12393 16011 15739 15898 15737 16012
+ gf180mcu_fd_sc_mcu9t5v0__oai31_1
* cell instance $7872 r0 *1 911.12,1038.24
X$7872 4545 15739 15900 15898 15737 15695 gf180mcu_fd_sc_mcu9t5v0__aoi21_1
* cell instance $7873 r0 *1 949.2,1038.24
X$7873 11835 15898 15737 13882 gf180mcu_fd_sc_mcu9t5v0__inv_1
* cell instance $7874 m0 *1 956.48,1088.64
X$7874 17126 17403 17123 17289 16962 gf180mcu_fd_sc_mcu9t5v0__nor2_1
* cell instance $7875 r0 *1 919.52,1068.48
X$7875 16960 16447 16446 16784 16653 14977 gf180mcu_fd_sc_mcu9t5v0__nor3_1
* cell instance $7876 m0 *1 929.04,1048.32
X$7876 14976 14977 15739 15898 16008 16013 gf180mcu_fd_sc_mcu9t5v0__oai21_1
* cell instance $7877 m0 *1 913.36,1058.4
X$7877 16196 16310 16194 16309 15142 gf180mcu_fd_sc_mcu9t5v0__nand2_2
* cell instance $7878 m0 *1 955.92,1078.56
X$7878 14189 16963 16661 4258 16784 16956 16961 gf180mcu_fd_sc_mcu9t5v0__aoi22_1
* cell instance $7879 r0 *1 962.64,1078.56
X$7879 17126 16961 17123 16956 17086 gf180mcu_fd_sc_mcu9t5v0__nor2_1
* cell instance $7880 r0 *1 919.52,1078.56
X$7880 16960 16660 17123 16956 16310 gf180mcu_fd_sc_mcu9t5v0__nor2_4
* cell instance $7881 m0 *1 919.52,1078.56
X$7881 16960 16784 16956 16657 gf180mcu_fd_sc_mcu9t5v0__clkinv_1
* cell instance $7882 r0 *1 917.28,1078.56
X$7882 16660 17123 16956 16447 gf180mcu_fd_sc_mcu9t5v0__clkinv_1
* cell instance $7883 m0 *1 849.52,1048.32
X$7883 16008 15898 gf180mcu_fd_sc_mcu9t5v0__filltie
* cell instance $7884 m0 *1 869.68,1048.32
X$7884 14975 15899 15858 13331 15898 16008 gf180mcu_fd_sc_mcu9t5v0__dffrnq_2
* cell instance $7885 m0 *1 849.52,1058.4
X$7885 16309 16194 gf180mcu_fd_sc_mcu9t5v0__filltie
* cell instance $7886 m0 *1 850.64,1048.32
X$7886 14975 12898 15738 13331 15898 16008 gf180mcu_fd_sc_mcu9t5v0__dffrnq_2
* cell instance $7887 m0 *1 860.16,1088.64
X$7887 16142 17242 17524 13331 17123 17289 gf180mcu_fd_sc_mcu9t5v0__dffrnq_2
* cell instance $7888 r0 *1 879.76,1058.4
X$7888 8086 10962 16442 16443 16506 16309 16512
+ gf180mcu_fd_sc_mcu9t5v0__oai211_1
* cell instance $7889 r0 *1 884.8,1068.48
X$7889 16789 13724 15405 16512 16784 16653 16790
+ gf180mcu_fd_sc_mcu9t5v0__oai31_1
* cell instance $7890 r0 *1 857.36,1058.4
X$7890 16441 16506 16309 16510 gf180mcu_fd_sc_mcu9t5v0__buf_8
* cell instance $7891 m0 *1 849.52,1078.56
X$7891 16956 16784 gf180mcu_fd_sc_mcu9t5v0__filltie
* cell instance $7892 r0 *1 867.44,1038.24
X$7892 15738 15898 15737 15857 gf180mcu_fd_sc_mcu9t5v0__clkinv_1
* cell instance $7893 r0 *1 882.56,1038.24
X$7893 15858 15898 15737 11835 gf180mcu_fd_sc_mcu9t5v0__buf_8
* cell instance $7894 m0 *1 875.84,1098.72
X$7894 17524 12622 17398 17521 17525 gf180mcu_fd_sc_mcu9t5v0__xnor2_1
* cell instance $7895 r0 *1 846.16,1068.48
X$7895 16656 13717 16784 16653 16786 gf180mcu_fd_sc_mcu9t5v0__nor2_1
* cell instance $7896 r0 *1 840,1068.48
X$7896 16958 15269 15399 16508 15575 16784 16653 16656
+ gf180mcu_fd_sc_mcu9t5v0__aoi221_1
* cell instance $7897 r0 *1 830.48,1048.32
X$7897 16146 16148 16439 16194 16008 16147 gf180mcu_fd_sc_mcu9t5v0__mux2_1
* cell instance $7898 r0 *1 830.48,1088.64
X$7898 17239 17241 16439 17398 17289 17240 gf180mcu_fd_sc_mcu9t5v0__mux2_1
* cell instance $7899 r0 *1 842.24,1078.56
X$7899 17241 15269 15399 17084 15575 17123 16956 17124
+ gf180mcu_fd_sc_mcu9t5v0__aoi221_1
* cell instance $7900 m0 *1 828.8,1098.72
X$7900 17571 16958 16439 17398 17521 17523 gf180mcu_fd_sc_mcu9t5v0__mux2_1
* cell instance $7901 r0 *1 845.6,1088.64
X$7901 17124 13155 17398 17289 17400 gf180mcu_fd_sc_mcu9t5v0__nor2_1
* cell instance $7902 m0 *1 828.8,1088.64
X$7902 16142 17240 17241 13331 17123 17289 gf180mcu_fd_sc_mcu9t5v0__dffrnq_2
* cell instance $7903 r0 *1 842.24,1048.32
X$7903 16148 15269 15399 14859 15575 16194 16008 16149
+ gf180mcu_fd_sc_mcu9t5v0__aoi221_1
* cell instance $7904 m0 *1 849.52,1088.64
X$7904 17289 17123 gf180mcu_fd_sc_mcu9t5v0__filltie
* cell instance $7905 m0 *1 852.32,1068.48
X$7905 15581 16506 16653 16509 gf180mcu_fd_sc_mcu9t5v0__buf_8
* cell instance $7906 m0 *1 849.52,1098.72
X$7906 17521 17398 gf180mcu_fd_sc_mcu9t5v0__filltie
* cell instance $7907 m0 *1 882.56,1098.72
X$7907 17711 17526 17525 17574 17398 17521 17243
+ gf180mcu_fd_sc_mcu9t5v0__aoi22_1
* cell instance $7908 r0 *1 863.52,1098.72
X$7908 17524 17572 17709 17521 17573 gf180mcu_fd_sc_mcu9t5v0__nand2_1
* cell instance $7909 r0 *1 866.32,1098.72
X$7909 17524 17574 17573 17711 17709 17521 17242
+ gf180mcu_fd_sc_mcu9t5v0__aoi22_1
* cell instance $7910 m0 *1 854.56,1078.56
X$7910 16786 16784 16956 16959 gf180mcu_fd_sc_mcu9t5v0__buf_8
* cell instance $7911 r0 *1 850.64,1088.64
X$7911 17400 17398 17289 17401 gf180mcu_fd_sc_mcu9t5v0__buf_8
* cell instance $7912 r0 *1 878.08,1068.48
X$7912 16512 16787 16784 16653 16788 gf180mcu_fd_sc_mcu9t5v0__xnor2_1
* cell instance $7913 m0 *1 850.64,1058.4
X$7913 16149 13158 16194 16309 16441 gf180mcu_fd_sc_mcu9t5v0__nor2_1
* cell instance $7914 m0 *1 849.52,1068.48
X$7914 16653 16506 gf180mcu_fd_sc_mcu9t5v0__filltie
* cell instance $7915 m0 *1 880.32,1068.48
X$7915 13724 15405 16506 16653 16787 gf180mcu_fd_sc_mcu9t5v0__nor2_1
* cell instance $7916 r0 *1 874.16,1058.4
X$7916 8086 10962 16442 4952 16506 16309 16511 gf180mcu_fd_sc_mcu9t5v0__oai211_1
* cell instance $7917 m0 *1 849.52,1028.16
X$7917 15402 15271 gf180mcu_fd_sc_mcu9t5v0__filltie
* cell instance $7918 r0 *1 854.56,977.76
X$7918 14010 11323 12898 14126 14009 13879 gf180mcu_fd_sc_mcu9t5v0__mux2_1
* cell instance $7919 m0 *1 879.76,997.92
X$7919 12623 14406 14448 13197 gf180mcu_fd_sc_mcu9t5v0__buf_8
* cell instance $7920 r0 *1 869.68,1008
X$7920 15139 14967 14857 12623 gf180mcu_fd_sc_mcu9t5v0__buf_8
* cell instance $7921 m0 *1 849.52,997.92
X$7921 14448 14406 gf180mcu_fd_sc_mcu9t5v0__filltie
* cell instance $7922 r0 *1 875.84,987.84
X$7922 13164 14406 14304 14305 gf180mcu_fd_sc_mcu9t5v0__buf_8
* cell instance $7923 m0 *1 862.96,997.92
X$7923 14172 14298 12898 14406 14448 14412 gf180mcu_fd_sc_mcu9t5v0__mux2_1
* cell instance $7924 m0 *1 849.52,1008
X$7924 14857 14708 gf180mcu_fd_sc_mcu9t5v0__filltie
* cell instance $7925 m0 *1 878.08,1028.16
X$7925 8086 15272 15271 15402 15405 gf180mcu_fd_sc_mcu9t5v0__nor2_1
* cell instance $7926 m0 *1 855.68,1018.08
X$7926 13831 15012 14972 13331 14967 15138 gf180mcu_fd_sc_mcu9t5v0__dffrnq_2
* cell instance $7927 r0 *1 848.4,1028.16
X$7927 15528 13444 15576 15402 15581 gf180mcu_fd_sc_mcu9t5v0__nor2_1
* cell instance $7928 r0 *1 856.8,987.84
X$7928 13831 14412 14172 13331 14406 14304 gf180mcu_fd_sc_mcu9t5v0__dffrnq_2
* cell instance $7929 r0 *1 862.4,1008
X$7929 14813 14972 13197 14967 14857 14013 gf180mcu_fd_sc_mcu9t5v0__mux2_1
* cell instance $7930 r0 *1 831.6,977.76
X$7930 13835 13826 12898 14126 14009 13877 gf180mcu_fd_sc_mcu9t5v0__mux2_1
* cell instance $7931 r0 *1 829.92,1028.16
X$7931 15579 15526 16439 15576 15402 15580 gf180mcu_fd_sc_mcu9t5v0__mux2_1
* cell instance $7932 m0 *1 842.24,1018.08
X$7932 15011 14850 12898 14967 15138 14971 gf180mcu_fd_sc_mcu9t5v0__mux2_1
* cell instance $7933 r0 *1 842.24,1028.16
X$7933 15526 15269 15399 15527 15575 15576 15402 15528
+ gf180mcu_fd_sc_mcu9t5v0__aoi221_1
* cell instance $7934 r0 *1 831.6,987.84
X$7934 13831 14410 14411 13331 14406 14304 gf180mcu_fd_sc_mcu9t5v0__dffrnq_2
* cell instance $7935 m0 *1 839.44,997.92
X$7935 14809 14411 13427 14406 14448 14410 gf180mcu_fd_sc_mcu9t5v0__mux2_1
* cell instance $7936 m0 *1 842.24,987.84
X$7936 14302 14411 13197 14126 14304 14170 gf180mcu_fd_sc_mcu9t5v0__mux2_1
* cell instance $7937 r0 *1 836.64,1008
X$7937 13831 14971 15011 13331 14967 14857 gf180mcu_fd_sc_mcu9t5v0__dffrnq_2
* cell instance $7938 r0 *1 835.52,967.68
X$7938 13835 13826 13197 13832 13719 13878 gf180mcu_fd_sc_mcu9t5v0__mux2_1
* cell instance $7939 r0 *1 884.8,967.68
X$7939 4908 12648 13832 13719 16442 gf180mcu_fd_sc_mcu9t5v0__or2_1
* cell instance $7940 m0 *1 890.96,1018.08
X$7940 3462 14127 14967 15138 15140 gf180mcu_fd_sc_mcu9t5v0__nor2_1
* cell instance $7941 r0 *1 858.48,967.68
X$7941 14010 11323 13197 13832 13719 13721 gf180mcu_fd_sc_mcu9t5v0__mux2_1
* cell instance $7942 r0 *1 865.76,967.68
X$7942 12018 13722 13723 13331 13832 13719 gf180mcu_fd_sc_mcu9t5v0__dffrnq_2
* cell instance $7943 m0 *1 884.8,1008
X$7943 14709 17951 12623 14708 14857 12750 gf180mcu_fd_sc_mcu9t5v0__mux2_1
* cell instance $7944 r0 *1 889.28,977.76
X$7944 3462 6259 14126 14009 14011 gf180mcu_fd_sc_mcu9t5v0__nor2_1
* cell instance $7945 m0 *1 868,987.84
X$7945 14172 14298 13197 14126 14304 14171 gf180mcu_fd_sc_mcu9t5v0__mux2_1
* cell instance $7946 m0 *1 850.64,1008
X$7946 15011 3795 13197 14708 14857 14814 gf180mcu_fd_sc_mcu9t5v0__mux2_1
* cell instance $7947 m0 *1 849.52,1018.08
X$7947 15138 14967 gf180mcu_fd_sc_mcu9t5v0__filltie
* cell instance $7948 r0 *1 859.04,1018.08
X$7948 14856 14972 13427 15271 15138 15012 gf180mcu_fd_sc_mcu9t5v0__mux2_1
* cell instance $7949 r0 *1 892.64,997.92
X$7949 14709 14708 14448 14710 gf180mcu_fd_sc_mcu9t5v0__clkinv_1
* cell instance $7950 m0 *1 850.64,977.76
X$7950 12018 13879 14010 13331 13832 14009 gf180mcu_fd_sc_mcu9t5v0__dffrnq_2
* cell instance $7951 m0 *1 849.52,977.76
X$7951 14009 13832 gf180mcu_fd_sc_mcu9t5v0__filltie
* cell instance $7952 r0 *1 891.52,1008
X$7952 17951 14967 14857 14973 gf180mcu_fd_sc_mcu9t5v0__clkinv_1
* cell instance $7953 r0 *1 859.6,1028.16
X$7953 15694 15693 15529 15857 15576 15402 13325
+ gf180mcu_fd_sc_mcu9t5v0__oai31_4
* cell instance $7954 m0 *1 849.52,987.84
X$7954 14304 14126 gf180mcu_fd_sc_mcu9t5v0__filltie
* cell instance $7955 r0 *1 928.48,997.92
X$7955 14814 14711 13167 14708 14448 9814 gf180mcu_fd_sc_mcu9t5v0__mux2_1
* cell instance $7956 r0 *1 903.84,967.68
X$7956 12259 13880 13448 13832 13719 13836 gf180mcu_fd_sc_mcu9t5v0__oai21_1
* cell instance $7957 r0 *1 934.08,987.84
X$7957 14171 14306 13167 14406 14304 9204 gf180mcu_fd_sc_mcu9t5v0__mux2_1
* cell instance $7958 r0 *1 926.8,1008
X$7958 14975 14976 14654 13331 14967 14857 gf180mcu_fd_sc_mcu9t5v0__dffrnq_2
* cell instance $7959 r0 *1 952,1028.16
X$7959 12259 15576 15402 15697 gf180mcu_fd_sc_mcu9t5v0__clkinv_1
* cell instance $7960 r0 *1 923.44,1018.08
X$7960 15143 15271 15138 4764 gf180mcu_fd_sc_mcu9t5v0__buf_8
* cell instance $7961 m0 *1 939.12,987.84
X$7961 13167 14171 14126 14304 14173 gf180mcu_fd_sc_mcu9t5v0__or2_1
* cell instance $7962 r0 *1 961.52,997.92
X$7962 14654 14653 14708 14448 14655 gf180mcu_fd_sc_mcu9t5v0__nor2_1
* cell instance $7963 m0 *1 912.24,1018.08
X$7963 14974 14967 15138 15013 gf180mcu_fd_sc_mcu9t5v0__buf_8
* cell instance $7964 r0 *1 913.36,1018.08
X$7964 15142 15271 15138 14974 gf180mcu_fd_sc_mcu9t5v0__inv_2
* cell instance $7965 r0 *1 945.84,1018.08
X$7965 4246 15271 15138 4489 gf180mcu_fd_sc_mcu9t5v0__clkinv_1
* cell instance $7966 r0 *1 941.36,997.92
X$7966 15010 14708 14448 14652 gf180mcu_fd_sc_mcu9t5v0__clkinv_1
* cell instance $7967 r0 *1 944.72,987.84
X$7967 14306 12789 14173 14406 14304 8968 gf180mcu_fd_sc_mcu9t5v0__oai21_1
* cell instance $7968 r0 *1 908.32,1008
X$7968 15141 14974 14967 14857 13448 gf180mcu_fd_sc_mcu9t5v0__nand2_1
* cell instance $7969 r0 *1 899.92,987.84
X$7969 14413 14406 14304 3679 gf180mcu_fd_sc_mcu9t5v0__buf_8
* cell instance $7970 m0 *1 907.76,997.92
X$7970 14449 14406 14448 3351 gf180mcu_fd_sc_mcu9t5v0__buf_8
* cell instance $7971 m0 *1 903.84,1018.08
X$7971 12259 15582 14974 14967 15138 14413 gf180mcu_fd_sc_mcu9t5v0__mux2_1
* cell instance $7972 r0 *1 955.36,987.84
X$7972 14169 14307 13167 14406 14304 10036 gf180mcu_fd_sc_mcu9t5v0__mux2_1
* cell instance $7973 m0 *1 949.76,1028.16
X$7973 14977 15584 15271 15402 15014 gf180mcu_fd_sc_mcu9t5v0__or2_1
* cell instance $7974 m0 *1 962.08,997.92
X$7974 14653 14406 14448 12624 gf180mcu_fd_sc_mcu9t5v0__clkinv_1
* cell instance $7975 r0 *1 936.88,1028.16
X$7975 11835 15584 15696 15576 15402 15273 gf180mcu_fd_sc_mcu9t5v0__oai21_1
* cell instance $7976 r0 *1 908.32,967.68
X$7976 13836 13832 13719 3106 gf180mcu_fd_sc_mcu9t5v0__buf_8
* cell instance $7977 r0 *1 919.52,987.84
X$7977 14414 14406 14304 3459 gf180mcu_fd_sc_mcu9t5v0__buf_8
* cell instance $7978 r0 *1 947.52,967.68
X$7978 13838 12789 13883 13832 13719 7205 gf180mcu_fd_sc_mcu9t5v0__oai21_1
* cell instance $7979 r0 *1 927.36,967.68
X$7979 13721 13837 13167 13832 13719 6253 gf180mcu_fd_sc_mcu9t5v0__mux2_1
* cell instance $7980 m0 *1 935.2,1028.16
X$7980 15273 15271 15402 3462 gf180mcu_fd_sc_mcu9t5v0__buf_8
* cell instance $7981 r0 *1 903.28,1008
X$7981 12259 13882 14967 14857 14128 gf180mcu_fd_sc_mcu9t5v0__nor2_1
* cell instance $7982 m0 *1 960.4,987.84
X$7982 13167 14169 14126 14304 14415 gf180mcu_fd_sc_mcu9t5v0__or2_1
* cell instance $7983 r0 *1 939.68,967.68
X$7983 13876 13838 13167 13832 13719 5296 gf180mcu_fd_sc_mcu9t5v0__mux2_1
* cell instance $7984 m0 *1 943.04,977.76
X$7984 13167 13876 13832 14009 13883 gf180mcu_fd_sc_mcu9t5v0__or2_1
* cell instance $7985 r0 *1 935.2,967.68
X$7985 13837 12789 13725 13832 13719 7680 gf180mcu_fd_sc_mcu9t5v0__oai21_1
* cell instance $7986 m0 *1 951.44,977.76
X$7986 13878 13884 13167 13832 14009 8079 gf180mcu_fd_sc_mcu9t5v0__mux2_1
* cell instance $7987 m0 *1 906.08,977.76
X$7987 13881 13832 14009 3806 gf180mcu_fd_sc_mcu9t5v0__buf_8
* cell instance $7988 m0 *1 901.6,977.76
X$7988 13882 13448 13880 13832 14009 13881 gf180mcu_fd_sc_mcu9t5v0__aoi21_1
* cell instance $7989 m0 *1 958.72,977.76
X$7989 13167 13878 13832 14009 13885 gf180mcu_fd_sc_mcu9t5v0__or2_1
* cell instance $7990 m0 *1 937.44,1008
X$7990 14975 15013 14653 13331 14857 14708 gf180mcu_fd_sc_mcu9t5v0__dffsnq_2
* cell instance $7991 r0 *1 912.24,1028.16
X$7991 15142 15576 15402 15583 gf180mcu_fd_sc_mcu9t5v0__buf_8
* cell instance $7992 m0 *1 883.12,907.2
X$7992 10306 12134 12257 11971 12019 gf180mcu_fd_sc_mcu9t5v0__dffq_2
* cell instance $7993 m0 *1 891.52,856.8
X$7993 10341 9813 10684 10682 2987 3106 10676 10714 10686
+ gf180mcu_fd_sc_mcu9t5v0__mux4_1
* cell instance $7994 r0 *1 894.32,846.72
X$7994 10312 10686 3351 10676 10570 10685 gf180mcu_fd_sc_mcu9t5v0__mux2_1
* cell instance $7995 r0 *1 886.48,856.8
X$7995 10684 10682 10341 9813 12133 3121 10833 10714 10963
+ gf180mcu_fd_sc_mcu9t5v0__mux4_1
* cell instance $7996 r0 *1 915.6,897.12
X$7996 12023 11978 7818 11971 11860 11977 gf180mcu_fd_sc_mcu9t5v0__mux2_1
* cell instance $7997 r0 *1 940.24,897.12
X$7997 4030 10036 11971 11860 11831 gf180mcu_fd_sc_mcu9t5v0__nand2_1
* cell instance $7998 r0 *1 928.48,897.12
X$7998 10687 4769 11971 11860 11979 gf180mcu_fd_sc_mcu9t5v0__nand2_1
* cell instance $7999 r0 *1 925.12,897.12
X$7999 11347 11979 11971 11860 11830 gf180mcu_fd_sc_mcu9t5v0__nand2_1
* cell instance $8000 r0 *1 937.44,897.12
X$8000 11831 11980 11971 11860 11976 gf180mcu_fd_sc_mcu9t5v0__nand2_1
* cell instance $8001 r0 *1 894.32,897.12
X$8001 10306 11862 11566 11971 11860 gf180mcu_fd_sc_mcu9t5v0__dffq_2
* cell instance $8002 r0 *1 892.64,907.2
X$8002 12257 11976 4029 12128 12019 12134 gf180mcu_fd_sc_mcu9t5v0__mux2_1
* cell instance $8003 r0 *1 840,897.12
X$8003 11826 11341 11564 10040 9436 3121 11971 11860 12021
+ gf180mcu_fd_sc_mcu9t5v0__mux4_1
* cell instance $8004 m0 *1 883.68,927.36
X$8004 11184 12512 10315 9545 12133 9436 12508 12646 12648
+ gf180mcu_fd_sc_mcu9t5v0__mux4_1
* cell instance $8005 r0 *1 887.6,957.6
X$8005 13447 13586 13428 4908 gf180mcu_fd_sc_mcu9t5v0__buf_8
* cell instance $8006 r0 *1 886.48,927.36
X$8006 11184 12512 10315 9545 2987 3459 12785 12646 14127
+ gf180mcu_fd_sc_mcu9t5v0__mux4_1
* cell instance $8007 m0 *1 894.32,836.64
X$8007 9847 9848 10311 10038 2987 3106 10188 10308 10312
+ gf180mcu_fd_sc_mcu9t5v0__mux4_1
* cell instance $8008 r0 *1 892.08,836.64
X$8008 10341 9813 2891 10338 10308 10340 gf180mcu_fd_sc_mcu9t5v0__mux2_1
* cell instance $8009 r0 *1 941.92,947.52
X$8009 14652 13201 12623 13318 13160 13205 gf180mcu_fd_sc_mcu9t5v0__mux2_1
* cell instance $8010 r0 *1 927.36,907.2
X$8010 10042 10687 5057 12128 12019 11978 gf180mcu_fd_sc_mcu9t5v0__mux2_1
* cell instance $8011 r0 *1 937.44,947.52
X$8011 13200 12789 13168 13318 13160 7955 gf180mcu_fd_sc_mcu9t5v0__oai21_1
* cell instance $8012 m0 *1 946.4,907.2
X$8012 11981 11971 12019 5057 gf180mcu_fd_sc_mcu9t5v0__buf_8
* cell instance $8013 r0 *1 936.88,957.6
X$8013 13450 13449 13167 13586 13428 10042 gf180mcu_fd_sc_mcu9t5v0__mux2_1
* cell instance $8014 r0 *1 903.28,957.6
X$8014 13323 13448 13586 13428 13163 gf180mcu_fd_sc_mcu9t5v0__and2_1
* cell instance $8015 r0 *1 936.32,917.28
X$8015 10036 11299 5057 12508 12253 12392 gf180mcu_fd_sc_mcu9t5v0__mux2_1
* cell instance $8016 r0 *1 952.56,917.28
X$8016 11835 12624 12260 12393 12508 12253 12024 gf180mcu_fd_sc_mcu9t5v0__or4_1
* cell instance $8017 r0 *1 922.32,927.36
X$8017 9816 12514 12256 12785 12646 gf180mcu_fd_sc_mcu9t5v0__dffq_2
* cell instance $8018 r0 *1 914.48,947.52
X$8018 13447 13318 13160 4916 gf180mcu_fd_sc_mcu9t5v0__buf_8
* cell instance $8019 r0 *1 929.04,917.28
X$8019 12256 12392 7818 12508 12253 12514 gf180mcu_fd_sc_mcu9t5v0__mux2_1
* cell instance $8020 r0 *1 950.32,947.52
X$8020 13196 13324 13167 13318 13160 3229 gf180mcu_fd_sc_mcu9t5v0__mux2_1
* cell instance $8021 r0 *1 920.64,917.28
X$8021 9814 10046 5057 12508 12253 12391 gf180mcu_fd_sc_mcu9t5v0__mux2_1
* cell instance $8022 r0 *1 943.04,927.36
X$8022 16445 17524 12623 12785 12646 12516 gf180mcu_fd_sc_mcu9t5v0__mux2_1
* cell instance $8023 r0 *1 929.04,947.52
X$8023 13446 13200 13167 13318 13160 7073 gf180mcu_fd_sc_mcu9t5v0__mux2_1
* cell instance $8024 m0 *1 953.12,947.52
X$8024 13167 13196 13054 13160 13202 gf180mcu_fd_sc_mcu9t5v0__or2_1
* cell instance $8025 r0 *1 944.72,957.6
X$8025 13167 13450 13586 13428 13451 gf180mcu_fd_sc_mcu9t5v0__or2_1
* cell instance $8026 r0 *1 954.24,957.6
X$8026 13449 12789 13451 13586 13428 9319 gf180mcu_fd_sc_mcu9t5v0__oai21_1
* cell instance $8027 m0 *1 931.28,947.52
X$8027 13167 13446 13054 13160 13168 gf180mcu_fd_sc_mcu9t5v0__or2_1
* cell instance $8028 m0 *1 903.28,957.6
X$8028 13323 13448 13318 13428 13199 gf180mcu_fd_sc_mcu9t5v0__nand2_1
* cell instance $8029 m0 *1 908.32,907.2
X$8029 9816 11977 12023 11971 12019 gf180mcu_fd_sc_mcu9t5v0__dffq_2
* cell instance $8030 m0 *1 960.96,907.2
X$8030 4545 12024 11971 12019 11981 gf180mcu_fd_sc_mcu9t5v0__nor2_1
* cell instance $8031 m0 *1 900.48,937.44
X$8031 9436 12785 12900 3239 gf180mcu_fd_sc_mcu9t5v0__buf_8
* cell instance $8032 r0 *1 908.32,937.44
X$8032 12133 13054 12900 3120 gf180mcu_fd_sc_mcu9t5v0__buf_12
* cell instance $8033 m0 *1 939.12,907.2
X$8033 11299 4769 11971 12019 11980 gf180mcu_fd_sc_mcu9t5v0__nand2_1
* cell instance $8034 r0 *1 899.92,947.52
X$8034 13199 13318 13160 3564 gf180mcu_fd_sc_mcu9t5v0__buf_8
* cell instance $8035 r0 *1 946.4,937.44
X$8035 16445 13054 12900 13015 gf180mcu_fd_sc_mcu9t5v0__clkinv_1
* cell instance $8036 r0 *1 936.88,937.44
X$8036 17524 13054 12900 13013 gf180mcu_fd_sc_mcu9t5v0__clkinv_1
* cell instance $8037 r0 *1 907.76,957.6
X$8037 11835 13448 13586 13428 13447 gf180mcu_fd_sc_mcu9t5v0__nand2_1
* cell instance $8038 r0 *1 911.12,917.28
X$8038 12512 12391 7818 12508 12253 12513 gf180mcu_fd_sc_mcu9t5v0__mux2_1
* cell instance $8039 m0 *1 943.04,927.36
X$8039 12386 12622 12623 12508 12646 12515 gf180mcu_fd_sc_mcu9t5v0__mux2_1
* cell instance $8040 m0 *1 955.36,927.36
X$8040 12624 12260 12393 12508 12646 12625 gf180mcu_fd_sc_mcu9t5v0__or3_2
* cell instance $8041 m0 *1 903.28,927.36
X$8041 10306 12513 12512 12508 12646 gf180mcu_fd_sc_mcu9t5v0__dffq_2
* cell instance $8042 r0 *1 939.12,937.44
X$8042 13015 13013 12623 13054 12900 13014 gf180mcu_fd_sc_mcu9t5v0__mux2_1
* cell instance $8043 r0 *1 957.6,947.52
X$8043 13324 12789 13202 13318 13160 6917 gf180mcu_fd_sc_mcu9t5v0__oai21_1
* cell instance $8044 m0 *1 831.6,937.44
X$8044 4764 12785 12900 9436 gf180mcu_fd_sc_mcu9t5v0__buf_8
* cell instance $8045 m0 *1 849.52,907.2
X$8045 12019 11971 gf180mcu_fd_sc_mcu9t5v0__filltie
* cell instance $8046 r0 *1 831.6,917.28
X$8046 3459 12388 12508 12253 12510 gf180mcu_fd_sc_mcu9t5v0__nor2_1
* cell instance $8047 m0 *1 832.72,927.36
X$8047 3351 12254 12508 12646 12618 gf180mcu_fd_sc_mcu9t5v0__nor2_1
* cell instance $8048 m0 *1 842.8,927.36
X$8048 3806 12620 12508 12646 12619 gf180mcu_fd_sc_mcu9t5v0__nand2_1
* cell instance $8049 m0 *1 843.36,917.28
X$8049 3806 12130 12132 12131 12128 12253 12255 gf180mcu_fd_sc_mcu9t5v0__oai31_1
* cell instance $8050 m0 *1 842.24,957.6
X$8050 15401 13322 13427 13318 13428 13429 gf180mcu_fd_sc_mcu9t5v0__mux2_1
* cell instance $8051 r0 *1 836.64,957.6
X$8051 12018 13429 13322 13331 13586 13428 gf180mcu_fd_sc_mcu9t5v0__dffrnq_2
* cell instance $8052 m0 *1 834.96,947.52
X$8052 3564 13054 13160 12133 gf180mcu_fd_sc_mcu9t5v0__buf_8
* cell instance $8053 m0 *1 849.52,917.28
X$8053 12253 12128 gf180mcu_fd_sc_mcu9t5v0__filltie
* cell instance $8054 m0 *1 869.68,927.36
X$8054 12257 4254 4252 10715 12508 12646 12621 gf180mcu_fd_sc_mcu9t5v0__aoi22_1
* cell instance $8055 r0 *1 865.76,917.28
X$8055 11721 4258 4154 11565 12508 12253 12389 gf180mcu_fd_sc_mcu9t5v0__aoi22_1
* cell instance $8056 r0 *1 866.88,927.36
X$8056 12621 12389 12785 12646 12749 gf180mcu_fd_sc_mcu9t5v0__nand2_1
* cell instance $8057 r0 *1 892.64,947.52
X$8057 3806 10685 4952 13318 13160 13198 gf180mcu_fd_sc_mcu9t5v0__oai21_1
* cell instance $8058 m0 *1 852.32,927.36
X$8058 12257 12256 10721 11565 2987 3459 12508 12646 12620
+ gf180mcu_fd_sc_mcu9t5v0__mux4_1
* cell instance $8059 r0 *1 873.6,917.28
X$8059 12257 12256 10721 11565 12133 9436 12508 12253 12390
+ gf180mcu_fd_sc_mcu9t5v0__mux4_1
* cell instance $8060 m0 *1 850.64,937.44
X$8060 12133 12021 12785 12900 12786 gf180mcu_fd_sc_mcu9t5v0__nor2_1
* cell instance $8061 m0 *1 870.8,947.52
X$8061 13166 12888 12898 13054 13160 13165 gf180mcu_fd_sc_mcu9t5v0__mux2_1
* cell instance $8062 m0 *1 849.52,927.36
X$8062 12646 12508 gf180mcu_fd_sc_mcu9t5v0__filltie
* cell instance $8063 m0 *1 857.92,947.52
X$8063 13163 11296 13054 13160 13011 gf180mcu_fd_sc_mcu9t5v0__nor2_1
* cell instance $8064 m0 *1 860.16,917.28
X$8064 12257 12256 2891 12128 12253 11722 gf180mcu_fd_sc_mcu9t5v0__mux2_1
* cell instance $8065 r0 *1 850.64,947.52
X$8065 13320 13322 13197 13318 13160 12792 gf180mcu_fd_sc_mcu9t5v0__mux2_1
* cell instance $8066 m0 *1 881.44,947.52
X$8066 13166 12888 13197 13054 13160 8560 gf180mcu_fd_sc_mcu9t5v0__mux2_1
* cell instance $8067 m0 *1 849.52,937.44
X$8067 12900 12785 gf180mcu_fd_sc_mcu9t5v0__filltie
* cell instance $8068 m0 *1 890.96,917.28
X$8068 4529 12512 12128 12253 11603 gf180mcu_fd_sc_mcu9t5v0__nor2_1
* cell instance $8069 m0 *1 849.52,947.52
X$8069 13160 13054 gf180mcu_fd_sc_mcu9t5v0__filltie
* cell instance $8070 r0 *1 839.44,907.2
X$8070 3459 11827 12128 12019 12130 gf180mcu_fd_sc_mcu9t5v0__nor2_1
* cell instance $8071 r0 *1 860.72,937.44
X$8071 12786 13011 4908 13054 12900 13012 gf180mcu_fd_sc_mcu9t5v0__oai21_1
* cell instance $8072 r0 *1 842.8,907.2
X$8072 3351 11342 12128 12019 12132 gf180mcu_fd_sc_mcu9t5v0__nor2_1
* cell instance $8073 m0 *1 849.52,957.6
X$8073 13428 13318 gf180mcu_fd_sc_mcu9t5v0__filltie
* cell instance $8074 r0 *1 865.76,907.2
X$8074 11566 12023 11183 10339 12133 9436 12128 12019 12511
+ gf180mcu_fd_sc_mcu9t5v0__mux4_1
* cell instance $8075 m0 *1 836.08,927.36
X$8075 3806 12510 12618 12619 12508 12646 12647 gf180mcu_fd_sc_mcu9t5v0__oai31_1
* cell instance $8076 r0 *1 866.32,947.52
X$8076 12018 13165 13166 13331 13318 13160 gf180mcu_fd_sc_mcu9t5v0__dffrnq_2
* cell instance $8077 r0 *1 847.84,907.2
X$8077 3806 12022 12128 12019 12131 gf180mcu_fd_sc_mcu9t5v0__nand2_1
* cell instance $8078 m0 *1 866.32,947.52
X$8078 4908 12511 13012 13054 13160 13164 gf180mcu_fd_sc_mcu9t5v0__oai21_1
* cell instance $8079 m0 *1 859.6,907.2
X$8079 11566 12023 11183 10339 2987 3459 11971 12019 12022
+ gf180mcu_fd_sc_mcu9t5v0__mux4_1
* cell instance $8080 m0 *1 849.52,866.88
X$8080 11079 10833 gf180mcu_fd_sc_mcu9t5v0__filltie
* cell instance $8081 r0 *1 843.92,856.8
X$8081 10306 10838 10715 10833 10714 gf180mcu_fd_sc_mcu9t5v0__dffq_2
* cell instance $8082 r0 *1 843.36,846.72
X$8082 10306 10574 11341 10676 10570 gf180mcu_fd_sc_mcu9t5v0__dffq_2
* cell instance $8083 m0 *1 832.16,846.72
X$8083 10042 10043 2777 10338 10570 10573 gf180mcu_fd_sc_mcu9t5v0__mux2_1
* cell instance $8084 m0 *1 859.04,846.72
X$8084 10043 10042 3335 10338 10570 10458 gf180mcu_fd_sc_mcu9t5v0__mux2_1
* cell instance $8085 m0 *1 850.64,846.72
X$8085 10458 11341 6914 10338 10570 10574 gf180mcu_fd_sc_mcu9t5v0__mux2_2
* cell instance $8086 m0 *1 841.12,856.8
X$8086 10961 10715 6914 10676 10714 10838 gf180mcu_fd_sc_mcu9t5v0__mux2_2
* cell instance $8087 m0 *1 849.52,846.72
X$8087 10570 10338 gf180mcu_fd_sc_mcu9t5v0__filltie
* cell instance $8088 m0 *1 832.16,897.12
X$8088 11564 11562 11826 10683 2987 3106 11720 11860 11827
+ gf180mcu_fd_sc_mcu9t5v0__mux4_1
* cell instance $8089 r0 *1 835.52,876.96
X$8089 10040 9441 11341 10959 2987 3106 11461 11294 11342
+ gf180mcu_fd_sc_mcu9t5v0__mux4_1
* cell instance $8090 m0 *1 871.92,846.72
X$8090 10311 4765 10575 2983 2880 10338 10570 10310
+ gf180mcu_fd_sc_mcu9t5v0__aoi221_1
* cell instance $8091 m0 *1 830.48,876.96
X$8091 10683 10959 11562 9441 9436 3121 11181 11294 11296
+ gf180mcu_fd_sc_mcu9t5v0__mux4_1
* cell instance $8092 m0 *1 849.52,876.96
X$8092 11294 11181 gf180mcu_fd_sc_mcu9t5v0__filltie
* cell instance $8093 m0 *1 849.52,897.12
X$8093 11860 11720 gf180mcu_fd_sc_mcu9t5v0__filltie
* cell instance $8094 m0 *1 867.44,887.04
X$8094 2891 11566 11461 11600 11344 gf180mcu_fd_sc_mcu9t5v0__nor2_1
* cell instance $8095 m0 *1 871.92,897.12
X$8095 4529 12023 11720 11860 11465 gf180mcu_fd_sc_mcu9t5v0__nor2_1
* cell instance $8096 m0 *1 854.56,866.88
X$8096 10677 10036 3335 10833 11079 10961 gf180mcu_fd_sc_mcu9t5v0__mux2_1
* cell instance $8097 m0 *1 864.64,866.88
X$8097 10306 10839 10311 10833 11079 gf180mcu_fd_sc_mcu9t5v0__dffq_2
* cell instance $8098 r0 *1 862.96,876.96
X$8098 4497 11344 11465 11343 11461 11294 11182 gf180mcu_fd_sc_mcu9t5v0__oai31_1
* cell instance $8099 r0 *1 881.44,887.04
X$8099 10315 4765 4949 9545 11720 11600 11723 gf180mcu_fd_sc_mcu9t5v0__aoi22_1
* cell instance $8100 r0 *1 886.48,887.04
X$8100 4497 11602 11603 11723 11720 11600 10192 gf180mcu_fd_sc_mcu9t5v0__oai31_1
* cell instance $8101 r0 *1 876.96,856.8
X$8101 9845 9815 3335 10833 10714 10840 gf180mcu_fd_sc_mcu9t5v0__mux2_1
* cell instance $8102 r0 *1 870.24,846.72
X$8102 10684 10682 2891 10676 10570 10575 gf180mcu_fd_sc_mcu9t5v0__mux2_1
* cell instance $8103 r0 *1 868.56,856.8
X$8103 10840 10311 6914 10833 10714 10839 gf180mcu_fd_sc_mcu9t5v0__mux2_2
* cell instance $8104 m0 *1 849.52,856.8
X$8104 10714 10676 gf180mcu_fd_sc_mcu9t5v0__filltie
* cell instance $8105 m0 *1 853.44,856.8
X$8105 3808 10676 10714 10306 gf180mcu_fd_sc_mcu9t5v0__clkbuf_8
* cell instance $8106 m0 *1 861.84,897.12
X$8106 11562 4258 4154 10339 11720 11860 11828 gf180mcu_fd_sc_mcu9t5v0__aoi22_1
* cell instance $8107 m0 *1 884.24,866.88
X$8107 10963 10044 9436 10833 11079 10962 gf180mcu_fd_sc_mcu9t5v0__mux2_1
* cell instance $8108 r0 *1 860.16,846.72
X$8108 10306 10676 10570 33554 gf180mcu_fd_sc_mcu9t5v0__inv_2
* cell instance $8109 m0 *1 875.28,897.12
X$8109 11829 11828 11720 11860 11861 gf180mcu_fd_sc_mcu9t5v0__nand2_1
* cell instance $8110 m0 *1 852.32,887.04
X$8110 10721 4765 4949 11565 11722 2983 11461 11600 11558
+ gf180mcu_fd_sc_mcu9t5v0__aoi222_1
* cell instance $8111 r0 *1 857.92,876.96
X$8111 11183 4765 4949 10339 11461 11294 11343 gf180mcu_fd_sc_mcu9t5v0__aoi22_1
* cell instance $8112 r0 *1 892.08,887.04
X$8112 2891 11184 11720 11600 11602 gf180mcu_fd_sc_mcu9t5v0__nor2_1
* cell instance $8113 m0 *1 866.88,897.12
X$8113 11566 4254 4252 11341 11720 11860 11829 gf180mcu_fd_sc_mcu9t5v0__aoi22_1
* cell instance $8114 m0 *1 885.92,876.96
X$8114 11184 4254 4252 10311 11181 11294 11568 gf180mcu_fd_sc_mcu9t5v0__aoi22_1
* cell instance $8115 r0 *1 882.56,876.96
X$8115 9813 4258 4154 9545 4545 11461 11294 11345
+ gf180mcu_fd_sc_mcu9t5v0__aoi221_1
* cell instance $8116 m0 *1 849.52,887.04
X$8116 11600 11461 gf180mcu_fd_sc_mcu9t5v0__filltie
* cell instance $8117 m0 *1 831.6,887.04
X$8117 11564 11562 2891 11461 11600 11464 gf180mcu_fd_sc_mcu9t5v0__mux2_1
* cell instance $8118 m0 *1 849.52,836.64
X$8118 10308 10188 gf180mcu_fd_sc_mcu9t5v0__filltie
* cell instance $8119 m0 *1 883.12,887.04
X$8119 4545 11345 11568 11461 11600 11567 gf180mcu_fd_sc_mcu9t5v0__oai21_1
* cell instance $8120 r0 *1 888.72,836.64
X$8120 2983 10340 10338 10308 10309 gf180mcu_fd_sc_mcu9t5v0__nand2_1
* cell instance $8121 m0 *1 890.4,836.64
X$8121 10038 4949 10188 10308 10193 gf180mcu_fd_sc_mcu9t5v0__nand2_1
* cell instance $8122 m0 *1 884.24,836.64
X$8122 10193 10310 10309 9811 3103 10188 10308 10082
+ gf180mcu_fd_sc_mcu9t5v0__aoi221_1
* cell instance $8123 m0 *1 865.2,836.64
X$8123 11721 10081 4156 10188 10308 10080 gf180mcu_fd_sc_mcu9t5v0__mux2_1
* cell instance $8124 m0 *1 901.04,897.12
X$8124 11566 11830 4029 11720 11860 11862 gf180mcu_fd_sc_mcu9t5v0__mux2_1
* cell instance $8125 r0 *1 923.44,856.8
X$8125 10046 4769 10833 10714 10716 gf180mcu_fd_sc_mcu9t5v0__nand2_1
* cell instance $8126 m0 *1 936.32,856.8
X$8126 10717 10688 5767 10676 10714 10844 gf180mcu_fd_sc_mcu9t5v0__and3_1
* cell instance $8127 r0 *1 938,846.72
X$8127 10688 5767 10042 10676 10570 10845 gf180mcu_fd_sc_mcu9t5v0__aoi21_1
* cell instance $8128 r0 *1 918.96,846.72
X$8128 4030 9815 10676 10570 10459 gf180mcu_fd_sc_mcu9t5v0__nand2_1
* cell instance $8129 r0 *1 908.88,856.8
X$8129 10842 10833 10714 4923 gf180mcu_fd_sc_mcu9t5v0__buf_8
* cell instance $8130 r0 *1 916.16,866.88
X$8130 4254 11301 11181 11079 10842 gf180mcu_fd_sc_mcu9t5v0__nand2_1
* cell instance $8131 m0 *1 926.24,897.12
X$8131 4030 10042 11720 11860 11347 gf180mcu_fd_sc_mcu9t5v0__nand2_1
* cell instance $8132 m0 *1 933.52,856.8
X$8132 10687 5766 10676 10714 10843 gf180mcu_fd_sc_mcu9t5v0__nand2_1
* cell instance $8133 m0 *1 950.32,856.8
X$8133 10721 10720 8706 10676 10714 10719 gf180mcu_fd_sc_mcu9t5v0__mux2_1
* cell instance $8134 r0 *1 929.6,856.8
X$8134 5766 10844 10845 10843 10833 10714 10846 gf180mcu_fd_sc_mcu9t5v0__oai31_1
* cell instance $8135 m0 *1 935.76,876.96
X$8135 10043 11181 11294 10717 gf180mcu_fd_sc_mcu9t5v0__clkinv_1
* cell instance $8136 r0 *1 935.2,856.8
X$8136 11183 10846 8706 10833 10714 10964 gf180mcu_fd_sc_mcu9t5v0__mux2_1
* cell instance $8137 r0 *1 924.56,876.96
X$8137 10717 4030 11347 11461 11294 11346 gf180mcu_fd_sc_mcu9t5v0__oai21_1
* cell instance $8138 m0 *1 904.96,876.96
X$8138 11184 10841 4029 11181 11294 11298 gf180mcu_fd_sc_mcu9t5v0__mux2_1
* cell instance $8139 r0 *1 915.6,876.96
X$8139 11564 11346 3340 11461 11294 11569 gf180mcu_fd_sc_mcu9t5v0__mux2_1
* cell instance $8140 r0 *1 898.24,876.96
X$8140 10306 11298 11184 11461 11294 gf180mcu_fd_sc_mcu9t5v0__dffq_2
* cell instance $8141 r0 *1 945.28,876.96
X$8141 10677 11461 11294 11348 gf180mcu_fd_sc_mcu9t5v0__clkinv_1
* cell instance $8142 m0 *1 945.84,856.8
X$8142 10688 6916 10036 10676 10714 10718 gf180mcu_fd_sc_mcu9t5v0__aoi21_1
* cell instance $8143 m0 *1 939.12,897.12
X$8143 11348 4030 11831 11720 11860 11570 gf180mcu_fd_sc_mcu9t5v0__oai21_1
* cell instance $8144 r0 *1 957.04,876.96
X$8144 11299 6669 10966 11349 11461 11294 11350 gf180mcu_fd_sc_mcu9t5v0__oai22_1
* cell instance $8145 m0 *1 960.4,887.04
X$8145 11565 11461 11600 11351 gf180mcu_fd_sc_mcu9t5v0__clkinv_1
* cell instance $8146 m0 *1 916.16,856.8
X$8146 10459 10716 10676 10714 10841 gf180mcu_fd_sc_mcu9t5v0__nand2_1
* cell instance $8147 r0 *1 929.04,887.04
X$8147 9816 11604 11563 11720 11600 gf180mcu_fd_sc_mcu9t5v0__dffq_2
* cell instance $8148 r0 *1 950.32,876.96
X$8148 11348 6557 7685 6669 11461 11294 11349 gf180mcu_fd_sc_mcu9t5v0__oai31_1
* cell instance $8149 r0 *1 908.32,836.64
X$8149 9816 10313 10341 10338 10308 gf180mcu_fd_sc_mcu9t5v0__dffq_2
* cell instance $8150 m0 *1 908.32,887.04
X$8150 9816 11569 11564 11461 11600 gf180mcu_fd_sc_mcu9t5v0__dffq_2
* cell instance $8151 m0 *1 923.44,836.64
X$8151 9845 10188 10308 10194 gf180mcu_fd_sc_mcu9t5v0__clkinv_1
* cell instance $8152 m0 *1 915.04,836.64
X$8152 10341 10314 3340 10188 10308 10313 gf180mcu_fd_sc_mcu9t5v0__mux2_1
* cell instance $8153 r0 *1 941.36,836.64
X$8153 5766 10196 9850 10343 10338 10308 10342 gf180mcu_fd_sc_mcu9t5v0__oai31_1
* cell instance $8154 m0 *1 931.28,836.64
X$8154 9816 10195 10315 10188 10308 gf180mcu_fd_sc_mcu9t5v0__dffq_2
* cell instance $8155 m0 *1 924.56,866.88
X$8155 9816 10964 11183 10833 11079 gf180mcu_fd_sc_mcu9t5v0__dffq_2
* cell instance $8156 r0 *1 949.76,846.72
X$8156 11348 10688 5767 10676 10570 10689 gf180mcu_fd_sc_mcu9t5v0__and3_1
* cell instance $8157 m0 *1 950.32,876.96
X$8157 11299 5766 11181 11294 10965 gf180mcu_fd_sc_mcu9t5v0__nand2_1
* cell instance $8158 m0 *1 957.6,856.8
X$8158 5766 10718 10689 10965 10676 10714 10720 gf180mcu_fd_sc_mcu9t5v0__oai31_1
* cell instance $8159 m0 *1 934.08,887.04
X$8159 11563 11570 3340 11461 11600 11604 gf180mcu_fd_sc_mcu9t5v0__mux2_1
* cell instance $8160 m0 *1 918.4,846.72
X$8160 10194 4030 10459 10338 10570 10314 gf180mcu_fd_sc_mcu9t5v0__oai21_1
* cell instance $8161 m0 *1 1033.2,927.36
X$8161 4154 12261 12508 12646 11837 gf180mcu_fd_sc_mcu9t5v0__and2_1
* cell instance $8162 r0 *1 1011.92,897.12
X$8162 11832 11834 11836 11860 11835 11863 11833 11971
+ gf180mcu_fd_sc_mcu9t5v0__aoi221_4
* cell instance $8163 r0 *1 996.24,897.12
X$8163 11985 11986 4545 11971 11860 11833 gf180mcu_fd_sc_mcu9t5v0__oai21_4
* cell instance $8164 r0 *1 981.68,897.12
X$8164 11983 11984 11971 11860 11832 gf180mcu_fd_sc_mcu9t5v0__nor2_4
* cell instance $8165 r0 *1 1024.8,856.8
X$8165 11356 11574 10695 10833 10714 10693 gf180mcu_fd_sc_mcu9t5v0__and3_4
* cell instance $8166 r0 *1 1054.48,897.12
X$8166 11863 11971 11860 10850 gf180mcu_fd_sc_mcu9t5v0__clkbuf_8
* cell instance $8167 r0 *1 1083.6,897.12
X$8167 11357 11971 11860 4048 gf180mcu_fd_sc_mcu9t5v0__buf_8
* cell instance $8168 r0 *1 969.36,897.12
X$8168 11860 11971 gf180mcu_fd_sc_mcu9t5v0__filltie
* cell instance $8169 m0 *1 1028.16,866.88
X$8169 9551 10833 11079 10849 gf180mcu_fd_sc_mcu9t5v0__buf_8
* cell instance $8170 r0 *1 1039.92,897.12
X$8170 11838 11971 11860 9553 gf180mcu_fd_sc_mcu9t5v0__buf_8
* cell instance $8171 r0 *1 1028.16,866.88
X$8171 11186 11181 11079 10694 gf180mcu_fd_sc_mcu9t5v0__buf_8
* cell instance $8172 m0 *1 1033.76,957.6
X$8172 13207 13318 13428 6250 gf180mcu_fd_sc_mcu9t5v0__buf_8
* cell instance $8173 m0 *1 1025.36,937.44
X$8173 11572 12751 12906 11356 12785 12900 11355
+ gf180mcu_fd_sc_mcu9t5v0__oai31_4
* cell instance $8174 r0 *1 1035.44,907.2
X$8174 10200 12026 12128 12019 11838 gf180mcu_fd_sc_mcu9t5v0__nor2_2
* cell instance $8175 m0 *1 1034.88,897.12
X$8175 11838 11863 11837 11720 11860 11839 gf180mcu_fd_sc_mcu9t5v0__aoi21_2
* cell instance $8176 m0 *1 1034.32,907.2
X$8176 12026 10200 11971 12019 9100 gf180mcu_fd_sc_mcu9t5v0__or2_4
* cell instance $8177 r0 *1 1027.04,846.72
X$8177 10693 10694 10204 10676 10570 10347 gf180mcu_fd_sc_mcu9t5v0__aoi21_4
* cell instance $8178 m0 *1 1035.44,887.04
X$8178 11606 11461 11600 6261 gf180mcu_fd_sc_mcu9t5v0__buf_8
* cell instance $8179 m0 *1 1025.92,846.72
X$8179 10347 10338 10570 2472 gf180mcu_fd_sc_mcu9t5v0__buf_12
* cell instance $8180 m0 *1 1024.24,836.64
X$8180 9552 10203 10202 10188 10308 10204 gf180mcu_fd_sc_mcu9t5v0__nor3_4
* cell instance $8181 r0 *1 1024.24,836.64
X$8181 10347 10338 10308 10457 gf180mcu_fd_sc_mcu9t5v0__buf_8
* cell instance $8182 r0 *1 1029.84,937.44
X$8182 11835 12904 11572 13054 12900 12907 gf180mcu_fd_sc_mcu9t5v0__nand3_2
* cell instance $8183 r0 *1 973.28,897.12
X$8183 12024 10318 11971 11860 11724 gf180mcu_fd_sc_mcu9t5v0__nor2_1
* cell instance $8184 r0 *1 1017.52,917.28
X$8184 11572 12259 11986 12253 12517 12026 12397 12508
+ gf180mcu_fd_sc_mcu9t5v0__aoi221_4
* cell instance $8185 r0 *1 1073.52,937.44
X$8185 7800 12902 13054 12900 12908 gf180mcu_fd_sc_mcu9t5v0__or2_1
* cell instance $8186 m0 *1 1047.2,947.52
X$8186 13453 11984 13054 13160 13018 gf180mcu_fd_sc_mcu9t5v0__nor2_2
* cell instance $8187 r0 *1 1086.4,917.28
X$8187 12399 12508 12253 8326 gf180mcu_fd_sc_mcu9t5v0__buf_8
* cell instance $8188 m0 *1 1089.2,947.52
X$8188 13160 13054 gf180mcu_fd_sc_mcu9t5v0__filltie
* cell instance $8189 m0 *1 1076.32,937.44
X$8189 12909 12789 12908 12785 12900 7331 gf180mcu_fd_sc_mcu9t5v0__oai21_1
* cell instance $8190 r0 *1 1071.84,957.6
X$8190 14189 2270 13586 13428 13589 gf180mcu_fd_sc_mcu9t5v0__nor2_1
* cell instance $8191 m0 *1 1089.2,957.6
X$8191 13428 13318 gf180mcu_fd_sc_mcu9t5v0__filltie
* cell instance $8192 m0 *1 1097.6,947.52
X$8192 13020 13170 13024 13054 13160 2262 gf180mcu_fd_sc_mcu9t5v0__mux2_1
* cell instance $8193 r0 *1 1078.56,947.52
X$8193 15275 13456 13894 13331 13318 13160 gf180mcu_fd_sc_mcu9t5v0__dffrnq_2
* cell instance $8194 m0 *1 1049.44,927.36
X$8194 12626 12398 12394 11984 12508 12646 8974 gf180mcu_fd_sc_mcu9t5v0__and4_4
* cell instance $8195 m0 *1 1067.36,917.28
X$8195 12265 12128 12253 11357 gf180mcu_fd_sc_mcu9t5v0__buf_8
* cell instance $8196 m0 *1 1048.88,937.44
X$8196 13018 12906 12905 12907 12785 12900 12266
+ gf180mcu_fd_sc_mcu9t5v0__oai211_2
* cell instance $8197 m0 *1 1090.32,917.28
X$8197 9856 11607 12266 12399 12128 12253 12267 gf180mcu_fd_sc_mcu9t5v0__oai31_2
* cell instance $8198 m0 *1 1056.72,907.2
X$8198 11863 11971 12019 10854 gf180mcu_fd_sc_mcu9t5v0__buf_8
* cell instance $8199 r0 *1 1050,917.28
X$8199 11984 12398 12394 12508 12253 12626 11303
+ gf180mcu_fd_sc_mcu9t5v0__nand4_2
* cell instance $8200 r0 *1 1058.96,917.28
X$8200 12626 12754 12650 12508 12253 11466 gf180mcu_fd_sc_mcu9t5v0__nand3_2
* cell instance $8201 r0 *1 1051.68,957.6
X$8201 13212 3470 13454 14189 13586 13428 13588
+ gf180mcu_fd_sc_mcu9t5v0__aoi211_1
* cell instance $8202 m0 *1 1089.2,917.28
X$8202 12253 12128 gf180mcu_fd_sc_mcu9t5v0__filltie
* cell instance $8203 r0 *1 1050.56,927.36
X$8203 11984 12398 12394 12785 12646 12754 gf180mcu_fd_sc_mcu9t5v0__nand3_2
* cell instance $8204 r0 *1 1057.84,927.36
X$8204 12650 12754 12626 12785 12646 10723 gf180mcu_fd_sc_mcu9t5v0__and3_2
* cell instance $8205 m0 *1 1089.2,927.36
X$8205 12646 12508 gf180mcu_fd_sc_mcu9t5v0__filltie
* cell instance $8206 r0 *1 1089.2,927.36
X$8206 12266 12785 12646 7685 gf180mcu_fd_sc_mcu9t5v0__buf_8
* cell instance $8207 m0 *1 1060.08,957.6
X$8207 15275 13327 13430 13331 13318 13428 gf180mcu_fd_sc_mcu9t5v0__dffrnq_2
* cell instance $8208 r0 *1 1064.56,957.6
X$8208 13430 13455 13214 13586 13428 13327 gf180mcu_fd_sc_mcu9t5v0__mux2_1
* cell instance $8209 m0 *1 1089.2,937.44
X$8209 12900 12785 gf180mcu_fd_sc_mcu9t5v0__filltie
* cell instance $8210 r0 *1 1054.48,937.44
X$8210 12905 13054 12900 10203 gf180mcu_fd_sc_mcu9t5v0__buf_8
* cell instance $8211 r0 *1 1078,937.44
X$8211 12902 12909 8452 13054 12900 2256 gf180mcu_fd_sc_mcu9t5v0__mux2_1
* cell instance $8212 m0 *1 1068.48,927.36
X$8212 12627 12508 12646 6669 gf180mcu_fd_sc_mcu9t5v0__buf_8
* cell instance $8213 r0 *1 1085.84,957.6
X$8213 13894 13457 13214 13586 13428 13456 gf180mcu_fd_sc_mcu9t5v0__mux2_1
* cell instance $8214 r0 *1 1039.92,937.44
X$8214 13018 12906 12907 13054 12900 9552 gf180mcu_fd_sc_mcu9t5v0__oai21_4
* cell instance $8215 m0 *1 1089.2,907.2
X$8215 12019 11971 gf180mcu_fd_sc_mcu9t5v0__filltie
* cell instance $8216 r0 *1 1069.6,907.2
X$8216 11357 12128 12019 4030 gf180mcu_fd_sc_mcu9t5v0__buf_8
* cell instance $8217 r0 *1 1039.92,917.28
X$8217 4252 12261 12508 12253 12399 gf180mcu_fd_sc_mcu9t5v0__nand2_1
* cell instance $8218 m0 *1 1037.68,927.36
X$8218 4275 12261 12508 12646 12627 gf180mcu_fd_sc_mcu9t5v0__nand2_1
* cell instance $8219 r0 *1 1023.68,947.52
X$8219 11983 4258 11572 13318 13160 13326 gf180mcu_fd_sc_mcu9t5v0__nand3_1
* cell instance $8220 m0 *1 1019.76,907.2
X$8220 12025 11971 12019 10200 gf180mcu_fd_sc_mcu9t5v0__clkbuf_8
* cell instance $8221 m0 *1 1000.72,907.2
X$8221 11985 11986 11835 11971 12019 11836 gf180mcu_fd_sc_mcu9t5v0__oai21_4
* cell instance $8222 r0 *1 1032.64,927.36
X$8222 12904 11572 12785 12646 12650 gf180mcu_fd_sc_mcu9t5v0__nand2_1
* cell instance $8223 r0 *1 1027.6,927.36
X$8223 4258 11572 12785 12646 11356 gf180mcu_fd_sc_mcu9t5v0__nand2_2
* cell instance $8224 r0 *1 979.44,937.44
X$8224 12649 13054 12900 11985 gf180mcu_fd_sc_mcu9t5v0__clkbuf_8
* cell instance $8225 r0 *1 1009.68,957.6
X$8225 11572 13587 13586 13428 12789 gf180mcu_fd_sc_mcu9t5v0__nor2_2
* cell instance $8226 m0 *1 1019.2,957.6
X$8226 13326 13318 13428 4018 gf180mcu_fd_sc_mcu9t5v0__buf_8
* cell instance $8227 m0 *1 1011.92,947.52
X$8227 12263 12397 13882 13054 13160 12905 gf180mcu_fd_sc_mcu9t5v0__aoi21_2
* cell instance $8228 r0 *1 1005.2,937.44
X$8228 11572 11986 11985 11835 13054 12900 12753
+ gf180mcu_fd_sc_mcu9t5v0__oai31_1
* cell instance $8229 r0 *1 1011.92,937.44
X$8229 12263 12397 12259 13054 12900 12906 gf180mcu_fd_sc_mcu9t5v0__aoi21_4
* cell instance $8230 m0 *1 967.12,917.28
X$8230 12259 12624 12260 12393 12128 12253 12395 gf180mcu_fd_sc_mcu9t5v0__or4_1
* cell instance $8231 m0 *1 983.92,917.28
X$8231 12263 12396 12262 12264 12128 12253 11353
+ gf180mcu_fd_sc_mcu9t5v0__aoi211_4
* cell instance $8232 r0 *1 969.36,957.6
X$8232 13428 13586 gf180mcu_fd_sc_mcu9t5v0__filltie
* cell instance $8233 r0 *1 969.36,927.36
X$8233 12646 12785 gf180mcu_fd_sc_mcu9t5v0__filltie
* cell instance $8234 r0 *1 1010.8,927.36
X$8234 11986 11985 12785 12646 12398 gf180mcu_fd_sc_mcu9t5v0__nor2_2
* cell instance $8235 r0 *1 1009.68,907.2
X$8235 11985 11986 11835 11834 12128 12019 12025
+ gf180mcu_fd_sc_mcu9t5v0__oai31_4
* cell instance $8236 r0 *1 991.76,907.2
X$8236 4545 11985 11834 12263 12019 11185 12128
+ gf180mcu_fd_sc_mcu9t5v0__oai211_4
* cell instance $8237 r0 *1 979.44,957.6
X$8237 13204 12393 13452 13586 13428 11984 gf180mcu_fd_sc_mcu9t5v0__or3_4
* cell instance $8238 r0 *1 976.08,947.52
X$8238 13204 12393 13203 13318 13160 12263 gf180mcu_fd_sc_mcu9t5v0__or3_4
* cell instance $8239 r0 *1 995.12,917.28
X$8239 12398 12263 11572 12253 12394 11186 12396 12508
+ gf180mcu_fd_sc_mcu9t5v0__aoi221_4
* cell instance $8240 m0 *1 981.68,947.52
X$8240 13204 12393 13056 13054 13160 12397 gf180mcu_fd_sc_mcu9t5v0__or3_4
* cell instance $8241 m0 *1 1010.24,917.28
X$8241 12261 12258 12263 12397 12128 12253 11571
+ gf180mcu_fd_sc_mcu9t5v0__oai211_1
* cell instance $8242 r0 *1 998.48,947.52
X$8242 13206 13205 13318 13160 12752 gf180mcu_fd_sc_mcu9t5v0__or2_1
* cell instance $8243 m0 *1 988.4,937.44
X$8243 12787 11986 11984 12785 12900 12626 gf180mcu_fd_sc_mcu9t5v0__oai21_2
* cell instance $8244 r0 *1 995.12,957.6
X$8244 13453 13204 12393 13586 13428 11834 13452 gf180mcu_fd_sc_mcu9t5v0__or4_4
* cell instance $8245 m0 *1 1020.32,917.28
X$8245 11835 11983 11572 12128 12253 10317 gf180mcu_fd_sc_mcu9t5v0__nand3_4
* cell instance $8246 r0 *1 988.4,927.36
X$8246 11984 12263 12397 12785 12646 12264 gf180mcu_fd_sc_mcu9t5v0__nand3_2
* cell instance $8247 r0 *1 969.36,947.52
X$8247 13160 13318 gf180mcu_fd_sc_mcu9t5v0__filltie
* cell instance $8248 m0 *1 995.68,947.52
X$8248 13169 13054 13160 13206 gf180mcu_fd_sc_mcu9t5v0__clkbuf_8
* cell instance $8249 r0 *1 1005.2,947.52
X$8249 13206 13318 13160 9701 gf180mcu_fd_sc_mcu9t5v0__buf_8
* cell instance $8250 r0 *1 969.36,937.44
X$8250 12900 13054 gf180mcu_fd_sc_mcu9t5v0__filltie
* cell instance $8251 r0 *1 969.36,907.2
X$8251 12019 12128 gf180mcu_fd_sc_mcu9t5v0__filltie
* cell instance $8252 r0 *1 1025.92,937.44
X$8252 13453 13054 12900 12517 gf180mcu_fd_sc_mcu9t5v0__clkinv_1
* cell instance $8253 m0 *1 979.44,927.36
X$8253 13882 12395 12508 12646 10967 gf180mcu_fd_sc_mcu9t5v0__nor2_1
* cell instance $8254 r0 *1 970.48,957.6
X$8254 12259 12624 13204 12393 13586 13428 13016 gf180mcu_fd_sc_mcu9t5v0__nor4_1
* cell instance $8255 m0 *1 985.6,957.6
X$8255 13169 13205 13318 13428 13017 gf180mcu_fd_sc_mcu9t5v0__nor2_2
* cell instance $8256 r0 *1 992.88,947.52
X$8256 13204 13169 13318 13160 12788 gf180mcu_fd_sc_mcu9t5v0__nor2_2
* cell instance $8257 m0 *1 971.6,927.36
X$8257 12624 12260 12393 12508 12646 12261 gf180mcu_fd_sc_mcu9t5v0__nor3_2
* cell instance $8258 m0 *1 970.48,937.44
X$8258 12393 12260 13056 12785 12900 12649 gf180mcu_fd_sc_mcu9t5v0__nor3_4
* cell instance $8259 r0 *1 969.36,917.28
X$8259 12253 12508 gf180mcu_fd_sc_mcu9t5v0__filltie
* cell instance $8260 m0 *1 996.24,937.44
X$8260 11835 12264 13017 12788 12785 12900 11354
+ gf180mcu_fd_sc_mcu9t5v0__aoi211_4
* cell instance $8261 r0 *1 974.4,917.28
X$8261 12261 12516 12395 12397 12508 12253 12396
+ gf180mcu_fd_sc_mcu9t5v0__oai211_2
* cell instance $8262 m0 *1 975.52,917.28
X$8262 12261 12515 12024 12128 12253 12262 gf180mcu_fd_sc_mcu9t5v0__oai21_2
* cell instance $8263 m0 *1 1029.28,927.36
X$8263 13882 12261 12026 12508 12646 12265 gf180mcu_fd_sc_mcu9t5v0__nand3_1
* cell instance $8264 r0 *1 1028.16,947.52
X$8264 11983 4254 11572 13318 13160 13207 gf180mcu_fd_sc_mcu9t5v0__and3_1
* cell instance $8265 r0 *1 998.48,927.36
X$8265 12752 12753 12788 12785 12646 11573 gf180mcu_fd_sc_mcu9t5v0__aoi21_2
* cell instance $8266 m0 *1 1000.16,957.6
X$8266 13204 12393 13839 11834 13318 13428 10847
+ gf180mcu_fd_sc_mcu9t5v0__oai31_1
* cell instance $8267 m0 *1 967.12,947.52
X$8267 12903 13054 13160 11986 gf180mcu_fd_sc_mcu9t5v0__buf_8
* cell instance $8268 r0 *1 996.8,866.88
X$8268 11185 11181 11079 10318 gf180mcu_fd_sc_mcu9t5v0__buf_8
* cell instance $8269 m0 *1 1018.08,856.8
X$8269 10848 10847 10676 10714 9550 gf180mcu_fd_sc_mcu9t5v0__and2_2
* cell instance $8270 r0 *1 1008,856.8
X$8270 10848 10847 10833 10714 10199 gf180mcu_fd_sc_mcu9t5v0__nand2_1
* cell instance $8271 m0 *1 1001.28,897.12
X$8271 11835 11301 11834 11833 11720 11860 10201
+ gf180mcu_fd_sc_mcu9t5v0__aoi22_2
* cell instance $8272 r0 *1 969.36,856.8
X$8272 10714 10833 gf180mcu_fd_sc_mcu9t5v0__filltie
* cell instance $8273 r0 *1 969.36,846.72
X$8273 10570 10676 gf180mcu_fd_sc_mcu9t5v0__filltie
* cell instance $8274 r0 *1 969.36,887.04
X$8274 11600 11720 gf180mcu_fd_sc_mcu9t5v0__filltie
* cell instance $8275 m0 *1 988.96,836.64
X$8275 5911 10188 10308 2363 gf180mcu_fd_sc_mcu9t5v0__buf_8
* cell instance $8276 r0 *1 969.36,876.96
X$8276 11294 11461 gf180mcu_fd_sc_mcu9t5v0__filltie
* cell instance $8277 m0 *1 1012.48,866.88
X$8277 10200 11185 10317 10833 11079 9551 gf180mcu_fd_sc_mcu9t5v0__oai21_4
* cell instance $8278 r0 *1 969.36,866.88
X$8278 11079 11181 gf180mcu_fd_sc_mcu9t5v0__filltie
* cell instance $8279 m0 *1 980,897.12
X$8279 11832 11720 11860 11301 gf180mcu_fd_sc_mcu9t5v0__buf_8
* cell instance $8280 r0 *1 979.44,836.64
X$8280 10693 10345 6432 10338 10308 10346 gf180mcu_fd_sc_mcu9t5v0__aoi21_4
* cell instance $8281 m0 *1 1010.24,836.64
X$8281 10318 10317 10200 10188 10308 10202 gf180mcu_fd_sc_mcu9t5v0__nand3_4
* cell instance $8282 r0 *1 992.88,836.64
X$8282 10346 10338 10308 5911 gf180mcu_fd_sc_mcu9t5v0__buf_8
* cell instance $8283 m0 *1 1028.16,887.04
X$8283 11356 11574 11573 11461 11600 11302 gf180mcu_fd_sc_mcu9t5v0__nand3_2
* cell instance $8284 m0 *1 967.68,856.8
X$8284 5901 10676 10714 9816 gf180mcu_fd_sc_mcu9t5v0__clkbuf_8
* cell instance $8285 m0 *1 1010.8,887.04
X$8285 11571 11833 11572 11461 11600 11605 gf180mcu_fd_sc_mcu9t5v0__aoi21_1
* cell instance $8286 r0 *1 995.12,876.96
X$8286 11354 11461 11294 10695 gf180mcu_fd_sc_mcu9t5v0__buf_8
* cell instance $8287 r0 *1 976.64,846.72
X$8287 6919 6916 9319 10676 10570 10576 gf180mcu_fd_sc_mcu9t5v0__aoi21_1
* cell instance $8288 m0 *1 1010.24,897.12
X$8288 11836 11720 11860 10848 gf180mcu_fd_sc_mcu9t5v0__buf_8
* cell instance $8289 m0 *1 996.8,846.72
X$8289 10692 10338 10570 1961 gf180mcu_fd_sc_mcu9t5v0__buf_8
* cell instance $8290 m0 *1 1024.8,897.12
X$8290 11984 11571 11833 11720 11860 11574 gf180mcu_fd_sc_mcu9t5v0__nand3_2
* cell instance $8291 r0 *1 981.12,846.72
X$8291 10692 10676 10570 3446 gf180mcu_fd_sc_mcu9t5v0__buf_8
* cell instance $8292 r0 *1 969.36,836.64
X$8292 10308 10338 gf180mcu_fd_sc_mcu9t5v0__filltie
* cell instance $8293 m0 *1 977.2,876.96
X$8293 10967 11181 11294 5766 gf180mcu_fd_sc_mcu9t5v0__buf_8
* cell instance $8294 m0 *1 991.76,876.96
X$8294 11301 11353 11181 11294 10345 gf180mcu_fd_sc_mcu9t5v0__or2_1
* cell instance $8295 r0 *1 1010.8,856.8
X$8295 10849 10201 10848 10833 10714 10722 gf180mcu_fd_sc_mcu9t5v0__nand3_4
* cell instance $8296 r0 *1 970.48,836.64
X$8296 6399 10344 10198 10338 10308 10316 gf180mcu_fd_sc_mcu9t5v0__aoi21_1
* cell instance $8297 m0 *1 996.8,897.12
X$8297 4258 11984 11720 11860 11725 gf180mcu_fd_sc_mcu9t5v0__nor2_1
* cell instance $8298 r0 *1 1005.2,846.72
X$8298 10722 10676 10570 2255 gf180mcu_fd_sc_mcu9t5v0__buf_8
* cell instance $8299 m0 *1 982.24,856.8
X$8299 10722 10676 10714 3335 gf180mcu_fd_sc_mcu9t5v0__buf_8
* cell instance $8300 m0 *1 1002.96,876.96
X$8300 11301 11353 10695 11355 11181 11294 9854
+ gf180mcu_fd_sc_mcu9t5v0__oai211_2
* cell instance $8301 m0 *1 1020.88,887.04
X$8301 11356 11574 11186 11573 11461 11600 11575 gf180mcu_fd_sc_mcu9t5v0__and4_2
* cell instance $8302 r0 *1 1024.8,876.96
X$8302 11356 11574 11573 11461 11294 11080 gf180mcu_fd_sc_mcu9t5v0__and3_1
* cell instance $8303 r0 *1 1005.76,887.04
X$8303 11725 11605 11353 11301 11573 11720 11600 11606
+ gf180mcu_fd_sc_mcu9t5v0__oai221_4
* cell instance $8304 r0 *1 970.48,856.8
X$8304 10717 6557 7685 6669 10833 10714 10691 gf180mcu_fd_sc_mcu9t5v0__oai31_1
* cell instance $8305 m0 *1 996.8,856.8
X$8305 10723 10693 10676 10714 10692 gf180mcu_fd_sc_mcu9t5v0__nand2_2
* cell instance $8306 r0 *1 971.04,846.72
X$8306 10687 6669 10576 10691 10676 10570 10344 gf180mcu_fd_sc_mcu9t5v0__oai22_1
* cell instance $8307 r0 *1 971.04,887.04
X$8307 11724 11720 11600 4769 gf180mcu_fd_sc_mcu9t5v0__buf_8
* cell instance $8308 m0 *1 1089.2,836.64
X$8308 10308 10188 gf180mcu_fd_sc_mcu9t5v0__filltie
* cell instance $8309 m0 *1 1062.88,876.96
X$8309 11302 11303 10968 11181 11294 9549 gf180mcu_fd_sc_mcu9t5v0__oai21_4
* cell instance $8310 r0 *1 1048.32,836.64
X$8310 10203 9552 10338 10308 10348 gf180mcu_fd_sc_mcu9t5v0__nor2_1
* cell instance $8311 m0 *1 1054.48,866.88
X$8311 10850 10849 10967 10833 11079 10968 gf180mcu_fd_sc_mcu9t5v0__aoi21_4
* cell instance $8312 m0 *1 1089.2,887.04
X$8312 11600 11461 gf180mcu_fd_sc_mcu9t5v0__filltie
* cell instance $8313 r0 *1 1049.44,856.8
X$8313 10849 10833 10714 10688 gf180mcu_fd_sc_mcu9t5v0__buf_8
* cell instance $8314 r0 *1 1064.56,856.8
X$8314 9549 10833 10714 5545 gf180mcu_fd_sc_mcu9t5v0__clkbuf_8
* cell instance $8315 r0 *1 1040.48,846.72
X$8315 10348 10693 8974 10676 10570 10319 5667 gf180mcu_fd_sc_mcu9t5v0__aoi22_4
* cell instance $8316 r0 *1 1076.32,866.88
X$8316 11080 11181 11079 11189 gf180mcu_fd_sc_mcu9t5v0__buf_8
* cell instance $8317 m0 *1 1071.28,897.12
X$8317 11358 11720 11860 4029 gf180mcu_fd_sc_mcu9t5v0__buf_8
* cell instance $8318 m0 *1 1090.32,846.72
X$8318 10694 10084 10460 10338 10570 10321 gf180mcu_fd_sc_mcu9t5v0__nand3_1
* cell instance $8319 m0 *1 1089.2,846.72
X$8319 10570 10338 gf180mcu_fd_sc_mcu9t5v0__filltie
* cell instance $8320 r0 *1 1037.12,887.04
X$8320 11606 11839 11720 11600 11726 gf180mcu_fd_sc_mcu9t5v0__nand2_2
* cell instance $8321 r0 *1 1043.84,887.04
X$8321 10317 10318 11720 11600 11607 gf180mcu_fd_sc_mcu9t5v0__and2_1
* cell instance $8322 r0 *1 1060.64,876.96
X$8322 11302 11466 11357 11461 11294 11358 gf180mcu_fd_sc_mcu9t5v0__oai21_4
* cell instance $8323 r0 *1 1088.64,856.8
X$8323 10723 11080 10833 10714 10851 gf180mcu_fd_sc_mcu9t5v0__nand2_1
* cell instance $8324 r0 *1 1080.24,876.96
X$8324 11360 11461 11294 3340 gf180mcu_fd_sc_mcu9t5v0__buf_8
* cell instance $8325 r0 *1 1065.68,866.88
X$8325 11303 11302 10968 11187 11181 11079 11188
+ gf180mcu_fd_sc_mcu9t5v0__oai211_1
* cell instance $8326 m0 *1 1060.08,887.04
X$8326 11726 11461 11600 7566 gf180mcu_fd_sc_mcu9t5v0__buf_8
* cell instance $8327 r0 *1 1075.2,876.96
X$8327 11355 10695 11461 11294 11359 gf180mcu_fd_sc_mcu9t5v0__nand2_1
* cell instance $8328 r0 *1 1046.08,876.96
X$8328 11726 11461 11294 6399 gf180mcu_fd_sc_mcu9t5v0__buf_8
* cell instance $8329 m0 *1 1056.72,897.12
X$8329 10854 11720 11860 11727 gf180mcu_fd_sc_mcu9t5v0__buf_8
* cell instance $8330 r0 *1 1092,846.72
X$8330 10723 10084 10676 10570 10696 gf180mcu_fd_sc_mcu9t5v0__nand2_1
* cell instance $8331 m0 *1 1089.2,876.96
X$8331 11294 11181 gf180mcu_fd_sc_mcu9t5v0__filltie
* cell instance $8332 r0 *1 1076.88,846.72
X$8332 11355 10695 10676 10570 10084 gf180mcu_fd_sc_mcu9t5v0__and2_1
* cell instance $8333 m0 *1 1089.2,856.8
X$8333 10714 10676 gf180mcu_fd_sc_mcu9t5v0__filltie
* cell instance $8334 m0 *1 1069.6,856.8
X$8334 11355 10695 10694 10676 10714 9582 gf180mcu_fd_sc_mcu9t5v0__nand3_4
* cell instance $8335 m0 *1 1077.44,887.04
X$8335 11359 11466 11357 11461 11600 11360 gf180mcu_fd_sc_mcu9t5v0__oai21_2
* cell instance $8336 m0 *1 1089.2,897.12
X$8336 11860 11720 gf180mcu_fd_sc_mcu9t5v0__filltie
* cell instance $8337 m0 *1 1042.16,897.12
X$8337 11839 11720 11860 6042 gf180mcu_fd_sc_mcu9t5v0__buf_8
* cell instance $8338 m0 *1 1089.2,866.88
X$8338 11079 10833 gf180mcu_fd_sc_mcu9t5v0__filltie
* cell instance $8339 m0 *1 1090.32,866.88
X$8339 10694 11189 10833 11079 8333 gf180mcu_fd_sc_mcu9t5v0__nand2_1
* cell instance $8340 m0 *1 1040.48,836.64
X$8340 10200 10317 10188 10308 9855 gf180mcu_fd_sc_mcu9t5v0__and2_2
* cell instance $8341 m0 *1 1092,836.64
X$8341 10323 4027 7345 10320 10321 10188 10308 10322
+ gf180mcu_fd_sc_mcu9t5v0__oai221_1
* cell instance $8342 m0 *1 1048.88,836.64
X$8342 10319 10188 10308 6914 gf180mcu_fd_sc_mcu9t5v0__buf_8
* cell instance $8343 r0 *1 1051.68,836.64
X$8343 10319 10338 10308 2134 gf180mcu_fd_sc_mcu9t5v0__buf_20
* cell instance $8344 r0 *1 684.88,1048.32
X$8344 16191 16647 12241 16194 16008 16137 gf180mcu_fd_sc_mcu9t5v0__mux2_1
* cell instance $8345 m0 *1 679.84,1058.4
X$8345 16641 16137 16191 12383 16194 16309 gf180mcu_fd_sc_mcu9t5v0__dffrnq_2
* cell instance $8346 r0 *1 687.68,1088.64
X$8346 16641 17287 17236 11958 17398 17289 gf180mcu_fd_sc_mcu9t5v0__dffrnq_2
* cell instance $8347 m0 *1 690.48,1088.64
X$8347 17236 17394 12241 17123 17289 17287 gf180mcu_fd_sc_mcu9t5v0__mux2_1
* cell instance $8348 r0 *1 674.8,997.92
X$8348 14160 14648 14704 12383 14708 14448 gf180mcu_fd_sc_mcu9t5v0__dffrnq_2
* cell instance $8349 m0 *1 690.48,1018.08
X$8349 15003 14852 14967 15138 15136 gf180mcu_fd_sc_mcu9t5v0__nand2_1
* cell instance $8350 r0 *1 684.88,1018.08
X$8350 14160 15136 15004 12383 15271 15138 gf180mcu_fd_sc_mcu9t5v0__dffrnq_2
* cell instance $8351 m0 *1 673.68,957.6
X$8351 12381 13316 13192 12383 13318 13428 gf180mcu_fd_sc_mcu9t5v0__dffrnq_2
* cell instance $8352 r0 *1 686,967.68
X$8352 15401 13828 13825 13832 13719 13827 gf180mcu_fd_sc_mcu9t5v0__mux2_1
* cell instance $8353 m0 *1 695.52,967.68
X$8353 13691 13586 13719 12892 gf180mcu_fd_sc_mcu9t5v0__buf_8
* cell instance $8354 m0 *1 657.44,967.68
X$8354 12381 13690 13191 11958 13586 13719 gf180mcu_fd_sc_mcu9t5v0__dffrnq_2
* cell instance $8355 r0 *1 690.48,947.52
X$8355 13192 11596 13318 13160 13052 gf180mcu_fd_sc_mcu9t5v0__nand2_1
* cell instance $8356 r0 *1 674.24,927.36
X$8356 12381 12644 12614 12383 12785 12646 gf180mcu_fd_sc_mcu9t5v0__dffrnq_2
* cell instance $8357 m0 *1 689.36,947.52
X$8357 12011 13193 13004 13154 13151 13054 13160 13152
+ gf180mcu_fd_sc_mcu9t5v0__aoi221_1
* cell instance $8358 r0 *1 687.68,917.28
X$8358 12381 12246 12248 12383 12508 12253 gf180mcu_fd_sc_mcu9t5v0__dffrnq_2
* cell instance $8359 m0 *1 676.48,967.68
X$8359 15401 13191 14702 13586 13719 13690 gf180mcu_fd_sc_mcu9t5v0__mux2_1
* cell instance $8360 m0 *1 645.12,967.68
X$8360 13692 12005 13002 13586 13719 13689 gf180mcu_fd_sc_mcu9t5v0__nand3_1
* cell instance $8361 m0 *1 639.52,967.68
X$8361 13442 12784 11964 13584 13586 13719 14157
+ gf180mcu_fd_sc_mcu9t5v0__oai211_1
* cell instance $8362 m0 *1 609.84,967.68
X$8362 13719 13586 gf180mcu_fd_sc_mcu9t5v0__filltie
* cell instance $8363 m0 *1 597.52,967.68
X$8363 13688 13713 14150 13586 13719 13714 gf180mcu_fd_sc_mcu9t5v0__nand3_1
* cell instance $8364 m0 *1 620.48,967.68
X$8364 12381 13583 13442 11958 13586 13719 gf180mcu_fd_sc_mcu9t5v0__dffrnq_2
* cell instance $8365 r0 *1 677.6,876.96
X$8365 10074 11288 11289 11461 11294 gf180mcu_fd_sc_mcu9t5v0__dffq_2
* cell instance $8366 r0 *1 690.48,897.12
X$8366 11963 11969 11964 11971 11860 11970 gf180mcu_fd_sc_mcu9t5v0__oai21_1
* cell instance $8367 r0 *1 681.52,846.72
X$8367 8197 10567 10453 10676 10570 gf180mcu_fd_sc_mcu9t5v0__dffq_2
* cell instance $8368 m0 *1 686,876.96
X$8368 11289 9709 6250 11181 11294 11288 gf180mcu_fd_sc_mcu9t5v0__mux2_1
* cell instance $8369 m0 *1 774.48,967.68
X$8369 13833 13873 12898 13586 13719 13718 gf180mcu_fd_sc_mcu9t5v0__mux2_1
* cell instance $8370 m0 *1 679.28,977.76
X$8370 14160 13827 13828 12383 13832 14009 gf180mcu_fd_sc_mcu9t5v0__dffrnq_2
* cell instance $8371 m0 *1 712.32,967.68
X$8371 12615 13193 13585 13154 13151 13586 13719 13715
+ gf180mcu_fd_sc_mcu9t5v0__aoi221_1
* cell instance $8372 m0 *1 815.92,967.68
X$8372 13720 13868 12898 13586 13719 13834 gf180mcu_fd_sc_mcu9t5v0__mux2_1
* cell instance $8373 m0 *1 733.04,967.68
X$8373 12506 13193 13424 13154 13151 13586 13719 13717
+ gf180mcu_fd_sc_mcu9t5v0__aoi221_1
* cell instance $8374 m0 *1 730.24,967.68
X$8374 13052 13445 13586 13719 13716 gf180mcu_fd_sc_mcu9t5v0__nand2_1
* cell instance $8375 m0 *1 688.24,836.64
X$8375 8197 10303 10185 10188 10308 gf180mcu_fd_sc_mcu9t5v0__dffq_2
* cell instance $8376 m0 *1 688.8,846.72
X$8376 9709 10453 4923 10338 10570 10567 gf180mcu_fd_sc_mcu9t5v0__mux2_1
* cell instance $8377 m0 *1 576.24,967.68
X$8377 13713 13685 13586 13719 13712 gf180mcu_fd_sc_mcu9t5v0__nor2_1
* cell instance $8378 m0 *1 579.6,967.68
X$8378 13687 13686 13586 13719 13685 gf180mcu_fd_sc_mcu9t5v0__nor2_1
* cell instance $8379 m0 *1 743.12,1018.08
X$8379 14160 14966 15006 13331 14967 15138 gf180mcu_fd_sc_mcu9t5v0__dffrnq_2
* cell instance $8380 m0 *1 734.72,1038.24
X$8380 14160 15687 15524 12383 15576 15737 gf180mcu_fd_sc_mcu9t5v0__dffrnq_2
* cell instance $8381 r0 *1 758.24,987.84
X$8381 13831 14301 14168 13331 14406 14304 gf180mcu_fd_sc_mcu9t5v0__dffrnq_2
* cell instance $8382 m0 *1 800.8,1038.24
X$8382 16144 15269 15399 15691 15575 15576 15737 15404
+ gf180mcu_fd_sc_mcu9t5v0__aoi221_1
* cell instance $8383 m0 *1 784.56,1038.24
X$8383 14709 16140 12898 15576 15737 15525 gf180mcu_fd_sc_mcu9t5v0__mux2_1
* cell instance $8384 m0 *1 808.64,1038.24
X$8384 16142 15692 15579 13331 15576 15737 gf180mcu_fd_sc_mcu9t5v0__dffrnq_2
* cell instance $8385 m0 *1 693.84,1038.24
X$8385 14160 15572 15523 12383 15576 15737 gf180mcu_fd_sc_mcu9t5v0__dffrnq_2
* cell instance $8386 m0 *1 760.48,1038.24
X$8386 15400 15689 15576 15737 15690 gf180mcu_fd_sc_mcu9t5v0__nor2_1
* cell instance $8387 m0 *1 740.88,1008
X$8387 14160 14707 14811 13331 14708 14857 gf180mcu_fd_sc_mcu9t5v0__dffrnq_2
* cell instance $8388 m0 *1 715.68,1038.24
X$8388 14160 15686 15398 12383 15576 15737 gf180mcu_fd_sc_mcu9t5v0__dffrnq_2
* cell instance $8389 m0 *1 756,977.76
X$8389 13874 13873 13055 13832 14009 13872 gf180mcu_fd_sc_mcu9t5v0__mux2_1
* cell instance $8390 r0 *1 749.84,967.68
X$8390 13831 13872 13873 13331 13832 13719 gf180mcu_fd_sc_mcu9t5v0__dffrnq_2
* cell instance $8391 m0 *1 753.76,1038.24
X$8391 15524 15269 15399 15007 15575 15576 15737 15688
+ gf180mcu_fd_sc_mcu9t5v0__aoi221_1
* cell instance $8392 m0 *1 763.84,1038.24
X$8392 13831 15690 15577 12383 15576 15737 gf180mcu_fd_sc_mcu9t5v0__dffrnq_2
* cell instance $8393 r0 *1 743.12,1078.56
X$8393 14160 17082 16650 12383 17123 16956 gf180mcu_fd_sc_mcu9t5v0__dffrnq_2
* cell instance $8394 m0 *1 756,1078.56
X$8394 16140 16783 16919 16784 16956 16918 gf180mcu_fd_sc_mcu9t5v0__oai21_1
* cell instance $8395 r0 *1 758.24,1048.32
X$8395 16140 16139 16194 16008 15855 gf180mcu_fd_sc_mcu9t5v0__and2_1
* cell instance $8396 r0 *1 758.8,1058.4
X$8396 16140 16139 16506 16309 16193 gf180mcu_fd_sc_mcu9t5v0__nor2_1
* cell instance $8397 m0 *1 757.68,1058.4
X$8397 15400 15855 16193 16194 16309 16195 gf180mcu_fd_sc_mcu9t5v0__nor3_1
* cell instance $8398 m0 *1 758.24,987.84
X$8398 14168 14165 12898 14126 14304 14301 gf180mcu_fd_sc_mcu9t5v0__mux2_1
* cell instance $8399 r0 *1 776.72,1078.56
X$8399 16142 16954 16955 12383 17123 16956 gf180mcu_fd_sc_mcu9t5v0__dffrnq_2
* cell instance $8400 m0 *1 767.76,1068.48
X$8400 16445 16650 12898 16506 16653 16651 gf180mcu_fd_sc_mcu9t5v0__mux2_1
* cell instance $8401 r0 *1 764.96,1068.48
X$8401 16142 16651 16445 12383 16784 16653 gf180mcu_fd_sc_mcu9t5v0__dffrnq_2
* cell instance $8402 r0 *1 795.2,1068.48
X$8402 16955 16652 16439 16784 16653 16785 gf180mcu_fd_sc_mcu9t5v0__mux2_1
* cell instance $8403 m0 *1 808.64,1058.4
X$8403 16142 16145 16146 13331 16194 16309 gf180mcu_fd_sc_mcu9t5v0__dffrnq_2
* cell instance $8404 m0 *1 806.4,1068.48
X$8404 16652 15269 15399 16507 15575 16506 16653 16654
+ gf180mcu_fd_sc_mcu9t5v0__aoi221_1
* cell instance $8405 m0 *1 812.56,1068.48
X$8405 16654 13194 16506 16653 16655 gf180mcu_fd_sc_mcu9t5v0__nor2_1
* cell instance $8406 m0 *1 794.08,1058.4
X$8406 16308 16144 16439 16194 16309 16143 gf180mcu_fd_sc_mcu9t5v0__mux2_1
* cell instance $8407 m0 *1 794.08,1098.72
X$8407 17518 17520 16439 17398 17521 17519 gf180mcu_fd_sc_mcu9t5v0__mux2_1
* cell instance $8408 r0 *1 804.16,1088.64
X$8408 17290 13715 17398 17289 17399 gf180mcu_fd_sc_mcu9t5v0__nor2_1
* cell instance $8409 m0 *1 784,1078.56
X$8409 13010 16955 16141 16784 16956 16954 gf180mcu_fd_sc_mcu9t5v0__mux2_1
* cell instance $8410 r0 *1 807.52,1078.56
X$8410 16142 17123 16956 gf180mcu_fd_sc_mcu9t5v0__clkinv_3
* cell instance $8411 m0 *1 785.68,1058.4
X$8411 13874 16308 16141 16194 16309 16307 gf180mcu_fd_sc_mcu9t5v0__mux2_1
* cell instance $8412 r0 *1 817.04,1098.72
X$8412 14856 17571 16141 17709 17521 17710 gf180mcu_fd_sc_mcu9t5v0__mux2_1
* cell instance $8413 r0 *1 816.48,1048.32
X$8413 15401 16146 16141 16194 16008 16145 gf180mcu_fd_sc_mcu9t5v0__mux2_1
* cell instance $8414 r0 *1 790.72,1098.72
X$8414 16142 17519 17520 12383 17709 17521 gf180mcu_fd_sc_mcu9t5v0__dffrnq_2
* cell instance $8415 r0 *1 790.16,1048.32
X$8415 16142 16143 16144 12383 16194 16008 gf180mcu_fd_sc_mcu9t5v0__dffrnq_2
* cell instance $8416 m0 *1 792.4,1078.56
X$8416 16142 16785 16652 12383 16784 16956 gf180mcu_fd_sc_mcu9t5v0__dffrnq_2
* cell instance $8417 r0 *1 809.2,1068.48
X$8417 4924 16784 16653 16142 gf180mcu_fd_sc_mcu9t5v0__clkbuf_8
* cell instance $8418 m0 *1 813.12,1078.56
X$8418 16655 16784 16956 16957 gf180mcu_fd_sc_mcu9t5v0__buf_8
* cell instance $8419 m0 *1 803.04,1098.72
X$8419 17520 15269 15399 17238 15575 17398 17521 17290
+ gf180mcu_fd_sc_mcu9t5v0__aoi221_1
* cell instance $8420 m0 *1 818.16,1088.64
X$8420 14166 17239 16141 17123 17289 17083 gf180mcu_fd_sc_mcu9t5v0__mux2_1
* cell instance $8421 m0 *1 762.16,1058.4
X$8421 16142 16195 16140 12383 16194 16309 gf180mcu_fd_sc_mcu9t5v0__dffrnq_2
* cell instance $8422 r0 *1 818.16,1038.24
X$8422 14809 15579 16141 15898 15737 15692 gf180mcu_fd_sc_mcu9t5v0__mux2_1
* cell instance $8423 m0 *1 775.6,1088.64
X$8423 13826 17123 17289 13010 gf180mcu_fd_sc_mcu9t5v0__clkbuf_1
* cell instance $8424 m0 *1 759.92,1068.48
X$8424 16306 15577 16650 16506 16653 16783 gf180mcu_fd_sc_mcu9t5v0__nand3_1
* cell instance $8425 r0 *1 771.68,1038.24
X$8425 15574 15898 15737 15856 gf180mcu_fd_sc_mcu9t5v0__buf_8
* cell instance $8426 r0 *1 759.92,1088.64
X$8426 16919 17398 17289 12898 gf180mcu_fd_sc_mcu9t5v0__buf_8
* cell instance $8427 r0 *1 762.16,1078.56
X$8427 16140 16783 17123 16956 18101 gf180mcu_fd_sc_mcu9t5v0__nor2_1
* cell instance $8428 m0 *1 780.64,1098.72
X$8428 14854 17518 16141 17398 17521 17517 gf180mcu_fd_sc_mcu9t5v0__mux2_1
* cell instance $8429 r0 *1 771.68,1098.72
X$8429 16142 17517 17518 12383 17709 17521 gf180mcu_fd_sc_mcu9t5v0__dffrnq_2
* cell instance $8430 r0 *1 761.04,1038.24
X$8430 15577 15855 15898 15737 15689 gf180mcu_fd_sc_mcu9t5v0__xnor2_1
* cell instance $8431 r0 *1 778.4,1058.4
X$8431 16142 16307 16308 12383 16506 16309 gf180mcu_fd_sc_mcu9t5v0__dffrnq_2
* cell instance $8432 r0 *1 730.8,1048.32
X$8432 16006 15269 15399 16007 16194 16008 16003
+ gf180mcu_fd_sc_mcu9t5v0__aoi22_1
* cell instance $8433 m0 *1 719.6,1068.48
X$8433 14160 16648 16649 12383 16506 16653 gf180mcu_fd_sc_mcu9t5v0__dffrnq_2
* cell instance $8434 m0 *1 692.16,1078.56
X$8434 16915 16784 16956 16952 gf180mcu_fd_sc_mcu9t5v0__buf_8
* cell instance $8435 m0 *1 698.88,1048.32
X$8435 16191 12784 13154 15573 15898 16008 16004
+ gf180mcu_fd_sc_mcu9t5v0__oai211_1
* cell instance $8436 r0 *1 745.92,1048.32
X$8436 15400 16139 16138 16194 16008 16192 gf180mcu_fd_sc_mcu9t5v0__nor3_1
* cell instance $8437 m0 *1 693.84,1048.32
X$8437 16004 15852 16003 13151 15898 16008 16915
+ gf180mcu_fd_sc_mcu9t5v0__aoi22_1
* cell instance $8438 m0 *1 753.2,1098.72
X$8438 17570 17397 17398 17521 17516 gf180mcu_fd_sc_mcu9t5v0__nor2_1
* cell instance $8439 r0 *1 729.68,1038.24
X$8439 15737 15898 gf180mcu_fd_sc_mcu9t5v0__filltie
* cell instance $8440 r0 *1 729.68,1088.64
X$8440 17289 17398 gf180mcu_fd_sc_mcu9t5v0__filltie
* cell instance $8441 r0 *1 729.68,1098.72
X$8441 17521 17709 gf180mcu_fd_sc_mcu9t5v0__filltie
* cell instance $8442 r0 *1 729.68,1048.32
X$8442 16008 16194 gf180mcu_fd_sc_mcu9t5v0__filltie
* cell instance $8443 r0 *1 744.24,1058.4
X$8443 16306 16440 16506 16309 16138 gf180mcu_fd_sc_mcu9t5v0__nor2_1
* cell instance $8444 r0 *1 729.68,1058.4
X$8444 16309 16506 gf180mcu_fd_sc_mcu9t5v0__filltie
* cell instance $8445 m0 *1 753.2,1078.56
X$8445 16650 16784 16956 16953 gf180mcu_fd_sc_mcu9t5v0__clkinv_1
* cell instance $8446 r0 *1 729.68,1068.48
X$8446 16653 16784 gf180mcu_fd_sc_mcu9t5v0__filltie
* cell instance $8447 m0 *1 744.24,1078.56
X$8447 16918 16917 16953 16784 16956 16440 gf180mcu_fd_sc_mcu9t5v0__aoi21_1
* cell instance $8448 r0 *1 729.68,1078.56
X$8448 16956 17123 gf180mcu_fd_sc_mcu9t5v0__filltie
* cell instance $8449 r0 *1 747.6,1058.4
X$8449 16306 16440 16506 16309 16139 gf180mcu_fd_sc_mcu9t5v0__and2_1
* cell instance $8450 m0 *1 721.28,1048.32
X$8450 14856 16006 16439 15898 16008 16005 gf180mcu_fd_sc_mcu9t5v0__mux2_1
* cell instance $8451 m0 *1 730.24,1078.56
X$8451 16649 15269 15399 16782 16784 16956 16644
+ gf180mcu_fd_sc_mcu9t5v0__aoi22_1
* cell instance $8452 r0 *1 720.72,1098.72
X$8452 17948 12784 13154 12507 17709 17521 18100
+ gf180mcu_fd_sc_mcu9t5v0__oai211_1
* cell instance $8453 m0 *1 745.92,1088.64
X$8453 16953 16918 16440 17123 17289 17082 gf180mcu_fd_sc_mcu9t5v0__aoi21_1
* cell instance $8454 m0 *1 708.96,1098.72
X$8454 17569 15269 15399 17515 17398 17521 17285
+ gf180mcu_fd_sc_mcu9t5v0__aoi22_1
* cell instance $8455 m0 *1 706.72,1058.4
X$8455 16438 15269 15399 16305 16194 16309 16304
+ gf180mcu_fd_sc_mcu9t5v0__aoi22_1
* cell instance $8456 r0 *1 730.8,1088.64
X$8456 17122 17120 17288 13151 17398 17289 17395
+ gf180mcu_fd_sc_mcu9t5v0__aoi22_1
* cell instance $8457 r0 *1 707.84,1098.72
X$8457 13010 17569 16439 17709 17521 17708 gf180mcu_fd_sc_mcu9t5v0__mux2_1
* cell instance $8458 r0 *1 710.64,1048.32
X$8458 14160 16005 16006 12383 16194 16008 gf180mcu_fd_sc_mcu9t5v0__dffrnq_2
* cell instance $8459 r0 *1 754.32,1098.72
X$8459 17570 17397 17709 17521 16919 gf180mcu_fd_sc_mcu9t5v0__and2_1
* cell instance $8460 m0 *1 706.16,1088.64
X$8460 16641 17121 17237 11958 17123 17289 gf180mcu_fd_sc_mcu9t5v0__dffrnq_2
* cell instance $8461 r0 *1 713.44,1078.56
X$8461 14166 17237 16439 17123 16956 17121 gf180mcu_fd_sc_mcu9t5v0__mux2_1
* cell instance $8462 r0 *1 704.48,1058.4
X$8462 13874 16438 16439 16506 16309 16505 gf180mcu_fd_sc_mcu9t5v0__mux2_1
* cell instance $8463 r0 *1 730.8,1068.48
X$8463 14854 16649 16439 16784 16653 16648 gf180mcu_fd_sc_mcu9t5v0__mux2_1
* cell instance $8464 m0 *1 736.96,1058.4
X$8464 14160 16192 16306 12383 16194 16309 gf180mcu_fd_sc_mcu9t5v0__dffrnq_2
* cell instance $8465 m0 *1 697.2,1068.48
X$8465 14160 16505 16438 12383 16506 16653 gf180mcu_fd_sc_mcu9t5v0__dffrnq_2
* cell instance $8466 r0 *1 749.84,1098.72
X$8466 17570 15529 18729 17709 17521 14167 gf180mcu_fd_sc_mcu9t5v0__nor3_1
* cell instance $8467 m0 *1 727.44,1088.64
X$8467 17236 12784 13154 15270 17123 17289 17122
+ gf180mcu_fd_sc_mcu9t5v0__oai211_1
* cell instance $8468 r0 *1 724.64,1088.64
X$8468 17237 15269 15399 17396 17398 17289 17288
+ gf180mcu_fd_sc_mcu9t5v0__aoi22_1
* cell instance $8469 r0 *1 701.68,1028.16
X$8469 11323 15523 13825 15576 15402 15572 gf180mcu_fd_sc_mcu9t5v0__mux2_1
* cell instance $8470 r0 *1 730.8,997.92
X$8470 14650 12005 13829 14708 14448 14706 gf180mcu_fd_sc_mcu9t5v0__nand3_1
* cell instance $8471 r0 *1 748.16,997.92
X$8471 14651 14708 14448 14707 gf180mcu_fd_sc_mcu9t5v0__clkinv_1
* cell instance $8472 m0 *1 749.84,987.84
X$8472 14166 14167 13055 14165 14126 14304 14164
+ gf180mcu_fd_sc_mcu9t5v0__aoi22_1
* cell instance $8473 m0 *1 756,1028.16
X$8473 15400 14167 15271 15402 13055 gf180mcu_fd_sc_mcu9t5v0__nor2_1
* cell instance $8474 r0 *1 753.2,1008
X$8474 14854 14167 13055 15006 14967 14857 14853
+ gf180mcu_fd_sc_mcu9t5v0__aoi22_1
* cell instance $8475 r0 *1 752.08,1028.16
X$8475 15688 13152 15576 15402 15574 gf180mcu_fd_sc_mcu9t5v0__nor2_1
* cell instance $8476 r0 *1 725.2,1018.08
X$8476 15005 12005 13829 15271 15138 15137 gf180mcu_fd_sc_mcu9t5v0__nand3_1
* cell instance $8477 r0 *1 731.92,1018.08
X$8477 12784 15137 6540 15271 15138 15270 gf180mcu_fd_sc_mcu9t5v0__nand3_1
* cell instance $8478 r0 *1 742,1028.16
X$8478 15401 15524 16439 15576 15402 15687 gf180mcu_fd_sc_mcu9t5v0__mux2_1
* cell instance $8479 r0 *1 729.68,977.76
X$8479 14009 14126 gf180mcu_fd_sc_mcu9t5v0__filltie
* cell instance $8480 r0 *1 729.68,987.84
X$8480 14304 14406 gf180mcu_fd_sc_mcu9t5v0__filltie
* cell instance $8481 m0 *1 728,1008
X$8481 12784 14706 6389 14708 14857 14703 gf180mcu_fd_sc_mcu9t5v0__nand3_1
* cell instance $8482 r0 *1 692.72,987.84
X$8482 14160 14300 14161 13331 14406 14304 gf180mcu_fd_sc_mcu9t5v0__dffrnq_2
* cell instance $8483 r0 *1 729.68,1008
X$8483 14857 14967 gf180mcu_fd_sc_mcu9t5v0__filltie
* cell instance $8484 m0 *1 722.4,1028.16
X$8484 14809 15398 16439 15271 15402 15686 gf180mcu_fd_sc_mcu9t5v0__mux2_1
* cell instance $8485 m0 *1 729.68,1028.16
X$8485 15398 15269 15399 15268 15271 15402 15396
+ gf180mcu_fd_sc_mcu9t5v0__aoi22_1
* cell instance $8486 r0 *1 711.76,977.76
X$8486 12784 13869 12015 14126 14009 14162 gf180mcu_fd_sc_mcu9t5v0__nand3_1
* cell instance $8487 m0 *1 706.16,987.84
X$8487 14161 12784 11964 14162 14126 14304 16916
+ gf180mcu_fd_sc_mcu9t5v0__oai211_1
* cell instance $8488 m0 *1 698.88,987.84
X$8488 14161 13868 12241 14126 14304 14300 gf180mcu_fd_sc_mcu9t5v0__mux2_1
* cell instance $8489 r0 *1 715.68,1008
X$8489 13692 15005 13825 14967 14857 14965 gf180mcu_fd_sc_mcu9t5v0__mux2_1
* cell instance $8490 r0 *1 714,1028.16
X$8490 4924 15576 15402 14160 gf180mcu_fd_sc_mcu9t5v0__clkbuf_8
* cell instance $8491 m0 *1 714,1028.16
X$8491 14160 15271 15402 gf180mcu_fd_sc_mcu9t5v0__clkbuf_4
* cell instance $8492 m0 *1 715.68,977.76
X$8492 14160 13870 13871 13331 13832 14009 gf180mcu_fd_sc_mcu9t5v0__dffrnq_2
* cell instance $8493 r0 *1 721.84,977.76
X$8493 13868 13871 13825 14126 14009 13870 gf180mcu_fd_sc_mcu9t5v0__mux2_1
* cell instance $8494 m0 *1 708.4,1018.08
X$8494 14160 14965 15005 12383 14967 15138 gf180mcu_fd_sc_mcu9t5v0__dffrnq_2
* cell instance $8495 m0 *1 710.64,977.76
X$8495 13868 12005 13829 13832 14009 13869 gf180mcu_fd_sc_mcu9t5v0__nand3_1
* cell instance $8496 r0 *1 729.68,997.92
X$8496 14448 14708 gf180mcu_fd_sc_mcu9t5v0__filltie
* cell instance $8497 r0 *1 725.76,967.68
X$8497 13871 12005 13829 13832 13719 12616 gf180mcu_fd_sc_mcu9t5v0__nand3_1
* cell instance $8498 r0 *1 729.68,967.68
X$8498 13719 13832 gf180mcu_fd_sc_mcu9t5v0__filltie
* cell instance $8499 r0 *1 735.84,967.68
X$8499 12384 13193 13716 13154 13151 13832 13719 13830
+ gf180mcu_fd_sc_mcu9t5v0__aoi221_1
* cell instance $8500 m0 *1 703.92,1028.16
X$8500 15523 12005 13829 15271 15402 15397 gf180mcu_fd_sc_mcu9t5v0__nand3_1
* cell instance $8501 m0 *1 693.28,1018.08
X$8501 15004 12245 14967 15138 15003 gf180mcu_fd_sc_mcu9t5v0__nand2_1
* cell instance $8502 r0 *1 699.44,997.92
X$8502 14298 12005 13829 14708 14448 14649 gf180mcu_fd_sc_mcu9t5v0__nand3_1
* cell instance $8503 r0 *1 749.84,1008
X$8503 14853 14967 14857 14966 gf180mcu_fd_sc_mcu9t5v0__clkinv_1
* cell instance $8504 r0 *1 729.68,1028.16
X$8504 15402 15576 gf180mcu_fd_sc_mcu9t5v0__filltie
* cell instance $8505 r0 *1 708.96,1028.16
X$8505 12784 15397 6803 15576 15402 15573 gf180mcu_fd_sc_mcu9t5v0__nand3_1
* cell instance $8506 r0 *1 703.36,997.92
X$8506 12784 14649 12505 14708 14448 14705 gf180mcu_fd_sc_mcu9t5v0__nand3_1
* cell instance $8507 m0 *1 693.28,1008
X$8507 14704 12784 11964 14705 14708 14857 14852
+ gf180mcu_fd_sc_mcu9t5v0__oai211_1
* cell instance $8508 m0 *1 744.24,987.84
X$8508 14164 14126 14304 14163 gf180mcu_fd_sc_mcu9t5v0__clkinv_1
* cell instance $8509 r0 *1 693.28,967.68
X$8509 13828 12005 13829 13832 13719 13691 gf180mcu_fd_sc_mcu9t5v0__and3_1
* cell instance $8510 m0 *1 717.36,997.92
X$8510 14160 14446 14650 12383 14406 14448 gf180mcu_fd_sc_mcu9t5v0__dffrnq_2
* cell instance $8511 r0 *1 729.68,1018.08
X$8511 15138 15271 gf180mcu_fd_sc_mcu9t5v0__filltie
* cell instance $8512 r0 *1 722.4,997.92
X$8512 14298 14650 13825 14708 14448 14446 gf180mcu_fd_sc_mcu9t5v0__mux2_1
* cell instance $8513 r0 *1 736.96,987.84
X$8513 14160 14163 14165 13331 14406 14304 gf180mcu_fd_sc_mcu9t5v0__dffrnq_2
* cell instance $8514 m0 *1 739.2,987.84
X$8514 13314 14126 14304 13868 gf180mcu_fd_sc_mcu9t5v0__buf_1
* cell instance $8515 r0 *1 752.64,997.92
X$8515 14809 14167 13055 14811 14708 14448 14651
+ gf180mcu_fd_sc_mcu9t5v0__aoi22_1
* cell instance $8516 r0 *1 767.76,1008
X$8516 15008 15006 12898 14967 14857 14968 gf180mcu_fd_sc_mcu9t5v0__mux2_1
* cell instance $8517 r0 *1 804.72,1028.16
X$8517 15403 15576 15402 15578 gf180mcu_fd_sc_mcu9t5v0__buf_8
* cell instance $8518 m0 *1 786.24,997.92
X$8518 13831 14407 14303 13331 14406 14448 gf180mcu_fd_sc_mcu9t5v0__dffrnq_2
* cell instance $8519 r0 *1 786.8,977.76
X$8519 13831 14008 13875 13331 14126 14009 gf180mcu_fd_sc_mcu9t5v0__dffrnq_2
* cell instance $8520 m0 *1 811.44,997.92
X$8520 14409 14123 12898 14406 14448 14408 gf180mcu_fd_sc_mcu9t5v0__mux2_1
* cell instance $8521 m0 *1 817.04,987.84
X$8521 14409 5662 13197 14126 14304 14169 gf180mcu_fd_sc_mcu9t5v0__mux2_1
* cell instance $8522 r0 *1 771.68,967.68
X$8522 13831 13718 13833 13331 13832 13719 gf180mcu_fd_sc_mcu9t5v0__dffrnq_2
* cell instance $8523 r0 *1 769.44,997.92
X$8523 14302 14811 12898 14708 14448 14447 gf180mcu_fd_sc_mcu9t5v0__mux2_1
* cell instance $8524 m0 *1 792.96,1018.08
X$8524 13831 14969 14970 13331 14967 15138 gf180mcu_fd_sc_mcu9t5v0__dffrnq_2
* cell instance $8525 m0 *1 792.4,977.76
X$8525 13874 13875 13427 13832 14009 14008 gf180mcu_fd_sc_mcu9t5v0__mux2_1
* cell instance $8526 m0 *1 801.36,977.76
X$8526 13833 13875 13197 13832 14009 13876 gf180mcu_fd_sc_mcu9t5v0__mux2_1
* cell instance $8527 r0 *1 796.88,997.92
X$8527 4924 14708 14448 13831 gf180mcu_fd_sc_mcu9t5v0__clkbuf_8
* cell instance $8528 m0 *1 803.6,987.84
X$8528 14168 14303 13197 14126 14304 13889 gf180mcu_fd_sc_mcu9t5v0__mux2_1
* cell instance $8529 r0 *1 794.08,987.84
X$8529 14166 14303 13427 14406 14304 14407 gf180mcu_fd_sc_mcu9t5v0__mux2_1
* cell instance $8530 m0 *1 817.04,1008
X$8530 14813 14812 12898 14708 14857 14858 gf180mcu_fd_sc_mcu9t5v0__mux2_1
* cell instance $8531 r0 *1 809.2,967.68
X$8531 13831 13834 13720 13331 13832 13719 gf180mcu_fd_sc_mcu9t5v0__dffrnq_2
* cell instance $8532 m0 *1 804.16,1008
X$8532 15008 14970 13197 14708 14857 14658 gf180mcu_fd_sc_mcu9t5v0__mux2_1
* cell instance $8533 r0 *1 799.68,1008
X$8533 14854 14970 13427 14967 14857 14969 gf180mcu_fd_sc_mcu9t5v0__mux2_1
* cell instance $8534 r0 *1 807.52,987.84
X$8534 13831 14408 14409 13331 14406 14304 gf180mcu_fd_sc_mcu9t5v0__dffrnq_2
* cell instance $8535 r0 *1 782.88,1028.16
X$8535 13831 15525 14709 12383 15576 15402 gf180mcu_fd_sc_mcu9t5v0__dffrnq_2
* cell instance $8536 m0 *1 780.08,1008
X$8536 14856 14812 13055 14708 14857 14855 gf180mcu_fd_sc_mcu9t5v0__mux2_1
* cell instance $8537 m0 *1 764.96,1018.08
X$8537 13831 14968 15008 13331 14967 15138 gf180mcu_fd_sc_mcu9t5v0__dffrnq_2
* cell instance $8538 m0 *1 767.2,997.92
X$8538 13831 14447 14302 13331 14406 14448 gf180mcu_fd_sc_mcu9t5v0__dffrnq_2
* cell instance $8539 m0 *1 800.8,1028.16
X$8539 15404 12897 15271 15402 15403 gf180mcu_fd_sc_mcu9t5v0__nor2_1
* cell instance $8540 r0 *1 777.84,1008
X$8540 13831 14855 14812 13331 14967 14857 gf180mcu_fd_sc_mcu9t5v0__dffrnq_2
* cell instance $8541 m0 *1 612.64,1098.72
X$8541 17513 17398 17521 13713 gf180mcu_fd_sc_mcu9t5v0__buf_8
* cell instance $8542 m0 *1 619.92,1048.32
X$8542 16641 16001 15896 11958 15898 16008 gf180mcu_fd_sc_mcu9t5v0__dffrnq_2
* cell instance $8543 r0 *1 617.12,1088.64
X$8543 12885 11711 17391 11596 17398 17289 17392
+ gf180mcu_fd_sc_mcu9t5v0__aoi211_1
* cell instance $8544 m0 *1 620.48,1068.48
X$8544 16642 16506 16653 16781 gf180mcu_fd_sc_mcu9t5v0__clkinv_1
* cell instance $8545 m0 *1 617.68,1088.64
X$8545 17119 17123 17289 17113 gf180mcu_fd_sc_mcu9t5v0__buf_8
* cell instance $8546 r0 *1 613.76,1068.48
X$8546 16641 16781 16502 11958 16784 16653 gf180mcu_fd_sc_mcu9t5v0__dffrnq_2
* cell instance $8547 r0 *1 615.44,1008
X$8547 15131 14961 14806 11958 14967 14857 gf180mcu_fd_sc_mcu9t5v0__dffrnq_2
* cell instance $8548 r0 *1 612.08,1028.16
X$8548 15131 15394 15521 11958 15576 15402 gf180mcu_fd_sc_mcu9t5v0__dffrnq_2
* cell instance $8549 m0 *1 646.8,1038.24
X$8549 15736 12245 15576 15737 15685 gf180mcu_fd_sc_mcu9t5v0__nand2_1
* cell instance $8550 m0 *1 609.84,1038.24
X$8550 15737 15576 gf180mcu_fd_sc_mcu9t5v0__filltie
* cell instance $8551 m0 *1 610.96,1038.24
X$8551 15388 15576 15737 13692 gf180mcu_fd_sc_mcu9t5v0__buf_1
* cell instance $8552 m0 *1 640.64,1038.24
X$8552 15685 14807 15576 15737 15735 gf180mcu_fd_sc_mcu9t5v0__nand2_1
* cell instance $8553 m0 *1 619.36,987.84
X$8553 9539 14126 14304 14298 gf180mcu_fd_sc_mcu9t5v0__buf_1
* cell instance $8554 r0 *1 607.6,987.84
X$8554 12381 14297 14155 11958 14406 14304 gf180mcu_fd_sc_mcu9t5v0__dffrnq_2
* cell instance $8555 m0 *1 605.36,1038.24
X$8555 14153 14404 15576 15737 15518 gf180mcu_fd_sc_mcu9t5v0__and2_1
* cell instance $8556 m0 *1 618.24,1028.16
X$8556 15521 13826 12241 15271 15402 15394 gf180mcu_fd_sc_mcu9t5v0__mux2_1
* cell instance $8557 m0 *1 619.92,1018.08
X$8557 13002 14849 14967 15138 14999 gf180mcu_fd_sc_mcu9t5v0__nand2_1
* cell instance $8558 m0 *1 581.84,1038.24
X$8558 15131 15684 14847 11958 15576 15737 gf180mcu_fd_sc_mcu9t5v0__dffrnq_2
* cell instance $8559 m0 *1 561.68,1038.24
X$8559 15131 15392 15393 11958 15576 15737 gf180mcu_fd_sc_mcu9t5v0__dffrnq_2
* cell instance $8560 r0 *1 659.68,1038.24
X$8560 13422 13193 13151 15898 15737 15852 gf180mcu_fd_sc_mcu9t5v0__aoi21_1
* cell instance $8561 r0 *1 648.48,1088.64
X$8561 17286 17233 17285 13151 17398 17289 17393
+ gf180mcu_fd_sc_mcu9t5v0__aoi22_1
* cell instance $8562 m0 *1 650.72,1048.32
X$8562 15896 12784 13154 14405 15898 16008 15897
+ gf180mcu_fd_sc_mcu9t5v0__oai211_1
* cell instance $8563 m0 *1 650.72,1058.4
X$8563 15897 16135 16304 13151 16194 16309 16188
+ gf180mcu_fd_sc_mcu9t5v0__aoi22_1
* cell instance $8564 m0 *1 651.84,1078.56
X$8564 16641 16784 16956 gf180mcu_fd_sc_mcu9t5v0__clkinv_3
* cell instance $8565 r0 *1 637.84,1038.24
X$8565 16641 15735 15736 11958 15898 15737 gf180mcu_fd_sc_mcu9t5v0__dffrnq_2
* cell instance $8566 r0 *1 633.92,1078.56
X$8566 16641 16949 16950 11958 17123 16956 gf180mcu_fd_sc_mcu9t5v0__dffrnq_2
* cell instance $8567 m0 *1 649.04,1098.72
X$8567 17514 12784 13154 14125 17398 17521 17286
+ gf180mcu_fd_sc_mcu9t5v0__oai211_1
* cell instance $8568 m0 *1 640.64,1058.4
X$8568 16190 12245 16194 16309 16189 gf180mcu_fd_sc_mcu9t5v0__nand2_1
* cell instance $8569 m0 *1 638.96,1098.72
X$8569 17514 17945 12241 17398 17521 17568 gf180mcu_fd_sc_mcu9t5v0__mux2_1
* cell instance $8570 m0 *1 657.44,1068.48
X$8570 15736 13193 13151 16506 16653 16643 gf180mcu_fd_sc_mcu9t5v0__aoi21_1
* cell instance $8571 r0 *1 625.52,1048.32
X$8571 15896 16502 12241 16194 16008 16001 gf180mcu_fd_sc_mcu9t5v0__mux2_1
* cell instance $8572 m0 *1 654.64,1088.64
X$8572 16641 16951 16504 11958 17123 17289 gf180mcu_fd_sc_mcu9t5v0__dffrnq_2
* cell instance $8573 m0 *1 622.72,1068.48
X$8573 13874 17080 14702 16502 16506 16653 16642
+ gf180mcu_fd_sc_mcu9t5v0__aoi22_1
* cell instance $8574 r0 *1 631.68,1098.72
X$8574 16641 17568 17514 11958 17709 17521 gf180mcu_fd_sc_mcu9t5v0__dffrnq_2
* cell instance $8575 m0 *1 670.88,1098.72
X$8575 14166 17080 14702 17394 17398 17521 17235
+ gf180mcu_fd_sc_mcu9t5v0__aoi22_1
* cell instance $8576 m0 *1 642.32,1078.56
X$8576 16950 12245 16784 16956 16914 gf180mcu_fd_sc_mcu9t5v0__nand2_1
* cell instance $8577 r0 *1 631.68,1058.4
X$8577 16641 16437 16190 11958 16506 16309 gf180mcu_fd_sc_mcu9t5v0__dffrnq_2
* cell instance $8578 m0 *1 636.72,1078.56
X$8578 16914 15571 16784 16956 16949 gf180mcu_fd_sc_mcu9t5v0__nand2_1
* cell instance $8579 m0 *1 673.68,1088.64
X$8579 17235 17123 17289 17234 gf180mcu_fd_sc_mcu9t5v0__clkinv_1
* cell instance $8580 m0 *1 636.72,1058.4
X$8580 16189 14157 16194 16309 16437 gf180mcu_fd_sc_mcu9t5v0__nand2_1
* cell instance $8581 m0 *1 682.64,1088.64
X$8581 16190 13193 13151 17123 17289 17120 gf180mcu_fd_sc_mcu9t5v0__aoi21_1
* cell instance $8582 m0 *1 673.12,1078.56
X$8582 14850 16784 16956 14854 gf180mcu_fd_sc_mcu9t5v0__clkbuf_1
* cell instance $8583 m0 *1 678.16,1068.48
X$8583 14856 16647 14702 16506 16653 16646 gf180mcu_fd_sc_mcu9t5v0__mux2_1
* cell instance $8584 r0 *1 652.96,1078.56
X$8584 4924 17123 16956 16641 gf180mcu_fd_sc_mcu9t5v0__clkbuf_8
* cell instance $8585 r0 *1 659.12,1068.48
X$8585 16645 16643 16644 13151 16784 16653 17119
+ gf180mcu_fd_sc_mcu9t5v0__aoi22_1
* cell instance $8586 r0 *1 653.52,1048.32
X$8586 15395 13193 13151 16194 16008 16135 gf180mcu_fd_sc_mcu9t5v0__aoi21_1
* cell instance $8587 m0 *1 650.16,1088.64
X$8587 16950 13193 13151 17123 17289 17233 gf180mcu_fd_sc_mcu9t5v0__aoi21_1
* cell instance $8588 r0 *1 671.44,1068.48
X$8588 16641 16646 16647 11958 16784 16653 gf180mcu_fd_sc_mcu9t5v0__dffrnq_2
* cell instance $8589 m0 *1 661.36,1048.32
X$8589 16641 16002 16136 12383 15898 16008 gf180mcu_fd_sc_mcu9t5v0__dffrnq_2
* cell instance $8590 r0 *1 668.64,1088.64
X$8590 16641 17234 17394 11958 17398 17289 gf180mcu_fd_sc_mcu9t5v0__dffrnq_2
* cell instance $8591 m0 *1 651.84,1068.48
X$8591 13154 16503 16506 16653 11964 gf180mcu_fd_sc_mcu9t5v0__and2_1
* cell instance $8592 r0 *1 675.36,1038.24
X$8592 15854 15898 15737 15731 gf180mcu_fd_sc_mcu9t5v0__buf_8
* cell instance $8593 r0 *1 668.64,1048.32
X$8593 14850 16136 13825 16194 16008 16002 gf180mcu_fd_sc_mcu9t5v0__mux2_1
* cell instance $8594 m0 *1 661.92,1078.56
X$8594 16504 17706 12241 16784 16956 16951 gf180mcu_fd_sc_mcu9t5v0__mux2_1
* cell instance $8595 m0 *1 665.84,1068.48
X$8595 16504 12784 13154 15853 16506 16653 16645
+ gf180mcu_fd_sc_mcu9t5v0__oai211_1
* cell instance $8596 m0 *1 609.84,1088.64
X$8596 17289 17123 gf180mcu_fd_sc_mcu9t5v0__filltie
* cell instance $8597 m0 *1 609.84,1048.32
X$8597 16008 15898 gf180mcu_fd_sc_mcu9t5v0__filltie
* cell instance $8598 r0 *1 608.72,1058.4
X$8598 15529 17705 16303 12743 16506 16309 16500
+ gf180mcu_fd_sc_mcu9t5v0__oai211_1
* cell instance $8599 r0 *1 600.32,1078.56
X$8599 17081 17123 16956 14702 gf180mcu_fd_sc_mcu9t5v0__buf_8
* cell instance $8600 r0 *1 588,1078.56
X$8600 16640 16499 17077 17123 16956 17118 gf180mcu_fd_sc_mcu9t5v0__nand3_1
* cell instance $8601 r0 *1 593.04,1098.72
X$8601 17567 17702 17118 17709 17521 17079 gf180mcu_fd_sc_mcu9t5v0__nand3_1
* cell instance $8602 m0 *1 609.84,1058.4
X$8602 16309 16194 gf180mcu_fd_sc_mcu9t5v0__filltie
* cell instance $8603 m0 *1 609.84,1068.48
X$8603 16653 16506 gf180mcu_fd_sc_mcu9t5v0__filltie
* cell instance $8604 m0 *1 609.84,1078.56
X$8604 16956 16784 gf180mcu_fd_sc_mcu9t5v0__filltie
* cell instance $8605 m0 *1 591.36,1088.64
X$8605 17117 15519 16948 17232 17123 17289 17284
+ gf180mcu_fd_sc_mcu9t5v0__oai31_1
* cell instance $8606 r0 *1 597.52,1058.4
X$8606 16640 12779 16506 16309 16303 gf180mcu_fd_sc_mcu9t5v0__nand2_1
* cell instance $8607 m0 *1 589.12,1068.48
X$8607 16134 16499 16506 16653 16187 gf180mcu_fd_sc_mcu9t5v0__nor2_1
* cell instance $8608 r0 *1 613.76,1098.72
X$8608 14121 12885 17513 17709 17521 17391 gf180mcu_fd_sc_mcu9t5v0__nor3_1
* cell instance $8609 m0 *1 590.8,1078.56
X$8609 16188 16784 16956 16941 gf180mcu_fd_sc_mcu9t5v0__buf_8
* cell instance $8610 r0 *1 591.92,1078.56
X$8610 16186 17080 17123 16956 17081 gf180mcu_fd_sc_mcu9t5v0__nor2_1
* cell instance $8611 r0 *1 588.56,1098.72
X$8611 17566 17702 17982 17709 17521 16186 gf180mcu_fd_sc_mcu9t5v0__nor3_1
* cell instance $8612 m0 *1 610.96,1068.48
X$8612 15263 16500 16506 16653 16501 gf180mcu_fd_sc_mcu9t5v0__and2_1
* cell instance $8613 m0 *1 588.56,1058.4
X$8613 16187 16194 16309 11596 gf180mcu_fd_sc_mcu9t5v0__buf_8
* cell instance $8614 r0 *1 560,1038.24
X$8614 15131 15898 15737 gf180mcu_fd_sc_mcu9t5v0__inv_3
* cell instance $8615 m0 *1 609.84,1098.72
X$8615 17521 17398 gf180mcu_fd_sc_mcu9t5v0__filltie
* cell instance $8616 r0 *1 573.44,1058.4
X$8616 12241 16506 16309 16133 gf180mcu_fd_sc_mcu9t5v0__clkinv_1
* cell instance $8617 m0 *1 572.32,1068.48
X$8617 16302 12784 16506 16653 16498 gf180mcu_fd_sc_mcu9t5v0__nor2_1
* cell instance $8618 m0 *1 565.04,1058.4
X$8618 16186 16194 16309 15998 gf180mcu_fd_sc_mcu9t5v0__buf_8
* cell instance $8619 m0 *1 585.2,1078.56
X$8619 16497 12784 16784 16956 16948 gf180mcu_fd_sc_mcu9t5v0__nor2_1
* cell instance $8620 r0 *1 576.8,1058.4
X$8620 16641 16436 16640 11958 16506 16309 gf180mcu_fd_sc_mcu9t5v0__dffrnq_2
* cell instance $8621 m0 *1 570.64,1088.64
X$8621 17229 17117 17123 17289 17232 gf180mcu_fd_sc_mcu9t5v0__nand2_1
* cell instance $8622 m0 *1 586.88,1068.48
X$8622 16640 16506 16653 16134 gf180mcu_fd_sc_mcu9t5v0__clkinv_1
* cell instance $8623 r0 *1 568.96,1098.72
X$8623 17564 12784 12241 17709 17521 17565 gf180mcu_fd_sc_mcu9t5v0__nor3_1
* cell instance $8624 m0 *1 573.44,1088.64
X$8624 16912 15529 17079 17123 17289 17080 gf180mcu_fd_sc_mcu9t5v0__nor3_1
* cell instance $8625 m0 *1 553.84,1088.64
X$8625 17230 17229 17123 17289 17231 gf180mcu_fd_sc_mcu9t5v0__and2_1
* cell instance $8626 r0 *1 558.88,1088.64
X$8626 17230 17229 17398 17289 17283 gf180mcu_fd_sc_mcu9t5v0__nor2_1
* cell instance $8627 m0 *1 561.12,1088.64
X$8627 17230 17123 17289 17078 gf180mcu_fd_sc_mcu9t5v0__clkinv_1
* cell instance $8628 r0 *1 574,1048.32
X$8628 16134 12779 15998 16133 16194 16008 16436
+ gf180mcu_fd_sc_mcu9t5v0__oai31_1
* cell instance $8629 r0 *1 574,1098.72
X$8629 17566 17709 17521 17564 gf180mcu_fd_sc_mcu9t5v0__clkinv_1
* cell instance $8630 m0 *1 570.08,1078.56
X$8630 15734 12784 15263 16784 16956 16913 gf180mcu_fd_sc_mcu9t5v0__oai21_1
* cell instance $8631 m0 *1 553.28,1058.4
X$8631 16302 15730 12241 16194 16309 16301 gf180mcu_fd_sc_mcu9t5v0__mux2_1
* cell instance $8632 r0 *1 563.92,1098.72
X$8632 17564 17562 17565 17709 17521 17704 gf180mcu_fd_sc_mcu9t5v0__aoi21_1
* cell instance $8633 r0 *1 568.96,1078.56
X$8633 15529 17079 17123 16956 16946 gf180mcu_fd_sc_mcu9t5v0__nor2_1
* cell instance $8634 r0 *1 576.24,1078.56
X$8634 17078 15263 13421 16913 17123 16956 16947
+ gf180mcu_fd_sc_mcu9t5v0__oai22_1
* cell instance $8635 r0 *1 602.56,1048.32
X$8635 16303 16194 16008 12784 gf180mcu_fd_sc_mcu9t5v0__buf_8
* cell instance $8636 r0 *1 605.92,1028.16
X$8636 15520 12784 12006 13149 15576 15402 15570 gf180mcu_fd_sc_mcu9t5v0__and4_1
* cell instance $8637 m0 *1 609.84,1018.08
X$8637 15138 14967 gf180mcu_fd_sc_mcu9t5v0__filltie
* cell instance $8638 m0 *1 609.84,997.92
X$8638 14448 14406 gf180mcu_fd_sc_mcu9t5v0__filltie
* cell instance $8639 r0 *1 602,1028.16
X$8639 14845 12005 13002 15576 15402 15520 gf180mcu_fd_sc_mcu9t5v0__nand3_1
* cell instance $8640 m0 *1 599.76,1018.08
X$8640 14700 12784 14848 15263 14967 15138 14998
+ gf180mcu_fd_sc_mcu9t5v0__oai211_1
* cell instance $8641 m0 *1 579.6,977.76
X$8641 13148 13865 13832 14009 13686 gf180mcu_fd_sc_mcu9t5v0__nor2_1
* cell instance $8642 m0 *1 594.16,1018.08
X$8642 15134 12784 14996 15263 14967 15138 14997
+ gf180mcu_fd_sc_mcu9t5v0__oai211_1
* cell instance $8643 m0 *1 611.52,987.84
X$8643 14155 14154 14126 14304 14849 gf180mcu_fd_sc_mcu9t5v0__and2_1
* cell instance $8644 m0 *1 606.48,987.84
X$8644 14155 14154 14126 14304 14296 gf180mcu_fd_sc_mcu9t5v0__nor2_1
* cell instance $8645 m0 *1 609.84,987.84
X$8645 14304 14126 gf180mcu_fd_sc_mcu9t5v0__filltie
* cell instance $8646 m0 *1 616,987.84
X$8646 7549 14126 14304 13826 gf180mcu_fd_sc_mcu9t5v0__buf_1
* cell instance $8647 m0 *1 605.92,997.92
X$8647 14155 14153 14406 14448 14122 gf180mcu_fd_sc_mcu9t5v0__nand2_1
* cell instance $8648 r0 *1 606.48,977.76
X$8648 14154 14122 14126 14009 13823 gf180mcu_fd_sc_mcu9t5v0__nand2_1
* cell instance $8649 r0 *1 603.12,987.84
X$8649 14404 14296 14122 14406 14304 14297 gf180mcu_fd_sc_mcu9t5v0__oai21_1
* cell instance $8650 m0 *1 599.76,977.76
X$8650 13714 13866 13832 14009 13441 gf180mcu_fd_sc_mcu9t5v0__nand2_1
* cell instance $8651 m0 *1 594.72,987.84
X$8651 14155 14154 14153 14126 14304 14148 gf180mcu_fd_sc_mcu9t5v0__nand3_1
* cell instance $8652 r0 *1 591.92,1008
X$8652 14153 14967 14857 14150 gf180mcu_fd_sc_mcu9t5v0__buf_8
* cell instance $8653 r0 *1 610.96,1008
X$8653 13713 14849 14967 14857 14404 gf180mcu_fd_sc_mcu9t5v0__or2_1
* cell instance $8654 m0 *1 609.84,1028.16
X$8654 15402 15271 gf180mcu_fd_sc_mcu9t5v0__filltie
* cell instance $8655 m0 *1 587.44,987.84
X$8655 13002 14152 14126 14304 14149 gf180mcu_fd_sc_mcu9t5v0__and2_1
* cell instance $8656 r0 *1 589.12,1028.16
X$8656 13002 15518 14847 15576 15402 15684 gf180mcu_fd_sc_mcu9t5v0__mux2_1
* cell instance $8657 m0 *1 596.4,1008
X$8657 14805 12885 13713 12124 14708 14857 14848
+ gf180mcu_fd_sc_mcu9t5v0__oai31_1
* cell instance $8658 r0 *1 600.32,967.68
X$8658 13688 13687 13823 13002 13832 13719 13866
+ gf180mcu_fd_sc_mcu9t5v0__oai211_1
* cell instance $8659 r0 *1 595.84,967.68
X$8659 13688 13687 13832 13719 14154 gf180mcu_fd_sc_mcu9t5v0__and2_1
* cell instance $8660 m0 *1 609.84,977.76
X$8660 14009 13832 gf180mcu_fd_sc_mcu9t5v0__filltie
* cell instance $8661 r0 *1 596.96,987.84
X$8661 14155 12005 14406 14304 14295 gf180mcu_fd_sc_mcu9t5v0__and2_1
* cell instance $8662 r0 *1 590.8,987.84
X$8662 12777 12123 14295 13002 11596 14406 14304 15519
+ gf180mcu_fd_sc_mcu9t5v0__aoi221_1
* cell instance $8663 m0 *1 609.84,1008
X$8663 14857 14708 gf180mcu_fd_sc_mcu9t5v0__filltie
* cell instance $8664 m0 *1 574.56,1008
X$8664 14845 14150 14708 14857 14844 gf180mcu_fd_sc_mcu9t5v0__nand2_1
* cell instance $8665 m0 *1 565.6,1028.16
X$8665 15393 15390 12241 15271 15402 15392 gf180mcu_fd_sc_mcu9t5v0__mux2_1
* cell instance $8666 m0 *1 581.28,1008
X$8666 14805 14960 14708 14857 14804 gf180mcu_fd_sc_mcu9t5v0__nand2_1
* cell instance $8667 r0 *1 579.04,1028.16
X$8667 15393 12784 15517 15263 15576 15402 15569
+ gf180mcu_fd_sc_mcu9t5v0__oai211_1
* cell instance $8668 m0 *1 574.56,987.84
X$8668 14120 14150 14126 14304 14151 gf180mcu_fd_sc_mcu9t5v0__nand2_1
* cell instance $8669 m0 *1 569.52,987.84
X$8669 13713 14151 14149 14148 14126 14304 14119
+ gf180mcu_fd_sc_mcu9t5v0__aoi22_1
* cell instance $8670 r0 *1 575.12,997.92
X$8670 14647 14804 13713 14708 14448 14441 gf180mcu_fd_sc_mcu9t5v0__aoi21_1
* cell instance $8671 r0 *1 586.32,1028.16
X$8671 15264 12504 15576 15402 15517 gf180mcu_fd_sc_mcu9t5v0__nand2_1
* cell instance $8672 m0 *1 590.8,1028.16
X$8672 14847 12005 13002 15271 15402 15264 gf180mcu_fd_sc_mcu9t5v0__nand3_1
* cell instance $8673 m0 *1 576.8,1018.08
X$8673 14845 14847 14967 15138 14846 gf180mcu_fd_sc_mcu9t5v0__or2_1
* cell instance $8674 r0 *1 576.8,1008
X$8674 14960 14846 13713 14967 14857 14843 gf180mcu_fd_sc_mcu9t5v0__aoi21_1
* cell instance $8675 r0 *1 557.76,1018.08
X$8675 15131 14959 14845 11958 15271 15138 gf180mcu_fd_sc_mcu9t5v0__dffrnq_2
* cell instance $8676 r0 *1 575.68,977.76
X$8676 14120 14126 14009 14121 gf180mcu_fd_sc_mcu9t5v0__clkinv_1
* cell instance $8677 m0 *1 577.36,1008
X$8677 14701 14845 14847 14708 14857 14647 gf180mcu_fd_sc_mcu9t5v0__nand3_1
* cell instance $8678 m0 *1 577.36,987.84
X$8678 14121 14647 14126 14304 13865 gf180mcu_fd_sc_mcu9t5v0__nor2_1
* cell instance $8679 r0 *1 553.28,977.76
X$8679 15131 14119 14120 11958 14126 14009 gf180mcu_fd_sc_mcu9t5v0__dffrnq_2
* cell instance $8680 r0 *1 581.28,1008
X$8680 14845 14847 14967 14857 14960 gf180mcu_fd_sc_mcu9t5v0__nand2_1
* cell instance $8681 r0 *1 571.76,1008
X$8681 13713 14844 14843 14148 14967 14857 14959
+ gf180mcu_fd_sc_mcu9t5v0__aoi22_1
* cell instance $8682 m0 *1 568.96,997.92
X$8682 13713 14442 14441 14148 14406 14448 14440
+ gf180mcu_fd_sc_mcu9t5v0__aoi22_1
* cell instance $8683 m0 *1 584.08,1008
X$8683 14701 14708 14857 14805 gf180mcu_fd_sc_mcu9t5v0__clkinv_1
* cell instance $8684 r0 *1 560,1028.16
X$8684 4924 15576 15402 15131 gf180mcu_fd_sc_mcu9t5v0__clkbuf_8
* cell instance $8685 r0 *1 572.32,997.92
X$8685 14701 14150 14708 14448 14442 gf180mcu_fd_sc_mcu9t5v0__nand2_1
* cell instance $8686 m0 *1 580.72,987.84
X$8686 14121 14647 14126 14304 14152 gf180mcu_fd_sc_mcu9t5v0__xnor2_1
* cell instance $8687 r0 *1 577.36,967.68
X$8687 13148 14150 13832 13719 13822 gf180mcu_fd_sc_mcu9t5v0__nand2_1
* cell instance $8688 r0 *1 572.32,967.68
X$8688 13713 13822 13712 14148 13832 13719 13439
+ gf180mcu_fd_sc_mcu9t5v0__aoi22_1
* cell instance $8689 r0 *1 580.16,967.68
X$8689 13148 13865 13832 13719 13687 gf180mcu_fd_sc_mcu9t5v0__and2_1
* cell instance $8690 m0 *1 652.4,1008
X$8690 14809 14808 14702 14708 14857 14962 gf180mcu_fd_sc_mcu9t5v0__mux2_1
* cell instance $8691 m0 *1 663.04,1008
X$8691 14810 14808 12241 14708 14857 14851 gf180mcu_fd_sc_mcu9t5v0__mux2_1
* cell instance $8692 r0 *1 675.36,1028.16
X$8692 12784 15522 6908 15576 15402 15853 gf180mcu_fd_sc_mcu9t5v0__nand3_1
* cell instance $8693 r0 *1 670.32,977.76
X$8693 12784 14007 7187 14126 14009 14125 gf180mcu_fd_sc_mcu9t5v0__nand3_1
* cell instance $8694 m0 *1 639.52,1028.16
X$8694 15131 15265 15395 11958 15271 15402 gf180mcu_fd_sc_mcu9t5v0__dffrnq_2
* cell instance $8695 r0 *1 631.12,977.76
X$8695 14006 14123 12241 14126 14009 14156 gf180mcu_fd_sc_mcu9t5v0__mux2_1
* cell instance $8696 r0 *1 657.44,967.68
X$8696 13826 13824 13825 13832 13719 13867 gf180mcu_fd_sc_mcu9t5v0__mux2_1
* cell instance $8697 m0 *1 679.84,987.84
X$8697 12784 14159 11968 14126 14304 14124 gf180mcu_fd_sc_mcu9t5v0__nand3_1
* cell instance $8698 m0 *1 657.44,997.92
X$8698 14158 12005 13002 14406 14448 14444 gf180mcu_fd_sc_mcu9t5v0__nand3_1
* cell instance $8699 r0 *1 638.4,977.76
X$8699 14006 12784 11964 14124 14126 14009 15135
+ gf180mcu_fd_sc_mcu9t5v0__oai211_1
* cell instance $8700 r0 *1 642.32,1018.08
X$8700 15266 15135 15271 15138 15265 gf180mcu_fd_sc_mcu9t5v0__nand2_1
* cell instance $8701 m0 *1 624.96,987.84
X$8701 12381 14156 14006 11958 14126 14304 gf180mcu_fd_sc_mcu9t5v0__dffrnq_2
* cell instance $8702 m0 *1 621.6,1008
X$8702 14806 14850 12241 14708 14857 14961 gf180mcu_fd_sc_mcu9t5v0__mux2_1
* cell instance $8703 m0 *1 631.12,1018.08
X$8703 13826 12005 13002 14967 15138 15000 gf180mcu_fd_sc_mcu9t5v0__nand3_1
* cell instance $8704 m0 *1 648.48,977.76
X$8704 12381 13867 13824 11958 13832 14009 gf180mcu_fd_sc_mcu9t5v0__dffrnq_2
* cell instance $8705 r0 *1 659.68,1008
X$8705 14160 14851 14810 11958 14967 14857 gf180mcu_fd_sc_mcu9t5v0__dffrnq_2
* cell instance $8706 r0 *1 663.6,987.84
X$8706 12784 14444 6422 14406 14304 14405 gf180mcu_fd_sc_mcu9t5v0__nand3_1
* cell instance $8707 m0 *1 685.44,1018.08
X$8707 15004 13193 13151 14967 15138 15002 gf180mcu_fd_sc_mcu9t5v0__aoi21_1
* cell instance $8708 r0 *1 644.56,987.84
X$8708 12381 14299 14158 11958 14406 14304 gf180mcu_fd_sc_mcu9t5v0__dffrnq_2
* cell instance $8709 m0 *1 635.04,1018.08
X$8709 12784 15000 11176 14967 15138 15001 gf180mcu_fd_sc_mcu9t5v0__nand3_1
* cell instance $8710 r0 *1 631.68,1028.16
X$8710 15521 12784 11964 15001 15576 15402 15571
+ gf180mcu_fd_sc_mcu9t5v0__oai211_1
* cell instance $8711 r0 *1 648.48,1018.08
X$8711 15395 12245 15271 15138 15266 gf180mcu_fd_sc_mcu9t5v0__nand2_1
* cell instance $8712 m0 *1 636.16,1008
X$8712 14806 12784 11964 13190 14708 14857 14807
+ gf180mcu_fd_sc_mcu9t5v0__oai211_1
* cell instance $8713 m0 *1 658.56,1028.16
X$8713 13002 15271 15402 13829 gf180mcu_fd_sc_mcu9t5v0__buf_8
* cell instance $8714 m0 *1 680.96,997.92
X$8714 14704 14298 12241 14406 14448 14648 gf180mcu_fd_sc_mcu9t5v0__mux2_1
* cell instance $8715 m0 *1 679.28,1028.16
X$8715 14963 15002 15396 13151 15271 15402 15854
+ gf180mcu_fd_sc_mcu9t5v0__aoi22_1
* cell instance $8716 r0 *1 678.72,1008
X$8716 14810 12784 13154 14703 14967 14857 14963
+ gf180mcu_fd_sc_mcu9t5v0__oai211_1
* cell instance $8717 r0 *1 666.4,977.76
X$8717 13824 12005 13829 14126 14009 14007 gf180mcu_fd_sc_mcu9t5v0__nand3_1
* cell instance $8718 m0 *1 675.92,987.84
X$8718 14123 12005 13829 14126 14304 14159 gf180mcu_fd_sc_mcu9t5v0__nand3_1
* cell instance $8719 r0 *1 671.44,1028.16
X$8719 16136 12005 13829 15576 15402 15522 gf180mcu_fd_sc_mcu9t5v0__nand3_1
* cell instance $8720 r0 *1 640.64,1008
X$8720 12381 14962 14808 11958 14967 14857 gf180mcu_fd_sc_mcu9t5v0__dffrnq_2
* cell instance $8721 m0 *1 656.32,987.84
X$8721 14123 14158 13825 14126 14304 14299 gf180mcu_fd_sc_mcu9t5v0__mux2_1
* cell instance $8722 m0 *1 612.08,957.6
X$8722 12381 13188 12885 11958 13318 13428 gf180mcu_fd_sc_mcu9t5v0__dffrnq_2
* cell instance $8723 m0 *1 619.36,937.44
X$8723 12381 12744 12780 11958 12785 12900 gf180mcu_fd_sc_mcu9t5v0__dffrnq_2
* cell instance $8724 r0 *1 619.36,836.64
X$8724 10333 10338 10308 2992 gf180mcu_fd_sc_mcu9t5v0__buf_8
* cell instance $8725 r0 *1 605.36,917.28
X$8725 10448 12380 11592 11958 12253 12508 gf180mcu_fd_sc_mcu9t5v0__dffsnq_2
* cell instance $8726 m0 *1 613.2,846.72
X$8726 8197 10449 9687 11958 10338 10570 gf180mcu_fd_sc_mcu9t5v0__dffrnq_2
* cell instance $8727 r0 *1 614.88,876.96
X$8727 10448 11324 11325 11958 11461 11294 gf180mcu_fd_sc_mcu9t5v0__dffrnq_2
* cell instance $8728 m0 *1 617.68,866.88
X$8728 10823 4765 10946 10833 11079 10948 gf180mcu_fd_sc_mcu9t5v0__oai21_1
* cell instance $8729 m0 *1 618.8,907.2
X$8729 12007 11971 12019 6906 gf180mcu_fd_sc_mcu9t5v0__buf_8
* cell instance $8730 r0 *1 612.64,897.12
X$8730 11592 11971 11860 11961 gf180mcu_fd_sc_mcu9t5v0__clkinv_1
* cell instance $8731 m0 *1 618.8,897.12
X$8731 11961 4949 10824 11720 11860 12887 gf180mcu_fd_sc_mcu9t5v0__nand3_1
* cell instance $8732 r0 *1 618.8,887.04
X$8732 2880 4949 11961 11720 11600 11556 gf180mcu_fd_sc_mcu9t5v0__oai21_1
* cell instance $8733 r0 *1 633.36,897.12
X$8733 11962 11971 11860 11595 gf180mcu_fd_sc_mcu9t5v0__buf_8
* cell instance $8734 r0 *1 664.72,897.12
X$8734 11963 11714 11964 11971 11860 11966 gf180mcu_fd_sc_mcu9t5v0__oai21_1
* cell instance $8735 r0 *1 669.2,897.12
X$8735 11963 11713 11964 11971 11860 11967 gf180mcu_fd_sc_mcu9t5v0__oai21_1
* cell instance $8736 r0 *1 655.2,897.12
X$8736 11963 11712 11964 11971 11860 11965 gf180mcu_fd_sc_mcu9t5v0__oai21_1
* cell instance $8737 r0 *1 578.48,897.12
X$8737 10448 11960 12003 11958 11971 11860 gf180mcu_fd_sc_mcu9t5v0__dffrnq_2
* cell instance $8738 r0 *1 618.24,907.2
X$8738 12005 11592 12128 12019 12007 gf180mcu_fd_sc_mcu9t5v0__nor2_1
* cell instance $8739 r0 *1 574,897.12
X$8739 12000 11959 11822 11971 11860 11960 gf180mcu_fd_sc_mcu9t5v0__nor3_1
* cell instance $8740 r0 *1 560.56,897.12
X$8740 12000 11957 11956 11971 11860 11859 gf180mcu_fd_sc_mcu9t5v0__nor3_1
* cell instance $8741 r0 *1 627.2,957.6
X$8741 13442 13692 12241 13586 13428 13583 gf180mcu_fd_sc_mcu9t5v0__mux2_1
* cell instance $8742 r0 *1 624.96,927.36
X$8742 12780 11323 12241 12785 12646 12744 gf180mcu_fd_sc_mcu9t5v0__mux2_1
* cell instance $8743 m0 *1 646.24,937.44
X$8743 11323 12005 13002 12785 12900 12889 gf180mcu_fd_sc_mcu9t5v0__nand3_1
* cell instance $8744 m0 *1 622.16,947.52
X$8744 12885 13054 13160 12005 gf180mcu_fd_sc_mcu9t5v0__clkinv_1
* cell instance $8745 r0 *1 645.12,937.44
X$8745 12784 13003 10450 13054 12900 13190 gf180mcu_fd_sc_mcu9t5v0__nand3_1
* cell instance $8746 m0 *1 636.16,917.28
X$8746 12382 12888 12241 12128 12253 12242 gf180mcu_fd_sc_mcu9t5v0__mux2_1
* cell instance $8747 r0 *1 641.76,947.52
X$8747 13189 12781 13318 13160 13315 gf180mcu_fd_sc_mcu9t5v0__nand2_1
* cell instance $8748 m0 *1 671.44,907.2
X$8748 12011 12245 11971 12019 12010 gf180mcu_fd_sc_mcu9t5v0__nand2_1
* cell instance $8749 m0 *1 680.4,927.36
X$8749 12613 12012 12508 12646 12644 gf180mcu_fd_sc_mcu9t5v0__nand2_1
* cell instance $8750 r0 *1 669.76,927.36
X$8750 12612 12245 12785 12646 12643 gf180mcu_fd_sc_mcu9t5v0__nand2_1
* cell instance $8751 m0 *1 661.36,927.36
X$8751 12381 12611 12612 12383 12508 12646 gf180mcu_fd_sc_mcu9t5v0__dffrnq_2
* cell instance $8752 r0 *1 663.04,907.2
X$8752 12381 12009 12011 12383 12128 12019 gf180mcu_fd_sc_mcu9t5v0__dffrnq_2
* cell instance $8753 r0 *1 645.68,947.52
X$8753 13422 12245 13318 13160 13189 gf180mcu_fd_sc_mcu9t5v0__nand2_1
* cell instance $8754 m0 *1 666.96,907.2
X$8754 12010 11967 11971 12019 12009 gf180mcu_fd_sc_mcu9t5v0__nand2_1
* cell instance $8755 m0 *1 658.56,947.52
X$8755 12381 13150 12890 11958 13054 13160 gf180mcu_fd_sc_mcu9t5v0__dffrnq_2
* cell instance $8756 r0 *1 642.88,957.6
X$8756 12784 13689 11177 13586 13428 13584 gf180mcu_fd_sc_mcu9t5v0__nand3_1
* cell instance $8757 m0 *1 678.72,907.2
X$8757 11963 11715 11964 11971 12019 12012 gf180mcu_fd_sc_mcu9t5v0__oai21_1
* cell instance $8758 m0 *1 655.76,947.52
X$8758 13051 11965 13054 13160 13150 gf180mcu_fd_sc_mcu9t5v0__nand2_1
* cell instance $8759 m0 *1 652.4,917.28
X$8759 12244 12008 12128 12253 12243 gf180mcu_fd_sc_mcu9t5v0__nand2_1
* cell instance $8760 m0 *1 638.96,937.44
X$8760 12780 12784 11964 12782 12785 12900 12781
+ gf180mcu_fd_sc_mcu9t5v0__oai211_1
* cell instance $8761 r0 *1 665.28,927.36
X$8761 12643 11966 12785 12646 12611 gf180mcu_fd_sc_mcu9t5v0__nand2_1
* cell instance $8762 m0 *1 683.76,927.36
X$8762 12614 12245 12508 12646 12613 gf180mcu_fd_sc_mcu9t5v0__nand2_1
* cell instance $8763 r0 *1 677.6,947.52
X$8763 13192 13191 12241 13318 13160 13316 gf180mcu_fd_sc_mcu9t5v0__mux2_1
* cell instance $8764 m0 *1 657.44,917.28
X$8764 12384 12245 12128 12253 12244 gf180mcu_fd_sc_mcu9t5v0__nand2_1
* cell instance $8765 r0 *1 665.84,937.44
X$8765 12890 12245 13054 12900 13051 gf180mcu_fd_sc_mcu9t5v0__nand2_1
* cell instance $8766 r0 *1 645.68,907.2
X$8766 12382 11596 12128 12019 11963 gf180mcu_fd_sc_mcu9t5v0__and2_1
* cell instance $8767 r0 *1 649.04,917.28
X$8767 12381 12243 12384 12383 12508 12253 gf180mcu_fd_sc_mcu9t5v0__dffrnq_2
* cell instance $8768 m0 *1 649.6,907.2
X$8768 11963 11823 11964 11971 12019 12008 gf180mcu_fd_sc_mcu9t5v0__oai21_1
* cell instance $8769 r0 *1 631.12,937.44
X$8769 12888 12005 13002 13054 12900 11962 gf180mcu_fd_sc_mcu9t5v0__nand3_1
* cell instance $8770 r0 *1 629.44,917.28
X$8770 12381 12242 12382 12383 12508 12253 gf180mcu_fd_sc_mcu9t5v0__dffrnq_2
* cell instance $8771 r0 *1 649.04,937.44
X$8771 3795 12005 13002 13054 12900 13003 gf180mcu_fd_sc_mcu9t5v0__nand3_1
* cell instance $8772 r0 *1 648.48,957.6
X$8772 12381 13586 13428 gf180mcu_fd_sc_mcu9t5v0__clkbuf_4
* cell instance $8773 m0 *1 637.84,957.6
X$8773 12381 13315 13422 11958 13318 13428 gf180mcu_fd_sc_mcu9t5v0__dffrnq_2
* cell instance $8774 m0 *1 650.16,937.44
X$8774 12784 12889 7945 12785 12900 12782 gf180mcu_fd_sc_mcu9t5v0__nand3_1
* cell instance $8775 r0 *1 648.48,947.52
X$8775 4924 13318 13160 12381 gf180mcu_fd_sc_mcu9t5v0__clkbuf_8
* cell instance $8776 r0 *1 605.36,927.36
X$8776 11592 12743 12000 12776 12785 12646 12379
+ gf180mcu_fd_sc_mcu9t5v0__aoi211_1
* cell instance $8777 r0 *1 603.12,917.28
X$8777 12379 12508 12253 12380 gf180mcu_fd_sc_mcu9t5v0__clkinv_1
* cell instance $8778 r0 *1 592.48,917.28
X$8778 4529 6906 12123 12378 11596 12508 12253 12504
+ gf180mcu_fd_sc_mcu9t5v0__aoi221_1
* cell instance $8779 r0 *1 594.16,907.2
X$8779 12003 12123 11460 12885 11596 12128 12019 12124
+ gf180mcu_fd_sc_mcu9t5v0__aoi221_1
* cell instance $8780 m0 *1 591.36,947.52
X$8780 13148 12005 13002 13054 13160 13050 gf180mcu_fd_sc_mcu9t5v0__nand3_1
* cell instance $8781 r0 *1 596.96,937.44
X$8781 11710 13000 13050 12784 13054 12900 14996
+ gf180mcu_fd_sc_mcu9t5v0__oai211_1
* cell instance $8782 m0 *1 612.64,947.52
X$8782 12885 12779 13054 13160 12743 gf180mcu_fd_sc_mcu9t5v0__nand2_1
* cell instance $8783 r0 *1 602,927.36
X$8783 12743 12778 12785 12646 12776 gf180mcu_fd_sc_mcu9t5v0__nor2_1
* cell instance $8784 r0 *1 616,937.44
X$8784 12743 12887 13054 12900 13001 gf180mcu_fd_sc_mcu9t5v0__nor2_1
* cell instance $8785 m0 *1 596.4,947.52
X$8785 12742 12123 13054 13160 13149 gf180mcu_fd_sc_mcu9t5v0__nand2_1
* cell instance $8786 m0 *1 609.84,957.6
X$8786 13428 13318 gf180mcu_fd_sc_mcu9t5v0__filltie
* cell instance $8787 r0 *1 598.64,957.6
X$8787 12381 13441 13688 11958 13586 13428 gf180mcu_fd_sc_mcu9t5v0__dffrnq_2
* cell instance $8788 r0 *1 592.48,957.6
X$8788 13688 12005 13586 13428 13440 gf180mcu_fd_sc_mcu9t5v0__and2_1
* cell instance $8789 m0 *1 569.52,947.52
X$8789 10448 12999 12742 11958 13054 13160 gf180mcu_fd_sc_mcu9t5v0__dffrnq_2
* cell instance $8790 m0 *1 609.84,937.44
X$8790 12900 12785 gf180mcu_fd_sc_mcu9t5v0__filltie
* cell instance $8791 r0 *1 571.2,917.28
X$8791 10448 12240 12378 11958 12508 12253 gf180mcu_fd_sc_mcu9t5v0__dffrnq_2
* cell instance $8792 r0 *1 616,947.52
X$8792 12005 12886 13001 13318 13160 13188 gf180mcu_fd_sc_mcu9t5v0__aoi21_1
* cell instance $8793 m0 *1 589.12,957.6
X$8793 12608 12123 13440 13002 11596 13318 13428 13421
+ gf180mcu_fd_sc_mcu9t5v0__aoi221_1
* cell instance $8794 m0 *1 598.08,927.36
X$8794 12004 12610 11592 12508 12646 12778 gf180mcu_fd_sc_mcu9t5v0__oai21_1
* cell instance $8795 m0 *1 609.84,947.52
X$8795 13160 13054 gf180mcu_fd_sc_mcu9t5v0__filltie
* cell instance $8796 m0 *1 562.24,927.36
X$8796 12608 12609 12508 12646 12607 gf180mcu_fd_sc_mcu9t5v0__nor2_1
* cell instance $8797 m0 *1 609.84,907.2
X$8797 12019 11971 gf180mcu_fd_sc_mcu9t5v0__filltie
* cell instance $8798 m0 *1 604.8,937.44
X$8798 12885 12779 12778 12887 12785 12900 11286
+ gf180mcu_fd_sc_mcu9t5v0__nand4_1
* cell instance $8799 r0 *1 557.2,917.28
X$8799 12000 12002 12607 12508 12253 12606 gf180mcu_fd_sc_mcu9t5v0__nor3_1
* cell instance $8800 m0 *1 563.36,937.44
X$8800 12777 12776 12785 12900 12609 gf180mcu_fd_sc_mcu9t5v0__and2_1
* cell instance $8801 m0 *1 568.4,907.2
X$8801 12001 12002 11971 12019 11957 gf180mcu_fd_sc_mcu9t5v0__and2_1
* cell instance $8802 m0 *1 580.72,907.2
X$8802 4924 11971 12019 10448 gf180mcu_fd_sc_mcu9t5v0__clkbuf_8
* cell instance $8803 r0 *1 561.68,917.28
X$8803 12608 12609 12508 12253 12002 gf180mcu_fd_sc_mcu9t5v0__and2_1
* cell instance $8804 m0 *1 572.88,907.2
X$8804 12003 11554 12001 12002 11971 12019 11959 gf180mcu_fd_sc_mcu9t5v0__and4_1
* cell instance $8805 m0 *1 599.2,907.2
X$8805 12005 11961 11971 12019 12123 gf180mcu_fd_sc_mcu9t5v0__nor2_1
* cell instance $8806 r0 *1 584.64,937.44
X$8806 12885 12886 11959 12742 13054 12900 12884
+ gf180mcu_fd_sc_mcu9t5v0__oai22_1
* cell instance $8807 r0 *1 602.56,937.44
X$8807 12885 12886 13054 12900 12000 gf180mcu_fd_sc_mcu9t5v0__nor2_1
* cell instance $8808 m0 *1 560,937.44
X$8808 12777 12776 12785 12900 12883 gf180mcu_fd_sc_mcu9t5v0__nor2_1
* cell instance $8809 r0 *1 589.12,927.36
X$8809 12608 12742 12777 12378 12785 12646 12610
+ gf180mcu_fd_sc_mcu9t5v0__nand4_1
* cell instance $8810 r0 *1 560,937.44
X$8810 12000 12609 12883 13054 12900 12882 gf180mcu_fd_sc_mcu9t5v0__nor3_1
* cell instance $8811 r0 *1 600.32,907.2
X$8811 11961 12001 12885 12128 12019 13000 gf180mcu_fd_sc_mcu9t5v0__oai21_1
* cell instance $8812 r0 *1 580.72,907.2
X$8812 10448 12128 12019 gf180mcu_fd_sc_mcu9t5v0__clkinv_8
* cell instance $8813 m0 *1 595.28,907.2
X$8813 12003 11554 12001 11971 12019 12004 gf180mcu_fd_sc_mcu9t5v0__nand3_1
* cell instance $8814 r0 *1 562.24,907.2
X$8814 12001 12002 12128 12019 11956 gf180mcu_fd_sc_mcu9t5v0__nor2_1
* cell instance $8815 m0 *1 580.72,927.36
X$8815 12742 11959 12378 12508 12646 12503 gf180mcu_fd_sc_mcu9t5v0__aoi21_1
* cell instance $8816 m0 *1 576.24,917.28
X$8816 12000 12503 12128 12253 12240 gf180mcu_fd_sc_mcu9t5v0__nor2_1
* cell instance $8817 r0 *1 579.6,937.44
X$8817 12742 11959 12884 13054 12900 12999 gf180mcu_fd_sc_mcu9t5v0__aoi21_1
* cell instance $8818 r0 *1 562.24,957.6
X$8818 10448 13439 13148 11958 13586 13428 gf180mcu_fd_sc_mcu9t5v0__dffrnq_2
* cell instance $8819 m0 *1 614.32,907.2
X$8819 10823 4765 12007 11971 12019 12006 gf180mcu_fd_sc_mcu9t5v0__oai21_1
* cell instance $8820 m0 *1 609.84,917.28
X$8820 12253 12128 gf180mcu_fd_sc_mcu9t5v0__filltie
* cell instance $8821 m0 *1 609.84,927.36
X$8821 12646 12508 gf180mcu_fd_sc_mcu9t5v0__filltie
* cell instance $8822 r0 *1 617.12,836.64
X$8822 10180 10338 10308 10333 gf180mcu_fd_sc_mcu9t5v0__clkinv_1
* cell instance $8823 r0 *1 596.96,846.72
X$8823 10448 10673 10180 11958 10676 10570 gf180mcu_fd_sc_mcu9t5v0__dffrnq_2
* cell instance $8824 m0 *1 588,846.72
X$8824 10448 10672 9836 11958 10338 10570 gf180mcu_fd_sc_mcu9t5v0__dffrnq_2
* cell instance $8825 m0 *1 609.84,846.72
X$8825 10570 10338 gf180mcu_fd_sc_mcu9t5v0__filltie
* cell instance $8826 r0 *1 600.32,887.04
X$8826 11592 11554 11720 11600 11593 gf180mcu_fd_sc_mcu9t5v0__nand2_1
* cell instance $8827 r0 *1 608.72,866.88
X$8827 3103 10947 11181 11079 11175 gf180mcu_fd_sc_mcu9t5v0__nand2_1
* cell instance $8828 m0 *1 605.92,887.04
X$8828 8838 11556 11461 11600 11460 gf180mcu_fd_sc_mcu9t5v0__nor2_1
* cell instance $8829 m0 *1 596.4,876.96
X$8829 2992 11286 11287 12000 11181 11294 10673
+ gf180mcu_fd_sc_mcu9t5v0__aoi211_1
* cell instance $8830 m0 *1 599.76,866.88
X$8830 10947 10946 4529 10833 11079 10672 gf180mcu_fd_sc_mcu9t5v0__mux2_1
* cell instance $8831 r0 *1 568.4,887.04
X$8831 11554 11957 11720 11600 11709 gf180mcu_fd_sc_mcu9t5v0__and2_1
* cell instance $8832 m0 *1 574.56,897.12
X$8832 12003 11709 11720 11860 11822 gf180mcu_fd_sc_mcu9t5v0__nor2_1
* cell instance $8833 r0 *1 612.08,887.04
X$8833 11594 11593 11720 11600 11711 gf180mcu_fd_sc_mcu9t5v0__nand2_1
* cell instance $8834 r0 *1 611.52,866.88
X$8834 11286 11181 11079 10822 gf180mcu_fd_sc_mcu9t5v0__clkinv_1
* cell instance $8835 m0 *1 609.84,856.8
X$8835 10714 10676 gf180mcu_fd_sc_mcu9t5v0__filltie
* cell instance $8836 m0 *1 609.84,836.64
X$8836 10308 10188 gf180mcu_fd_sc_mcu9t5v0__filltie
* cell instance $8837 m0 *1 602.56,876.96
X$8837 11592 11286 11181 11294 10946 gf180mcu_fd_sc_mcu9t5v0__nor2_1
* cell instance $8838 r0 *1 608.72,876.96
X$8838 11594 11286 11175 11461 11294 11324 gf180mcu_fd_sc_mcu9t5v0__oai21_1
* cell instance $8839 r0 *1 597.52,876.96
X$8839 11460 11286 11461 11294 11287 gf180mcu_fd_sc_mcu9t5v0__nor2_1
* cell instance $8840 r0 *1 607.6,887.04
X$8840 3103 8838 11592 11720 11600 11710 gf180mcu_fd_sc_mcu9t5v0__aoi21_1
* cell instance $8841 r0 *1 603.12,887.04
X$8841 3103 8838 11710 11720 11600 11594 gf180mcu_fd_sc_mcu9t5v0__oai21_1
* cell instance $8842 m0 *1 609.84,887.04
X$8842 11600 11461 gf180mcu_fd_sc_mcu9t5v0__filltie
* cell instance $8843 m0 *1 612.08,866.88
X$8843 2983 10822 12000 10948 10833 11079 10449 gf180mcu_fd_sc_mcu9t5v0__oai31_1
* cell instance $8844 r0 *1 565.04,887.04
X$8844 11554 11957 11720 11600 11553 gf180mcu_fd_sc_mcu9t5v0__nor2_1
* cell instance $8845 m0 *1 609.84,876.96
X$8845 11294 11181 gf180mcu_fd_sc_mcu9t5v0__filltie
* cell instance $8846 r0 *1 607.6,856.8
X$8846 10822 12000 10833 10714 10947 gf180mcu_fd_sc_mcu9t5v0__nor2_1
* cell instance $8847 m0 *1 576.8,887.04
X$8847 10448 11555 11554 11958 11461 11600 gf180mcu_fd_sc_mcu9t5v0__dffrnq_2
* cell instance $8848 m0 *1 609.84,897.12
X$8848 11860 11720 gf180mcu_fd_sc_mcu9t5v0__filltie
* cell instance $8849 m0 *1 571.76,887.04
X$8849 12000 11709 11553 11461 11600 11555 gf180mcu_fd_sc_mcu9t5v0__nor3_1
* cell instance $8850 m0 *1 609.84,866.88
X$8850 11079 10833 gf180mcu_fd_sc_mcu9t5v0__filltie
* cell instance $8851 m0 *1 626.08,856.8
X$8851 10710 10676 10714 4922 gf180mcu_fd_sc_mcu9t5v0__buf_8
* cell instance $8852 r0 *1 665.28,887.04
X$8852 11595 8950 11596 11720 11600 11714 gf180mcu_fd_sc_mcu9t5v0__aoi21_1
* cell instance $8853 m0 *1 673.12,856.8
X$8853 10452 4922 10676 10714 10711 gf180mcu_fd_sc_mcu9t5v0__nand2_1
* cell instance $8854 m0 *1 674.8,866.88
X$8854 10954 10826 10711 4900 10833 11079 10953
+ gf180mcu_fd_sc_mcu9t5v0__oai211_1
* cell instance $8855 m0 *1 664.72,876.96
X$8855 10952 4900 10953 6906 11181 11294 11177 gf180mcu_fd_sc_mcu9t5v0__oai211_1
* cell instance $8856 r0 *1 660.8,887.04
X$8856 11595 6907 11596 11720 11600 11713 gf180mcu_fd_sc_mcu9t5v0__aoi21_1
* cell instance $8857 r0 *1 642.88,846.72
X$8857 8197 10565 10451 10676 10570 gf180mcu_fd_sc_mcu9t5v0__dffq_2
* cell instance $8858 m0 *1 656.32,887.04
X$8858 5389 2880 11461 11600 10824 gf180mcu_fd_sc_mcu9t5v0__nor2_1
* cell instance $8859 r0 *1 677.6,856.8
X$8859 10302 10073 4539 10833 10714 10826 gf180mcu_fd_sc_mcu9t5v0__oai21_1
* cell instance $8860 m0 *1 686,897.12
X$8860 11595 6938 11596 11720 11860 11969 gf180mcu_fd_sc_mcu9t5v0__aoi21_1
* cell instance $8861 m0 *1 635.04,897.12
X$8861 4529 4497 11720 11860 10823 gf180mcu_fd_sc_mcu9t5v0__nor2_1
* cell instance $8862 r0 *1 669.2,836.64
X$8862 8197 10301 10302 10338 10308 gf180mcu_fd_sc_mcu9t5v0__dffq_2
* cell instance $8863 m0 *1 651.84,836.64
X$8863 10072 4538 4539 10188 10308 10182 gf180mcu_fd_sc_mcu9t5v0__oai21_1
* cell instance $8864 r0 *1 678.72,887.04
X$8864 11595 7917 11596 11720 11600 11715 gf180mcu_fd_sc_mcu9t5v0__aoi21_1
* cell instance $8865 m0 *1 675.92,836.64
X$8865 10043 10302 4018 10188 10308 10301 gf180mcu_fd_sc_mcu9t5v0__mux2_1
* cell instance $8866 m0 *1 666.96,846.72
X$8866 10043 10452 4923 10338 10570 10566 gf180mcu_fd_sc_mcu9t5v0__mux2_1
* cell instance $8867 r0 *1 653.52,887.04
X$8867 11595 10181 11596 11720 11600 11712 gf180mcu_fd_sc_mcu9t5v0__aoi21_1
* cell instance $8868 r0 *1 655.2,866.88
X$8868 8197 10951 10952 11181 11079 gf180mcu_fd_sc_mcu9t5v0__dffq_2
* cell instance $8869 r0 *1 644.56,866.88
X$8869 10950 4900 8807 6906 11181 11079 11176 gf180mcu_fd_sc_mcu9t5v0__oai211_1
* cell instance $8870 r0 *1 633.92,856.8
X$8870 10823 10824 10833 10714 10825 gf180mcu_fd_sc_mcu9t5v0__nand2_1
* cell instance $8871 r0 *1 627.76,866.88
X$8871 10448 10949 10950 11181 11079 gf180mcu_fd_sc_mcu9t5v0__dffq_2
* cell instance $8872 r0 *1 623.28,856.8
X$8872 10823 10824 10833 10714 10710 gf180mcu_fd_sc_mcu9t5v0__and2_1
* cell instance $8873 m0 *1 634.48,887.04
X$8873 11325 11461 11600 3103 gf180mcu_fd_sc_mcu9t5v0__buf_8
* cell instance $8874 m0 *1 637.84,866.88
X$8874 10950 7951 6250 10833 11079 10949 gf180mcu_fd_sc_mcu9t5v0__mux2_1
* cell instance $8875 m0 *1 656.88,846.72
X$8875 10451 4900 10184 6906 10338 10570 10450 gf180mcu_fd_sc_mcu9t5v0__oai211_1
* cell instance $8876 r0 *1 638.96,856.8
X$8876 10825 10833 10714 4539 gf180mcu_fd_sc_mcu9t5v0__buf_8
* cell instance $8877 m0 *1 663.04,866.88
X$8877 10952 10043 6250 10833 11079 10951 gf180mcu_fd_sc_mcu9t5v0__mux2_1
* cell instance $8878 m0 *1 648.48,897.12
X$8878 11595 6905 11596 11720 11860 11823 gf180mcu_fd_sc_mcu9t5v0__aoi21_1
* cell instance $8879 r0 *1 642.88,876.96
X$8879 11325 11461 11294 5389 gf180mcu_fd_sc_mcu9t5v0__inv_1
* cell instance $8880 m0 *1 649.6,846.72
X$8880 10451 9845 6250 10338 10570 10565 gf180mcu_fd_sc_mcu9t5v0__mux2_1
* cell instance $8881 r0 *1 660.24,846.72
X$8881 8197 10566 10452 10676 10570 gf180mcu_fd_sc_mcu9t5v0__dffq_2
* cell instance $8882 r0 *1 781.2,897.12
X$8882 10036 11975 3446 11971 11860 11974 gf180mcu_fd_sc_mcu9t5v0__mux2_1
* cell instance $8883 m0 *1 757.68,917.28
X$8883 12385 2257 6250 12128 12253 12252 gf180mcu_fd_sc_mcu9t5v0__mux2_1
* cell instance $8884 r0 *1 751.52,917.28
X$8884 12018 12252 12385 12508 12253 gf180mcu_fd_sc_mcu9t5v0__dffq_2
* cell instance $8885 r0 *1 750.96,937.44
X$8885 12018 13006 13007 13331 13054 12900 gf180mcu_fd_sc_mcu9t5v0__dffrnq_2
* cell instance $8886 r0 *1 750.96,957.6
X$8886 13831 13425 13195 13331 13586 13428 gf180mcu_fd_sc_mcu9t5v0__dffrnq_2
* cell instance $8887 m0 *1 756.56,957.6
X$8887 15401 13195 13055 13318 13428 13425 gf180mcu_fd_sc_mcu9t5v0__mux2_1
* cell instance $8888 m0 *1 757.12,947.52
X$8888 13159 13007 13055 13054 13160 13006 gf180mcu_fd_sc_mcu9t5v0__mux2_1
* cell instance $8889 m0 *1 758.24,907.2
X$8889 12018 11973 11972 11971 12019 gf180mcu_fd_sc_mcu9t5v0__dffq_2
* cell instance $8890 r0 *1 729.68,897.12
X$8890 11860 11971 gf180mcu_fd_sc_mcu9t5v0__filltie
* cell instance $8891 r0 *1 742,897.12
X$8891 11598 4900 7315 6906 11971 11860 12015 gf180mcu_fd_sc_mcu9t5v0__oai211_1
* cell instance $8892 r0 *1 757.12,897.12
X$8892 11972 4900 11333 6906 11971 11860 11968 gf180mcu_fd_sc_mcu9t5v0__oai211_1
* cell instance $8893 r0 *1 765.52,897.12
X$8893 11972 10677 6250 11971 11860 11973 gf180mcu_fd_sc_mcu9t5v0__mux2_1
* cell instance $8894 m0 *1 753.76,887.04
X$8894 12018 11331 11462 11461 11600 gf180mcu_fd_sc_mcu9t5v0__dffq_2
* cell instance $8895 r0 *1 752.08,846.72
X$8895 10074 10569 10456 10676 10570 gf180mcu_fd_sc_mcu9t5v0__dffq_2
* cell instance $8896 r0 *1 758.24,876.96
X$8896 4900 11332 10713 11461 11294 11333 gf180mcu_fd_sc_mcu9t5v0__nand3_1
* cell instance $8897 r0 *1 794.64,897.12
X$8897 12018 11825 11826 11971 11860 gf180mcu_fd_sc_mcu9t5v0__dffq_2
* cell instance $8898 r0 *1 792.4,937.44
X$8898 12018 12899 12901 13331 13054 12900 gf180mcu_fd_sc_mcu9t5v0__dffrnq_2
* cell instance $8899 r0 *1 804.16,947.52
X$8899 12901 13321 13197 13318 13160 13196 gf180mcu_fd_sc_mcu9t5v0__mux2_1
* cell instance $8900 r0 *1 803.04,917.28
X$8900 10715 10835 10305 9853 12133 3121 12508 12253 12387
+ gf180mcu_fd_sc_mcu9t5v0__mux4_1
* cell instance $8901 m0 *1 795.76,937.44
X$8901 12901 13009 12898 12785 12900 12899 gf180mcu_fd_sc_mcu9t5v0__mux2_1
* cell instance $8902 m0 *1 771.68,957.6
X$8902 12018 13319 13320 13331 13318 13428 gf180mcu_fd_sc_mcu9t5v0__dffrnq_2
* cell instance $8903 r0 *1 795.2,907.2
X$8903 12129 12128 12019 12125 gf180mcu_fd_sc_mcu9t5v0__clkbuf_8
* cell instance $8904 m0 *1 777.28,927.36
X$8904 12018 12509 12386 13331 12508 12646 gf180mcu_fd_sc_mcu9t5v0__dffrnq_2
* cell instance $8905 r0 *1 764.96,927.36
X$8905 12018 12747 12748 13331 12785 12646 gf180mcu_fd_sc_mcu9t5v0__dffrnq_2
* cell instance $8906 m0 *1 767.76,937.44
X$8906 12748 13007 12898 12785 12900 12747 gf180mcu_fd_sc_mcu9t5v0__mux2_1
* cell instance $8907 r0 *1 773.92,947.52
X$8907 13320 13195 12898 13318 13160 13319 gf180mcu_fd_sc_mcu9t5v0__mux2_1
* cell instance $8908 r0 *1 778.96,937.44
X$8908 13010 13009 13055 13054 12900 13008 gf180mcu_fd_sc_mcu9t5v0__mux2_1
* cell instance $8909 m0 *1 775.04,907.2
X$8909 12018 11974 11975 11971 12019 gf180mcu_fd_sc_mcu9t5v0__dffq_2
* cell instance $8910 r0 *1 780.64,917.28
X$8910 12386 16306 12898 12508 12253 12509 gf180mcu_fd_sc_mcu9t5v0__mux2_1
* cell instance $8911 m0 *1 774.48,947.52
X$8911 12018 13008 13009 13331 13054 13160 gf180mcu_fd_sc_mcu9t5v0__dffrnq_2
* cell instance $8912 m0 *1 806.4,937.44
X$8912 3679 12785 12900 3121 gf180mcu_fd_sc_mcu9t5v0__buf_12
* cell instance $8913 m0 *1 797.44,957.6
X$8913 13010 13321 13427 13318 13428 13426 gf180mcu_fd_sc_mcu9t5v0__mux2_1
* cell instance $8914 r0 *1 796.88,927.36
X$8914 4924 12785 12646 12018 gf180mcu_fd_sc_mcu9t5v0__clkbuf_8
* cell instance $8915 m0 *1 790.16,937.44
X$8915 12018 12785 12900 gf180mcu_fd_sc_mcu9t5v0__inv_4
* cell instance $8916 m0 *1 812.56,927.36
X$8916 12020 12387 9436 12508 12646 15272 gf180mcu_fd_sc_mcu9t5v0__mux2_1
* cell instance $8917 r0 *1 792.4,957.6
X$8917 13831 13426 13321 13331 13586 13428 gf180mcu_fd_sc_mcu9t5v0__dffrnq_2
* cell instance $8918 m0 *1 795.2,917.28
X$8918 10305 9853 10715 10835 2987 3106 12128 12253 12254
+ gf180mcu_fd_sc_mcu9t5v0__mux4_1
* cell instance $8919 m0 *1 791.84,907.2
X$8919 11975 10679 2891 11971 12019 11599 gf180mcu_fd_sc_mcu9t5v0__mux2_1
* cell instance $8920 m0 *1 809.76,907.2
X$8920 11975 10679 11563 11721 12133 3121 11971 12019 12020
+ gf180mcu_fd_sc_mcu9t5v0__mux4_1
* cell instance $8921 m0 *1 754.88,927.36
X$8921 12385 4900 6906 12508 12646 12617 gf180mcu_fd_sc_mcu9t5v0__oai21_1
* cell instance $8922 m0 *1 703.92,947.52
X$8922 13052 13053 13054 13160 13153 gf180mcu_fd_sc_mcu9t5v0__nand2_1
* cell instance $8923 r0 *1 730.8,957.6
X$8923 12892 13423 12784 13586 13428 13445 gf180mcu_fd_sc_mcu9t5v0__oai21_1
* cell instance $8924 m0 *1 712.32,907.2
X$8924 10074 12017 12126 13331 11971 12019 gf180mcu_fd_sc_mcu9t5v0__dffrnq_2
* cell instance $8925 m0 *1 731.92,917.28
X$8925 10074 12127 12251 12128 12253 gf180mcu_fd_sc_mcu9t5v0__dffq_2
* cell instance $8926 r0 *1 703.36,927.36
X$8926 12381 12746 12615 13331 12785 12646 gf180mcu_fd_sc_mcu9t5v0__dffrnq_2
* cell instance $8927 r0 *1 693.84,907.2
X$8927 12125 12019 12128 4924 gf180mcu_fd_sc_mcu9t5v0__clkbuf_16
* cell instance $8928 r0 *1 729.68,927.36
X$8928 12646 12785 gf180mcu_fd_sc_mcu9t5v0__filltie
* cell instance $8929 m0 *1 691.6,907.2
X$8929 11716 11963 11964 11971 12019 12013 gf180mcu_fd_sc_mcu9t5v0__oai21_1
* cell instance $8930 r0 *1 729.68,917.28
X$8930 12253 12508 gf180mcu_fd_sc_mcu9t5v0__filltie
* cell instance $8931 m0 *1 733.04,927.36
X$8931 9310 12617 12784 12616 12508 12646 12507
+ gf180mcu_fd_sc_mcu9t5v0__oai211_1
* cell instance $8932 m0 *1 709.52,907.2
X$8932 12016 11970 11971 12019 12017 gf180mcu_fd_sc_mcu9t5v0__nand2_1
* cell instance $8933 m0 *1 731.92,937.44
X$8933 12892 11597 12784 12785 12900 12783 gf180mcu_fd_sc_mcu9t5v0__oai21_1
* cell instance $8934 r0 *1 723.52,957.6
X$8934 12892 10674 12784 13586 13428 13317 gf180mcu_fd_sc_mcu9t5v0__oai21_1
* cell instance $8935 m0 *1 729.12,957.6
X$8935 13052 13317 13318 13428 13424 gf180mcu_fd_sc_mcu9t5v0__nand2_1
* cell instance $8936 r0 *1 729.68,937.44
X$8936 12900 13054 gf180mcu_fd_sc_mcu9t5v0__filltie
* cell instance $8937 r0 *1 729.68,947.52
X$8937 13160 13318 gf180mcu_fd_sc_mcu9t5v0__filltie
* cell instance $8938 r0 *1 734.16,937.44
X$8938 13052 12783 13054 12900 12896 gf180mcu_fd_sc_mcu9t5v0__nand2_1
* cell instance $8939 m0 *1 736.96,947.52
X$8939 12890 13193 12896 13154 13151 13054 13160 13158
+ gf180mcu_fd_sc_mcu9t5v0__aoi221_1
* cell instance $8940 m0 *1 716.24,917.28
X$8940 12506 12245 12128 12253 12250 gf180mcu_fd_sc_mcu9t5v0__nand2_1
* cell instance $8941 r0 *1 729.68,957.6
X$8941 13428 13586 gf180mcu_fd_sc_mcu9t5v0__filltie
* cell instance $8942 r0 *1 719.6,937.44
X$8942 12892 8810 12784 13054 12900 13005 gf180mcu_fd_sc_mcu9t5v0__oai21_1
* cell instance $8943 r0 *1 721.84,907.2
X$8943 12126 12245 12128 12019 12016 gf180mcu_fd_sc_mcu9t5v0__nand2_1
* cell instance $8944 r0 *1 708.96,957.6
X$8944 13052 13443 13586 13428 13585 gf180mcu_fd_sc_mcu9t5v0__nand2_1
* cell instance $8945 r0 *1 703.36,947.52
X$8945 12614 13193 13153 13154 13151 13318 13160 13444
+ gf180mcu_fd_sc_mcu9t5v0__aoi221_1
* cell instance $8946 m0 *1 720.72,947.52
X$8946 13005 13052 13054 13160 13156 gf180mcu_fd_sc_mcu9t5v0__nand2_1
* cell instance $8947 r0 *1 739.76,917.28
X$8947 12251 4900 9430 6906 12508 12253 12505 gf180mcu_fd_sc_mcu9t5v0__oai211_1
* cell instance $8948 m0 *1 692.72,917.28
X$8948 12247 12013 12128 12253 12246 gf180mcu_fd_sc_mcu9t5v0__nand2_1
* cell instance $8949 m0 *1 736.4,937.44
X$8949 12892 8199 12784 12785 12900 12895 gf180mcu_fd_sc_mcu9t5v0__oai21_1
* cell instance $8950 m0 *1 734.16,947.52
X$8950 13052 12895 13054 13160 13157 gf180mcu_fd_sc_mcu9t5v0__nand2_1
* cell instance $8951 r0 *1 736.96,947.52
X$8951 12126 13193 13157 13154 13151 13318 13160 13194
+ gf180mcu_fd_sc_mcu9t5v0__aoi221_1
* cell instance $8952 m0 *1 699.44,947.52
X$8952 12892 11557 12784 13054 13160 13053 gf180mcu_fd_sc_mcu9t5v0__oai21_1
* cell instance $8953 m0 *1 712.88,917.28
X$8953 12250 12014 12128 12253 12249 gf180mcu_fd_sc_mcu9t5v0__nand2_1
* cell instance $8954 r0 *1 729.68,907.2
X$8954 12019 12128 gf180mcu_fd_sc_mcu9t5v0__filltie
* cell instance $8955 r0 *1 738.08,907.2
X$8955 12251 8816 6250 12128 12019 12127 gf180mcu_fd_sc_mcu9t5v0__mux2_1
* cell instance $8956 m0 *1 714.56,947.52
X$8956 13154 13156 13193 12248 13151 13054 13160 13155
+ gf180mcu_fd_sc_mcu9t5v0__aoi221_1
* cell instance $8957 r0 *1 693.28,937.44
X$8957 13052 12891 13054 12900 13004 gf180mcu_fd_sc_mcu9t5v0__nand2_1
* cell instance $8958 m0 *1 700.56,907.2
X$8958 11963 11718 11964 11971 12019 12014 gf180mcu_fd_sc_mcu9t5v0__oai21_1
* cell instance $8959 m0 *1 698.32,917.28
X$8959 12248 12245 12128 12253 12247 gf180mcu_fd_sc_mcu9t5v0__nand2_1
* cell instance $8960 r0 *1 704.48,957.6
X$8960 12892 9540 12784 13586 13428 13443 gf180mcu_fd_sc_mcu9t5v0__oai21_1
* cell instance $8961 m0 *1 711.2,927.36
X$8961 12615 12245 12508 12646 12645 gf180mcu_fd_sc_mcu9t5v0__nand2_1
* cell instance $8962 r0 *1 700.56,927.36
X$8962 12645 12745 12785 12646 12746 gf180mcu_fd_sc_mcu9t5v0__nand2_1
* cell instance $8963 m0 *1 740.88,937.44
X$8963 12892 10955 12784 12785 12900 12893 gf180mcu_fd_sc_mcu9t5v0__oai21_1
* cell instance $8964 m0 *1 696.08,907.2
X$8964 11963 11717 11964 11971 12019 12745 gf180mcu_fd_sc_mcu9t5v0__oai21_1
* cell instance $8965 m0 *1 696.08,937.44
X$8965 12892 10033 12784 12785 12900 12891 gf180mcu_fd_sc_mcu9t5v0__oai21_1
* cell instance $8966 r0 *1 731.36,937.44
X$8966 13052 12893 13054 12900 12894 gf180mcu_fd_sc_mcu9t5v0__nand2_1
* cell instance $8967 r0 *1 736.96,937.44
X$8967 12612 13193 12894 13154 13151 13054 12900 12897
+ gf180mcu_fd_sc_mcu9t5v0__aoi221_1
* cell instance $8968 r0 *1 710.64,917.28
X$8968 10074 12249 12506 13331 12508 12253 gf180mcu_fd_sc_mcu9t5v0__dffrnq_2
* cell instance $8969 m0 *1 703.92,876.96
X$8969 10828 10073 4539 11290 11181 11294 11178
+ gf180mcu_fd_sc_mcu9t5v0__oai211_1
* cell instance $8970 m0 *1 693.84,866.88
X$8970 10074 10827 10828 10833 11079 gf180mcu_fd_sc_mcu9t5v0__dffq_2
* cell instance $8971 r0 *1 697.2,887.04
X$8971 11595 7312 11596 11720 11600 11717 gf180mcu_fd_sc_mcu9t5v0__aoi21_1
* cell instance $8972 m0 *1 692.72,856.8
X$8972 10453 4922 10676 10714 10712 gf180mcu_fd_sc_mcu9t5v0__nand2_1
* cell instance $8973 r0 *1 714.56,876.96
X$8973 11329 9596 6250 11461 11294 11328 gf180mcu_fd_sc_mcu9t5v0__mux2_1
* cell instance $8974 r0 *1 729.68,846.72
X$8974 10570 10676 gf180mcu_fd_sc_mcu9t5v0__filltie
* cell instance $8975 r0 *1 720.72,846.72
X$8975 10675 10336 10454 10676 10570 10674 gf180mcu_fd_sc_mcu9t5v0__aoi21_1
* cell instance $8976 m0 *1 752.08,876.96
X$8976 10832 10073 4539 11293 11181 11294 11330
+ gf180mcu_fd_sc_mcu9t5v0__oai211_1
* cell instance $8977 r0 *1 730.8,846.72
X$8977 10074 10568 10455 10676 10570 gf180mcu_fd_sc_mcu9t5v0__dffq_2
* cell instance $8978 r0 *1 739.76,887.04
X$8978 11598 7069 6250 11720 11600 11824 gf180mcu_fd_sc_mcu9t5v0__mux2_1
* cell instance $8979 m0 *1 735.28,866.88
X$8979 10956 9820 6250 10833 11079 11291 gf180mcu_fd_sc_mcu9t5v0__mux2_1
* cell instance $8980 r0 *1 694.96,866.88
X$8980 4900 11178 10712 11181 11079 11179 gf180mcu_fd_sc_mcu9t5v0__nand3_1
* cell instance $8981 r0 *1 729.68,866.88
X$8981 11079 11181 gf180mcu_fd_sc_mcu9t5v0__filltie
* cell instance $8982 m0 *1 731.36,897.12
X$8982 10074 11824 11598 11720 11860 gf180mcu_fd_sc_mcu9t5v0__dffq_2
* cell instance $8983 m0 *1 742.56,866.88
X$8983 10074 10957 10832 10833 11079 gf180mcu_fd_sc_mcu9t5v0__dffq_2
* cell instance $8984 r0 *1 719.04,887.04
X$8984 11329 4900 9840 6906 11720 11600 11719 gf180mcu_fd_sc_mcu9t5v0__oai211_1
* cell instance $8985 m0 *1 725.2,897.12
X$8985 11719 11720 11860 13423 gf180mcu_fd_sc_mcu9t5v0__clkinv_1
* cell instance $8986 m0 *1 744.24,876.96
X$8986 10956 4900 6906 11181 11294 11292 gf180mcu_fd_sc_mcu9t5v0__oai21_1
* cell instance $8987 r0 *1 701.68,856.8
X$8987 9709 10828 4018 10833 10714 10827 gf180mcu_fd_sc_mcu9t5v0__mux2_1
* cell instance $8988 r0 *1 729.68,856.8
X$8988 10714 10833 gf180mcu_fd_sc_mcu9t5v0__filltie
* cell instance $8989 r0 *1 740.88,876.96
X$8989 11330 10337 11292 11461 11294 11597 gf180mcu_fd_sc_mcu9t5v0__aoi21_1
* cell instance $8990 m0 *1 727.44,876.96
X$8990 10074 11291 10956 11181 11294 gf180mcu_fd_sc_mcu9t5v0__dffq_2
* cell instance $8991 r0 *1 694.4,876.96
X$8991 11289 4900 11179 6906 11461 11294 11326 gf180mcu_fd_sc_mcu9t5v0__oai211_1
* cell instance $8992 r0 *1 717.92,856.8
X$8992 9112 10830 4018 10833 10714 10829 gf180mcu_fd_sc_mcu9t5v0__mux2_1
* cell instance $8993 r0 *1 749.84,856.8
X$8993 9820 10832 4018 10833 10714 10957 gf180mcu_fd_sc_mcu9t5v0__mux2_1
* cell instance $8994 m0 *1 696.64,887.04
X$8994 11326 11461 11600 11557 gf180mcu_fd_sc_mcu9t5v0__clkinv_1
* cell instance $8995 r0 *1 739.2,836.64
X$8995 10455 4922 8579 10338 10308 10337 gf180mcu_fd_sc_mcu9t5v0__aoi21_1
* cell instance $8996 r0 *1 729.68,836.64
X$8996 10308 10338 gf180mcu_fd_sc_mcu9t5v0__filltie
* cell instance $8997 r0 *1 717.92,836.64
X$8997 10185 4922 8579 10338 10308 10336 gf180mcu_fd_sc_mcu9t5v0__aoi21_1
* cell instance $8998 r0 *1 730.8,866.88
X$8998 10073 11180 11181 11079 10831 gf180mcu_fd_sc_mcu9t5v0__nand2_1
* cell instance $8999 m0 *1 722.96,856.8
X$8999 10830 10073 4539 10831 10676 10714 10675
+ gf180mcu_fd_sc_mcu9t5v0__oai211_1
* cell instance $9000 r0 *1 734.16,866.88
X$9000 4924 11181 11079 10074 gf180mcu_fd_sc_mcu9t5v0__clkbuf_8
* cell instance $9001 m0 *1 730.8,866.88
X$9001 10074 10833 11079 gf180mcu_fd_sc_mcu9t5v0__clkinv_3
* cell instance $9002 r0 *1 729.68,876.96
X$9002 11294 11461 gf180mcu_fd_sc_mcu9t5v0__filltie
* cell instance $9003 m0 *1 747.04,836.64
X$9003 10035 4900 6906 10188 10308 10304 gf180mcu_fd_sc_mcu9t5v0__oai21_1
* cell instance $9004 r0 *1 729.68,887.04
X$9004 11600 11720 gf180mcu_fd_sc_mcu9t5v0__filltie
* cell instance $9005 m0 *1 708.4,887.04
X$9005 10074 11328 11329 11461 11600 gf180mcu_fd_sc_mcu9t5v0__dffq_2
* cell instance $9006 m0 *1 742,836.64
X$9006 10187 10034 10304 10188 10308 10955 gf180mcu_fd_sc_mcu9t5v0__aoi21_1
* cell instance $9007 r0 *1 692.72,887.04
X$9007 11595 6939 11596 11720 11600 11716 gf180mcu_fd_sc_mcu9t5v0__aoi21_1
* cell instance $9008 m0 *1 737.52,846.72
X$9008 9820 10455 4923 10338 10570 10568 gf180mcu_fd_sc_mcu9t5v0__mux2_1
* cell instance $9009 m0 *1 710.64,866.88
X$9009 10074 10829 10830 10833 11079 gf180mcu_fd_sc_mcu9t5v0__dffq_2
* cell instance $9010 m0 *1 703.92,846.72
X$9010 10074 10334 10335 10338 10570 gf180mcu_fd_sc_mcu9t5v0__dffq_2
* cell instance $9011 r0 *1 701.68,887.04
X$9011 11595 8198 11596 11720 11600 11718 gf180mcu_fd_sc_mcu9t5v0__aoi21_1
* cell instance $9012 m0 *1 720.72,846.72
X$9012 10335 4900 6906 10338 10570 10454 gf180mcu_fd_sc_mcu9t5v0__oai21_1
* cell instance $9013 r0 *1 710.64,836.64
X$9013 10335 9112 6250 10338 10308 10334 gf180mcu_fd_sc_mcu9t5v0__mux2_1
* cell instance $9014 r0 *1 711.76,876.96
X$9014 10073 11327 11461 11294 11290 gf180mcu_fd_sc_mcu9t5v0__nand2_1
* cell instance $9015 m0 *1 773.92,887.04
X$9015 5389 11558 10073 11461 11600 11463 gf180mcu_fd_sc_mcu9t5v0__oai21_1
* cell instance $9016 r0 *1 794.08,836.64
X$9016 10191 9693 10457 10338 10308 10307 gf180mcu_fd_sc_mcu9t5v0__mux2_2
* cell instance $9017 r0 *1 776.16,856.8
X$9017 10036 10677 2264 10833 10714 10836 gf180mcu_fd_sc_mcu9t5v0__mux2_1
* cell instance $9018 m0 *1 759.92,856.8
X$9018 10456 4922 10676 10714 10713 gf180mcu_fd_sc_mcu9t5v0__nand2_1
* cell instance $9019 m0 *1 800.24,897.12
X$9019 10042 11826 3446 11720 11860 11825 gf180mcu_fd_sc_mcu9t5v0__mux2_1
* cell instance $9020 m0 *1 814.24,876.96
X$9020 3103 11182 11295 4930 11181 11294 10954 gf180mcu_fd_sc_mcu9t5v0__aoi211_1
* cell instance $9021 m0 *1 766.08,866.88
X$9021 10074 10834 10835 10833 11079 gf180mcu_fd_sc_mcu9t5v0__dffq_2
* cell instance $9022 r0 *1 787.92,846.72
X$9022 10680 10679 10457 10676 10570 10678 gf180mcu_fd_sc_mcu9t5v0__mux2_2
* cell instance $9023 r0 *1 805.84,887.04
X$9023 11563 11721 2891 11720 11600 11561 gf180mcu_fd_sc_mcu9t5v0__mux2_1
* cell instance $9024 m0 *1 810.32,856.8
X$9024 10571 10682 10457 10676 10714 10681 gf180mcu_fd_sc_mcu9t5v0__mux2_2
* cell instance $9025 m0 *1 780.08,856.8
X$9025 10074 10678 10679 10676 10714 gf180mcu_fd_sc_mcu9t5v0__dffq_2
* cell instance $9026 r0 *1 820.4,856.8
X$9026 9815 10684 3446 10833 10714 10837 gf180mcu_fd_sc_mcu9t5v0__mux2_1
* cell instance $9027 m0 *1 792.4,866.88
X$9027 10960 10959 4024 10833 11079 10958 gf180mcu_fd_sc_mcu9t5v0__mux2_1
* cell instance $9028 r0 *1 790.16,876.96
X$9028 10305 4765 4949 9853 2992 11461 11294 11336
+ gf180mcu_fd_sc_mcu9t5v0__aoi221_1
* cell instance $9029 m0 *1 771.68,836.64
X$9029 10074 10190 10305 10188 10308 gf180mcu_fd_sc_mcu9t5v0__dffq_2
* cell instance $9030 r0 *1 796.32,846.72
X$9030 10036 10677 3677 10676 10570 10680 gf180mcu_fd_sc_mcu9t5v0__mux2_2
* cell instance $9031 r0 *1 788.48,866.88
X$9031 10074 10958 10959 11181 11079 gf180mcu_fd_sc_mcu9t5v0__dffq_2
* cell instance $9032 r0 *1 813.68,876.96
X$9032 10959 4949 11461 11294 11338 gf180mcu_fd_sc_mcu9t5v0__nand2_1
* cell instance $9033 m0 *1 820.96,897.12
X$9033 11826 10683 2891 11720 11860 11601 gf180mcu_fd_sc_mcu9t5v0__mux2_1
* cell instance $9034 r0 *1 817.04,887.04
X$9034 11341 4765 11601 2983 2880 11720 11600 11339
+ gf180mcu_fd_sc_mcu9t5v0__aoi221_1
* cell instance $9035 m0 *1 815.36,846.72
X$9035 9815 9845 2564 10338 10570 10571 gf180mcu_fd_sc_mcu9t5v0__mux2_2
* cell instance $9036 m0 *1 799.68,866.88
X$9036 10042 10043 2264 10833 11079 10960 gf180mcu_fd_sc_mcu9t5v0__mux2_1
* cell instance $9037 r0 *1 796.32,876.96
X$9037 10835 4949 11461 11294 11337 gf180mcu_fd_sc_mcu9t5v0__nand2_1
* cell instance $9038 r0 *1 816.48,876.96
X$9038 2880 11340 11338 11339 3103 11461 11294 11295
+ gf180mcu_fd_sc_mcu9t5v0__aoi221_1
* cell instance $9039 r0 *1 768.88,856.8
X$9039 10836 10835 4024 10833 10714 10834 gf180mcu_fd_sc_mcu9t5v0__mux2_1
* cell instance $9040 r0 *1 769.44,876.96
X$9040 11462 10073 11334 11463 4539 11461 11294 11332
+ gf180mcu_fd_sc_mcu9t5v0__oai221_1
* cell instance $9041 r0 *1 805.28,846.72
X$9041 10306 10681 10682 10676 10570 gf180mcu_fd_sc_mcu9t5v0__dffq_2
* cell instance $9042 r0 *1 776.72,876.96
X$9042 11335 11297 10073 11461 11294 11293 gf180mcu_fd_sc_mcu9t5v0__oai21_1
* cell instance $9043 r0 *1 762.16,876.96
X$9043 10677 11462 4018 11461 11294 11331 gf180mcu_fd_sc_mcu9t5v0__mux2_1
* cell instance $9044 r0 *1 790.16,887.04
X$9044 10715 4765 11599 2983 2880 11720 11600 11560
+ gf180mcu_fd_sc_mcu9t5v0__aoi221_1
* cell instance $9045 m0 *1 791.84,887.04
X$9045 11337 11560 11559 11336 3103 11461 11600 11334
+ gf180mcu_fd_sc_mcu9t5v0__aoi221_1
* cell instance $9046 m0 *1 800.24,887.04
X$9046 2983 11561 11461 11600 11559 gf180mcu_fd_sc_mcu9t5v0__nand2_1
* cell instance $9047 m0 *1 788.48,836.64
X$9047 10306 10307 9693 10188 10308 gf180mcu_fd_sc_mcu9t5v0__dffq_2
* cell instance $9048 m0 *1 759.92,846.72
X$9048 10677 10456 4923 10338 10570 10569 gf180mcu_fd_sc_mcu9t5v0__mux2_1
* cell instance $9049 m0 *1 683.76,776.16
X$9049 8197 8808 8689 8693 8818 gf180mcu_fd_sc_mcu9t5v0__dffq_2
* cell instance $9050 m0 *1 683.2,796.32
X$9050 8197 9081 9305 9201 9315 gf180mcu_fd_sc_mcu9t5v0__dffq_2
* cell instance $9051 r0 *1 677.04,816.48
X$9051 4924 9841 9810 8197 gf180mcu_fd_sc_mcu9t5v0__clkbuf_8
* cell instance $9052 r0 *1 688.8,745.92
X$9052 6017 7946 8073 8078 7948 gf180mcu_fd_sc_mcu9t5v0__dffq_2
* cell instance $9053 m0 *1 684.32,816.48
X$9053 8197 9689 9573 9691 9810 gf180mcu_fd_sc_mcu9t5v0__dffq_2
* cell instance $9054 m0 *1 684.88,685.44
X$9054 6017 6388 6423 6392 6425 gf180mcu_fd_sc_mcu9t5v0__dffq_2
* cell instance $9055 r0 *1 690.48,624.96
X$9055 4508 5052 4898 5183 5056 gf180mcu_fd_sc_mcu9t5v0__dffq_2
* cell instance $9056 m0 *1 690.48,665.28
X$9056 6017 6032 5892 5920 6034 gf180mcu_fd_sc_mcu9t5v0__dffq_2
* cell instance $9057 r0 *1 705.6,685.44
X$9057 6771 2688 6250 6664 6425 6663 gf180mcu_fd_sc_mcu9t5v0__mux2_1
* cell instance $9058 m0 *1 679.84,695.52
X$9058 6770 2262 6250 6664 6805 6769 gf180mcu_fd_sc_mcu9t5v0__mux2_1
* cell instance $9059 r0 *1 661.92,685.44
X$9059 6536 2148 6250 6664 6425 6662 gf180mcu_fd_sc_mcu9t5v0__mux2_1
* cell instance $9060 m0 *1 655.2,695.52
X$9060 6017 6662 6536 6664 6805 gf180mcu_fd_sc_mcu9t5v0__dffq_2
* cell instance $9061 m0 *1 688.8,715.68
X$9061 6017 7066 7067 7071 7195 gf180mcu_fd_sc_mcu9t5v0__dffq_2
* cell instance $9062 r0 *1 674.8,604.8
X$9062 4508 4507 4537 4667 4512 gf180mcu_fd_sc_mcu9t5v0__dffq_2
* cell instance $9063 m0 *1 699.44,695.52
X$9063 6017 6663 6771 6664 6805 gf180mcu_fd_sc_mcu9t5v0__dffq_2
* cell instance $9064 m0 *1 689.92,604.8
X$9064 4508 4387 4368 4389 4512 gf180mcu_fd_sc_mcu9t5v0__dffq_2
* cell instance $9065 m0 *1 609.84,695.52
X$9065 6805 6664 gf180mcu_fd_sc_mcu9t5v0__filltie
* cell instance $9066 m0 *1 685.44,614.88
X$9066 4537 4538 4539 4662 4667 4794 4761 gf180mcu_fd_sc_mcu9t5v0__oai211_1
* cell instance $9067 r0 *1 689.36,635.04
X$9067 4900 4761 5387 5390 5297 5792 gf180mcu_fd_sc_mcu9t5v0__nand3_1
* cell instance $9068 r0 *1 700,685.44
X$9068 6538 6142 6424 4900 6664 6425 6537 gf180mcu_fd_sc_mcu9t5v0__oai211_1
* cell instance $9069 m0 *1 771.12,695.52
X$9069 7781 6665 6666 6664 6805 gf180mcu_fd_sc_mcu9t5v0__dffq_2
* cell instance $9070 r0 *1 780.64,685.44
X$9070 6253 6146 2264 6664 6425 6542 gf180mcu_fd_sc_mcu9t5v0__mux2_1
* cell instance $9071 r0 *1 804.16,685.44
X$9071 6666 4949 6543 2983 2880 6664 6425 6544 gf180mcu_fd_sc_mcu9t5v0__aoi221_1
* cell instance $9072 m0 *1 814.24,695.52
X$9072 6774 4949 6664 6805 6546 gf180mcu_fd_sc_mcu9t5v0__nand2_1
* cell instance $9073 m0 *1 811.44,695.52
X$9073 6807 4765 6664 6805 6667 gf180mcu_fd_sc_mcu9t5v0__nand2_1
* cell instance $9074 r0 *1 810.32,685.44
X$9074 6667 6544 6546 6545 3103 6664 6425 6547 gf180mcu_fd_sc_mcu9t5v0__aoi221_1
* cell instance $9075 r0 *1 773.36,685.44
X$9075 6542 6666 4024 6664 6425 6665 gf180mcu_fd_sc_mcu9t5v0__mux2_1
* cell instance $9076 r0 *1 729.68,685.44
X$9076 6425 6664 gf180mcu_fd_sc_mcu9t5v0__filltie
* cell instance $9077 r0 *1 733.6,685.44
X$9077 6772 4900 4926 6906 6664 6425 6803 gf180mcu_fd_sc_mcu9t5v0__oai211_1
* cell instance $9078 r0 *1 753.2,685.44
X$9078 6541 4246 6250 6664 6425 6773 gf180mcu_fd_sc_mcu9t5v0__mux2_1
* cell instance $9079 m0 *1 745.92,695.52
X$9079 6017 6773 6541 6664 6805 gf180mcu_fd_sc_mcu9t5v0__dffq_2
* cell instance $9080 m0 *1 724.64,695.52
X$9080 6017 6804 6772 6664 6805 gf180mcu_fd_sc_mcu9t5v0__dffq_2
* cell instance $9081 r0 *1 758.8,715.68
X$9081 7072 4538 7318 7317 4539 7316 7195 7314 gf180mcu_fd_sc_mcu9t5v0__oai221_1
* cell instance $9082 r0 *1 712.88,756
X$9082 8453 8314 4923 8445 8204 8313 gf180mcu_fd_sc_mcu9t5v0__mux2_1
* cell instance $9083 r0 *1 754.88,695.52
X$9083 6541 4900 5155 6906 6909 6805 6908 gf180mcu_fd_sc_mcu9t5v0__oai211_1
* cell instance $9084 m0 *1 758.8,705.6
X$9084 7069 7072 4018 6909 6943 7070 gf180mcu_fd_sc_mcu9t5v0__mux2_1
* cell instance $9085 r0 *1 750.96,705.6
X$9085 7781 7070 7072 7071 6943 gf180mcu_fd_sc_mcu9t5v0__dffq_2
* cell instance $9086 r0 *1 753.76,796.32
X$9086 2257 9312 4923 9432 9315 9431 gf180mcu_fd_sc_mcu9t5v0__mux2_1
* cell instance $9087 m0 *1 746.48,806.4
X$9087 6428 9431 9312 9432 9575 gf180mcu_fd_sc_mcu9t5v0__dffq_2
* cell instance $9088 m0 *1 757.68,735.84
X$9088 3808 7671 7814 7781 gf180mcu_fd_sc_mcu9t5v0__clkbuf_8
* cell instance $9089 r0 *1 761.04,756
X$9089 7781 8317 8318 8445 8204 gf180mcu_fd_sc_mcu9t5v0__dffq_2
* cell instance $9090 r0 *1 745.36,735.84
X$9090 7781 7813 7782 7919 7814 gf180mcu_fd_sc_mcu9t5v0__dffq_2
* cell instance $9091 r0 *1 731.36,756
X$9091 7781 8316 8200 8445 8204 gf180mcu_fd_sc_mcu9t5v0__dffq_2
* cell instance $9092 r0 *1 754.32,766.08
X$9092 3103 8580 8541 4930 8693 8582 8578 gf180mcu_fd_sc_mcu9t5v0__aoi211_1
* cell instance $9093 r0 *1 722.96,756
X$9093 8075 4900 6906 8445 8204 8315 gf180mcu_fd_sc_mcu9t5v0__oai21_1
* cell instance $9094 r0 *1 729.68,756
X$9094 8204 8445 gf180mcu_fd_sc_mcu9t5v0__filltie
* cell instance $9095 r0 *1 798.56,756
X$9095 8203 8082 2891 8445 8204 8319 gf180mcu_fd_sc_mcu9t5v0__mux2_1
* cell instance $9096 r0 *1 791.84,786.24
X$9096 9085 4765 4949 8956 2880 9201 8961 9084 gf180mcu_fd_sc_mcu9t5v0__aoi221_1
* cell instance $9097 r0 *1 799.68,786.24
X$9097 8957 8959 9085 8956 2987 3106 9201 8961 9086
+ gf180mcu_fd_sc_mcu9t5v0__mux4_1
* cell instance $9098 m0 *1 804.72,806.4
X$9098 9543 9542 2891 9432 9575 9434 gf180mcu_fd_sc_mcu9t5v0__mux2_1
* cell instance $9099 r0 *1 814.8,816.48
X$9099 9815 9845 2264 9841 9810 9844 gf180mcu_fd_sc_mcu9t5v0__mux2_1
* cell instance $9100 m0 *1 782.88,816.48
X$9100 10306 9692 9574 9691 9810 gf180mcu_fd_sc_mcu9t5v0__dffq_2
* cell instance $9101 r0 *1 797.44,806.4
X$9101 9574 9693 2891 9691 9575 9541 gf180mcu_fd_sc_mcu9t5v0__mux2_1
* cell instance $9102 m0 *1 795.76,806.4
X$9102 2983 9541 9432 9575 9202 gf180mcu_fd_sc_mcu9t5v0__nand2_1
* cell instance $9103 r0 *1 781.76,786.24
X$9103 9204 8816 2264 9201 8961 8958 gf180mcu_fd_sc_mcu9t5v0__mux2_1
* cell instance $9104 r0 *1 787.92,806.4
X$9104 9204 9574 3446 9691 9575 9692 gf180mcu_fd_sc_mcu9t5v0__mux2_1
* cell instance $9105 m0 *1 808.08,796.32
X$9105 9085 8956 8957 8959 6775 3679 9201 9315 9316
+ gf180mcu_fd_sc_mcu9t5v0__mux4_1
* cell instance $9106 m0 *1 770.56,826.56
X$9106 5389 10189 10073 9841 10078 9842 gf180mcu_fd_sc_mcu9t5v0__oai21_1
* cell instance $9107 r0 *1 773.36,766.08
X$9107 8581 8695 2573 8693 8582 8817 gf180mcu_fd_sc_mcu9t5v0__mux2_2
* cell instance $9108 m0 *1 771.12,786.24
X$9108 8958 8956 4024 8843 8961 8955 gf180mcu_fd_sc_mcu9t5v0__mux2_1
* cell instance $9109 r0 *1 764.96,816.48
X$9109 9843 10073 8711 9842 4539 9841 9810 10187
+ gf180mcu_fd_sc_mcu9t5v0__oai221_1
* cell instance $9110 m0 *1 763.28,826.56
X$9110 9809 9843 4018 9841 10078 10076 gf180mcu_fd_sc_mcu9t5v0__mux2_1
* cell instance $9111 r0 *1 772.24,796.32
X$9111 9313 8957 2573 9432 9315 9433 gf180mcu_fd_sc_mcu9t5v0__mux2_2
* cell instance $9112 m0 *1 763.84,806.4
X$9112 6428 9433 8957 9432 9575 gf180mcu_fd_sc_mcu9t5v0__dffq_2
* cell instance $9113 m0 *1 787.36,786.24
X$9113 8957 4765 4949 8959 2992 8843 8961 8960 gf180mcu_fd_sc_mcu9t5v0__aoi221_1
* cell instance $9114 m0 *1 780.64,806.4
X$9114 8816 9204 2986 9432 9575 9313 gf180mcu_fd_sc_mcu9t5v0__mux2_1
* cell instance $9115 r0 *1 764.96,786.24
X$9115 7781 8955 8956 9201 8961 gf180mcu_fd_sc_mcu9t5v0__dffq_2
* cell instance $9116 r0 *1 759.92,766.08
X$9116 8446 8692 8694 8693 8582 8580 gf180mcu_fd_sc_mcu9t5v0__oai21_1
* cell instance $9117 r0 *1 814.24,796.32
X$9117 9317 9316 9436 9432 9315 9435 gf180mcu_fd_sc_mcu9t5v0__mux2_1
* cell instance $9118 m0 *1 768.32,766.08
X$9118 8202 8318 4024 8445 8582 8317 gf180mcu_fd_sc_mcu9t5v0__mux2_1
* cell instance $9119 m0 *1 764.4,776.16
X$9119 7781 8817 8695 8693 8818 gf180mcu_fd_sc_mcu9t5v0__dffq_2
* cell instance $9120 m0 *1 804.16,826.56
X$9120 10306 10037 10038 9841 10078 gf180mcu_fd_sc_mcu9t5v0__dffq_2
* cell instance $9121 r0 *1 796.88,796.32
X$9121 2983 9434 9432 9315 9314 gf180mcu_fd_sc_mcu9t5v0__nand2_1
* cell instance $9122 m0 *1 782.88,826.56
X$9122 10677 10036 2986 9841 10078 10077 gf180mcu_fd_sc_mcu9t5v0__mux2_1
* cell instance $9123 m0 *1 790.72,796.32
X$9123 9202 9084 9314 8960 3103 9201 9315 9083 gf180mcu_fd_sc_mcu9t5v0__aoi221_1
* cell instance $9124 m0 *1 798.56,766.08
X$9124 2983 8319 8445 8582 8447 gf180mcu_fd_sc_mcu9t5v0__nand2_1
* cell instance $9125 r0 *1 794.08,766.08
X$9125 8696 4765 4949 8318 2880 8693 8582 8544 gf180mcu_fd_sc_mcu9t5v0__aoi221_1
* cell instance $9126 r0 *1 791.28,766.08
X$9126 8695 4765 8693 8582 8543 gf180mcu_fd_sc_mcu9t5v0__nand2_1
* cell instance $9127 m0 *1 813.12,766.08
X$9127 8698 4949 8545 2983 2992 8445 8582 8542 gf180mcu_fd_sc_mcu9t5v0__aoi221_1
* cell instance $9128 m0 *1 792.4,766.08
X$9128 8447 8544 8543 8542 3103 8445 8582 8541 gf180mcu_fd_sc_mcu9t5v0__aoi221_1
* cell instance $9129 r0 *1 805.84,766.08
X$9129 8695 8698 8696 8318 2987 3106 8693 8582 8697
+ gf180mcu_fd_sc_mcu9t5v0__mux4_1
* cell instance $9130 r0 *1 781.76,766.08
X$9130 7951 8079 2986 8693 8582 8581 gf180mcu_fd_sc_mcu9t5v0__mux2_1
* cell instance $9131 m0 *1 719.04,816.48
X$9131 9806 9805 9690 4900 9691 9810 9840 gf180mcu_fd_sc_mcu9t5v0__oai211_1
* cell instance $9132 r0 *1 733.04,776.16
X$9132 4538 8813 8843 8818 8812 gf180mcu_fd_sc_mcu9t5v0__nand2_1
* cell instance $9133 r0 *1 703.36,796.32
X$9133 8197 9307 9308 9432 9315 gf180mcu_fd_sc_mcu9t5v0__dffq_2
* cell instance $9134 m0 *1 744.8,826.56
X$9134 10035 9809 6250 9841 10078 10075 gf180mcu_fd_sc_mcu9t5v0__mux2_1
* cell instance $9135 r0 *1 748.16,796.32
X$9135 9312 4922 8579 4666 9432 9315 9310 gf180mcu_fd_sc_mcu9t5v0__aoi211_1
* cell instance $9136 m0 *1 700.56,776.16
X$9136 8689 4538 4539 8690 8693 8818 8809 gf180mcu_fd_sc_mcu9t5v0__oai211_1
* cell instance $9137 m0 *1 694.96,786.24
X$9137 9305 4922 8843 8961 8951 gf180mcu_fd_sc_mcu9t5v0__nand2_1
* cell instance $9138 r0 *1 732.48,796.32
X$9138 8816 9311 4923 9432 9315 9309 gf180mcu_fd_sc_mcu9t5v0__mux2_1
* cell instance $9139 r0 *1 698.88,786.24
X$9139 4900 8809 8951 9201 8961 9306 gf180mcu_fd_sc_mcu9t5v0__nand3_1
* cell instance $9140 r0 *1 748.72,786.24
X$9140 8815 4538 9083 8953 4539 9201 8961 9082 gf180mcu_fd_sc_mcu9t5v0__oai221_1
* cell instance $9141 m0 *1 736.96,806.4
X$9141 9311 4922 9432 9575 9429 gf180mcu_fd_sc_mcu9t5v0__nand2_1
* cell instance $9142 r0 *1 729.68,796.32
X$9142 9315 9432 gf180mcu_fd_sc_mcu9t5v0__filltie
* cell instance $9143 m0 *1 736.4,816.48
X$9143 9809 9808 4923 9691 9810 9807 gf180mcu_fd_sc_mcu9t5v0__mux2_1
* cell instance $9144 r0 *1 742,796.32
X$9144 4900 9082 9429 9432 9315 9430 gf180mcu_fd_sc_mcu9t5v0__nand3_1
* cell instance $9145 r0 *1 730.8,816.48
X$9145 8197 9807 9808 9841 9810 gf180mcu_fd_sc_mcu9t5v0__dffq_2
* cell instance $9146 r0 *1 729.68,806.4
X$9146 9575 9691 gf180mcu_fd_sc_mcu9t5v0__filltie
* cell instance $9147 r0 *1 729.68,786.24
X$9147 8961 9201 gf180mcu_fd_sc_mcu9t5v0__filltie
* cell instance $9148 m0 *1 738.08,826.56
X$9148 9808 4922 8579 9841 10078 10034 gf180mcu_fd_sc_mcu9t5v0__aoi21_1
* cell instance $9149 r0 *1 729.68,816.48
X$9149 9810 9841 gf180mcu_fd_sc_mcu9t5v0__filltie
* cell instance $9150 m0 *1 696.08,826.56
X$9150 9839 9841 10078 10033 gf180mcu_fd_sc_mcu9t5v0__clkinv_1
* cell instance $9151 r0 *1 691.6,786.24
X$9151 6281 9305 4923 9201 8961 9081 gf180mcu_fd_sc_mcu9t5v0__mux2_1
* cell instance $9152 r0 *1 718.48,766.08
X$9152 8314 4922 8579 8693 8582 8691 gf180mcu_fd_sc_mcu9t5v0__aoi21_1
* cell instance $9153 m0 *1 721.84,776.16
X$9153 8811 8691 8315 8693 8818 8810 gf180mcu_fd_sc_mcu9t5v0__aoi21_1
* cell instance $9154 m0 *1 752.08,776.16
X$9154 2891 4497 8693 8818 8692 gf180mcu_fd_sc_mcu9t5v0__nand2_1
* cell instance $9155 r0 *1 729.68,766.08
X$9155 8582 8693 gf180mcu_fd_sc_mcu9t5v0__filltie
* cell instance $9156 r0 *1 729.68,776.16
X$9156 8818 8843 gf180mcu_fd_sc_mcu9t5v0__filltie
* cell instance $9157 m0 *1 714.56,806.4
X$9157 9308 4538 4539 9432 9575 9805 gf180mcu_fd_sc_mcu9t5v0__oai21_1
* cell instance $9158 r0 *1 717.92,776.16
X$9158 8453 8842 4018 8843 8818 8952 gf180mcu_fd_sc_mcu9t5v0__mux2_1
* cell instance $9159 r0 *1 702.24,766.08
X$9159 4538 6913 8693 8582 8690 gf180mcu_fd_sc_mcu9t5v0__nand2_1
* cell instance $9160 m0 *1 741.44,766.08
X$9160 8200 4922 8579 8445 8582 8201 gf180mcu_fd_sc_mcu9t5v0__aoi21_1
* cell instance $9161 r0 *1 691.04,806.4
X$9161 9573 6281 6250 9691 9575 9689 gf180mcu_fd_sc_mcu9t5v0__mux2_1
* cell instance $9162 m0 *1 743.68,776.16
X$9162 8816 8815 4018 8693 8818 8814 gf180mcu_fd_sc_mcu9t5v0__mux2_1
* cell instance $9163 r0 *1 693.84,816.48
X$9163 9573 4900 9306 6906 9841 9810 9839 gf180mcu_fd_sc_mcu9t5v0__oai211_1
* cell instance $9164 m0 *1 726.32,776.16
X$9164 8842 4538 8812 4539 8693 8818 8811 gf180mcu_fd_sc_mcu9t5v0__oai211_1
* cell instance $9165 r0 *1 691.6,766.08
X$9165 6281 8689 4018 8693 8582 8808 gf180mcu_fd_sc_mcu9t5v0__mux2_1
* cell instance $9166 m0 *1 711.76,796.32
X$9166 9596 9308 4018 9201 9315 9307 gf180mcu_fd_sc_mcu9t5v0__mux2_1
* cell instance $9167 m0 *1 711.76,816.48
X$9167 9596 9804 4923 9691 9810 9803 gf180mcu_fd_sc_mcu9t5v0__mux2_1
* cell instance $9168 r0 *1 692.16,796.32
X$9168 9200 9432 9315 9540 gf180mcu_fd_sc_mcu9t5v0__clkinv_1
* cell instance $9169 m0 *1 708.96,786.24
X$9169 8197 8952 8842 8843 8961 gf180mcu_fd_sc_mcu9t5v0__dffq_2
* cell instance $9170 r0 *1 702.8,816.48
X$9170 8197 9803 9804 9841 9810 gf180mcu_fd_sc_mcu9t5v0__dffq_2
* cell instance $9171 m0 *1 702.24,766.08
X$9171 6017 8313 8314 8445 8582 gf180mcu_fd_sc_mcu9t5v0__dffq_2
* cell instance $9172 r0 *1 716.24,806.4
X$9172 9804 4922 9691 9575 9690 gf180mcu_fd_sc_mcu9t5v0__nand2_1
* cell instance $9173 m0 *1 753.76,786.24
X$9173 5389 8954 4538 8843 8961 8953 gf180mcu_fd_sc_mcu9t5v0__oai21_1
* cell instance $9174 m0 *1 724.64,796.32
X$9174 8197 9309 9311 9201 9315 gf180mcu_fd_sc_mcu9t5v0__dffq_2
* cell instance $9175 r0 *1 735.84,776.16
X$9175 7781 8814 8815 8843 8818 gf180mcu_fd_sc_mcu9t5v0__dffq_2
* cell instance $9176 r0 *1 696.64,695.52
X$9176 6017 6909 6805 33560 gf180mcu_fd_sc_mcu9t5v0__inv_1
* cell instance $9177 m0 *1 717.92,705.6
X$9177 7068 3230 6250 6909 6943 6940 gf180mcu_fd_sc_mcu9t5v0__mux2_1
* cell instance $9178 r0 *1 732.48,695.52
X$9178 6772 2365 6250 6909 6805 6804 gf180mcu_fd_sc_mcu9t5v0__mux2_1
* cell instance $9179 r0 *1 691.04,725.76
X$9179 6017 7551 7440 7671 7558 gf180mcu_fd_sc_mcu9t5v0__dffq_2
* cell instance $9180 m0 *1 698.32,725.76
X$9180 3470 7440 4923 7316 7558 7551 gf180mcu_fd_sc_mcu9t5v0__mux2_1
* cell instance $9181 m0 *1 710.64,735.84
X$9181 7781 7668 7441 7671 7814 gf180mcu_fd_sc_mcu9t5v0__dffq_2
* cell instance $9182 m0 *1 719.04,715.68
X$9182 7068 4900 4901 6906 7071 7195 7187 gf180mcu_fd_sc_mcu9t5v0__oai211_1
* cell instance $9183 r0 *1 729.68,695.52
X$9183 6805 6909 gf180mcu_fd_sc_mcu9t5v0__filltie
* cell instance $9184 m0 *1 702.8,705.6
X$9184 6771 4900 6539 6906 6909 6943 6939 gf180mcu_fd_sc_mcu9t5v0__oai211_1
* cell instance $9185 r0 *1 698.88,695.52
X$9185 4924 6909 6805 6017 gf180mcu_fd_sc_mcu9t5v0__clkbuf_8
* cell instance $9186 r0 *1 695.52,705.6
X$9186 7067 6286 6250 7071 6943 7066 gf180mcu_fd_sc_mcu9t5v0__mux2_1
* cell instance $9187 r0 *1 737.52,725.76
X$9187 7552 7670 6250 7671 7558 7669 gf180mcu_fd_sc_mcu9t5v0__mux2_1
* cell instance $9188 m0 *1 701.12,735.84
X$9188 7440 4922 7671 7814 7780 gf180mcu_fd_sc_mcu9t5v0__nand2_1
* cell instance $9189 r0 *1 717.36,725.76
X$9189 3470 7441 4018 7671 7558 7668 gf180mcu_fd_sc_mcu9t5v0__mux2_1
* cell instance $9190 m0 *1 743.12,725.76
X$9190 7191 4922 7316 7558 7443 gf180mcu_fd_sc_mcu9t5v0__nand2_1
* cell instance $9191 r0 *1 729.68,725.76
X$9191 7558 7671 gf180mcu_fd_sc_mcu9t5v0__filltie
* cell instance $9192 r0 *1 729.68,735.84
X$9192 7814 7919 gf180mcu_fd_sc_mcu9t5v0__filltie
* cell instance $9193 r0 *1 729.68,745.92
X$9193 7948 8078 gf180mcu_fd_sc_mcu9t5v0__filltie
* cell instance $9194 r0 *1 718.48,745.92
X$9194 8075 8453 6250 8078 7948 8074 gf180mcu_fd_sc_mcu9t5v0__mux2_1
* cell instance $9195 r0 *1 730.8,715.68
X$9195 6017 7313 7191 7316 7195 gf180mcu_fd_sc_mcu9t5v0__dffq_2
* cell instance $9196 r0 *1 729.68,715.68
X$9196 7195 7316 gf180mcu_fd_sc_mcu9t5v0__filltie
* cell instance $9197 m0 *1 728.56,735.84
X$9197 7781 7669 7552 7671 7814 gf180mcu_fd_sc_mcu9t5v0__dffq_2
* cell instance $9198 m0 *1 739.2,715.68
X$9198 7069 7191 4923 7071 7195 7313 gf180mcu_fd_sc_mcu9t5v0__mux2_1
* cell instance $9199 r0 *1 753.2,745.92
X$9199 7782 4538 4539 8077 8078 7948 8076 gf180mcu_fd_sc_mcu9t5v0__oai211_1
* cell instance $9200 m0 *1 742,745.92
X$9200 7552 4900 6906 7919 7948 7947 gf180mcu_fd_sc_mcu9t5v0__oai21_1
* cell instance $9201 m0 *1 746.48,756
X$9201 8076 8201 7947 8078 8204 8199 gf180mcu_fd_sc_mcu9t5v0__aoi21_1
* cell instance $9202 m0 *1 739.2,756
X$9202 7670 8200 4923 8078 8204 8316 gf180mcu_fd_sc_mcu9t5v0__mux2_1
* cell instance $9203 m0 *1 735.28,725.76
X$9203 4538 6143 7316 7558 7442 gf180mcu_fd_sc_mcu9t5v0__nand2_1
* cell instance $9204 m0 *1 720.16,725.76
X$9204 7441 4538 4539 7442 7316 7558 7667 gf180mcu_fd_sc_mcu9t5v0__oai211_1
* cell instance $9205 m0 *1 750.4,735.84
X$9205 7670 7782 4018 7671 7814 7813 gf180mcu_fd_sc_mcu9t5v0__mux2_1
* cell instance $9206 r0 *1 697.76,715.68
X$9206 7067 4900 6537 6906 7316 7195 7312 gf180mcu_fd_sc_mcu9t5v0__oai211_1
* cell instance $9207 r0 *1 747.6,715.68
X$9207 4900 7314 7443 7316 7195 7315 gf180mcu_fd_sc_mcu9t5v0__nand3_1
* cell instance $9208 m0 *1 711.76,756
X$9208 7781 8074 8075 8078 8204 gf180mcu_fd_sc_mcu9t5v0__dffq_2
* cell instance $9209 r0 *1 711.2,705.6
X$9209 6017 6940 7068 7071 6943 gf180mcu_fd_sc_mcu9t5v0__dffq_2
* cell instance $9210 r0 *1 729.68,705.6
X$9210 6943 7071 gf180mcu_fd_sc_mcu9t5v0__filltie
* cell instance $9211 m0 *1 703.92,735.84
X$9211 4900 7667 7780 7671 7814 7918 gf180mcu_fd_sc_mcu9t5v0__nand3_1
* cell instance $9212 m0 *1 698.88,756
X$9212 8073 4900 7918 6906 8078 8204 8198 gf180mcu_fd_sc_mcu9t5v0__oai211_1
* cell instance $9213 m0 *1 696.64,745.92
X$9213 8073 3470 6250 7919 7948 7946 gf180mcu_fd_sc_mcu9t5v0__mux2_1
* cell instance $9214 m0 *1 773.92,756
X$9214 8079 7951 2141 8078 8204 8202 gf180mcu_fd_sc_mcu9t5v0__mux2_1
* cell instance $9215 m0 *1 778.96,705.6
X$9215 7073 7074 3446 6909 6943 6941 gf180mcu_fd_sc_mcu9t5v0__mux2_1
* cell instance $9216 m0 *1 792.4,715.68
X$9216 7074 6942 2891 7071 7195 7192 gf180mcu_fd_sc_mcu9t5v0__mux2_1
* cell instance $9217 r0 *1 771.68,705.6
X$9217 7781 6941 7074 7071 6943 gf180mcu_fd_sc_mcu9t5v0__dffq_2
* cell instance $9218 r0 *1 785.12,715.68
X$9218 7554 4949 7316 7195 7320 gf180mcu_fd_sc_mcu9t5v0__nand2_1
* cell instance $9219 r0 *1 813.12,715.68
X$9219 7197 7196 2891 7316 7195 7322 gf180mcu_fd_sc_mcu9t5v0__mux2_1
* cell instance $9220 r0 *1 803.6,705.6
X$9220 7073 7069 2777 7071 6943 6806 gf180mcu_fd_sc_mcu9t5v0__mux2_1
* cell instance $9221 m0 *1 786.24,715.68
X$9221 7194 4765 7192 2983 2880 7071 7195 7193 gf180mcu_fd_sc_mcu9t5v0__aoi221_1
* cell instance $9222 m0 *1 792.4,705.6
X$9222 7781 6910 6942 6909 6943 gf180mcu_fd_sc_mcu9t5v0__dffq_2
* cell instance $9223 r0 *1 805.84,715.68
X$9223 2983 7322 7316 7195 7321 gf180mcu_fd_sc_mcu9t5v0__nand2_1
* cell instance $9224 r0 *1 768.32,735.84
X$9224 7555 7554 4024 7919 7814 7553 gf180mcu_fd_sc_mcu9t5v0__mux2_1
* cell instance $9225 r0 *1 765.52,715.68
X$9225 5389 7319 4538 7316 7195 7317 gf180mcu_fd_sc_mcu9t5v0__oai21_1
* cell instance $9226 r0 *1 801.92,745.92
X$9226 7781 8081 8082 8078 7948 gf180mcu_fd_sc_mcu9t5v0__dffq_2
* cell instance $9227 r0 *1 789.6,715.68
X$9227 7321 7557 7320 7193 3103 7316 7195 7318 gf180mcu_fd_sc_mcu9t5v0__aoi221_1
* cell instance $9228 r0 *1 788.48,735.84
X$9228 7069 7073 2986 7919 7814 7556 gf180mcu_fd_sc_mcu9t5v0__mux2_1
* cell instance $9229 r0 *1 795.2,725.76
X$9229 7783 4765 4949 7673 2992 7671 7558 7557 gf180mcu_fd_sc_mcu9t5v0__aoi221_1
* cell instance $9230 r0 *1 782.88,725.76
X$9230 7556 7783 2573 7671 7558 7672 gf180mcu_fd_sc_mcu9t5v0__mux2_2
* cell instance $9231 r0 *1 786.24,745.92
X$9231 8079 8203 3446 8078 7948 8080 gf180mcu_fd_sc_mcu9t5v0__mux2_1
* cell instance $9232 r0 *1 801.36,725.76
X$9232 7783 7673 7194 7554 2987 3106 7671 7558 7674
+ gf180mcu_fd_sc_mcu9t5v0__mux4_1
* cell instance $9233 m0 *1 805.84,756
X$9233 7949 8082 2472 8078 8204 8081 gf180mcu_fd_sc_mcu9t5v0__mux2_2
* cell instance $9234 r0 *1 798,695.52
X$9234 6806 6942 2472 6909 6805 6910 gf180mcu_fd_sc_mcu9t5v0__mux2_1
* cell instance $9235 m0 *1 810.32,715.68
X$9235 3103 7075 6547 4930 7071 7195 7310 gf180mcu_fd_sc_mcu9t5v0__aoi211_1
* cell instance $9236 r0 *1 761.04,745.92
X$9236 4538 7920 8078 7948 8077 gf180mcu_fd_sc_mcu9t5v0__nand2_1
* cell instance $9237 m0 *1 781.2,756
X$9237 7781 8080 8203 8078 8204 gf180mcu_fd_sc_mcu9t5v0__dffq_2
* cell instance $9238 m0 *1 777.84,735.84
X$9238 7781 7672 7783 7671 7814 gf180mcu_fd_sc_mcu9t5v0__dffq_2
* cell instance $9239 r0 *1 761.04,725.76
X$9239 7781 7553 7554 7671 7558 gf180mcu_fd_sc_mcu9t5v0__dffq_2
* cell instance $9240 m0 *1 810.88,745.92
X$9240 8079 7951 2564 7919 7948 7949 gf180mcu_fd_sc_mcu9t5v0__mux2_2
* cell instance $9241 m0 *1 774.48,725.76
X$9241 7073 7069 2141 7316 7558 7555 gf180mcu_fd_sc_mcu9t5v0__mux2_1
* cell instance $9242 r0 *1 647.36,806.4
X$9242 9845 9802 4923 9691 9575 9801 gf180mcu_fd_sc_mcu9t5v0__mux2_1
* cell instance $9243 m0 *1 646.24,766.08
X$9243 7951 8540 4018 8445 8582 8577 gf180mcu_fd_sc_mcu9t5v0__mux2_1
* cell instance $9244 m0 *1 645.68,826.56
X$9244 9845 10072 4018 9841 10078 10071 gf180mcu_fd_sc_mcu9t5v0__mux2_1
* cell instance $9245 r0 *1 680.4,786.24
X$9245 9080 4900 8688 6906 9201 8961 9200 gf180mcu_fd_sc_mcu9t5v0__oai211_1
* cell instance $9246 m0 *1 636.72,745.92
X$9246 6937 7916 7944 7919 7948 gf180mcu_fd_sc_mcu9t5v0__dffq_2
* cell instance $9247 m0 *1 609.84,806.4
X$9247 9575 9432 gf180mcu_fd_sc_mcu9t5v0__filltie
* cell instance $9248 m0 *1 609.84,745.92
X$9248 7948 7919 gf180mcu_fd_sc_mcu9t5v0__filltie
* cell instance $9249 m0 *1 609.84,816.48
X$9249 9810 9691 gf180mcu_fd_sc_mcu9t5v0__filltie
* cell instance $9250 r0 *1 614.32,776.16
X$9250 2992 8692 8843 8818 8838 gf180mcu_fd_sc_mcu9t5v0__nor2_1
* cell instance $9251 m0 *1 609.84,756
X$9251 8204 8078 gf180mcu_fd_sc_mcu9t5v0__filltie
* cell instance $9252 m0 *1 638.96,816.48
X$9252 8197 9801 9802 9691 9810 gf180mcu_fd_sc_mcu9t5v0__dffq_2
* cell instance $9253 r0 *1 654.64,735.84
X$9253 8196 7811 7779 7919 7814 gf180mcu_fd_sc_mcu9t5v0__dffq_2
* cell instance $9254 m0 *1 672.56,735.84
X$9254 6017 7666 7812 7671 7814 gf180mcu_fd_sc_mcu9t5v0__dffq_2
* cell instance $9255 r0 *1 676.48,745.92
X$9255 4967 8072 4923 8078 7948 8071 gf180mcu_fd_sc_mcu9t5v0__mux2_1
* cell instance $9256 m0 *1 677.04,816.48
X$9256 8197 9691 9810 gf180mcu_fd_sc_mcu9t5v0__clkinv_3
* cell instance $9257 r0 *1 679.28,735.84
X$9257 7812 4900 7190 6906 7919 7814 7917 gf180mcu_fd_sc_mcu9t5v0__oai211_1
* cell instance $9258 m0 *1 609.84,766.08
X$9258 8582 8445 gf180mcu_fd_sc_mcu9t5v0__filltie
* cell instance $9259 m0 *1 638.96,796.32
X$9259 9199 8823 6250 9201 9315 9303 gf180mcu_fd_sc_mcu9t5v0__mux2_1
* cell instance $9260 r0 *1 666.96,806.4
X$9260 9688 9691 9575 4930 gf180mcu_fd_sc_mcu9t5v0__buf_8
* cell instance $9261 m0 *1 625.52,786.24
X$9261 8196 8839 8840 8843 8961 gf180mcu_fd_sc_mcu9t5v0__dffq_2
* cell instance $9262 m0 *1 609.84,735.84
X$9262 7814 7671 gf180mcu_fd_sc_mcu9t5v0__filltie
* cell instance $9263 r0 *1 630.56,796.32
X$9263 8196 9303 9199 9432 9315 gf180mcu_fd_sc_mcu9t5v0__dffq_2
* cell instance $9264 m0 *1 609.84,776.16
X$9264 8818 8693 gf180mcu_fd_sc_mcu9t5v0__filltie
* cell instance $9265 m0 *1 609.84,786.24
X$9265 8961 8843 gf180mcu_fd_sc_mcu9t5v0__filltie
* cell instance $9266 r0 *1 635.04,776.16
X$9266 8823 8840 4923 8843 8818 8839 gf180mcu_fd_sc_mcu9t5v0__mux2_1
* cell instance $9267 m0 *1 650.16,786.24
X$9267 8196 8949 8841 8843 8961 gf180mcu_fd_sc_mcu9t5v0__dffq_2
* cell instance $9268 r0 *1 657.44,776.16
X$9268 8823 8841 4018 8843 8818 8949 gf180mcu_fd_sc_mcu9t5v0__mux2_1
* cell instance $9269 m0 *1 668.64,756
X$9269 8197 8071 8072 8078 8204 gf180mcu_fd_sc_mcu9t5v0__dffq_2
* cell instance $9270 m0 *1 653.52,766.08
X$9270 8540 4538 4539 8445 8582 8444 gf180mcu_fd_sc_mcu9t5v0__oai21_1
* cell instance $9271 r0 *1 678.72,725.76
X$9271 7812 2270 6250 7671 7558 7666 gf180mcu_fd_sc_mcu9t5v0__mux2_1
* cell instance $9272 m0 *1 640.64,766.08
X$9272 8538 4922 8445 8582 8539 gf180mcu_fd_sc_mcu9t5v0__nand2_1
* cell instance $9273 m0 *1 624.4,816.48
X$9273 9687 9691 9810 4497 gf180mcu_fd_sc_mcu9t5v0__buf_8
* cell instance $9274 r0 *1 596.96,816.48
X$9274 9836 9841 9810 2891 gf180mcu_fd_sc_mcu9t5v0__buf_20
* cell instance $9275 m0 *1 651.28,715.68
X$9275 7185 4922 7071 7195 7186 gf180mcu_fd_sc_mcu9t5v0__nand2_1
* cell instance $9276 r0 *1 656.32,796.32
X$9276 9428 9078 9304 4900 9432 9315 9427 gf180mcu_fd_sc_mcu9t5v0__oai211_1
* cell instance $9277 m0 *1 638.96,756
X$9277 8196 8078 8204 gf180mcu_fd_sc_mcu9t5v0__inv_8
* cell instance $9278 m0 *1 609.84,725.76
X$9278 7558 7316 gf180mcu_fd_sc_mcu9t5v0__filltie
* cell instance $9279 m0 *1 665.84,796.32
X$9279 8197 9079 9080 9201 9315 gf180mcu_fd_sc_mcu9t5v0__dffq_2
* cell instance $9280 m0 *1 643.44,715.68
X$9280 6146 7185 4923 7071 7195 7307 gf180mcu_fd_sc_mcu9t5v0__mux2_1
* cell instance $9281 m0 *1 609.84,715.68
X$9281 7195 7071 gf180mcu_fd_sc_mcu9t5v0__filltie
* cell instance $9282 m0 *1 653.52,745.92
X$9282 7944 4900 7309 6906 7919 7948 7945 gf180mcu_fd_sc_mcu9t5v0__oai211_1
* cell instance $9283 r0 *1 640.64,695.52
X$9283 6802 5564 6250 6909 6805 6904 gf180mcu_fd_sc_mcu9t5v0__mux2_1
* cell instance $9284 r0 *1 664.72,695.52
X$9284 6536 4900 4920 6906 6909 6805 6907 gf180mcu_fd_sc_mcu9t5v0__oai211_1
* cell instance $9285 m0 *1 663.04,816.48
X$9285 4765 10824 9691 9810 9688 gf180mcu_fd_sc_mcu9t5v0__and2_1
* cell instance $9286 m0 *1 609.84,796.32
X$9286 9315 9201 gf180mcu_fd_sc_mcu9t5v0__filltie
* cell instance $9287 r0 *1 668.08,756
X$9287 4967 8311 4018 8445 8204 8310 gf180mcu_fd_sc_mcu9t5v0__mux2_1
* cell instance $9288 m0 *1 669.76,826.56
X$9288 9838 9841 10078 10073 gf180mcu_fd_sc_mcu9t5v0__buf_8
* cell instance $9289 m0 *1 609.84,826.56
X$9289 10078 9841 gf180mcu_fd_sc_mcu9t5v0__filltie
* cell instance $9290 m0 *1 679.28,715.68
X$9290 4900 6249 7189 7071 7195 7190 gf180mcu_fd_sc_mcu9t5v0__nand3_1
* cell instance $9291 r0 *1 662.48,816.48
X$9291 9838 9841 9810 4538 gf180mcu_fd_sc_mcu9t5v0__buf_8
* cell instance $9292 r0 *1 647.92,695.52
X$9292 6802 4900 6420 6906 6909 6805 6905 gf180mcu_fd_sc_mcu9t5v0__oai211_1
* cell instance $9293 r0 *1 621.04,766.08
X$9293 8196 8576 8538 8693 8582 gf180mcu_fd_sc_mcu9t5v0__dffq_2
* cell instance $9294 r0 *1 672.56,786.24
X$9294 9080 4967 6250 9201 8961 9079 gf180mcu_fd_sc_mcu9t5v0__mux2_1
* cell instance $9295 m0 *1 683.2,705.6
X$9295 6770 4900 5792 6906 6909 6943 6938 gf180mcu_fd_sc_mcu9t5v0__oai211_1
* cell instance $9296 r0 *1 672,695.52
X$9296 6017 6769 6770 6909 6805 gf180mcu_fd_sc_mcu9t5v0__dffq_2
* cell instance $9297 r0 *1 650.72,796.32
X$9297 9199 4900 9427 6906 9432 9315 10181 gf180mcu_fd_sc_mcu9t5v0__oai211_1
* cell instance $9298 m0 *1 664.72,745.92
X$9298 7779 4900 5916 6906 7919 7948 8950 gf180mcu_fd_sc_mcu9t5v0__oai211_1
* cell instance $9299 m0 *1 609.84,705.6
X$9299 6943 6909 gf180mcu_fd_sc_mcu9t5v0__filltie
* cell instance $9300 r0 *1 659.68,816.48
X$9300 4765 10824 9841 9810 9838 gf180mcu_fd_sc_mcu9t5v0__nand2_1
* cell instance $9301 r0 *1 679.84,715.68
X$9301 7188 4922 7316 7195 7189 gf180mcu_fd_sc_mcu9t5v0__nand2_1
* cell instance $9302 m0 *1 672,715.68
X$9302 2270 7188 4923 7071 7195 7311 gf180mcu_fd_sc_mcu9t5v0__mux2_1
* cell instance $9303 m0 *1 630.56,705.6
X$9303 6937 6904 6802 6909 6943 gf180mcu_fd_sc_mcu9t5v0__dffq_2
* cell instance $9304 r0 *1 649.6,715.68
X$9304 7439 4538 4539 7316 7195 7308 gf180mcu_fd_sc_mcu9t5v0__oai21_1
* cell instance $9305 m0 *1 659.68,766.08
X$9305 8196 8310 8311 8445 8582 gf180mcu_fd_sc_mcu9t5v0__dffq_2
* cell instance $9306 r0 *1 673.12,766.08
X$9306 8311 4538 4539 8693 8582 8686 gf180mcu_fd_sc_mcu9t5v0__oai21_1
* cell instance $9307 r0 *1 654.08,715.68
X$9307 7310 7308 7186 4900 7316 7195 7309 gf180mcu_fd_sc_mcu9t5v0__oai211_1
* cell instance $9308 r0 *1 632.8,715.68
X$9308 6937 7307 7185 7316 7195 gf180mcu_fd_sc_mcu9t5v0__dffq_2
* cell instance $9309 r0 *1 652.96,816.48
X$9309 9802 4922 9841 9810 9837 gf180mcu_fd_sc_mcu9t5v0__nand2_1
* cell instance $9310 r0 *1 680.96,756
X$9310 8072 4922 8445 8204 8312 gf180mcu_fd_sc_mcu9t5v0__nand2_1
* cell instance $9311 r0 *1 637.84,766.08
X$9311 8196 8577 8540 8693 8582 gf180mcu_fd_sc_mcu9t5v0__dffq_2
* cell instance $9312 r0 *1 679.84,766.08
X$9312 8687 8686 8312 4900 8693 8582 8688 gf180mcu_fd_sc_mcu9t5v0__oai211_1
* cell instance $9313 r0 *1 663.04,715.68
X$9313 6017 7311 7188 7316 7195 gf180mcu_fd_sc_mcu9t5v0__dffq_2
* cell instance $9314 r0 *1 638.96,756
X$9314 4924 8445 8204 8196 gf180mcu_fd_sc_mcu9t5v0__clkbuf_8
* cell instance $9315 m0 *1 647.36,725.76
X$9315 6146 7439 4018 7316 7558 7550 gf180mcu_fd_sc_mcu9t5v0__mux2_1
* cell instance $9316 r0 *1 637.28,725.76
X$9316 6937 7550 7439 7671 7558 gf180mcu_fd_sc_mcu9t5v0__dffq_2
* cell instance $9317 m0 *1 661.36,735.84
X$9317 7779 5529 6250 7671 7814 7811 gf180mcu_fd_sc_mcu9t5v0__mux2_1
* cell instance $9318 m0 *1 646.8,776.16
X$9318 8578 8444 8539 4900 8693 8818 8807 gf180mcu_fd_sc_mcu9t5v0__oai211_1
* cell instance $9319 r0 *1 658,786.24
X$9319 8841 4538 4539 9201 8961 9078 gf180mcu_fd_sc_mcu9t5v0__oai21_1
* cell instance $9320 m0 *1 646.24,796.32
X$9320 8840 4922 9201 9315 9304 gf180mcu_fd_sc_mcu9t5v0__nand2_1
* cell instance $9321 m0 *1 632.8,766.08
X$9321 7951 8538 4923 8445 8582 8576 gf180mcu_fd_sc_mcu9t5v0__mux2_1
* cell instance $9322 r0 *1 644.56,735.84
X$9322 7944 6146 6250 7919 7814 7916 gf180mcu_fd_sc_mcu9t5v0__mux2_1
* cell instance $9323 m0 *1 609.84,604.8
X$9323 4512 4389 gf180mcu_fd_sc_mcu9t5v0__filltie
* cell instance $9324 m0 *1 609.84,655.2
X$9324 5794 5665 gf180mcu_fd_sc_mcu9t5v0__filltie
* cell instance $9325 m0 *1 682.64,675.36
X$9325 6248 4538 4539 5917 6144 6292 6249 gf180mcu_fd_sc_mcu9t5v0__oai211_1
* cell instance $9326 m0 *1 609.84,685.44
X$9326 6425 6392 gf180mcu_fd_sc_mcu9t5v0__filltie
* cell instance $9327 m0 *1 651.84,635.04
X$9327 4508 5150 5151 5183 5297 gf180mcu_fd_sc_mcu9t5v0__dffq_2
* cell instance $9328 r0 *1 637.84,675.36
X$9328 5564 6385 4923 6392 6292 6384 gf180mcu_fd_sc_mcu9t5v0__mux2_1
* cell instance $9329 m0 *1 609.84,635.04
X$9329 5297 5183 gf180mcu_fd_sc_mcu9t5v0__filltie
* cell instance $9330 r0 *1 679.84,624.96
X$9330 2262 5153 4923 5183 5056 5152 gf180mcu_fd_sc_mcu9t5v0__mux2_1
* cell instance $9331 m0 *1 653.52,655.2
X$9331 4508 5527 5528 5665 5794 gf180mcu_fd_sc_mcu9t5v0__dffq_2
* cell instance $9332 r0 *1 669.2,675.36
X$9332 4538 6387 6392 6292 6386 gf180mcu_fd_sc_mcu9t5v0__nand2_1
* cell instance $9333 r0 *1 657.44,675.36
X$9333 6140 4538 4539 6386 6392 6292 6421 gf180mcu_fd_sc_mcu9t5v0__oai211_1
* cell instance $9334 m0 *1 644.56,685.44
X$9334 6385 4922 6392 6425 6419 gf180mcu_fd_sc_mcu9t5v0__nand2_1
* cell instance $9335 m0 *1 649.6,685.44
X$9335 4900 6421 6419 6392 6425 6420 gf180mcu_fd_sc_mcu9t5v0__nand3_1
* cell instance $9336 r0 *1 661.36,645.12
X$9336 5529 5528 4923 5665 5411 5527 gf180mcu_fd_sc_mcu9t5v0__mux2_1
* cell instance $9337 r0 *1 660.24,624.96
X$9337 2148 5151 4923 5183 5056 5150 gf180mcu_fd_sc_mcu9t5v0__mux2_1
* cell instance $9338 m0 *1 672.56,635.04
X$9338 4508 5152 5153 5183 5297 gf180mcu_fd_sc_mcu9t5v0__dffq_2
* cell instance $9339 r0 *1 665.28,655.2
X$9339 5528 4922 5920 5794 5791 gf180mcu_fd_sc_mcu9t5v0__nand2_1
* cell instance $9340 m0 *1 626.64,685.44
X$9340 4508 6384 6385 6392 6425 gf180mcu_fd_sc_mcu9t5v0__dffq_2
* cell instance $9341 m0 *1 609.84,665.28
X$9341 6034 5920 gf180mcu_fd_sc_mcu9t5v0__filltie
* cell instance $9342 r0 *1 683.76,655.2
X$9342 5531 4538 4539 5891 5920 5794 5890 gf180mcu_fd_sc_mcu9t5v0__oai211_1
* cell instance $9343 r0 *1 668.08,655.2
X$9343 4900 5791 5890 5920 5794 5916 gf180mcu_fd_sc_mcu9t5v0__nand3_1
* cell instance $9344 m0 *1 609.84,594.72
X$9344 4266 4150 gf180mcu_fd_sc_mcu9t5v0__filltie
* cell instance $9345 m0 *1 609.84,614.88
X$9345 4794 4667 gf180mcu_fd_sc_mcu9t5v0__filltie
* cell instance $9346 m0 *1 609.84,675.36
X$9346 6292 6144 gf180mcu_fd_sc_mcu9t5v0__filltie
* cell instance $9347 r0 *1 673.68,665.28
X$9347 2270 6248 4018 6144 6034 6247 gf180mcu_fd_sc_mcu9t5v0__mux2_1
* cell instance $9348 m0 *1 681.52,604.8
X$9348 2262 4537 4018 4389 4512 4507 gf180mcu_fd_sc_mcu9t5v0__mux2_1
* cell instance $9349 m0 *1 652.4,614.88
X$9349 4508 4661 4792 4667 4794 gf180mcu_fd_sc_mcu9t5v0__dffq_2
* cell instance $9350 r0 *1 663.04,614.88
X$9350 4792 4538 4539 4903 4794 4897 gf180mcu_fd_sc_mcu9t5v0__oai21_1
* cell instance $9351 m0 *1 609.84,645.12
X$9351 5411 5390 gf180mcu_fd_sc_mcu9t5v0__filltie
* cell instance $9352 m0 *1 672.56,655.2
X$9352 6017 5530 5531 5665 5794 gf180mcu_fd_sc_mcu9t5v0__dffq_2
* cell instance $9353 r0 *1 667.52,624.96
X$9353 5151 4922 5183 5056 4921 gf180mcu_fd_sc_mcu9t5v0__nand2_1
* cell instance $9354 m0 *1 665.84,675.36
X$9354 6017 6247 6248 6144 6292 gf180mcu_fd_sc_mcu9t5v0__dffq_2
* cell instance $9355 m0 *1 665.28,624.96
X$9355 4793 4897 4921 4900 4903 5056 4920 gf180mcu_fd_sc_mcu9t5v0__oai211_1
* cell instance $9356 m0 *1 646.8,675.36
X$9356 4508 6139 6140 6144 6292 gf180mcu_fd_sc_mcu9t5v0__dffq_2
* cell instance $9357 r0 *1 654.08,665.28
X$9357 5564 6140 4018 6144 6034 6139 gf180mcu_fd_sc_mcu9t5v0__mux2_1
* cell instance $9358 m0 *1 609.84,624.96
X$9358 5056 4903 gf180mcu_fd_sc_mcu9t5v0__filltie
* cell instance $9359 r0 *1 679.84,645.12
X$9359 5529 5531 4018 5665 5411 5530 gf180mcu_fd_sc_mcu9t5v0__mux2_1
* cell instance $9360 m0 *1 609.84,574.56
X$9360 3781 3558 gf180mcu_fd_sc_mcu9t5v0__filltie
* cell instance $9361 m0 *1 609.84,584.64
X$9361 3907 3796 gf180mcu_fd_sc_mcu9t5v0__filltie
* cell instance $9362 r0 *1 660.8,604.8
X$9362 2148 4792 4018 4667 4512 4661 gf180mcu_fd_sc_mcu9t5v0__mux2_1
* cell instance $9363 m0 *1 609.84,564.48
X$9363 3444 3334 gf180mcu_fd_sc_mcu9t5v0__filltie
* cell instance $9364 r0 *1 683.2,635.04
X$9364 5153 4922 5390 5297 5387 gf180mcu_fd_sc_mcu9t5v0__nand2_1
* cell instance $9365 m0 *1 692.72,624.96
X$9365 4924 4903 5056 4508 gf180mcu_fd_sc_mcu9t5v0__clkbuf_8
* cell instance $9366 m0 *1 707.28,624.96
X$9366 4898 4922 4903 5056 4899 gf180mcu_fd_sc_mcu9t5v0__nand2_1
* cell instance $9367 r0 *1 759.36,675.36
X$9367 6390 2244 6250 6392 6292 6251 gf180mcu_fd_sc_mcu9t5v0__mux2_1
* cell instance $9368 m0 *1 751.52,675.36
X$9368 7781 6251 6390 6144 6292 gf180mcu_fd_sc_mcu9t5v0__dffq_2
* cell instance $9369 r0 *1 754.88,604.8
X$9369 4246 4541 4018 4667 4512 4665 gf180mcu_fd_sc_mcu9t5v0__mux2_1
* cell instance $9370 m0 *1 736.4,624.96
X$9370 4927 4762 4928 4900 4903 5056 4926 gf180mcu_fd_sc_mcu9t5v0__oai211_1
* cell instance $9371 m0 *1 746.48,614.88
X$9371 4508 4665 4541 4667 4794 gf180mcu_fd_sc_mcu9t5v0__dffq_2
* cell instance $9372 m0 *1 759.36,594.72
X$9372 3559 4151 4021 4150 4266 gf180mcu_fd_sc_mcu9t5v0__dffq_2
* cell instance $9373 m0 *1 717.36,624.96
X$9373 3230 4925 4923 4903 5056 5053 gf180mcu_fd_sc_mcu9t5v0__mux2_1
* cell instance $9374 m0 *1 724.64,624.96
X$9374 4925 4922 4903 5056 4902 gf180mcu_fd_sc_mcu9t5v0__nand2_1
* cell instance $9375 m0 *1 751.52,624.96
X$9375 4246 5055 4923 4903 5056 5054 gf180mcu_fd_sc_mcu9t5v0__mux2_1
* cell instance $9376 r0 *1 743.12,624.96
X$9376 4508 5054 5055 5183 5056 gf180mcu_fd_sc_mcu9t5v0__dffq_2
* cell instance $9377 r0 *1 757.68,614.88
X$9377 4541 4538 4539 4903 4794 4904 gf180mcu_fd_sc_mcu9t5v0__oai21_1
* cell instance $9378 m0 *1 820.4,624.96
X$9378 3103 4929 4370 4930 4903 5056 5156 gf180mcu_fd_sc_mcu9t5v0__aoi211_1
* cell instance $9379 m0 *1 753.76,655.2
X$9379 7781 5533 5534 5665 5794 gf180mcu_fd_sc_mcu9t5v0__dffq_2
* cell instance $9380 m0 *1 788.48,655.2
X$9380 5296 5275 2264 5665 5794 5536 gf180mcu_fd_sc_mcu9t5v0__mux2_1
* cell instance $9381 m0 *1 771.68,655.2
X$9381 3559 5535 5666 5665 5794 gf180mcu_fd_sc_mcu9t5v0__dffq_2
* cell instance $9382 r0 *1 808.64,675.36
X$9382 6018 6293 2891 6392 6292 6543 gf180mcu_fd_sc_mcu9t5v0__mux2_1
* cell instance $9383 m0 *1 770,675.36
X$9383 7781 6145 6252 6144 6292 gf180mcu_fd_sc_mcu9t5v0__dffq_2
* cell instance $9384 r0 *1 777.28,624.96
X$9384 2244 5184 4018 5183 5056 5159 gf180mcu_fd_sc_mcu9t5v0__mux2_1
* cell instance $9385 r0 *1 761.6,655.2
X$9385 5534 4922 5920 5794 5409 gf180mcu_fd_sc_mcu9t5v0__nand2_1
* cell instance $9386 r0 *1 791.84,675.36
X$9386 3559 6291 6293 6392 6292 gf180mcu_fd_sc_mcu9t5v0__dffq_2
* cell instance $9387 m0 *1 817.6,675.36
X$9387 6252 4765 6255 2983 2992 6144 6292 6545 gf180mcu_fd_sc_mcu9t5v0__aoi221_1
* cell instance $9388 m0 *1 800.8,675.36
X$9388 6253 6146 3677 6144 6292 6254 gf180mcu_fd_sc_mcu9t5v0__mux2_2
* cell instance $9389 m0 *1 792.4,675.36
X$9389 6254 6293 2472 6144 6292 6291 gf180mcu_fd_sc_mcu9t5v0__mux2_2
* cell instance $9390 m0 *1 762.16,645.12
X$9390 4900 5409 5271 5390 5411 6391 gf180mcu_fd_sc_mcu9t5v0__nand3_1
* cell instance $9391 r0 *1 817.6,655.2
X$9391 3103 5895 5762 4930 5920 5794 5759 gf180mcu_fd_sc_mcu9t5v0__aoi211_1
* cell instance $9392 m0 *1 794.64,665.28
X$9392 3559 5921 6018 5920 6034 gf180mcu_fd_sc_mcu9t5v0__dffq_2
* cell instance $9393 r0 *1 781.2,675.36
X$9393 6146 6253 2986 6392 6292 6033 gf180mcu_fd_sc_mcu9t5v0__mux2_1
* cell instance $9394 r0 *1 777.28,645.12
X$9394 5536 5666 4024 5665 5411 5535 gf180mcu_fd_sc_mcu9t5v0__mux2_1
* cell instance $9395 r0 *1 775.6,665.28
X$9395 6033 6252 2573 6144 6034 6145 gf180mcu_fd_sc_mcu9t5v0__mux2_2
* cell instance $9396 r0 *1 761.04,645.12
X$9396 2244 5534 4923 5665 5411 5533 gf180mcu_fd_sc_mcu9t5v0__mux2_1
* cell instance $9397 r0 *1 759.92,624.96
X$9397 5156 4904 5157 4900 5183 5056 5155 gf180mcu_fd_sc_mcu9t5v0__oai211_1
* cell instance $9398 r0 *1 768.88,624.96
X$9398 5184 4538 2877 5158 4539 5183 5056 5271 gf180mcu_fd_sc_mcu9t5v0__oai221_1
* cell instance $9399 m0 *1 766.08,635.04
X$9399 5389 5160 4538 5183 5297 5158 gf180mcu_fd_sc_mcu9t5v0__oai21_1
* cell instance $9400 r0 *1 814.24,645.12
X$9400 5795 2786 5412 2983 2880 5665 5411 5537 gf180mcu_fd_sc_mcu9t5v0__aoi221_1
* cell instance $9401 m0 *1 815.36,655.2
X$9401 5666 4949 5665 5794 5761 gf180mcu_fd_sc_mcu9t5v0__nand2_1
* cell instance $9402 r0 *1 791.28,635.04
X$9402 5296 5410 3446 5390 5297 5391 gf180mcu_fd_sc_mcu9t5v0__mux2_1
* cell instance $9403 m0 *1 786.24,645.12
X$9403 3559 5391 5410 5390 5411 gf180mcu_fd_sc_mcu9t5v0__dffq_2
* cell instance $9404 m0 *1 812.56,645.12
X$9404 5410 5273 2891 5390 5411 5412 gf180mcu_fd_sc_mcu9t5v0__mux2_1
* cell instance $9405 m0 *1 806.96,635.04
X$9405 5296 5275 3677 5183 5297 5274 gf180mcu_fd_sc_mcu9t5v0__mux2_2
* cell instance $9406 r0 *1 815.92,624.96
X$9406 3559 5183 5056 33572 gf180mcu_fd_sc_mcu9t5v0__clkinv_1
* cell instance $9407 r0 *1 799.12,635.04
X$9407 3559 5272 5273 5390 5297 gf180mcu_fd_sc_mcu9t5v0__dffq_2
* cell instance $9408 m0 *1 798.56,635.04
X$9408 5274 5273 2472 5183 5297 5272 gf180mcu_fd_sc_mcu9t5v0__mux2_2
* cell instance $9409 r0 *1 799.68,655.2
X$9409 6253 6018 3446 5920 5794 5921 gf180mcu_fd_sc_mcu9t5v0__mux2_1
* cell instance $9410 m0 *1 818.16,655.2
X$9410 2880 5763 5761 5537 3103 5665 5794 5762 gf180mcu_fd_sc_mcu9t5v0__aoi221_1
* cell instance $9411 m0 *1 770.56,635.04
X$9411 3559 5159 5184 5183 5297 gf180mcu_fd_sc_mcu9t5v0__dffq_2
* cell instance $9412 m0 *1 741.44,675.36
X$9412 6290 2370 6250 6144 6292 6289 gf180mcu_fd_sc_mcu9t5v0__mux2_1
* cell instance $9413 m0 *1 692.72,635.04
X$9413 4508 5183 5297 gf180mcu_fd_sc_mcu9t5v0__inv_4
* cell instance $9414 m0 *1 724.64,635.04
X$9414 4508 5270 5154 5183 5297 gf180mcu_fd_sc_mcu9t5v0__dffq_2
* cell instance $9415 r0 *1 700,665.28
X$9415 5892 4538 4539 6144 6034 6142 gf180mcu_fd_sc_mcu9t5v0__oai21_1
* cell instance $9416 m0 *1 715.12,645.12
X$9416 5275 5408 4018 5390 5411 5407 gf180mcu_fd_sc_mcu9t5v0__mux2_1
* cell instance $9417 r0 *1 693.28,675.36
X$9417 6286 6423 4923 6392 6292 6388 gf180mcu_fd_sc_mcu9t5v0__mux2_1
* cell instance $9418 r0 *1 722.4,655.2
X$9418 5275 5893 4923 5920 5794 5918 gf180mcu_fd_sc_mcu9t5v0__mux2_1
* cell instance $9419 r0 *1 700.56,635.04
X$9419 5389 2880 2786 5390 5297 5388 gf180mcu_fd_sc_mcu9t5v0__nand3_1
* cell instance $9420 m0 *1 756,635.04
X$9420 5055 4922 5183 5297 5157 gf180mcu_fd_sc_mcu9t5v0__nand2_1
* cell instance $9421 r0 *1 729.68,645.12
X$9421 5411 5665 gf180mcu_fd_sc_mcu9t5v0__filltie
* cell instance $9422 r0 *1 712.32,675.36
X$9422 6017 6287 6288 6392 6292 gf180mcu_fd_sc_mcu9t5v0__dffq_2
* cell instance $9423 r0 *1 697.76,655.2
X$9423 6286 5892 4018 5920 5794 6032 gf180mcu_fd_sc_mcu9t5v0__mux2_1
* cell instance $9424 r0 *1 704.48,645.12
X$9424 4508 5407 5408 5665 5411 gf180mcu_fd_sc_mcu9t5v0__dffq_2
* cell instance $9425 m0 *1 716.24,665.28
X$9425 6017 5918 5893 5920 6034 gf180mcu_fd_sc_mcu9t5v0__dffq_2
* cell instance $9426 m0 *1 696.64,645.12
X$9426 5388 5390 5411 4900 gf180mcu_fd_sc_mcu9t5v0__buf_8
* cell instance $9427 r0 *1 740.32,624.96
X$9427 5154 4922 5183 5056 4928 gf180mcu_fd_sc_mcu9t5v0__nand2_1
* cell instance $9428 m0 *1 740.88,685.44
X$9428 6290 4900 5919 6906 6392 6425 6540 gf180mcu_fd_sc_mcu9t5v0__oai211_1
* cell instance $9429 m0 *1 720.72,685.44
X$9429 6288 4900 5664 6906 6392 6425 6422 gf180mcu_fd_sc_mcu9t5v0__oai211_1
* cell instance $9430 r0 *1 743.68,645.12
X$9430 2370 5793 4923 5665 5411 5532 gf180mcu_fd_sc_mcu9t5v0__mux2_1
* cell instance $9431 r0 *1 733.04,624.96
X$9431 2365 5154 4923 5183 5056 5270 gf180mcu_fd_sc_mcu9t5v0__mux2_1
* cell instance $9432 r0 *1 729.68,635.04
X$9432 5297 5390 gf180mcu_fd_sc_mcu9t5v0__filltie
* cell instance $9433 r0 *1 729.68,624.96
X$9433 5056 5183 gf180mcu_fd_sc_mcu9t5v0__filltie
* cell instance $9434 r0 *1 692.72,665.28
X$9434 4538 6141 6144 6034 5891 gf180mcu_fd_sc_mcu9t5v0__nand2_1
* cell instance $9435 r0 *1 730.8,655.2
X$9435 5893 4922 5920 5794 5760 gf180mcu_fd_sc_mcu9t5v0__nand2_1
* cell instance $9436 r0 *1 729.68,665.28
X$9436 6034 6144 gf180mcu_fd_sc_mcu9t5v0__filltie
* cell instance $9437 r0 *1 742,655.2
X$9437 5793 4922 5920 5794 5894 gf180mcu_fd_sc_mcu9t5v0__nand2_1
* cell instance $9438 r0 *1 729.68,675.36
X$9438 6292 6392 gf180mcu_fd_sc_mcu9t5v0__filltie
* cell instance $9439 r0 *1 753.76,675.36
X$9439 6390 4900 6391 6906 6392 6292 6389 gf180mcu_fd_sc_mcu9t5v0__oai211_1
* cell instance $9440 r0 *1 709.52,624.96
X$9440 4508 5053 4925 5183 5056 gf180mcu_fd_sc_mcu9t5v0__dffq_2
* cell instance $9441 r0 *1 691.04,645.12
X$9441 4538 4147 5665 5411 5917 gf180mcu_fd_sc_mcu9t5v0__nand2_1
* cell instance $9442 r0 *1 744.8,655.2
X$9442 4900 4510 5894 5920 5794 5919 gf180mcu_fd_sc_mcu9t5v0__nand3_1
* cell instance $9443 r0 *1 729.68,655.2
X$9443 5794 5920 gf180mcu_fd_sc_mcu9t5v0__filltie
* cell instance $9444 m0 *1 736.96,655.2
X$9444 6017 5532 5793 5665 5794 gf180mcu_fd_sc_mcu9t5v0__dffq_2
* cell instance $9445 m0 *1 725.2,655.2
X$9445 5759 5663 5760 4900 5665 5794 5664 gf180mcu_fd_sc_mcu9t5v0__oai211_1
* cell instance $9446 m0 *1 719.6,655.2
X$9446 5408 4538 4539 5665 5794 5663 gf180mcu_fd_sc_mcu9t5v0__oai21_1
* cell instance $9447 r0 *1 734.16,675.36
X$9447 6017 6289 6290 6392 6292 gf180mcu_fd_sc_mcu9t5v0__dffq_2
* cell instance $9448 m0 *1 719.04,675.36
X$9448 6288 5275 6250 6144 6292 6287 gf180mcu_fd_sc_mcu9t5v0__mux2_1
* cell instance $9449 m0 *1 701.68,685.44
X$9449 6423 4922 6392 6425 6424 gf180mcu_fd_sc_mcu9t5v0__nand2_1
* cell instance $9450 r0 *1 724.08,614.88
X$9450 4664 4540 4902 4900 4903 4794 4901 gf180mcu_fd_sc_mcu9t5v0__oai211_1
* cell instance $9451 r0 *1 729.68,604.8
X$9451 4512 4667 gf180mcu_fd_sc_mcu9t5v0__filltie
* cell instance $9452 r0 *1 693.28,604.8
X$9452 4538 4509 4667 4512 4662 gf180mcu_fd_sc_mcu9t5v0__nand2_1
* cell instance $9453 m0 *1 722.96,594.72
X$9453 4508 4148 4019 4150 4266 gf180mcu_fd_sc_mcu9t5v0__dffq_2
* cell instance $9454 m0 *1 712.88,604.8
X$9454 4508 4388 4369 4389 4512 gf180mcu_fd_sc_mcu9t5v0__dffq_2
* cell instance $9455 r0 *1 720.72,594.72
X$9455 3230 4369 4018 4389 4266 4388 gf180mcu_fd_sc_mcu9t5v0__mux2_1
* cell instance $9456 r0 *1 729.68,594.72
X$9456 4266 4389 gf180mcu_fd_sc_mcu9t5v0__filltie
* cell instance $9457 r0 *1 706.16,614.88
X$9457 4786 4663 4899 4900 4903 4794 6539 gf180mcu_fd_sc_mcu9t5v0__oai211_1
* cell instance $9458 m0 *1 746.48,604.8
X$9458 4020 4538 4539 4484 4389 4512 4510 gf180mcu_fd_sc_mcu9t5v0__oai211_1
* cell instance $9459 r0 *1 698.88,614.88
X$9459 2688 4898 4923 4903 4794 5052 gf180mcu_fd_sc_mcu9t5v0__mux2_1
* cell instance $9460 m0 *1 752.08,604.8
X$9460 4538 4485 4389 4512 4484 gf180mcu_fd_sc_mcu9t5v0__nand2_1
* cell instance $9461 r0 *1 699.44,594.72
X$9461 2688 4368 4018 4389 4266 4387 gf180mcu_fd_sc_mcu9t5v0__mux2_1
* cell instance $9462 r0 *1 732.48,584.64
X$9462 2365 4019 4018 4150 3907 4148 gf180mcu_fd_sc_mcu9t5v0__mux2_1
* cell instance $9463 r0 *1 746.48,584.64
X$9463 2370 4020 4018 4150 3907 4149 gf180mcu_fd_sc_mcu9t5v0__mux2_1
* cell instance $9464 r0 *1 729.68,584.64
X$9464 3907 4150 gf180mcu_fd_sc_mcu9t5v0__filltie
* cell instance $9465 r0 *1 729.68,614.88
X$9465 4794 4903 gf180mcu_fd_sc_mcu9t5v0__filltie
* cell instance $9466 r0 *1 702.8,604.8
X$9466 4368 4538 4539 4667 4512 4663 gf180mcu_fd_sc_mcu9t5v0__oai21_1
* cell instance $9467 r0 *1 729.68,574.56
X$9467 3781 3796 gf180mcu_fd_sc_mcu9t5v0__filltie
* cell instance $9468 m0 *1 739.76,594.72
X$9468 4508 4149 4020 4150 4266 gf180mcu_fd_sc_mcu9t5v0__dffq_2
* cell instance $9469 r0 *1 724.08,604.8
X$9469 4369 4538 4539 4667 4512 4540 gf180mcu_fd_sc_mcu9t5v0__oai21_1
* cell instance $9470 r0 *1 729.68,564.48
X$9470 3444 3558 gf180mcu_fd_sc_mcu9t5v0__filltie
* cell instance $9471 m0 *1 735.28,614.88
X$9471 4019 4538 4539 4667 4794 4762 gf180mcu_fd_sc_mcu9t5v0__oai21_1
* cell instance $9472 r0 *1 729.68,554.4
X$9472 3227 3334 gf180mcu_fd_sc_mcu9t5v0__filltie
* cell instance $9473 m0 *1 800.8,604.8
X$9473 4514 4486 2573 4389 4512 4513 gf180mcu_fd_sc_mcu9t5v0__mux2_2
* cell instance $9474 m0 *1 787.36,594.72
X$9474 3559 4152 4022 4150 4266 gf180mcu_fd_sc_mcu9t5v0__dffq_2
* cell instance $9475 m0 *1 767.76,604.8
X$9475 4021 4538 4539 4389 4512 4511 gf180mcu_fd_sc_mcu9t5v0__oai21_1
* cell instance $9476 m0 *1 804.16,594.72
X$9476 4247 4246 2264 4150 4266 4023 gf180mcu_fd_sc_mcu9t5v0__mux2_1
* cell instance $9477 m0 *1 825.44,594.72
X$9477 2983 4248 4150 4266 4267 gf180mcu_fd_sc_mcu9t5v0__nand2_1
* cell instance $9478 r0 *1 790.72,614.88
X$9478 4906 4903 4794 4949 gf180mcu_fd_sc_mcu9t5v0__buf_8
* cell instance $9479 m0 *1 777.84,604.8
X$9479 2891 4389 4512 4543 gf180mcu_fd_sc_mcu9t5v0__clkinv_1
* cell instance $9480 r0 *1 809.76,614.88
X$9480 4906 4903 4794 2997 gf180mcu_fd_sc_mcu9t5v0__buf_8
* cell instance $9481 r0 *1 766.64,584.64
X$9481 2257 4021 4018 4150 3907 4151 gf180mcu_fd_sc_mcu9t5v0__mux2_1
* cell instance $9482 r0 *1 793.52,584.64
X$9482 4023 4022 4024 4150 3907 4152 gf180mcu_fd_sc_mcu9t5v0__mux2_1
* cell instance $9483 m0 *1 802.48,584.64
X$9483 3782 3799 2472 3796 3907 3798 gf180mcu_fd_sc_mcu9t5v0__mux2_2
* cell instance $9484 r0 *1 776.16,614.88
X$9484 4905 4903 4794 4906 gf180mcu_fd_sc_mcu9t5v0__buf_8
* cell instance $9485 m0 *1 806.96,574.56
X$9485 4247 4246 3677 3558 3781 3782 gf180mcu_fd_sc_mcu9t5v0__mux2_2
* cell instance $9486 m0 *1 821.52,604.8
X$9486 4486 2786 4949 4488 2992 4389 4512 4487 gf180mcu_fd_sc_mcu9t5v0__aoi221_1
* cell instance $9487 r0 *1 768.32,604.8
X$9487 4542 4511 4667 4512 4666 gf180mcu_fd_sc_mcu9t5v0__nor2_1
* cell instance $9488 r0 *1 798,574.56
X$9488 3559 3798 3799 3796 3781 gf180mcu_fd_sc_mcu9t5v0__dffq_2
* cell instance $9489 r0 *1 775.04,604.8
X$9489 4543 4667 4512 4529 gf180mcu_fd_sc_mcu9t5v0__buf_8
* cell instance $9490 m0 *1 781.2,614.88
X$9490 4543 4668 4667 4794 4905 gf180mcu_fd_sc_mcu9t5v0__nor2_1
* cell instance $9491 m0 *1 818.72,584.64
X$9491 3678 3799 2891 3796 3907 3908 gf180mcu_fd_sc_mcu9t5v0__mux2_1
* cell instance $9492 r0 *1 820.96,594.72
X$9492 4390 4268 4267 4487 3103 4389 4266 4370 gf180mcu_fd_sc_mcu9t5v0__aoi221_1
* cell instance $9493 r0 *1 795.76,604.8
X$9493 3559 4513 4486 4667 4512 gf180mcu_fd_sc_mcu9t5v0__dffq_2
* cell instance $9494 m0 *1 809.2,604.8
X$9494 4246 4247 2986 4389 4512 4514 gf180mcu_fd_sc_mcu9t5v0__mux2_1
* cell instance $9495 m0 *1 817.04,594.72
X$9495 4022 2997 3908 2983 2880 4150 4266 4268 gf180mcu_fd_sc_mcu9t5v0__aoi221_1
* cell instance $9496 r0 *1 962.64,776.16
X$9496 8970 6261 6042 8843 8818 9096 gf180mcu_fd_sc_mcu9t5v0__and3_1
* cell instance $9497 r0 *1 952.56,806.4
X$9497 9816 9580 9545 9691 9575 gf180mcu_fd_sc_mcu9t5v0__dffq_2
* cell instance $9498 r0 *1 966,786.24
X$9498 9088 9201 8961 8970 gf180mcu_fd_sc_mcu9t5v0__clkinv_1
* cell instance $9499 m0 *1 962.64,756
X$9499 7080 8209 8323 8078 8204 gf180mcu_fd_sc_mcu9t5v0__dffq_2
* cell instance $9500 r0 *1 964.88,756
X$9500 6399 8325 8324 8445 8204 8209 gf180mcu_fd_sc_mcu9t5v0__aoi21_1
* cell instance $9501 r0 *1 965.44,745.92
X$9501 7080 8078 7948 33571 gf180mcu_fd_sc_mcu9t5v0__clkinv_1
* cell instance $9502 r0 *1 952.56,735.84
X$9502 7080 7956 7445 7919 7814 gf180mcu_fd_sc_mcu9t5v0__dffq_2
* cell instance $9503 r0 *1 964.88,766.08
X$9503 6919 6916 8589 8693 8582 8555 gf180mcu_fd_sc_mcu9t5v0__aoi21_1
* cell instance $9504 r0 *1 894.32,685.44
X$9504 6428 6429 6808 6664 6425 gf180mcu_fd_sc_mcu9t5v0__dffq_2
* cell instance $9505 m0 *1 964.32,655.2
X$9505 4939 5766 5665 5794 5770 gf180mcu_fd_sc_mcu9t5v0__nand2_1
* cell instance $9506 r0 *1 918.4,685.44
X$9506 4030 6253 6664 6425 6551 gf180mcu_fd_sc_mcu9t5v0__nand2_1
* cell instance $9507 r0 *1 921.2,685.44
X$9507 6668 4030 6551 6664 6425 6395 gf180mcu_fd_sc_mcu9t5v0__oai21_1
* cell instance $9508 m0 *1 941.36,695.52
X$9508 5544 6557 7685 6669 6664 6805 6552 gf180mcu_fd_sc_mcu9t5v0__oai31_1
* cell instance $9509 m0 *1 922.32,695.52
X$9509 6956 4769 6664 6805 6550 gf180mcu_fd_sc_mcu9t5v0__nand2_1
* cell instance $9510 r0 *1 946.4,685.44
X$9510 5899 6669 6553 6552 6664 6425 6554 gf180mcu_fd_sc_mcu9t5v0__oai22_1
* cell instance $9511 r0 *1 963.76,675.36
X$9511 6396 6261 6042 6392 6292 6397 gf180mcu_fd_sc_mcu9t5v0__and3_1
* cell instance $9512 r0 *1 964.32,685.44
X$9512 6399 6554 6397 6664 6425 6556 gf180mcu_fd_sc_mcu9t5v0__aoi21_1
* cell instance $9513 r0 *1 915.6,685.44
X$9513 6551 6550 6664 6425 6430 gf180mcu_fd_sc_mcu9t5v0__nand2_1
* cell instance $9514 m0 *1 946.96,695.52
X$9514 4374 6557 7685 6669 6664 6805 6778 gf180mcu_fd_sc_mcu9t5v0__oai31_1
* cell instance $9515 m0 *1 955.92,695.52
X$9515 4770 6669 6809 6778 6664 6805 6555 gf180mcu_fd_sc_mcu9t5v0__oai22_1
* cell instance $9516 r0 *1 952.56,665.28
X$9516 5418 6041 4550 6144 6034 gf180mcu_fd_sc_mcu9t5v0__dffq_2
* cell instance $9517 m0 *1 934.64,695.52
X$9517 6146 6664 6805 6668 gf180mcu_fd_sc_mcu9t5v0__clkinv_1
* cell instance $9518 r0 *1 969.36,685.44
X$9518 6425 6664 gf180mcu_fd_sc_mcu9t5v0__filltie
* cell instance $9519 r0 *1 938,685.44
X$9519 5275 6664 6425 5544 gf180mcu_fd_sc_mcu9t5v0__clkinv_1
* cell instance $9520 r0 *1 859.6,685.44
X$9520 5275 5296 3335 6664 6425 6548 gf180mcu_fd_sc_mcu9t5v0__mux2_1
* cell instance $9521 r0 *1 872.48,685.44
X$9521 6428 6549 6807 6664 6425 gf180mcu_fd_sc_mcu9t5v0__dffq_2
* cell instance $9522 m0 *1 876.96,695.52
X$9522 6427 6807 6914 6664 6805 6549 gf180mcu_fd_sc_mcu9t5v0__mux2_2
* cell instance $9523 m0 *1 851.2,695.52
X$9523 3559 6777 5795 6664 6805 gf180mcu_fd_sc_mcu9t5v0__dffq_2
* cell instance $9524 m0 *1 849.52,695.52
X$9524 6805 6664 gf180mcu_fd_sc_mcu9t5v0__filltie
* cell instance $9525 m0 *1 964.88,624.96
X$9525 4942 4941 4497 4903 5056 4940 gf180mcu_fd_sc_mcu9t5v0__aoi21_1
* cell instance $9526 r0 *1 960.96,624.96
X$9526 4553 2786 4949 4554 4940 5183 5056 5160 gf180mcu_fd_sc_mcu9t5v0__aoi221_1
* cell instance $9527 r0 *1 952,604.8
X$9527 4272 4555 4553 4554 2987 3459 4667 4512 3914
+ gf180mcu_fd_sc_mcu9t5v0__mux4_1
* cell instance $9528 r0 *1 964.32,594.72
X$9528 4272 4254 4252 2248 4389 4266 4394 gf180mcu_fd_sc_mcu9t5v0__aoi22_1
* cell instance $9529 m0 *1 966.56,604.8
X$9529 4394 4520 4389 4512 4521 gf180mcu_fd_sc_mcu9t5v0__nand2_1
* cell instance $9530 r0 *1 1036,685.44
X$9530 4037 6557 7685 6669 6664 6425 6559 gf180mcu_fd_sc_mcu9t5v0__oai31_1
* cell instance $9531 m0 *1 1066.8,695.52
X$9531 5926 6557 7685 6669 6664 6805 6673 gf180mcu_fd_sc_mcu9t5v0__oai31_1
* cell instance $9532 r0 *1 1055.6,685.44
X$9532 6399 6561 6562 6664 6425 6434 gf180mcu_fd_sc_mcu9t5v0__aoi21_1
* cell instance $9533 m0 *1 1078.56,695.52
X$9533 3103 6781 6563 4930 6664 6805 6538 gf180mcu_fd_sc_mcu9t5v0__aoi211_1
* cell instance $9534 m0 *1 1097.6,695.52
X$9534 6783 6675 3120 6664 6805 6966 gf180mcu_fd_sc_mcu9t5v0__mux2_1
* cell instance $9535 r0 *1 1041.6,685.44
X$9535 4946 6669 6560 6559 6664 6425 6401 gf180mcu_fd_sc_mcu9t5v0__oai22_1
* cell instance $9536 m0 *1 1089.2,695.52
X$9536 6805 6664 gf180mcu_fd_sc_mcu9t5v0__filltie
* cell instance $9537 m0 *1 1086.4,695.52
X$9537 3459 6782 6664 6805 6964 gf180mcu_fd_sc_mcu9t5v0__nand2_1
* cell instance $9538 m0 *1 1061.2,695.52
X$9538 5280 6669 6674 6673 6664 6805 6561 gf180mcu_fd_sc_mcu9t5v0__oai22_1
* cell instance $9539 m0 *1 982.24,695.52
X$9539 4939 6669 6670 6779 6664 6805 6398 gf180mcu_fd_sc_mcu9t5v0__oai22_1
* cell instance $9540 m0 *1 1018.08,695.52
X$9540 4773 6557 7685 6669 6664 6805 6780 gf180mcu_fd_sc_mcu9t5v0__oai31_1
* cell instance $9541 m0 *1 1023.68,695.52
X$9541 5164 6669 6672 6780 6664 6805 6433 gf180mcu_fd_sc_mcu9t5v0__oai22_1
* cell instance $9542 r0 *1 997.36,685.44
X$9542 4032 6557 7685 6669 6664 6425 6558 gf180mcu_fd_sc_mcu9t5v0__oai31_1
* cell instance $9543 r0 *1 1022.56,685.44
X$9543 2365 6664 6425 4773 gf180mcu_fd_sc_mcu9t5v0__clkinv_1
* cell instance $9544 r0 *1 1003.52,685.44
X$9544 4914 6669 6671 6558 6664 6425 6431 gf180mcu_fd_sc_mcu9t5v0__oai22_1
* cell instance $9545 m0 *1 976.64,695.52
X$9545 4489 6557 7685 6669 6664 6805 6779 gf180mcu_fd_sc_mcu9t5v0__oai31_1
* cell instance $9546 m0 *1 959.28,786.24
X$9546 7080 9095 9088 8843 8961 gf180mcu_fd_sc_mcu9t5v0__dffq_2
* cell instance $9547 r0 *1 952.56,715.68
X$9547 7080 7324 6948 7316 7195 gf180mcu_fd_sc_mcu9t5v0__dffq_2
* cell instance $9548 m0 *1 961.52,685.44
X$9548 5418 6556 5896 6392 6425 gf180mcu_fd_sc_mcu9t5v0__dffq_2
* cell instance $9549 m0 *1 964.32,645.12
X$9549 5418 5422 4935 5390 5411 gf180mcu_fd_sc_mcu9t5v0__dffq_2
* cell instance $9550 m0 *1 965.44,766.08
X$9550 5901 8445 8582 7080 gf180mcu_fd_sc_mcu9t5v0__clkbuf_8
* cell instance $9551 m0 *1 965.44,574.56
X$9551 4764 3558 3781 3233 gf180mcu_fd_sc_mcu9t5v0__buf_8
* cell instance $9552 m0 *1 949.76,564.48
X$9552 3342 3341 2783 2466 2987 3106 3334 3444 3450
+ gf180mcu_fd_sc_mcu9t5v0__mux4_1
* cell instance $9553 m0 *1 952.56,584.64
X$9553 2776 3915 3341 3796 3907 gf180mcu_fd_sc_mcu9t5v0__dffq_2
* cell instance $9554 r0 *1 1094.24,756
X$9554 7931 4911 8451 8333 8334 8445 8204 8335 gf180mcu_fd_sc_mcu9t5v0__oai221_1
* cell instance $9555 r0 *1 1055.6,756
X$9555 8210 8216 8331 4527 8445 8204 8332 gf180mcu_fd_sc_mcu9t5v0__aoi211_1
* cell instance $9556 r0 *1 1034.32,735.84
X$9556 7961 7960 7930 7919 7814 7929 gf180mcu_fd_sc_mcu9t5v0__aoi21_1
* cell instance $9557 r0 *1 969.36,756
X$9557 8204 8445 gf180mcu_fd_sc_mcu9t5v0__filltie
* cell instance $9558 m0 *1 1020.32,725.76
X$9558 6268 7329 3220 7316 7558 gf180mcu_fd_sc_mcu9t5v0__dffq_2
* cell instance $9559 r0 *1 1033.76,756
X$9559 8210 8216 8331 7787 8445 8204 8330 gf180mcu_fd_sc_mcu9t5v0__aoi211_1
* cell instance $9560 r0 *1 1025.36,756
X$9560 7961 8328 8330 8445 8204 8329 gf180mcu_fd_sc_mcu9t5v0__aoi21_1
* cell instance $9561 r0 *1 1011.36,756
X$9561 7790 8326 8445 8204 8327 gf180mcu_fd_sc_mcu9t5v0__or2_1
* cell instance $9562 m0 *1 1024.24,786.24
X$9562 6268 8849 8967 8843 8961 gf180mcu_fd_sc_mcu9t5v0__dffq_2
* cell instance $9563 m0 *1 1033.2,745.92
X$9563 6268 7929 7079 7919 7948 gf180mcu_fd_sc_mcu9t5v0__dffq_2
* cell instance $9564 m0 *1 1024.24,766.08
X$9564 6268 8329 7787 8445 8582 gf180mcu_fd_sc_mcu9t5v0__dffq_2
* cell instance $9565 r0 *1 1033.2,776.16
X$9565 8210 8216 8331 8967 8843 8818 8850 gf180mcu_fd_sc_mcu9t5v0__aoi211_1
* cell instance $9566 m0 *1 1027.6,826.56
X$9566 6022 9841 10078 2777 gf180mcu_fd_sc_mcu9t5v0__clkbuf_20
* cell instance $9567 m0 *1 1035.44,776.16
X$9567 10083 8693 8818 7681 gf180mcu_fd_sc_mcu9t5v0__buf_8
* cell instance $9568 r0 *1 1020.32,806.4
X$9568 9551 9691 9575 5667 gf180mcu_fd_sc_mcu9t5v0__buf_12
* cell instance $9569 r0 *1 1034.88,796.32
X$9569 9552 10203 9100 9432 9315 9320 gf180mcu_fd_sc_mcu9t5v0__nor3_4
* cell instance $9570 r0 *1 1100.96,756
X$9570 7797 8445 8204 7931 gf180mcu_fd_sc_mcu9t5v0__clkinv_1
* cell instance $9571 m0 *1 1048.32,786.24
X$9571 8974 8843 8961 8210 gf180mcu_fd_sc_mcu9t5v0__buf_8
* cell instance $9572 m0 *1 1089.2,786.24
X$9572 8961 8843 gf180mcu_fd_sc_mcu9t5v0__filltie
* cell instance $9573 r0 *1 1082.48,776.16
X$9573 7334 8843 8818 8709 gf180mcu_fd_sc_mcu9t5v0__clkinv_1
* cell instance $9574 r0 *1 1077.44,776.16
X$9574 7566 8708 8710 8843 8818 8821 gf180mcu_fd_sc_mcu9t5v0__aoi21_1
* cell instance $9575 m0 *1 1072.4,776.16
X$9575 6268 8821 7334 8693 8818 gf180mcu_fd_sc_mcu9t5v0__dffq_2
* cell instance $9576 r0 *1 1078.56,766.08
X$9576 8709 6261 6042 8693 8582 8710 gf180mcu_fd_sc_mcu9t5v0__and3_1
* cell instance $9577 m0 *1 1089.2,766.08
X$9577 8582 8445 gf180mcu_fd_sc_mcu9t5v0__filltie
* cell instance $9578 r0 *1 1084.16,766.08
X$9578 6919 6916 8451 8693 8582 8592 gf180mcu_fd_sc_mcu9t5v0__aoi21_1
* cell instance $9579 m0 *1 1089.2,776.16
X$9579 8818 8693 gf180mcu_fd_sc_mcu9t5v0__filltie
* cell instance $9580 m0 *1 1064.56,776.16
X$9580 7454 6557 7685 6669 8693 8818 8707 gf180mcu_fd_sc_mcu9t5v0__oai31_1
* cell instance $9581 r0 *1 1072.4,766.08
X$9581 7963 6669 8592 8707 8693 8582 8708 gf180mcu_fd_sc_mcu9t5v0__oai22_1
* cell instance $9582 r0 *1 1056.72,766.08
X$9582 7961 8591 8332 8693 8582 8559 gf180mcu_fd_sc_mcu9t5v0__aoi21_1
* cell instance $9583 m0 *1 1036.56,796.32
X$9583 9442 9201 9315 2788 gf180mcu_fd_sc_mcu9t5v0__buf_8
* cell instance $9584 m0 *1 1089.2,806.4
X$9584 9575 9432 gf180mcu_fd_sc_mcu9t5v0__filltie
* cell instance $9585 m0 *1 1089.2,816.48
X$9585 9810 9691 gf180mcu_fd_sc_mcu9t5v0__filltie
* cell instance $9586 m0 *1 1089.2,826.56
X$9586 10078 9841 gf180mcu_fd_sc_mcu9t5v0__filltie
* cell instance $9587 m0 *1 1040.48,806.4
X$9587 9320 9432 9575 6432 gf180mcu_fd_sc_mcu9t5v0__buf_8
* cell instance $9588 m0 *1 1055.04,806.4
X$9588 9552 9553 9550 9432 9575 8091 gf180mcu_fd_sc_mcu9t5v0__nand3_4
* cell instance $9589 r0 *1 1080.8,786.24
X$9589 9101 9201 8961 4156 gf180mcu_fd_sc_mcu9t5v0__buf_8
* cell instance $9590 r0 *1 1082.48,796.32
X$9590 9101 9432 9315 7345 gf180mcu_fd_sc_mcu9t5v0__buf_8
* cell instance $9591 r0 *1 1041.04,786.24
X$9591 9100 9201 8961 6557 gf180mcu_fd_sc_mcu9t5v0__buf_8
* cell instance $9592 r0 *1 1083.6,806.4
X$9592 9555 9582 9691 9575 9101 gf180mcu_fd_sc_mcu9t5v0__nand2_4
* cell instance $9593 r0 *1 1053.36,816.48
X$9593 9855 9841 9810 9856 gf180mcu_fd_sc_mcu9t5v0__buf_8
* cell instance $9594 m0 *1 1089.2,796.32
X$9594 9315 9201 gf180mcu_fd_sc_mcu9t5v0__filltie
* cell instance $9595 m0 *1 1040.48,816.48
X$9595 9855 9552 10318 9550 9691 9810 9555 gf180mcu_fd_sc_mcu9t5v0__nand4_4
* cell instance $9596 r0 *1 1054.48,806.4
X$9596 9553 9691 9575 6919 gf180mcu_fd_sc_mcu9t5v0__buf_8
* cell instance $9597 m0 *1 1058.96,796.32
X$9597 9581 9201 9315 6925 gf180mcu_fd_sc_mcu9t5v0__buf_8
* cell instance $9598 r0 *1 1069.04,806.4
X$9598 9555 9691 9575 4027 gf180mcu_fd_sc_mcu9t5v0__buf_8
* cell instance $9599 m0 *1 1052.24,766.08
X$9599 6268 8559 4527 8445 8582 gf180mcu_fd_sc_mcu9t5v0__dffq_2
* cell instance $9600 m0 *1 1071.28,786.24
X$9600 8091 8843 8961 6030 gf180mcu_fd_sc_mcu9t5v0__buf_8
* cell instance $9601 r0 *1 1096.48,766.08
X$9601 7963 5057 8693 8582 8334 gf180mcu_fd_sc_mcu9t5v0__nand2_1
* cell instance $9602 r0 *1 969.36,816.48
X$9602 9810 9841 gf180mcu_fd_sc_mcu9t5v0__filltie
* cell instance $9603 m0 *1 980.56,806.4
X$9603 9845 6919 7681 9432 9575 9548 gf180mcu_fd_sc_mcu9t5v0__nand3_1
* cell instance $9604 r0 *1 983.92,816.48
X$9604 9848 9841 9810 9697 gf180mcu_fd_sc_mcu9t5v0__clkinv_1
* cell instance $9605 m0 *1 988.96,776.16
X$9605 8698 8693 8818 8557 gf180mcu_fd_sc_mcu9t5v0__clkinv_1
* cell instance $9606 r0 *1 969.36,776.16
X$9606 8818 8843 gf180mcu_fd_sc_mcu9t5v0__filltie
* cell instance $9607 r0 *1 1008.56,766.08
X$9607 5667 6916 7955 8693 8582 8590 gf180mcu_fd_sc_mcu9t5v0__aoi21_1
* cell instance $9608 r0 *1 1005.2,796.32
X$9608 6432 9432 9315 2141 gf180mcu_fd_sc_mcu9t5v0__buf_8
* cell instance $9609 r0 *1 969.36,766.08
X$9609 8582 8693 gf180mcu_fd_sc_mcu9t5v0__filltie
* cell instance $9610 r0 *1 969.36,796.32
X$9610 9315 9432 gf180mcu_fd_sc_mcu9t5v0__filltie
* cell instance $9611 r0 *1 983.92,766.08
X$9611 7080 8556 8698 8693 8582 gf180mcu_fd_sc_mcu9t5v0__dffq_2
* cell instance $9612 m0 *1 1012.48,766.08
X$9612 5766 8558 8590 8327 8445 8582 8328 gf180mcu_fd_sc_mcu9t5v0__oai31_1
* cell instance $9613 r0 *1 969.36,806.4
X$9613 9575 9691 gf180mcu_fd_sc_mcu9t5v0__filltie
* cell instance $9614 m0 *1 1011.36,786.24
X$9614 9090 8326 8843 8961 8972 gf180mcu_fd_sc_mcu9t5v0__or2_1
* cell instance $9615 m0 *1 1015.84,786.24
X$9615 5766 8848 9099 8972 8843 8961 8973 gf180mcu_fd_sc_mcu9t5v0__oai31_1
* cell instance $9616 r0 *1 1025.36,776.16
X$9616 7961 8973 8850 8843 8818 8849 gf180mcu_fd_sc_mcu9t5v0__aoi21_1
* cell instance $9617 m0 *1 991.76,786.24
X$9617 7080 8847 8959 8843 8961 gf180mcu_fd_sc_mcu9t5v0__dffq_2
* cell instance $9618 m0 *1 987.84,786.24
X$9618 8816 6919 7681 8843 8961 8971 gf180mcu_fd_sc_mcu9t5v0__nand3_1
* cell instance $9619 r0 *1 990.08,776.16
X$9619 8846 8449 8968 7081 8971 8843 8818 8847 gf180mcu_fd_sc_mcu9t5v0__oai221_1
* cell instance $9620 r0 *1 1013.04,776.16
X$9620 8816 5667 5767 8843 8818 8848 gf180mcu_fd_sc_mcu9t5v0__and3_1
* cell instance $9621 r0 *1 969.36,786.24
X$9621 8961 9201 gf180mcu_fd_sc_mcu9t5v0__filltie
* cell instance $9622 m0 *1 976.64,816.48
X$9622 9816 9818 9848 9691 9810 gf180mcu_fd_sc_mcu9t5v0__dffq_2
* cell instance $9623 r0 *1 979.44,806.4
X$9623 9697 8449 9696 7081 9548 9691 9575 9818 gf180mcu_fd_sc_mcu9t5v0__oai221_1
* cell instance $9624 r0 *1 1005.2,816.48
X$9624 9854 9841 9810 7081 gf180mcu_fd_sc_mcu9t5v0__buf_8
* cell instance $9625 m0 *1 1025.36,806.4
X$9625 9552 9551 9550 9432 9575 9442 gf180mcu_fd_sc_mcu9t5v0__nand3_2
* cell instance $9626 m0 *1 994.56,816.48
X$9626 9816 9700 9853 9691 9810 gf180mcu_fd_sc_mcu9t5v0__dffq_2
* cell instance $9627 r0 *1 1020.32,796.32
X$9627 9442 9432 9315 2986 gf180mcu_fd_sc_mcu9t5v0__buf_8
* cell instance $9628 r0 *1 992.88,806.4
X$9628 9699 8449 10690 7081 9698 9691 9575 9700
+ gf180mcu_fd_sc_mcu9t5v0__oai221_1
* cell instance $9629 m0 *1 1006.88,766.08
X$9629 7069 5667 5767 8445 8582 8558 gf180mcu_fd_sc_mcu9t5v0__and3_1
* cell instance $9630 m0 *1 977.76,796.32
X$9630 7080 9209 9441 9201 9315 gf180mcu_fd_sc_mcu9t5v0__dffq_2
* cell instance $9631 m0 *1 999.04,806.4
X$9631 9549 9432 9575 8706 gf180mcu_fd_sc_mcu9t5v0__buf_4
* cell instance $9632 m0 *1 983.92,766.08
X$9632 8557 8449 8589 7081 8450 8445 8582 8556 gf180mcu_fd_sc_mcu9t5v0__oai221_1
* cell instance $9633 m0 *1 990.64,766.08
X$9633 7951 6919 7681 8445 8582 8450 gf180mcu_fd_sc_mcu9t5v0__nand3_1
* cell instance $9634 r0 *1 984.48,796.32
X$9634 9441 9432 9315 9098 gf180mcu_fd_sc_mcu9t5v0__clkinv_1
* cell instance $9635 r0 *1 980.56,796.32
X$9635 10043 6919 7681 9432 9315 9097 gf180mcu_fd_sc_mcu9t5v0__nand3_1
* cell instance $9636 r0 *1 979.44,786.24
X$9636 9098 8449 9319 7081 9097 9201 8961 9209 gf180mcu_fd_sc_mcu9t5v0__oai221_1
* cell instance $9637 r0 *1 999.6,816.48
X$9637 9853 9841 9810 9699 gf180mcu_fd_sc_mcu9t5v0__clkinv_1
* cell instance $9638 r0 *1 1004.08,806.4
X$9638 8706 9691 9575 7961 gf180mcu_fd_sc_mcu9t5v0__buf_8
* cell instance $9639 r0 *1 995.68,786.24
X$9639 8959 9201 8961 8846 gf180mcu_fd_sc_mcu9t5v0__clkinv_1
* cell instance $9640 r0 *1 1011.36,786.24
X$9640 5667 6916 8968 9201 8961 9099 gf180mcu_fd_sc_mcu9t5v0__aoi21_1
* cell instance $9641 r0 *1 999.6,806.4
X$9641 10677 6919 7681 9691 9575 9698 gf180mcu_fd_sc_mcu9t5v0__nand3_1
* cell instance $9642 m0 *1 982.8,725.76
X$9642 6918 7081 3920 7326 7451 7316 7558 7561 gf180mcu_fd_sc_mcu9t5v0__oai221_1
* cell instance $9643 m0 *1 1020.32,745.92
X$9643 6956 8326 7919 7948 7959 gf180mcu_fd_sc_mcu9t5v0__or2_1
* cell instance $9644 r0 *1 969.36,735.84
X$9644 7814 7919 gf180mcu_fd_sc_mcu9t5v0__filltie
* cell instance $9645 r0 *1 969.36,725.76
X$9645 7558 7671 gf180mcu_fd_sc_mcu9t5v0__filltie
* cell instance $9646 m0 *1 1025.36,745.92
X$9646 5766 7928 7958 7959 7919 7948 7960 gf180mcu_fd_sc_mcu9t5v0__oai31_1
* cell instance $9647 m0 *1 986.16,756
X$9647 3920 8078 8204 8449 gf180mcu_fd_sc_mcu9t5v0__buf_8
* cell instance $9648 m0 *1 988.96,705.6
X$9648 5418 6959 3563 6909 6943 gf180mcu_fd_sc_mcu9t5v0__dffq_2
* cell instance $9649 r0 *1 969.36,745.92
X$9649 7948 8078 gf180mcu_fd_sc_mcu9t5v0__filltie
* cell instance $9650 m0 *1 976.08,715.68
X$9650 5922 7071 7195 7207 gf180mcu_fd_sc_mcu9t5v0__clkinv_1
* cell instance $9651 r0 *1 1008,695.52
X$9651 6919 6916 7084 6909 6805 6671 gf180mcu_fd_sc_mcu9t5v0__aoi21_1
* cell instance $9652 r0 *1 1025.36,695.52
X$9652 6919 6916 6920 6909 6805 6672 gf180mcu_fd_sc_mcu9t5v0__aoi21_1
* cell instance $9653 r0 *1 1021.44,725.76
X$9653 2365 6919 7681 7671 7558 7328 gf180mcu_fd_sc_mcu9t5v0__nand3_1
* cell instance $9654 r0 *1 988.4,705.6
X$9654 6917 7081 3920 6958 7082 7071 6943 6959 gf180mcu_fd_sc_mcu9t5v0__oai221_1
* cell instance $9655 m0 *1 1009.68,705.6
X$9655 5418 6960 2989 6909 6943 gf180mcu_fd_sc_mcu9t5v0__dffq_2
* cell instance $9656 m0 *1 978.32,715.68
X$9656 7205 7081 3920 7207 7208 7071 7195 7325 gf180mcu_fd_sc_mcu9t5v0__oai221_1
* cell instance $9657 r0 *1 1006.88,705.6
X$9657 2989 7071 6943 7083 gf180mcu_fd_sc_mcu9t5v0__clkinv_1
* cell instance $9658 m0 *1 1009.68,715.68
X$9658 2244 6919 7681 7071 7195 7085 gf180mcu_fd_sc_mcu9t5v0__nand3_1
* cell instance $9659 r0 *1 1009.12,705.6
X$9659 7084 7081 3920 7083 7085 7071 6943 6960 gf180mcu_fd_sc_mcu9t5v0__oai221_1
* cell instance $9660 r0 *1 982.24,695.52
X$9660 6919 6916 6918 6909 6805 6670 gf180mcu_fd_sc_mcu9t5v0__aoi21_1
* cell instance $9661 m0 *1 986.72,705.6
X$9661 3563 6909 6943 6958 gf180mcu_fd_sc_mcu9t5v0__clkinv_1
* cell instance $9662 r0 *1 995.12,705.6
X$9662 3230 6919 7681 7071 6943 7082 gf180mcu_fd_sc_mcu9t5v0__nand3_1
* cell instance $9663 r0 *1 970.48,715.68
X$9663 7080 7325 5922 7316 7195 gf180mcu_fd_sc_mcu9t5v0__dffq_2
* cell instance $9664 r0 *1 1018.64,715.68
X$9664 3220 7316 7195 7327 gf180mcu_fd_sc_mcu9t5v0__clkinv_1
* cell instance $9665 r0 *1 969.36,715.68
X$9665 7195 7316 gf180mcu_fd_sc_mcu9t5v0__filltie
* cell instance $9666 r0 *1 1020.88,715.68
X$9666 6920 7081 3920 7327 7328 7316 7195 7329 gf180mcu_fd_sc_mcu9t5v0__oai221_1
* cell instance $9667 r0 *1 987.28,715.68
X$9667 4488 7316 7195 7326 gf180mcu_fd_sc_mcu9t5v0__clkinv_1
* cell instance $9668 m0 *1 978.88,745.92
X$9668 7080 7925 6774 7919 7948 gf180mcu_fd_sc_mcu9t5v0__dffq_2
* cell instance $9669 r0 *1 1023.68,735.84
X$9669 6146 5667 5767 7919 7814 7928 gf180mcu_fd_sc_mcu9t5v0__and3_1
* cell instance $9670 r0 *1 969.36,695.52
X$9670 6805 6909 gf180mcu_fd_sc_mcu9t5v0__filltie
* cell instance $9671 r0 *1 1019.2,735.84
X$9671 5667 6916 7680 7919 7814 7958 gf180mcu_fd_sc_mcu9t5v0__aoi21_1
* cell instance $9672 r0 *1 969.36,705.6
X$9672 6943 7071 gf180mcu_fd_sc_mcu9t5v0__filltie
* cell instance $9673 m0 *1 1008,735.84
X$9673 7673 7671 7814 7821 gf180mcu_fd_sc_mcu9t5v0__clkinv_1
* cell instance $9674 m0 *1 1009.68,745.92
X$9674 7069 6919 7681 7919 7948 7957 gf180mcu_fd_sc_mcu9t5v0__nand3_1
* cell instance $9675 m0 *1 1002.96,745.92
X$9675 7821 3920 7955 7081 7957 7919 7948 7820 gf180mcu_fd_sc_mcu9t5v0__oai221_1
* cell instance $9676 r0 *1 988.4,735.84
X$9676 6774 7919 7814 7927 gf180mcu_fd_sc_mcu9t5v0__clkinv_1
* cell instance $9677 m0 *1 978.88,725.76
X$9677 5275 6919 7681 7316 7558 7208 gf180mcu_fd_sc_mcu9t5v0__nand3_1
* cell instance $9678 r0 *1 983.92,745.92
X$9678 6146 6919 7681 8078 7948 7926 gf180mcu_fd_sc_mcu9t5v0__nand3_1
* cell instance $9679 r0 *1 981.68,735.84
X$9679 7927 3920 7680 7081 7926 7919 7814 7925 gf180mcu_fd_sc_mcu9t5v0__oai221_1
* cell instance $9680 r0 *1 1001.28,735.84
X$9680 7080 7820 7673 7919 7814 gf180mcu_fd_sc_mcu9t5v0__dffq_2
* cell instance $9681 m0 *1 989.52,725.76
X$9681 7080 7561 4488 7316 7558 gf180mcu_fd_sc_mcu9t5v0__dffq_2
* cell instance $9682 r0 *1 990.08,725.76
X$9682 4246 6919 7681 7671 7558 7451 gf180mcu_fd_sc_mcu9t5v0__nand3_1
* cell instance $9683 m0 *1 1037.12,756
X$9683 8210 8216 8331 7079 8078 8204 7930 gf180mcu_fd_sc_mcu9t5v0__aoi211_1
* cell instance $9684 r0 *1 1091.44,745.92
X$9684 7965 6966 4916 8078 7948 8092 gf180mcu_fd_sc_mcu9t5v0__mux2_1
* cell instance $9685 m0 *1 1052.24,745.92
X$9685 7962 7919 7948 3920 gf180mcu_fd_sc_mcu9t5v0__buf_8
* cell instance $9686 r0 *1 1081.36,695.52
X$9686 5775 5777 7087 6295 2987 3106 6909 6805 6782
+ gf180mcu_fd_sc_mcu9t5v0__mux4_1
* cell instance $9687 m0 *1 1073.52,745.92
X$9687 8091 7919 7948 3575 gf180mcu_fd_sc_mcu9t5v0__buf_8
* cell instance $9688 r0 *1 1042.16,695.52
X$9688 6919 6916 6921 6909 6805 6560 gf180mcu_fd_sc_mcu9t5v0__aoi21_1
* cell instance $9689 m0 *1 1089.2,715.68
X$9689 7195 7071 gf180mcu_fd_sc_mcu9t5v0__filltie
* cell instance $9690 m0 *1 1091.44,705.6
X$9690 3462 6967 6964 6909 6943 6965 gf180mcu_fd_sc_mcu9t5v0__nand3_1
* cell instance $9691 m0 *1 1089.2,745.92
X$9691 7948 7919 gf180mcu_fd_sc_mcu9t5v0__filltie
* cell instance $9692 m0 *1 1043.84,725.76
X$9692 6268 7452 3455 7316 7558 gf180mcu_fd_sc_mcu9t5v0__dffq_2
* cell instance $9693 r0 *1 1055.6,745.92
X$9693 7962 8078 7948 5299 gf180mcu_fd_sc_mcu9t5v0__buf_8
* cell instance $9694 m0 *1 1072.4,735.84
X$9694 5766 7793 7794 7964 7671 7814 7453 gf180mcu_fd_sc_mcu9t5v0__oai31_1
* cell instance $9695 m0 *1 1064,725.76
X$9695 7564 7453 5545 7316 7558 7563 gf180mcu_fd_sc_mcu9t5v0__mux2_1
* cell instance $9696 r0 *1 1057.84,725.76
X$9696 6268 7671 7558 33556 gf180mcu_fd_sc_mcu9t5v0__inv_2
* cell instance $9697 m0 *1 1089.2,756
X$9697 8204 8078 gf180mcu_fd_sc_mcu9t5v0__filltie
* cell instance $9698 r0 *1 1083.6,705.6
X$9698 6286 6025 2250 7071 6943 7088 gf180mcu_fd_sc_mcu9t5v0__mux2_1
* cell instance $9699 m0 *1 1072.96,705.6
X$9699 7088 7087 2134 6909 6943 7086 gf180mcu_fd_sc_mcu9t5v0__mux2_2
* cell instance $9700 m0 *1 1089.2,705.6
X$9700 6943 6909 gf180mcu_fd_sc_mcu9t5v0__filltie
* cell instance $9701 r0 *1 1097.6,735.84
X$9701 7822 7931 2891 7919 7814 7332 gf180mcu_fd_sc_mcu9t5v0__mux2_1
* cell instance $9702 r0 *1 1044.96,715.68
X$9702 7331 7081 3920 7562 7330 7316 7195 7452 gf180mcu_fd_sc_mcu9t5v0__oai221_1
* cell instance $9703 r0 *1 1095.92,715.68
X$9703 6922 4258 4275 7334 4545 7316 7195 7335 gf180mcu_fd_sc_mcu9t5v0__aoi221_1
* cell instance $9704 r0 *1 1084.16,715.68
X$9704 7564 2786 4949 7334 7316 7195 7333 gf180mcu_fd_sc_mcu9t5v0__aoi22_1
* cell instance $9705 r0 *1 1079.68,715.68
X$9705 4497 7332 7333 7316 7195 6781 gf180mcu_fd_sc_mcu9t5v0__oai21_1
* cell instance $9706 r0 *1 1051.12,725.76
X$9706 3455 7671 7558 7562 gf180mcu_fd_sc_mcu9t5v0__clkinv_1
* cell instance $9707 m0 *1 1079.12,735.84
X$9707 5667 5767 7795 7671 7814 7794 gf180mcu_fd_sc_mcu9t5v0__aoi21_1
* cell instance $9708 m0 *1 1089.2,735.84
X$9708 7814 7671 gf180mcu_fd_sc_mcu9t5v0__filltie
* cell instance $9709 r0 *1 1065.68,735.84
X$9709 7454 5667 5767 7919 7814 7793 gf180mcu_fd_sc_mcu9t5v0__and3_1
* cell instance $9710 r0 *1 1066.8,705.6
X$9710 6268 7086 7087 7071 6943 gf180mcu_fd_sc_mcu9t5v0__dffq_2
* cell instance $9711 m0 *1 1060.08,705.6
X$9711 6919 6916 7331 6909 6943 6674 gf180mcu_fd_sc_mcu9t5v0__aoi21_1
* cell instance $9712 r0 *1 1050.56,745.92
X$9712 8091 7081 8078 7948 7962 gf180mcu_fd_sc_mcu9t5v0__nand2_2
* cell instance $9713 r0 *1 1061.76,725.76
X$9713 6268 7563 7564 7671 7558 gf180mcu_fd_sc_mcu9t5v0__dffq_2
* cell instance $9714 r0 *1 1070.16,745.92
X$9714 10850 8078 7948 6916 gf180mcu_fd_sc_mcu9t5v0__buf_12
* cell instance $9715 r0 *1 1089.76,725.76
X$9715 3462 7796 6965 4952 7671 7558 7682 gf180mcu_fd_sc_mcu9t5v0__oai211_1
* cell instance $9716 m0 *1 1039.36,715.68
X$9716 2370 6919 7681 7071 7195 6962 gf180mcu_fd_sc_mcu9t5v0__nand3_1
* cell instance $9717 r0 *1 1038.24,705.6
X$9717 6268 6963 2998 7071 6943 gf180mcu_fd_sc_mcu9t5v0__dffq_2
* cell instance $9718 m0 *1 1057.84,735.84
X$9718 5901 7671 7814 6268 gf180mcu_fd_sc_mcu9t5v0__clkbuf_8
* cell instance $9719 m0 *1 1089.2,725.76
X$9719 7558 7316 gf180mcu_fd_sc_mcu9t5v0__filltie
* cell instance $9720 m0 *1 1039.92,705.6
X$9720 6921 7081 3920 6961 6962 6909 6943 6963 gf180mcu_fd_sc_mcu9t5v0__oai221_1
* cell instance $9721 m0 *1 1069.04,745.92
X$9721 7963 5766 7919 7948 7964 gf180mcu_fd_sc_mcu9t5v0__nand2_1
* cell instance $9722 m0 *1 1039.92,725.76
X$9722 2257 6919 7681 7316 7558 7330 gf180mcu_fd_sc_mcu9t5v0__nand3_1
* cell instance $9723 m0 *1 1043.28,715.68
X$9723 2998 7071 7195 6961 gf180mcu_fd_sc_mcu9t5v0__clkinv_1
* cell instance $9724 r0 *1 896.56,705.6
X$9724 6808 6953 7079 6948 4766 4764 7071 6943 6952
+ gf180mcu_fd_sc_mcu9t5v0__mux4_1
* cell instance $9725 m0 *1 894.88,705.6
X$9725 6808 6953 7079 6948 2987 3459 6909 6943 6947
+ gf180mcu_fd_sc_mcu9t5v0__mux4_1
* cell instance $9726 r0 *1 841.12,756
X$9726 3459 8320 8445 8204 8321 gf180mcu_fd_sc_mcu9t5v0__nor2_1
* cell instance $9727 m0 *1 884.8,796.32
X$9727 8965 8966 8967 9088 4766 9436 9201 9315 9579
+ gf180mcu_fd_sc_mcu9t5v0__mux4_1
* cell instance $9728 r0 *1 881.44,816.48
X$9728 10311 10038 9847 9848 4766 3121 9841 9810 10044
+ gf180mcu_fd_sc_mcu9t5v0__mux4_1
* cell instance $9729 m0 *1 893.2,816.48
X$9729 10306 9812 9813 9691 9810 gf180mcu_fd_sc_mcu9t5v0__dffq_2
* cell instance $9730 r0 *1 876.4,756
X$9730 8550 8551 2891 8445 8204 8322 gf180mcu_fd_sc_mcu9t5v0__mux2_1
* cell instance $9731 r0 *1 868,756
X$9731 8205 4258 4154 8323 4545 8445 8204 8585 gf180mcu_fd_sc_mcu9t5v0__aoi221_1
* cell instance $9732 r0 *1 888.72,735.84
X$9732 7789 7788 7787 7445 4766 4764 7919 7814 7952
+ gf180mcu_fd_sc_mcu9t5v0__mux4_1
* cell instance $9733 r0 *1 887.6,766.08
X$9733 8550 8551 8549 8323 4766 4764 8693 8582 8703
+ gf180mcu_fd_sc_mcu9t5v0__mux4_1
* cell instance $9734 r0 *1 884.24,796.32
X$9734 12125 9315 9432 5901 gf180mcu_fd_sc_mcu9t5v0__clkbuf_16
* cell instance $9735 r0 *1 894.88,756
X$9735 6428 8206 8550 8445 8204 gf180mcu_fd_sc_mcu9t5v0__dffq_2
* cell instance $9736 m0 *1 893.76,786.24
X$9736 6428 8844 8965 8843 8961 gf180mcu_fd_sc_mcu9t5v0__dffq_2
* cell instance $9737 r0 *1 954.8,756
X$9737 8323 8445 8204 8446 gf180mcu_fd_sc_mcu9t5v0__clkinv_1
* cell instance $9738 r0 *1 920.64,756
X$9738 8553 4769 8445 8204 8208 gf180mcu_fd_sc_mcu9t5v0__nand2_1
* cell instance $9739 r0 *1 902.16,786.24
X$9739 3564 9201 8961 4766 gf180mcu_fd_sc_mcu9t5v0__buf_8
* cell instance $9740 r0 *1 900.48,776.16
X$9740 8965 8845 4029 8843 8818 8844 gf180mcu_fd_sc_mcu9t5v0__mux2_1
* cell instance $9741 r0 *1 909.44,816.48
X$9741 9816 9849 9847 9841 9810 gf180mcu_fd_sc_mcu9t5v0__dffq_2
* cell instance $9742 r0 *1 944.72,786.24
X$9742 9207 6557 7685 6669 9201 8961 9093 gf180mcu_fd_sc_mcu9t5v0__oai31_1
* cell instance $9743 r0 *1 917.28,786.24
X$9743 8966 9089 7818 9201 8961 9206 gf180mcu_fd_sc_mcu9t5v0__mux2_1
* cell instance $9744 m0 *1 955.36,816.48
X$9744 6919 6916 9696 9691 9810 9817 gf180mcu_fd_sc_mcu9t5v0__aoi21_1
* cell instance $9745 r0 *1 941.36,786.24
X$9745 8816 9201 8961 9207 gf180mcu_fd_sc_mcu9t5v0__clkinv_1
* cell instance $9746 r0 *1 931.28,786.24
X$9746 4030 9204 9201 8961 9092 gf180mcu_fd_sc_mcu9t5v0__nand2_1
* cell instance $9747 m0 *1 937.44,796.32
X$9747 9207 4030 9092 9201 9315 9208 gf180mcu_fd_sc_mcu9t5v0__oai21_1
* cell instance $9748 r0 *1 938,796.32
X$9748 9543 9208 3340 9432 9315 9440 gf180mcu_fd_sc_mcu9t5v0__mux2_1
* cell instance $9749 r0 *1 955.92,816.48
X$9749 10046 6669 9817 9851 9841 9810 9852 gf180mcu_fd_sc_mcu9t5v0__oai22_1
* cell instance $9750 m0 *1 948.64,816.48
X$9750 9814 9691 9810 9696 gf180mcu_fd_sc_mcu9t5v0__clkinv_1
* cell instance $9751 r0 *1 925.12,786.24
X$9751 9090 4769 9201 8961 9091 gf180mcu_fd_sc_mcu9t5v0__nand2_1
* cell instance $9752 m0 *1 922.32,816.48
X$9752 9814 9691 9810 9815 gf180mcu_fd_sc_mcu9t5v0__buf_8
* cell instance $9753 m0 *1 927.92,796.32
X$9753 9204 9090 5057 9201 9315 9089 gf180mcu_fd_sc_mcu9t5v0__mux2_1
* cell instance $9754 r0 *1 901.6,806.4
X$9754 9845 9815 4027 9691 9575 9695 gf180mcu_fd_sc_mcu9t5v0__mux2_1
* cell instance $9755 r0 *1 898.8,816.48
X$9755 9813 9695 4156 9841 9810 9812 gf180mcu_fd_sc_mcu9t5v0__mux2_1
* cell instance $9756 m0 *1 943.04,826.56
X$9756 10688 5767 9814 9841 10078 9850 gf180mcu_fd_sc_mcu9t5v0__aoi21_1
* cell instance $9757 m0 *1 957.6,806.4
X$9757 9545 9432 9575 9546 gf180mcu_fd_sc_mcu9t5v0__clkinv_1
* cell instance $9758 m0 *1 959.84,806.4
X$9758 9546 6261 6042 9432 9575 9547 gf180mcu_fd_sc_mcu9t5v0__and3_1
* cell instance $9759 r0 *1 926.24,816.48
X$9759 9845 9815 2986 9841 9810 10045 gf180mcu_fd_sc_mcu9t5v0__mux2_1
* cell instance $9760 m0 *1 914.48,826.56
X$9760 10045 9847 2573 9841 10078 9849 gf180mcu_fd_sc_mcu9t5v0__mux2_2
* cell instance $9761 m0 *1 934.08,806.4
X$9761 7080 9440 9543 9432 9575 gf180mcu_fd_sc_mcu9t5v0__dffq_2
* cell instance $9762 m0 *1 959.84,766.08
X$9762 8553 6669 8555 8448 8445 8582 8325 gf180mcu_fd_sc_mcu9t5v0__oai22_1
* cell instance $9763 m0 *1 931.28,776.16
X$9763 7080 8704 8549 8693 8818 gf180mcu_fd_sc_mcu9t5v0__dffq_2
* cell instance $9764 r0 *1 941.92,766.08
X$9764 5766 8554 8588 8587 8693 8582 8705 gf180mcu_fd_sc_mcu9t5v0__oai31_1
* cell instance $9765 m0 *1 959.84,816.48
X$9765 6399 9852 9547 9691 9810 9580 gf180mcu_fd_sc_mcu9t5v0__aoi21_1
* cell instance $9766 r0 *1 951.44,786.24
X$9766 9090 6669 8969 9093 9201 8961 9094 gf180mcu_fd_sc_mcu9t5v0__oai22_1
* cell instance $9767 r0 *1 934.64,766.08
X$9767 8549 8705 8706 8693 8582 8704 gf180mcu_fd_sc_mcu9t5v0__mux2_1
* cell instance $9768 m0 *1 939.12,766.08
X$9768 8090 5667 5767 8445 8582 8554 gf180mcu_fd_sc_mcu9t5v0__and3_1
* cell instance $9769 r0 *1 961.52,786.24
X$9769 6399 9094 9096 9201 8961 9095 gf180mcu_fd_sc_mcu9t5v0__aoi21_1
* cell instance $9770 m0 *1 911.12,796.32
X$9770 7080 9206 8966 9201 9315 gf180mcu_fd_sc_mcu9t5v0__dffq_2
* cell instance $9771 r0 *1 931.84,766.08
X$9771 8553 5766 8693 8582 8587 gf180mcu_fd_sc_mcu9t5v0__nand2_1
* cell instance $9772 m0 *1 914.48,776.16
X$9772 8551 8552 7818 8693 8818 8586 gf180mcu_fd_sc_mcu9t5v0__mux2_1
* cell instance $9773 m0 *1 950.88,786.24
X$9773 6919 6916 8968 8843 8961 8969 gf180mcu_fd_sc_mcu9t5v0__aoi21_1
* cell instance $9774 r0 *1 947.52,766.08
X$9774 5667 6916 8079 8693 8582 8588 gf180mcu_fd_sc_mcu9t5v0__aoi21_1
* cell instance $9775 r0 *1 908.32,766.08
X$9775 7080 8586 8551 8693 8582 gf180mcu_fd_sc_mcu9t5v0__dffq_2
* cell instance $9776 m0 *1 919.52,766.08
X$9776 8079 8553 5057 8445 8582 8552 gf180mcu_fd_sc_mcu9t5v0__mux2_1
* cell instance $9777 m0 *1 938.56,826.56
X$9777 10046 5766 9841 10078 10343 gf180mcu_fd_sc_mcu9t5v0__nand2_1
* cell instance $9778 r0 *1 927.92,786.24
X$9778 9092 9091 9201 8961 8845 gf180mcu_fd_sc_mcu9t5v0__nand2_1
* cell instance $9779 m0 *1 948.64,766.08
X$9779 8090 6557 7685 6669 8445 8582 8448 gf180mcu_fd_sc_mcu9t5v0__oai31_1
* cell instance $9780 m0 *1 954.24,766.08
X$9780 8446 6261 6042 8445 8582 8324 gf180mcu_fd_sc_mcu9t5v0__and3_1
* cell instance $9781 r0 *1 849.52,806.4
X$9781 10306 9577 9542 9691 9575 gf180mcu_fd_sc_mcu9t5v0__dffq_2
* cell instance $9782 r0 *1 878.64,806.4
X$9782 9687 9691 9575 4668 gf180mcu_fd_sc_mcu9t5v0__clkinv_1
* cell instance $9783 r0 *1 874.72,786.24
X$9783 8965 8966 8967 9088 2987 3459 9201 8961 9087
+ gf180mcu_fd_sc_mcu9t5v0__mux4_1
* cell instance $9784 m0 *1 833.84,806.4
X$9784 3459 9576 9432 9575 9438 gf180mcu_fd_sc_mcu9t5v0__nor2_1
* cell instance $9785 m0 *1 829.92,786.24
X$9785 3564 8843 8961 6775 gf180mcu_fd_sc_mcu9t5v0__buf_8
* cell instance $9786 r0 *1 845.6,786.24
X$9786 6428 8962 9085 9201 8961 gf180mcu_fd_sc_mcu9t5v0__dffq_2
* cell instance $9787 m0 *1 849.52,806.4
X$9787 9575 9432 gf180mcu_fd_sc_mcu9t5v0__filltie
* cell instance $9788 r0 *1 866.88,786.24
X$9788 8967 4765 4949 9088 8964 2983 9201 8961 8954
+ gf180mcu_fd_sc_mcu9t5v0__aoi222_1
* cell instance $9789 r0 *1 873.6,766.08
X$9789 4545 8585 8702 8693 8582 8701 gf180mcu_fd_sc_mcu9t5v0__oai21_1
* cell instance $9790 m0 *1 849.52,776.16
X$9790 8818 8693 gf180mcu_fd_sc_mcu9t5v0__filltie
* cell instance $9791 m0 *1 849.52,766.08
X$9791 8582 8445 gf180mcu_fd_sc_mcu9t5v0__filltie
* cell instance $9792 m0 *1 885.92,776.16
X$9792 8703 8699 4908 8693 8818 8820 gf180mcu_fd_sc_mcu9t5v0__mux2_1
* cell instance $9793 m0 *1 855.68,776.16
X$9793 7951 8079 3335 8693 8818 8548 gf180mcu_fd_sc_mcu9t5v0__mux2_1
* cell instance $9794 r0 *1 863.52,766.08
X$9794 8549 4765 8322 2983 8693 8582 8694 gf180mcu_fd_sc_mcu9t5v0__aoi22_1
* cell instance $9795 m0 *1 842.8,766.08
X$9795 3806 8547 8445 8582 8546 gf180mcu_fd_sc_mcu9t5v0__nand2_1
* cell instance $9796 m0 *1 877.52,786.24
X$9796 8965 8966 2891 8843 8961 8964 gf180mcu_fd_sc_mcu9t5v0__mux2_1
* cell instance $9797 m0 *1 850.64,766.08
X$9797 8548 8696 6914 8445 8582 8584 gf180mcu_fd_sc_mcu9t5v0__mux2_2
* cell instance $9798 r0 *1 868.56,766.08
X$9798 8550 4254 4252 8696 8693 8582 8702 gf180mcu_fd_sc_mcu9t5v0__aoi22_1
* cell instance $9799 m0 *1 850.64,786.24
X$9799 8963 9085 6914 8843 8961 8962 gf180mcu_fd_sc_mcu9t5v0__mux2_2
* cell instance $9800 r0 *1 880.88,806.4
X$9800 9579 9435 4908 9691 9575 9694 gf180mcu_fd_sc_mcu9t5v0__mux2_1
* cell instance $9801 m0 *1 849.52,796.32
X$9801 9315 9201 gf180mcu_fd_sc_mcu9t5v0__filltie
* cell instance $9802 m0 *1 871.36,766.08
X$9802 8550 8551 8549 8323 2987 3459 8445 8582 8547
+ gf180mcu_fd_sc_mcu9t5v0__mux4_1
* cell instance $9803 m0 *1 832.72,796.32
X$9803 3351 9086 9201 9315 9203 gf180mcu_fd_sc_mcu9t5v0__nor2_1
* cell instance $9804 m0 *1 835.52,826.56
X$9804 10043 10042 2986 9841 10078 10041 gf180mcu_fd_sc_mcu9t5v0__mux2_1
* cell instance $9805 r0 *1 839.44,766.08
X$9805 3806 8321 8583 8546 8693 8582 8700 gf180mcu_fd_sc_mcu9t5v0__oai31_1
* cell instance $9806 m0 *1 855.68,796.32
X$9806 8816 9204 3335 9201 9315 8963 gf180mcu_fd_sc_mcu9t5v0__mux2_1
* cell instance $9807 m0 *1 882,816.48
X$9807 9847 4765 4949 9848 2992 9691 9810 9811 gf180mcu_fd_sc_mcu9t5v0__aoi221_1
* cell instance $9808 m0 *1 852.32,826.56
X$9808 10043 10042 4027 9841 10078 9846 gf180mcu_fd_sc_mcu9t5v0__mux2_1
* cell instance $9809 r0 *1 848.4,816.48
X$9809 11562 9846 4156 9841 9810 10079 gf180mcu_fd_sc_mcu9t5v0__mux2_1
* cell instance $9810 m0 *1 849.52,816.48
X$9810 9810 9691 gf180mcu_fd_sc_mcu9t5v0__filltie
* cell instance $9811 m0 *1 849.52,826.56
X$9811 10078 9841 gf180mcu_fd_sc_mcu9t5v0__filltie
* cell instance $9812 m0 *1 869.68,796.32
X$9812 8965 4254 4252 9085 9201 9315 9205 gf180mcu_fd_sc_mcu9t5v0__aoi22_1
* cell instance $9813 r0 *1 869.12,796.32
X$9813 9542 4258 4154 9088 9432 9315 9439 gf180mcu_fd_sc_mcu9t5v0__aoi22_1
* cell instance $9814 m0 *1 871.36,806.4
X$9814 9205 9439 9432 9575 9544 gf180mcu_fd_sc_mcu9t5v0__nand2_1
* cell instance $9815 m0 *1 884.24,806.4
X$9815 5901 9432 9575 gf180mcu_fd_sc_mcu9t5v0__clkinv_8
* cell instance $9816 r0 *1 836.08,796.32
X$9816 3806 9438 9203 9318 9432 9315 9437 gf180mcu_fd_sc_mcu9t5v0__oai31_1
* cell instance $9817 m0 *1 838.88,796.32
X$9817 3806 9087 9201 9315 9318 gf180mcu_fd_sc_mcu9t5v0__nand2_1
* cell instance $9818 m0 *1 858.48,806.4
X$9818 8816 9204 4027 9432 9575 9578 gf180mcu_fd_sc_mcu9t5v0__mux2_1
* cell instance $9819 m0 *1 849.52,786.24
X$9819 8961 8843 gf180mcu_fd_sc_mcu9t5v0__filltie
* cell instance $9820 r0 *1 835.52,766.08
X$9820 3351 8697 8693 8582 8583 gf180mcu_fd_sc_mcu9t5v0__nor2_1
* cell instance $9821 m0 *1 855.12,816.48
X$9821 9542 9578 4156 9691 9810 9577 gf180mcu_fd_sc_mcu9t5v0__mux2_1
* cell instance $9822 m0 *1 867.44,826.56
X$9822 10677 10036 4027 9841 10078 10081 gf180mcu_fd_sc_mcu9t5v0__mux2_1
* cell instance $9823 r0 *1 845.6,766.08
X$9823 6428 8584 8696 8693 8582 gf180mcu_fd_sc_mcu9t5v0__dffq_2
* cell instance $9824 r0 *1 846.16,725.76
X$9824 6428 7559 7194 7671 7558 gf180mcu_fd_sc_mcu9t5v0__dffq_2
* cell instance $9825 r0 *1 870.8,735.84
X$9825 6428 7919 7814 gf180mcu_fd_sc_mcu9t5v0__inv_4
* cell instance $9826 r0 *1 843.36,705.6
X$9826 3806 6947 7071 6943 6945 gf180mcu_fd_sc_mcu9t5v0__nand2_1
* cell instance $9827 m0 *1 860.72,745.92
X$9827 7951 8079 4027 7919 7948 7950 gf180mcu_fd_sc_mcu9t5v0__mux2_1
* cell instance $9828 m0 *1 857.92,756
X$9828 8205 7950 4156 8078 8204 8085 gf180mcu_fd_sc_mcu9t5v0__mux2_1
* cell instance $9829 m0 *1 849.52,735.84
X$9829 7814 7671 gf180mcu_fd_sc_mcu9t5v0__filltie
* cell instance $9830 r0 *1 881.44,735.84
X$9830 7789 7788 2891 7919 7814 7817 gf180mcu_fd_sc_mcu9t5v0__mux2_1
* cell instance $9831 m0 *1 870.24,735.84
X$9831 7787 4765 4949 7445 7817 2983 7671 7814 7319
+ gf180mcu_fd_sc_mcu9t5v0__aoi222_1
* cell instance $9832 m0 *1 849.52,745.92
X$9832 7948 7919 gf180mcu_fd_sc_mcu9t5v0__filltie
* cell instance $9833 r0 *1 854,745.92
X$9833 6428 8085 8205 8078 7948 gf180mcu_fd_sc_mcu9t5v0__dffq_2
* cell instance $9834 m0 *1 832.16,756
X$9834 8083 8205 8203 8082 2987 3106 8078 8204 8320
+ gf180mcu_fd_sc_mcu9t5v0__mux4_1
* cell instance $9835 m0 *1 859.04,725.76
X$9835 7069 7073 3335 7316 7558 7444 gf180mcu_fd_sc_mcu9t5v0__mux2_1
* cell instance $9836 r0 *1 879.2,695.52
X$9836 6808 4254 4252 6807 6909 6805 6915 gf180mcu_fd_sc_mcu9t5v0__aoi22_1
* cell instance $9837 r0 *1 855.12,695.52
X$9837 6548 5795 6914 6909 6805 6777 gf180mcu_fd_sc_mcu9t5v0__mux2_1
* cell instance $9838 m0 *1 851.76,715.68
X$9838 6428 7076 7196 7071 7195 gf180mcu_fd_sc_mcu9t5v0__dffq_2
* cell instance $9839 m0 *1 878.08,735.84
X$9839 7789 7788 7787 7445 2987 3459 7671 7814 7816
+ gf180mcu_fd_sc_mcu9t5v0__mux4_1
* cell instance $9840 r0 *1 833.84,695.52
X$9840 6257 6776 4764 6909 6805 6912 gf180mcu_fd_sc_mcu9t5v0__mux2_1
* cell instance $9841 m0 *1 874.16,705.6
X$9841 6147 4258 4154 6948 6909 6943 6950 gf180mcu_fd_sc_mcu9t5v0__aoi22_1
* cell instance $9842 r0 *1 851.2,705.6
X$9842 7196 7077 4156 7071 6943 7076 gf180mcu_fd_sc_mcu9t5v0__mux2_1
* cell instance $9843 m0 *1 879.2,705.6
X$9843 6915 6950 6909 6943 6949 gf180mcu_fd_sc_mcu9t5v0__nand2_1
* cell instance $9844 r0 *1 884.8,705.6
X$9844 7079 4765 4949 6948 7071 6943 7078 gf180mcu_fd_sc_mcu9t5v0__aoi22_1
* cell instance $9845 m0 *1 849.52,756
X$9845 8204 8078 gf180mcu_fd_sc_mcu9t5v0__filltie
* cell instance $9846 r0 *1 835.52,725.76
X$9846 3459 7323 7671 7558 7676 gf180mcu_fd_sc_mcu9t5v0__nor2_1
* cell instance $9847 m0 *1 833.84,735.84
X$9847 3351 7674 7671 7814 7785 gf180mcu_fd_sc_mcu9t5v0__nor2_1
* cell instance $9848 r0 *1 842.24,735.84
X$9848 3806 7816 7919 7814 7786 gf180mcu_fd_sc_mcu9t5v0__nand2_1
* cell instance $9849 m0 *1 837.2,735.84
X$9849 3806 7676 7785 7786 7671 7814 7815 gf180mcu_fd_sc_mcu9t5v0__oai31_1
* cell instance $9850 m0 *1 849.52,705.6
X$9850 6943 6909 gf180mcu_fd_sc_mcu9t5v0__filltie
* cell instance $9851 m0 *1 850.64,725.76
X$9851 7444 7194 6914 7316 7558 7559 gf180mcu_fd_sc_mcu9t5v0__mux2_2
* cell instance $9852 m0 *1 880.88,715.68
X$9852 2891 6808 7071 7195 7199 gf180mcu_fd_sc_mcu9t5v0__nor2_1
* cell instance $9853 m0 *1 887.6,705.6
X$9853 6952 6912 4908 6909 6943 6951 gf180mcu_fd_sc_mcu9t5v0__mux2_1
* cell instance $9854 r0 *1 888.16,745.92
X$9854 8086 7675 8088 8078 7948 8087 gf180mcu_fd_sc_mcu9t5v0__oai21_1
* cell instance $9855 r0 *1 874.16,725.76
X$9855 7789 4254 4252 7194 7671 7558 7677 gf180mcu_fd_sc_mcu9t5v0__aoi22_1
* cell instance $9856 m0 *1 870.8,745.92
X$9856 3808 7919 7948 6428 gf180mcu_fd_sc_mcu9t5v0__clkbuf_8
* cell instance $9857 m0 *1 871.92,725.76
X$9857 7196 4258 4154 7445 7316 7558 7446 gf180mcu_fd_sc_mcu9t5v0__aoi22_1
* cell instance $9858 m0 *1 889.84,745.92
X$9858 4908 7952 7919 7948 8088 gf180mcu_fd_sc_mcu9t5v0__or2_1
* cell instance $9859 r0 *1 879.2,725.76
X$9859 7677 7446 7671 7558 7678 gf180mcu_fd_sc_mcu9t5v0__nand2_1
* cell instance $9860 m0 *1 884.24,715.68
X$9860 4497 7199 7200 7078 7071 7195 7075 gf180mcu_fd_sc_mcu9t5v0__oai31_1
* cell instance $9861 m0 *1 849.52,715.68
X$9861 7195 7071 gf180mcu_fd_sc_mcu9t5v0__filltie
* cell instance $9862 m0 *1 849.52,725.76
X$9862 7558 7316 gf180mcu_fd_sc_mcu9t5v0__filltie
* cell instance $9863 m0 *1 839.44,705.6
X$9863 3806 6426 6944 6945 6909 6943 6946 gf180mcu_fd_sc_mcu9t5v0__oai31_1
* cell instance $9864 r0 *1 858.48,705.6
X$9864 7069 7073 4027 7071 6943 7077 gf180mcu_fd_sc_mcu9t5v0__mux2_1
* cell instance $9865 m0 *1 834.96,705.6
X$9865 3351 6911 6909 6943 6944 gf180mcu_fd_sc_mcu9t5v0__nor2_1
* cell instance $9866 m0 *1 960.96,725.76
X$9866 6948 7316 7558 7206 gf180mcu_fd_sc_mcu9t5v0__clkinv_1
* cell instance $9867 m0 *1 924.56,735.84
X$9867 7790 4769 7671 7814 7679 gf180mcu_fd_sc_mcu9t5v0__nand2_1
* cell instance $9868 r0 *1 920.64,735.84
X$9868 7073 7790 5057 7919 7814 7922 gf180mcu_fd_sc_mcu9t5v0__mux2_1
* cell instance $9869 m0 *1 960.96,735.84
X$9869 7791 6261 6042 7671 7814 7792 gf180mcu_fd_sc_mcu9t5v0__and3_1
* cell instance $9870 m0 *1 906.64,745.92
X$9870 6428 7921 7788 7919 7948 gf180mcu_fd_sc_mcu9t5v0__dffq_2
* cell instance $9871 m0 *1 898.24,715.68
X$9871 4529 6953 7071 7195 7200 gf180mcu_fd_sc_mcu9t5v0__nor2_1
* cell instance $9872 r0 *1 946.96,695.52
X$9872 6919 6916 7205 6909 6805 6553 gf180mcu_fd_sc_mcu9t5v0__aoi21_1
* cell instance $9873 m0 *1 946.4,715.68
X$9873 6956 6669 7203 6957 7071 7195 7204 gf180mcu_fd_sc_mcu9t5v0__oai22_1
* cell instance $9874 m0 *1 958.16,715.68
X$9874 7206 6261 6042 7071 7195 7450 gf180mcu_fd_sc_mcu9t5v0__and3_1
* cell instance $9875 m0 *1 924,705.6
X$9875 6253 6956 5057 6909 6943 6955 gf180mcu_fd_sc_mcu9t5v0__mux2_1
* cell instance $9876 m0 *1 929.04,715.68
X$9876 7197 7202 3340 7071 7195 7201 gf180mcu_fd_sc_mcu9t5v0__mux2_1
* cell instance $9877 r0 *1 959.84,695.52
X$9877 6919 6916 6917 6909 6805 6809 gf180mcu_fd_sc_mcu9t5v0__aoi21_1
* cell instance $9878 r0 *1 946.4,715.68
X$9878 6919 6916 7680 7316 7195 7203 gf180mcu_fd_sc_mcu9t5v0__aoi21_1
* cell instance $9879 r0 *1 924,715.68
X$9879 7080 7201 7197 7316 7195 gf180mcu_fd_sc_mcu9t5v0__dffq_2
* cell instance $9880 r0 *1 916.16,705.6
X$9880 7080 6954 6953 7071 6943 gf180mcu_fd_sc_mcu9t5v0__dffq_2
* cell instance $9881 m0 *1 916.72,705.6
X$9881 6953 6955 4911 6909 6943 6954 gf180mcu_fd_sc_mcu9t5v0__mux2_1
* cell instance $9882 m0 *1 901.6,756
X$9882 8550 8207 4029 8078 8204 8206 gf180mcu_fd_sc_mcu9t5v0__mux2_1
* cell instance $9883 m0 *1 929.04,745.92
X$9883 7080 7923 8083 7919 7948 gf180mcu_fd_sc_mcu9t5v0__dffq_2
* cell instance $9884 m0 *1 922.88,756
X$9884 4030 8079 8078 8204 8089 gf180mcu_fd_sc_mcu9t5v0__nand2_1
* cell instance $9885 r0 *1 933.52,745.92
X$9885 8090 4030 8089 8078 7948 7924 gf180mcu_fd_sc_mcu9t5v0__oai21_1
* cell instance $9886 m0 *1 941.92,705.6
X$9886 6668 6557 7685 6669 6909 6943 6957 gf180mcu_fd_sc_mcu9t5v0__oai31_1
* cell instance $9887 m0 *1 951.44,745.92
X$9887 6919 6916 7955 7919 7948 7953 gf180mcu_fd_sc_mcu9t5v0__aoi21_1
* cell instance $9888 m0 *1 944.72,735.84
X$9888 7449 6557 7685 6669 7671 7814 7819 gf180mcu_fd_sc_mcu9t5v0__oai31_1
* cell instance $9889 m0 *1 904.96,725.76
X$9889 7789 7447 4029 7316 7558 7560 gf180mcu_fd_sc_mcu9t5v0__mux2_1
* cell instance $9890 r0 *1 946.96,735.84
X$9890 7790 6669 7953 7819 7919 7814 7954 gf180mcu_fd_sc_mcu9t5v0__oai22_1
* cell instance $9891 m0 *1 956.48,725.76
X$9891 6399 7204 7450 7316 7558 7324 gf180mcu_fd_sc_mcu9t5v0__aoi21_1
* cell instance $9892 m0 *1 959.84,745.92
X$9892 6399 7954 7792 7919 7948 7956 gf180mcu_fd_sc_mcu9t5v0__aoi21_1
* cell instance $9893 r0 *1 913.36,735.84
X$9893 7788 7922 7818 7919 7814 7921 gf180mcu_fd_sc_mcu9t5v0__mux2_1
* cell instance $9894 r0 *1 940.8,725.76
X$9894 7069 7671 7558 7449 gf180mcu_fd_sc_mcu9t5v0__clkinv_1
* cell instance $9895 r0 *1 933.52,735.84
X$9895 8083 7924 3340 7919 7814 7923 gf180mcu_fd_sc_mcu9t5v0__mux2_1
* cell instance $9896 m0 *1 958.72,735.84
X$9896 7445 7671 7814 7791 gf180mcu_fd_sc_mcu9t5v0__clkinv_1
* cell instance $9897 m0 *1 919.52,756
X$9897 8089 8208 8078 8204 8207 gf180mcu_fd_sc_mcu9t5v0__nand2_1
* cell instance $9898 m0 *1 926.8,725.76
X$9898 4030 7073 7316 7558 7448 gf180mcu_fd_sc_mcu9t5v0__nand2_1
* cell instance $9899 m0 *1 931.84,725.76
X$9899 7449 4030 7448 7316 7558 7202 gf180mcu_fd_sc_mcu9t5v0__oai21_1
* cell instance $9900 r0 *1 924.56,725.76
X$9900 7448 7679 7671 7558 7447 gf180mcu_fd_sc_mcu9t5v0__nand2_1
* cell instance $9901 r0 *1 898.24,725.76
X$9901 6428 7560 7789 7671 7558 gf180mcu_fd_sc_mcu9t5v0__dffq_2
* cell instance $9902 m0 *1 944.16,756
X$9902 7951 8078 8204 8090 gf180mcu_fd_sc_mcu9t5v0__clkinv_1
* cell instance $9903 m0 *1 894.88,655.2
X$9903 4529 6037 5665 5794 5765 gf180mcu_fd_sc_mcu9t5v0__nor2_1
* cell instance $9904 m0 *1 899.92,624.96
X$9904 4271 4767 4802 4550 4766 4764 4903 5056 4938
+ gf180mcu_fd_sc_mcu9t5v0__mux4_1
* cell instance $9905 m0 *1 888.16,675.36
X$9905 5540 6037 6036 5896 2987 3459 6144 6292 6259
+ gf180mcu_fd_sc_mcu9t5v0__mux4_1
* cell instance $9906 r0 *1 885.92,665.28
X$9906 5540 6037 6036 5896 4766 4764 6144 6034 6035
+ gf180mcu_fd_sc_mcu9t5v0__mux4_1
* cell instance $9907 m0 *1 855.68,624.96
X$9907 4516 4937 4935 4936 2987 3459 4903 5056 4934
+ gf180mcu_fd_sc_mcu9t5v0__mux4_1
* cell instance $9908 m0 *1 846.72,624.96
X$9908 3806 4934 4903 5056 4796 gf180mcu_fd_sc_mcu9t5v0__nand2_1
* cell instance $9909 r0 *1 891.52,614.88
X$9909 4938 3804 4908 4903 4794 4909 gf180mcu_fd_sc_mcu9t5v0__mux2_1
* cell instance $9910 m0 *1 897.68,614.88
X$9910 4802 4765 4949 4550 4667 4794 4548 gf180mcu_fd_sc_mcu9t5v0__aoi22_1
* cell instance $9911 m0 *1 897.68,594.72
X$9911 4271 4254 4252 3099 4150 4266 4372 gf180mcu_fd_sc_mcu9t5v0__aoi22_1
* cell instance $9912 r0 *1 897.68,594.72
X$9912 3448 4258 4154 4550 4389 4266 4371 gf180mcu_fd_sc_mcu9t5v0__aoi22_1
* cell instance $9913 m0 *1 849.52,624.96
X$9913 5056 4903 gf180mcu_fd_sc_mcu9t5v0__filltie
* cell instance $9914 m0 *1 877.52,624.96
X$9914 4516 4937 4935 4936 4766 4764 4903 5056 4801
+ gf180mcu_fd_sc_mcu9t5v0__mux4_1
* cell instance $9915 m0 *1 918.4,624.96
X$9915 2776 4910 4937 4903 5056 gf180mcu_fd_sc_mcu9t5v0__dffq_2
* cell instance $9916 m0 *1 939.68,624.96
X$9916 2776 4912 4767 4903 5056 gf180mcu_fd_sc_mcu9t5v0__dffq_2
* cell instance $9917 r0 *1 893.2,564.48
X$9917 2985 2878 3336 3448 3564 3679 3558 3444 3565
+ gf180mcu_fd_sc_mcu9t5v0__mux4_1
* cell instance $9918 m0 *1 885.36,574.56
X$9918 3099 3561 2982 3563 3564 3679 3558 3781 3680
+ gf180mcu_fd_sc_mcu9t5v0__mux4_1
* cell instance $9919 r0 *1 892.08,574.56
X$9919 3565 3680 4764 3796 3781 3804 gf180mcu_fd_sc_mcu9t5v0__mux2_1
* cell instance $9920 r0 *1 913.92,655.2
X$9920 6037 5898 4911 5920 5794 5924 gf180mcu_fd_sc_mcu9t5v0__mux2_1
* cell instance $9921 m0 *1 908.88,685.44
X$9921 6428 6394 6256 6392 6425 gf180mcu_fd_sc_mcu9t5v0__dffq_2
* cell instance $9922 m0 *1 929.6,675.36
X$9922 7080 6152 6036 6144 6292 gf180mcu_fd_sc_mcu9t5v0__dffq_2
* cell instance $9923 m0 *1 959.28,685.44
X$9923 5896 6392 6425 6396 gf180mcu_fd_sc_mcu9t5v0__clkinv_1
* cell instance $9924 m0 *1 943.04,655.2
X$9924 4374 5667 5767 5665 5794 5768 gf180mcu_fd_sc_mcu9t5v0__and3_1
* cell instance $9925 m0 *1 903.84,645.12
X$9925 5540 5417 4029 5390 5411 5416 gf180mcu_fd_sc_mcu9t5v0__mux2_1
* cell instance $9926 m0 *1 906.08,665.28
X$9926 6428 5924 6037 5920 6034 gf180mcu_fd_sc_mcu9t5v0__dffq_2
* cell instance $9927 r0 *1 940.8,645.12
X$9927 5418 5419 4802 5665 5411 gf180mcu_fd_sc_mcu9t5v0__dffq_2
* cell instance $9928 r0 *1 924,645.12
X$9928 5296 4030 5665 5411 5543 gf180mcu_fd_sc_mcu9t5v0__nand2_1
* cell instance $9929 m0 *1 942.48,645.12
X$9929 4802 5420 5545 5390 5411 5419 gf180mcu_fd_sc_mcu9t5v0__mux2_1
* cell instance $9930 m0 *1 958.72,675.36
X$9930 5925 6261 6042 6144 6292 6260 gf180mcu_fd_sc_mcu9t5v0__and3_1
* cell instance $9931 r0 *1 926.8,645.12
X$9931 5544 4030 5543 5665 5411 5395 gf180mcu_fd_sc_mcu9t5v0__oai21_1
* cell instance $9932 r0 *1 921.76,635.04
X$9932 5414 5395 3340 5390 5297 5394 gf180mcu_fd_sc_mcu9t5v0__mux2_1
* cell instance $9933 r0 *1 921.2,645.12
X$9933 5543 5542 5665 5411 5417 gf180mcu_fd_sc_mcu9t5v0__nand2_1
* cell instance $9934 r0 *1 947.52,624.96
X$9934 3229 4770 5057 5183 5056 4913 gf180mcu_fd_sc_mcu9t5v0__mux2_1
* cell instance $9935 m0 *1 948.64,655.2
X$9935 5766 5768 5769 5421 5665 5794 5420 gf180mcu_fd_sc_mcu9t5v0__oai31_1
* cell instance $9936 r0 *1 898.8,624.96
X$9936 4908 5183 5056 4556 gf180mcu_fd_sc_mcu9t5v0__buf_8
* cell instance $9937 m0 *1 915.6,645.12
X$9937 2776 5394 5414 5390 5411 gf180mcu_fd_sc_mcu9t5v0__dffq_2
* cell instance $9938 m0 *1 949.76,645.12
X$9938 4770 5766 5390 5411 5421 gf180mcu_fd_sc_mcu9t5v0__nand2_1
* cell instance $9939 m0 *1 935.2,665.28
X$9939 5899 5766 5920 6034 6021 gf180mcu_fd_sc_mcu9t5v0__nand2_1
* cell instance $9940 r0 *1 932.4,665.28
X$9940 5766 6038 6039 6021 6144 6034 6040 gf180mcu_fd_sc_mcu9t5v0__oai31_1
* cell instance $9941 r0 *1 898.24,645.12
X$9941 3559 5416 5540 5665 5411 gf180mcu_fd_sc_mcu9t5v0__dffq_2
* cell instance $9942 m0 *1 958.72,665.28
X$9942 4550 5920 6034 5925 gf180mcu_fd_sc_mcu9t5v0__clkinv_1
* cell instance $9943 m0 *1 922.88,665.28
X$9943 5296 5899 5057 5920 6034 5898 gf180mcu_fd_sc_mcu9t5v0__mux2_1
* cell instance $9944 r0 *1 945.28,665.28
X$9944 5667 5767 5296 6144 6034 6039 gf180mcu_fd_sc_mcu9t5v0__aoi21_1
* cell instance $9945 r0 *1 948.08,655.2
X$9945 5667 5767 3229 5920 5794 5769 gf180mcu_fd_sc_mcu9t5v0__aoi21_1
* cell instance $9946 m0 *1 954.24,675.36
X$9946 6399 6555 6260 6144 6292 6041 gf180mcu_fd_sc_mcu9t5v0__aoi21_1
* cell instance $9947 r0 *1 938,665.28
X$9947 6036 6040 5545 6144 6034 6152 gf180mcu_fd_sc_mcu9t5v0__mux2_1
* cell instance $9948 r0 *1 915.6,675.36
X$9948 6256 6395 3340 6392 6292 6394 gf180mcu_fd_sc_mcu9t5v0__mux2_1
* cell instance $9949 m0 *1 938.56,665.28
X$9949 5544 5667 5767 5920 6034 6038 gf180mcu_fd_sc_mcu9t5v0__and3_1
* cell instance $9950 r0 *1 923.44,655.2
X$9950 5899 4769 5920 5794 5542 gf180mcu_fd_sc_mcu9t5v0__nand2_1
* cell instance $9951 m0 *1 900.48,685.44
X$9951 6808 6430 4029 6392 6425 6429 gf180mcu_fd_sc_mcu9t5v0__mux2_1
* cell instance $9952 r0 *1 860.72,665.28
X$9952 6146 6253 4027 6144 6034 6150 gf180mcu_fd_sc_mcu9t5v0__mux2_1
* cell instance $9953 r0 *1 858.48,675.36
X$9953 6147 6150 4156 6392 6292 6258 gf180mcu_fd_sc_mcu9t5v0__mux2_1
* cell instance $9954 m0 *1 849.52,655.2
X$9954 5794 5665 gf180mcu_fd_sc_mcu9t5v0__filltie
* cell instance $9955 m0 *1 837.2,665.28
X$9955 6019 5413 3351 5920 6034 6148 gf180mcu_fd_sc_mcu9t5v0__mux2_1
* cell instance $9956 m0 *1 883.68,685.44
X$9956 6146 6253 3335 6392 6425 6427 gf180mcu_fd_sc_mcu9t5v0__mux2_1
* cell instance $9957 m0 *1 853.44,655.2
X$9957 5795 5666 4932 5922 3564 3679 5665 5794 5539
+ gf180mcu_fd_sc_mcu9t5v0__mux4_1
* cell instance $9958 m0 *1 887.6,655.2
X$9958 4497 5541 5765 5764 5665 5794 5895 gf180mcu_fd_sc_mcu9t5v0__oai31_1
* cell instance $9959 m0 *1 840.56,685.44
X$9959 3459 6393 6392 6425 6426 gf180mcu_fd_sc_mcu9t5v0__nor2_1
* cell instance $9960 m0 *1 854.56,675.36
X$9960 3559 6258 6147 6144 6292 gf180mcu_fd_sc_mcu9t5v0__dffq_2
* cell instance $9961 r0 *1 845.04,665.28
X$9961 3806 6148 4952 6144 6034 6149 gf180mcu_fd_sc_mcu9t5v0__oai21_1
* cell instance $9962 m0 *1 874.72,645.12
X$9962 3559 5276 5393 5390 5411 gf180mcu_fd_sc_mcu9t5v0__dffq_2
* cell instance $9963 m0 *1 887.04,665.28
X$9963 6036 4765 4949 5896 5920 6034 5764 gf180mcu_fd_sc_mcu9t5v0__aoi22_1
* cell instance $9964 r0 *1 888.72,645.12
X$9964 2891 5540 5665 5411 5541 gf180mcu_fd_sc_mcu9t5v0__nor2_1
* cell instance $9965 m0 *1 855.12,645.12
X$9965 5410 5273 5414 5393 3564 3679 5390 5411 5415
+ gf180mcu_fd_sc_mcu9t5v0__mux4_1
* cell instance $9966 m0 *1 849.52,645.12
X$9966 5411 5390 gf180mcu_fd_sc_mcu9t5v0__filltie
* cell instance $9967 r0 *1 834.4,675.36
X$9967 6256 6147 6018 6293 2987 3106 6392 6292 6393
+ gf180mcu_fd_sc_mcu9t5v0__mux4_1
* cell instance $9968 r0 *1 831.04,655.2
X$9968 4932 5922 5795 5666 2987 3106 5920 5794 6019
+ gf180mcu_fd_sc_mcu9t5v0__mux4_1
* cell instance $9969 r0 *1 875.84,655.2
X$9969 5393 4258 4154 5896 4545 5920 5794 5897 gf180mcu_fd_sc_mcu9t5v0__aoi221_1
* cell instance $9970 m0 *1 832.16,645.12
X$9970 5414 5393 5410 5273 2987 3106 5390 5411 5413
+ gf180mcu_fd_sc_mcu9t5v0__mux4_1
* cell instance $9971 r0 *1 859.04,645.12
X$9971 5415 5539 4764 5665 5411 5538 gf180mcu_fd_sc_mcu9t5v0__mux2_1
* cell instance $9972 r0 *1 843.36,635.04
X$9972 5414 5393 2891 5390 5297 5392 gf180mcu_fd_sc_mcu9t5v0__mux2_1
* cell instance $9973 r0 *1 881.44,635.04
X$9973 5275 5296 4027 5390 5297 5277 gf180mcu_fd_sc_mcu9t5v0__mux2_1
* cell instance $9974 m0 *1 873.6,665.28
X$9974 5540 4254 4252 5795 5920 6034 6020 gf180mcu_fd_sc_mcu9t5v0__aoi22_1
* cell instance $9975 r0 *1 865.2,624.96
X$9975 2891 4516 5183 5056 4799 gf180mcu_fd_sc_mcu9t5v0__nor2_1
* cell instance $9976 m0 *1 878.64,665.28
X$9976 4545 5897 6020 5920 6034 5923 gf180mcu_fd_sc_mcu9t5v0__oai21_1
* cell instance $9977 r0 *1 832.72,635.04
X$9977 5275 5296 2986 5390 5297 4933 gf180mcu_fd_sc_mcu9t5v0__mux2_1
* cell instance $9978 m0 *1 849.52,665.28
X$9978 6034 5920 gf180mcu_fd_sc_mcu9t5v0__filltie
* cell instance $9979 m0 *1 849.52,685.44
X$9979 6425 6392 gf180mcu_fd_sc_mcu9t5v0__filltie
* cell instance $9980 m0 *1 834.4,655.2
X$9980 4932 2786 4949 5922 5392 2983 5665 5794 5763
+ gf180mcu_fd_sc_mcu9t5v0__aoi222_1
* cell instance $9981 r0 *1 857.36,624.96
X$9981 4935 4765 4949 4936 5183 5056 4798 gf180mcu_fd_sc_mcu9t5v0__aoi22_1
* cell instance $9982 m0 *1 879.2,635.04
X$9982 5393 5277 4156 5183 5297 5276 gf180mcu_fd_sc_mcu9t5v0__mux2_1
* cell instance $9983 m0 *1 849.52,635.04
X$9983 5297 5183 gf180mcu_fd_sc_mcu9t5v0__filltie
* cell instance $9984 r0 *1 878.64,665.28
X$9984 6035 5538 4908 6144 6034 6151 gf180mcu_fd_sc_mcu9t5v0__mux2_1
* cell instance $9985 m0 *1 849.52,675.36
X$9985 6292 6144 gf180mcu_fd_sc_mcu9t5v0__filltie
* cell instance $9986 r0 *1 839.44,574.56
X$9986 3678 3799 3801 3800 3564 3679 3796 3781 3802
+ gf180mcu_fd_sc_mcu9t5v0__mux4_1
* cell instance $9987 r0 *1 841.68,564.48
X$9987 3559 3560 3561 3558 3444 gf180mcu_fd_sc_mcu9t5v0__dffq_2
* cell instance $9988 r0 *1 859.04,614.88
X$9988 4497 4799 4800 4798 4903 4794 4929 gf180mcu_fd_sc_mcu9t5v0__oai31_1
* cell instance $9989 r0 *1 851.76,594.72
X$9989 3559 4269 3800 4389 4266 gf180mcu_fd_sc_mcu9t5v0__dffq_2
* cell instance $9990 r0 *1 864.64,614.88
X$9990 4529 4937 4903 4794 4800 gf180mcu_fd_sc_mcu9t5v0__nor2_1
* cell instance $9991 m0 *1 849.52,614.88
X$9991 4794 4667 gf180mcu_fd_sc_mcu9t5v0__filltie
* cell instance $9992 r0 *1 833.28,584.64
X$9992 3801 3800 2891 4150 3907 4248 gf180mcu_fd_sc_mcu9t5v0__mux2_1
* cell instance $9993 r0 *1 887.04,584.64
X$9993 3230 3229 4027 4150 3907 4025 gf180mcu_fd_sc_mcu9t5v0__mux2_1
* cell instance $9994 m0 *1 849.52,584.64
X$9994 3907 3796 gf180mcu_fd_sc_mcu9t5v0__filltie
* cell instance $9995 r0 *1 888.72,554.4
X$9995 3336 3448 2891 3334 3227 3101 gf180mcu_fd_sc_mcu9t5v0__mux2_1
* cell instance $9996 m0 *1 851.76,564.48
X$9996 3229 3230 2264 3334 3444 3447 gf180mcu_fd_sc_mcu9t5v0__mux2_1
* cell instance $9997 m0 *1 870.8,574.56
X$9997 4246 4247 3335 3558 3781 3783 gf180mcu_fd_sc_mcu9t5v0__mux2_1
* cell instance $9998 m0 *1 849.52,564.48
X$9998 3444 3334 gf180mcu_fd_sc_mcu9t5v0__filltie
* cell instance $9999 m0 *1 850.64,574.56
X$9999 3447 3561 4024 3558 3781 3560 gf180mcu_fd_sc_mcu9t5v0__mux2_1
* cell instance $10000 r0 *1 861.28,574.56
X$10000 2776 3803 3911 3796 3781 gf180mcu_fd_sc_mcu9t5v0__dffq_2
* cell instance $10001 r0 *1 869.68,564.48
X$10001 2982 3563 3099 3561 2987 3106 3558 3444 3562
+ gf180mcu_fd_sc_mcu9t5v0__mux4_1
* cell instance $10002 m0 *1 849.52,574.56
X$10002 3781 3558 gf180mcu_fd_sc_mcu9t5v0__filltie
* cell instance $10003 m0 *1 866.88,584.64
X$10003 3783 3911 2134 3796 3907 3803 gf180mcu_fd_sc_mcu9t5v0__mux2_1
* cell instance $10004 m0 *1 878.08,574.56
X$10004 3351 3562 3558 3781 3784 gf180mcu_fd_sc_mcu9t5v0__nor2_1
* cell instance $10005 m0 *1 880.88,594.72
X$10005 2776 4270 3448 4150 4266 gf180mcu_fd_sc_mcu9t5v0__dffq_2
* cell instance $10006 r0 *1 894.88,594.72
X$10006 4372 4371 4389 4266 4391 gf180mcu_fd_sc_mcu9t5v0__nand2_1
* cell instance $10007 r0 *1 876.4,614.88
X$10007 4801 4763 4908 4903 4794 4907 gf180mcu_fd_sc_mcu9t5v0__mux2_1
* cell instance $10008 r0 *1 885.36,594.72
X$10008 3448 4025 4156 4389 4266 4270 gf180mcu_fd_sc_mcu9t5v0__mux2_1
* cell instance $10009 r0 *1 867.44,604.8
X$10009 3800 4258 4154 4936 4545 4667 4512 4546
+ gf180mcu_fd_sc_mcu9t5v0__aoi221_1
* cell instance $10010 r0 *1 869.12,554.4
X$10010 3230 3229 3335 3334 3227 3100 gf180mcu_fd_sc_mcu9t5v0__mux2_1
* cell instance $10011 m0 *1 836.64,584.64
X$10011 3459 3909 3796 3907 3910 gf180mcu_fd_sc_mcu9t5v0__nor2_1
* cell instance $10012 m0 *1 871.92,604.8
X$10012 4516 4254 4252 3911 4389 4512 4517 gf180mcu_fd_sc_mcu9t5v0__aoi22_1
* cell instance $10013 r0 *1 873.6,604.8
X$10013 4545 4546 4517 4667 4512 4669 gf180mcu_fd_sc_mcu9t5v0__oai21_1
* cell instance $10014 m0 *1 849.52,604.8
X$10014 4512 4389 gf180mcu_fd_sc_mcu9t5v0__filltie
* cell instance $10015 m0 *1 851.2,594.72
X$10015 3800 4249 4156 4150 4266 4269 gf180mcu_fd_sc_mcu9t5v0__mux2_1
* cell instance $10016 r0 *1 838.32,604.8
X$10016 3911 4022 4486 4488 3564 3679 4667 4512 4544
+ gf180mcu_fd_sc_mcu9t5v0__mux4_1
* cell instance $10017 m0 *1 858.48,594.72
X$10017 4246 4247 4027 4150 4266 4249 gf180mcu_fd_sc_mcu9t5v0__mux2_1
* cell instance $10018 r0 *1 882,604.8
X$10018 3103 4547 3217 4930 4667 4512 4664 gf180mcu_fd_sc_mcu9t5v0__aoi211_1
* cell instance $10019 m0 *1 837.2,614.88
X$10019 3351 4515 4667 4794 4795 gf180mcu_fd_sc_mcu9t5v0__nor2_1
* cell instance $10020 m0 *1 842.24,614.88
X$10020 3802 4544 4764 4667 4794 4763 gf180mcu_fd_sc_mcu9t5v0__mux2_1
* cell instance $10021 m0 *1 849.52,594.72
X$10021 4266 4150 gf180mcu_fd_sc_mcu9t5v0__filltie
* cell instance $10022 r0 *1 840,614.88
X$10022 3806 3910 4795 4796 4903 4794 4797 gf180mcu_fd_sc_mcu9t5v0__oai31_1
* cell instance $10023 r0 *1 922.88,574.56
X$10023 3808 3796 3781 2776 gf180mcu_fd_sc_mcu9t5v0__clkbuf_8
* cell instance $10024 r0 *1 959.28,584.64
X$10024 2244 2140 4027 4150 3907 4153 gf180mcu_fd_sc_mcu9t5v0__mux2_1
* cell instance $10025 m0 *1 944.72,614.88
X$10025 4770 4769 4667 4794 4768 gf180mcu_fd_sc_mcu9t5v0__nand2_1
* cell instance $10026 r0 *1 934.08,554.4
X$10026 3336 3339 3340 3334 3227 3338 gf180mcu_fd_sc_mcu9t5v0__mux2_1
* cell instance $10027 m0 *1 913.92,584.64
X$10027 3806 3912 3796 3907 3805 gf180mcu_fd_sc_mcu9t5v0__nand2_1
* cell instance $10028 r0 *1 913.92,574.56
X$10028 3806 3785 3784 3805 3796 3781 3807 gf180mcu_fd_sc_mcu9t5v0__oai31_1
* cell instance $10029 r0 *1 937.44,594.72
X$10029 4373 4768 4389 4266 4250 gf180mcu_fd_sc_mcu9t5v0__nand2_1
* cell instance $10030 r0 *1 932.4,614.88
X$10030 4247 4939 5057 4903 4794 4803 gf180mcu_fd_sc_mcu9t5v0__mux2_1
* cell instance $10031 r0 *1 924,614.88
X$10031 4937 4803 4911 4903 4794 4910 gf180mcu_fd_sc_mcu9t5v0__mux2_1
* cell instance $10032 m0 *1 938,604.8
X$10032 4247 4030 4389 4512 4519 gf180mcu_fd_sc_mcu9t5v0__nand2_1
* cell instance $10033 r0 *1 909.44,604.8
X$10033 4271 4767 4802 4550 2987 3459 4667 4512 3912
+ gf180mcu_fd_sc_mcu9t5v0__mux4_1
* cell instance $10034 r0 *1 910.56,564.48
X$10034 3564 3558 3444 3337 gf180mcu_fd_sc_mcu9t5v0__buf_8
* cell instance $10035 m0 *1 940.8,604.8
X$10035 4489 4030 4519 4389 4512 4393 gf180mcu_fd_sc_mcu9t5v0__oai21_1
* cell instance $10036 m0 *1 946.96,604.8
X$10036 3230 4389 4512 4374 gf180mcu_fd_sc_mcu9t5v0__clkinv_1
* cell instance $10037 m0 *1 922.88,584.64
X$10037 2776 3796 3907 33553 gf180mcu_fd_sc_mcu9t5v0__inv_2
* cell instance $10038 r0 *1 946.4,574.56
X$10038 3806 3451 3566 3913 3796 3781 3810 gf180mcu_fd_sc_mcu9t5v0__oai31_1
* cell instance $10039 m0 *1 928.48,564.48
X$10039 2776 3338 3336 3334 3444 gf180mcu_fd_sc_mcu9t5v0__dffq_2
* cell instance $10040 m0 *1 946.4,564.48
X$10040 3459 3450 3334 3444 3451 gf180mcu_fd_sc_mcu9t5v0__nor2_1
* cell instance $10041 m0 *1 957.04,594.72
X$10041 3341 4153 4156 4150 4266 3915 gf180mcu_fd_sc_mcu9t5v0__mux2_1
* cell instance $10042 r0 *1 949.76,564.48
X$10042 3351 2988 3558 3444 3566 gf180mcu_fd_sc_mcu9t5v0__nor2_1
* cell instance $10043 m0 *1 915.04,594.72
X$10043 4271 4250 4029 4150 4266 4026 gf180mcu_fd_sc_mcu9t5v0__mux2_1
* cell instance $10044 r0 *1 944.72,594.72
X$10044 3229 4030 4389 4266 4373 gf180mcu_fd_sc_mcu9t5v0__nand2_1
* cell instance $10045 r0 *1 937.44,574.56
X$10045 3801 4393 3340 3796 3781 3809 gf180mcu_fd_sc_mcu9t5v0__mux2_1
* cell instance $10046 r0 *1 958.16,554.4
X$10046 3342 3341 2891 3334 3227 3105 gf180mcu_fd_sc_mcu9t5v0__mux2_1
* cell instance $10047 m0 *1 911.12,564.48
X$10047 3336 3448 2985 2878 2987 3106 3334 3444 3449
+ gf180mcu_fd_sc_mcu9t5v0__mux4_1
* cell instance $10048 m0 *1 901.04,604.8
X$10048 2891 4271 4389 4512 4518 gf180mcu_fd_sc_mcu9t5v0__nor2_1
* cell instance $10049 r0 *1 906.08,604.8
X$10049 4529 4767 4667 4512 4549 gf180mcu_fd_sc_mcu9t5v0__nor2_1
* cell instance $10050 r0 *1 898.24,604.8
X$10050 4497 4518 4549 4548 4667 4512 4547 gf180mcu_fd_sc_mcu9t5v0__oai31_1
* cell instance $10051 r0 *1 940.24,594.72
X$10051 4374 4030 4373 4389 4266 3339 gf180mcu_fd_sc_mcu9t5v0__oai21_1
* cell instance $10052 m0 *1 938,614.88
X$10052 4939 4769 4667 4794 4552 gf180mcu_fd_sc_mcu9t5v0__nand2_1
* cell instance $10053 r0 *1 938,604.8
X$10053 4519 4552 4667 4512 4551 gf180mcu_fd_sc_mcu9t5v0__nand2_1
* cell instance $10054 m0 *1 949.76,584.64
X$10054 3806 3914 3796 3907 3913 gf180mcu_fd_sc_mcu9t5v0__nand2_1
* cell instance $10055 r0 *1 928.48,594.72
X$10055 4516 4551 4029 4389 4266 4392 gf180mcu_fd_sc_mcu9t5v0__mux2_1
* cell instance $10056 r0 *1 944.72,614.88
X$10056 4767 4913 4911 4903 4794 4912 gf180mcu_fd_sc_mcu9t5v0__mux2_1
* cell instance $10057 m0 *1 916.72,574.56
X$10057 3459 3449 3558 3781 3785 gf180mcu_fd_sc_mcu9t5v0__nor2_1
* cell instance $10058 m0 *1 920.64,604.8
X$10058 2776 4392 4516 4389 4512 gf180mcu_fd_sc_mcu9t5v0__dffq_2
* cell instance $10059 m0 *1 961.52,604.8
X$10059 3341 4258 4154 4554 4389 4512 4520 gf180mcu_fd_sc_mcu9t5v0__aoi22_1
* cell instance $10060 m0 *1 929.04,584.64
X$10060 2776 3809 3801 3796 3907 gf180mcu_fd_sc_mcu9t5v0__dffq_2
* cell instance $10061 r0 *1 908.88,584.64
X$10061 2776 4026 4271 4150 3907 gf180mcu_fd_sc_mcu9t5v0__dffq_2
* cell instance $10062 m0 *1 969.36,624.96
X$10062 4529 4272 4903 5056 4942 gf180mcu_fd_sc_mcu9t5v0__nand2_1
* cell instance $10063 m0 *1 1015.84,665.28
X$10063 6022 5920 6034 2564 gf180mcu_fd_sc_mcu9t5v0__clkbuf_20
* cell instance $10064 m0 *1 1000.16,624.96
X$10064 3103 4943 3222 4930 4903 5056 4927 gf180mcu_fd_sc_mcu9t5v0__aoi211_1
* cell instance $10065 m0 *1 986.72,624.96
X$10065 2140 4914 5057 4903 5056 5058 gf180mcu_fd_sc_mcu9t5v0__mux2_1
* cell instance $10066 m0 *1 1007.44,624.96
X$10066 2891 4376 4903 5056 5059 gf180mcu_fd_sc_mcu9t5v0__nor2_1
* cell instance $10067 r0 *1 1019.76,584.64
X$10067 5418 4035 3108 4150 3907 gf180mcu_fd_sc_mcu9t5v0__dffq_2
* cell instance $10068 m0 *1 1041.04,624.96
X$10068 4944 2786 4949 4490 4945 2983 4903 5056 4559
+ gf180mcu_fd_sc_mcu9t5v0__aoi222_1
* cell instance $10069 m0 *1 1052.8,624.96
X$10069 4274 5060 4944 4490 4766 3233 4903 5056 4948
+ gf180mcu_fd_sc_mcu9t5v0__mux4_1
* cell instance $10070 m0 *1 1089.2,624.96
X$10070 5056 4903 gf180mcu_fd_sc_mcu9t5v0__filltie
* cell instance $10071 m0 *1 1050,624.96
X$10071 4946 4769 4903 5056 4947 gf180mcu_fd_sc_mcu9t5v0__nand2_1
* cell instance $10072 r0 *1 1085.28,624.96
X$10072 2245 5167 5060 5183 5056 gf180mcu_fd_sc_mcu9t5v0__dffq_2
* cell instance $10073 r0 *1 1041.6,665.28
X$10073 6154 6261 6042 6144 6034 6155 gf180mcu_fd_sc_mcu9t5v0__and3_1
* cell instance $10074 r0 *1 1042.72,675.36
X$10074 6399 6401 6155 6392 6292 6269 gf180mcu_fd_sc_mcu9t5v0__aoi21_1
* cell instance $10075 r0 *1 1084.72,655.2
X$10075 6268 5797 5775 5920 5794 gf180mcu_fd_sc_mcu9t5v0__dffq_2
* cell instance $10076 m0 *1 1089.2,665.28
X$10076 6034 5920 gf180mcu_fd_sc_mcu9t5v0__filltie
* cell instance $10077 m0 *1 1093.68,665.28
X$10077 6286 6025 2788 5920 6034 5776 gf180mcu_fd_sc_mcu9t5v0__mux2_1
* cell instance $10078 m0 *1 1071.84,645.12
X$10078 4378 5279 4911 5390 5411 5298 gf180mcu_fd_sc_mcu9t5v0__mux2_1
* cell instance $10079 m0 *1 1072.4,655.2
X$10079 5667 5767 2256 5665 5794 5774 gf180mcu_fd_sc_mcu9t5v0__aoi21_1
* cell instance $10080 r0 *1 1039.36,665.28
X$10080 4490 6144 6034 6154 gf180mcu_fd_sc_mcu9t5v0__clkinv_1
* cell instance $10081 m0 *1 1090.32,655.2
X$10081 5776 5775 2573 5665 5794 5797 gf180mcu_fd_sc_mcu9t5v0__mux2_2
* cell instance $10082 m0 *1 1039.36,675.36
X$10082 6268 6269 4490 6144 6292 gf180mcu_fd_sc_mcu9t5v0__dffq_2
* cell instance $10083 m0 *1 1043.28,655.2
X$10083 4037 5667 5767 5665 5794 5555 gf180mcu_fd_sc_mcu9t5v0__and3_1
* cell instance $10084 m0 *1 1038.8,645.12
X$10084 5418 5425 4944 5390 5411 gf180mcu_fd_sc_mcu9t5v0__dffq_2
* cell instance $10085 r0 *1 1066.24,665.28
X$10085 5280 5766 6144 6034 6024 gf180mcu_fd_sc_mcu9t5v0__nand2_1
* cell instance $10086 m0 *1 1048.88,655.2
X$10086 5667 5767 2252 5665 5794 5556 gf180mcu_fd_sc_mcu9t5v0__aoi21_1
* cell instance $10087 m0 *1 1040.48,655.2
X$10087 4946 5766 5665 5794 5553 gf180mcu_fd_sc_mcu9t5v0__nand2_1
* cell instance $10088 m0 *1 1089.2,655.2
X$10088 5794 5665 gf180mcu_fd_sc_mcu9t5v0__filltie
* cell instance $10089 m0 *1 1062.32,655.2
X$10089 4804 5796 5545 5665 5794 5670 gf180mcu_fd_sc_mcu9t5v0__mux2_1
* cell instance $10090 r0 *1 1089.76,675.36
X$10090 6025 6286 2141 6392 6292 6271 gf180mcu_fd_sc_mcu9t5v0__mux2_1
* cell instance $10091 m0 *1 1078,675.36
X$10091 6271 6295 2363 6144 6292 6270 gf180mcu_fd_sc_mcu9t5v0__mux2_1
* cell instance $10092 m0 *1 1053.92,685.44
X$10092 6268 6434 4377 6392 6425 gf180mcu_fd_sc_mcu9t5v0__dffq_2
* cell instance $10093 r0 *1 1062.32,675.36
X$10093 4377 6392 6292 6402 gf180mcu_fd_sc_mcu9t5v0__clkinv_1
* cell instance $10094 r0 *1 1056.72,675.36
X$10094 6402 6261 6042 6392 6292 6562 gf180mcu_fd_sc_mcu9t5v0__and3_1
* cell instance $10095 m0 *1 1075.2,635.04
X$10095 2256 5280 5057 5183 5297 5279 gf180mcu_fd_sc_mcu9t5v0__mux2_1
* cell instance $10096 r0 *1 1064,624.96
X$10096 4948 3344 4556 5183 5056 5166 gf180mcu_fd_sc_mcu9t5v0__mux2_1
* cell instance $10097 r0 *1 1061.2,655.2
X$10097 6268 5670 4804 5920 5794 gf180mcu_fd_sc_mcu9t5v0__dffq_2
* cell instance $10098 r0 *1 1072.96,675.36
X$10098 6268 6270 6295 6392 6292 gf180mcu_fd_sc_mcu9t5v0__dffq_2
* cell instance $10099 m0 *1 1093.68,635.04
X$10099 2252 4946 5057 5183 5297 5281 gf180mcu_fd_sc_mcu9t5v0__mux2_1
* cell instance $10100 m0 *1 1063.44,665.28
X$10100 5926 5667 5767 5920 6034 6023 gf180mcu_fd_sc_mcu9t5v0__and3_1
* cell instance $10101 r0 *1 1090.32,635.04
X$10101 5060 5281 4911 5390 5297 5167 gf180mcu_fd_sc_mcu9t5v0__mux2_1
* cell instance $10102 m0 *1 1089.2,635.04
X$10102 5297 5183 gf180mcu_fd_sc_mcu9t5v0__filltie
* cell instance $10103 m0 *1 1069.04,665.28
X$10103 5766 6023 5774 6024 5920 6034 5796 gf180mcu_fd_sc_mcu9t5v0__oai31_1
* cell instance $10104 m0 *1 1089.2,675.36
X$10104 6292 6144 gf180mcu_fd_sc_mcu9t5v0__filltie
* cell instance $10105 m0 *1 1089.2,685.44
X$10105 6425 6392 gf180mcu_fd_sc_mcu9t5v0__filltie
* cell instance $10106 r0 *1 1066.8,635.04
X$10106 5418 5298 4378 5390 5297 gf180mcu_fd_sc_mcu9t5v0__dffq_2
* cell instance $10107 m0 *1 1089.2,645.12
X$10107 5411 5390 gf180mcu_fd_sc_mcu9t5v0__filltie
* cell instance $10108 r0 *1 1046.08,624.96
X$10108 4274 5060 2891 5183 5056 4945 gf180mcu_fd_sc_mcu9t5v0__mux2_1
* cell instance $10109 r0 *1 1040.48,645.12
X$10109 5766 5555 5556 5553 5665 5411 5554 gf180mcu_fd_sc_mcu9t5v0__oai31_1
* cell instance $10110 r0 *1 1046.64,645.12
X$10110 4944 5554 5545 5665 5411 5425 gf180mcu_fd_sc_mcu9t5v0__mux2_1
* cell instance $10111 m0 *1 1022.56,675.36
X$10111 6266 6261 6042 6144 6292 6267 gf180mcu_fd_sc_mcu9t5v0__and3_1
* cell instance $10112 r0 *1 1003.52,655.2
X$10112 5418 5920 5794 33555 gf180mcu_fd_sc_mcu9t5v0__inv_2
* cell instance $10113 r0 *1 969.36,655.2
X$10113 5794 5920 gf180mcu_fd_sc_mcu9t5v0__filltie
* cell instance $10114 m0 *1 977.2,675.36
X$10114 4936 6144 6292 6262 gf180mcu_fd_sc_mcu9t5v0__clkinv_1
* cell instance $10115 m0 *1 1023.12,685.44
X$10115 6399 6433 6267 6392 6425 6400 gf180mcu_fd_sc_mcu9t5v0__aoi21_1
* cell instance $10116 m0 *1 972.72,655.2
X$10116 5766 5772 5900 5770 5665 5794 5546 gf180mcu_fd_sc_mcu9t5v0__oai31_1
* cell instance $10117 r0 *1 1021.44,655.2
X$10117 4773 5667 5767 5920 5794 5551 gf180mcu_fd_sc_mcu9t5v0__and3_1
* cell instance $10118 r0 *1 970.48,645.12
X$10118 4935 5546 5545 5665 5411 5422 gf180mcu_fd_sc_mcu9t5v0__mux2_1
* cell instance $10119 r0 *1 972.16,655.2
X$10119 5667 6916 4247 5920 5794 5900 gf180mcu_fd_sc_mcu9t5v0__aoi21_1
* cell instance $10120 m0 *1 1004.64,685.44
X$10120 6432 6392 6425 2264 gf180mcu_fd_sc_mcu9t5v0__buf_8
* cell instance $10121 m0 *1 1000.16,675.36
X$10121 4554 6144 6292 6264 gf180mcu_fd_sc_mcu9t5v0__clkinv_1
* cell instance $10122 m0 *1 979.44,675.36
X$10122 5418 6263 4936 6144 6292 gf180mcu_fd_sc_mcu9t5v0__dffq_2
* cell instance $10123 r0 *1 992.32,655.2
X$10123 4032 5667 5767 5920 5794 5423 gf180mcu_fd_sc_mcu9t5v0__and3_1
* cell instance $10124 r0 *1 969.36,645.12
X$10124 5411 5665 gf180mcu_fd_sc_mcu9t5v0__filltie
* cell instance $10125 r0 *1 1006.88,655.2
X$10125 5901 5920 5794 5418 gf180mcu_fd_sc_mcu9t5v0__clkbuf_8
* cell instance $10126 r0 *1 969.36,675.36
X$10126 6292 6392 gf180mcu_fd_sc_mcu9t5v0__filltie
* cell instance $10127 r0 *1 969.36,624.96
X$10127 5056 5183 gf180mcu_fd_sc_mcu9t5v0__filltie
* cell instance $10128 r0 *1 999.6,675.36
X$10128 5418 6294 4554 6392 6292 gf180mcu_fd_sc_mcu9t5v0__dffq_2
* cell instance $10129 r0 *1 1018.64,675.36
X$10129 5418 6400 4251 6392 6292 gf180mcu_fd_sc_mcu9t5v0__dffq_2
* cell instance $10130 m0 *1 1002.4,675.36
X$10130 6264 6261 6042 6144 6292 6265 gf180mcu_fd_sc_mcu9t5v0__and3_1
* cell instance $10131 r0 *1 1023.68,645.12
X$10131 5766 5551 5552 5550 5665 5411 5549 gf180mcu_fd_sc_mcu9t5v0__oai31_1
* cell instance $10132 r0 *1 1016.4,645.12
X$10132 4771 5549 5545 5665 5411 5548 gf180mcu_fd_sc_mcu9t5v0__mux2_1
* cell instance $10133 r0 *1 1009.12,624.96
X$10133 4529 4772 5183 5056 5163 gf180mcu_fd_sc_mcu9t5v0__nor2_1
* cell instance $10134 m0 *1 1000.16,685.44
X$10134 6399 6431 6265 6392 6425 6294 gf180mcu_fd_sc_mcu9t5v0__aoi21_1
* cell instance $10135 m0 *1 1002.96,635.04
X$10135 4771 2786 4949 4251 5183 5297 5162 gf180mcu_fd_sc_mcu9t5v0__aoi22_1
* cell instance $10136 r0 *1 1003.52,624.96
X$10136 4497 5059 5163 5162 5183 5056 4943 gf180mcu_fd_sc_mcu9t5v0__oai31_1
* cell instance $10137 m0 *1 982.8,635.04
X$10137 4555 5058 4911 5183 5297 5161 gf180mcu_fd_sc_mcu9t5v0__mux2_1
* cell instance $10138 r0 *1 977.76,624.96
X$10138 5418 5161 4555 5183 5056 gf180mcu_fd_sc_mcu9t5v0__dffq_2
* cell instance $10139 r0 *1 1021.44,635.04
X$10139 4772 5165 4911 5390 5297 5278 gf180mcu_fd_sc_mcu9t5v0__mux2_1
* cell instance $10140 r0 *1 1022.56,624.96
X$10140 5164 4769 5183 5056 4774 gf180mcu_fd_sc_mcu9t5v0__nand2_1
* cell instance $10141 m0 *1 997.36,645.12
X$10141 5766 5423 5424 5668 5390 5411 5547 gf180mcu_fd_sc_mcu9t5v0__oai31_1
* cell instance $10142 r0 *1 988.96,645.12
X$10142 5418 5669 4553 5665 5411 gf180mcu_fd_sc_mcu9t5v0__dffq_2
* cell instance $10143 m0 *1 1016.4,635.04
X$10143 5418 5278 4772 5183 5297 gf180mcu_fd_sc_mcu9t5v0__dffq_2
* cell instance $10144 r0 *1 1025.36,624.96
X$10144 2366 5164 5057 5183 5056 5165 gf180mcu_fd_sc_mcu9t5v0__mux2_1
* cell instance $10145 m0 *1 967.12,655.2
X$10145 4489 5667 5767 5665 5794 5772 gf180mcu_fd_sc_mcu9t5v0__and3_1
* cell instance $10146 r0 *1 969.36,665.28
X$10146 6034 6144 gf180mcu_fd_sc_mcu9t5v0__filltie
* cell instance $10147 r0 *1 969.36,635.04
X$10147 5297 5390 gf180mcu_fd_sc_mcu9t5v0__filltie
* cell instance $10148 r0 *1 1027.04,655.2
X$10148 5667 5767 2366 5920 5794 5552 gf180mcu_fd_sc_mcu9t5v0__aoi21_1
* cell instance $10149 r0 *1 970.48,624.96
X$10149 2891 4555 5183 5056 4941 gf180mcu_fd_sc_mcu9t5v0__nand2_1
* cell instance $10150 m0 *1 1020.32,675.36
X$10150 4251 6144 6292 6266 gf180mcu_fd_sc_mcu9t5v0__clkinv_1
* cell instance $10151 m0 *1 990.64,655.2
X$10151 4553 5547 5545 5665 5794 5669 gf180mcu_fd_sc_mcu9t5v0__mux2_1
* cell instance $10152 m0 *1 997.92,655.2
X$10152 5667 5767 2140 5665 5794 5424 gf180mcu_fd_sc_mcu9t5v0__aoi21_1
* cell instance $10153 m0 *1 1013.04,655.2
X$10153 5418 5548 4771 5665 5794 gf180mcu_fd_sc_mcu9t5v0__dffq_2
* cell instance $10154 m0 *1 987.84,655.2
X$10154 4914 5766 5665 5794 5668 gf180mcu_fd_sc_mcu9t5v0__nand2_1
* cell instance $10155 m0 *1 1029.84,655.2
X$10155 5164 5766 5665 5794 5550 gf180mcu_fd_sc_mcu9t5v0__nand2_1
* cell instance $10156 r0 *1 982.8,665.28
X$10156 6262 6261 6042 6144 6034 6153 gf180mcu_fd_sc_mcu9t5v0__and3_1
* cell instance $10157 r0 *1 983.36,675.36
X$10157 6399 6398 6153 6392 6292 6263 gf180mcu_fd_sc_mcu9t5v0__aoi21_1
* cell instance $10158 m0 *1 1017.52,574.56
X$10158 2245 3568 3235 3558 3781 gf180mcu_fd_sc_mcu9t5v0__dffq_2
* cell instance $10159 m0 *1 1001.28,574.56
X$10159 3351 3567 3558 3781 3681 gf180mcu_fd_sc_mcu9t5v0__nor2_1
* cell instance $10160 m0 *1 1001.28,584.64
X$10160 3806 3916 3796 3907 3812 gf180mcu_fd_sc_mcu9t5v0__nand2_1
* cell instance $10161 r0 *1 1000.16,574.56
X$10161 3806 3786 3681 3812 3796 3781 3811 gf180mcu_fd_sc_mcu9t5v0__oai31_1
* cell instance $10162 m0 *1 1014.16,574.56
X$10162 3459 3234 3558 3781 3786 gf180mcu_fd_sc_mcu9t5v0__nor2_1
* cell instance $10163 r0 *1 969.36,574.56
X$10163 3781 3796 gf180mcu_fd_sc_mcu9t5v0__filltie
* cell instance $10164 r0 *1 1024.8,614.88
X$10164 2366 4030 4903 4794 4775 gf180mcu_fd_sc_mcu9t5v0__nand2_1
* cell instance $10165 m0 *1 1022.56,614.88
X$10165 4773 4030 4775 4667 4794 3569 gf180mcu_fd_sc_mcu9t5v0__oai21_1
* cell instance $10166 m0 *1 1008.56,594.72
X$10166 3108 4258 4154 4251 4545 4150 4266 4273
+ gf180mcu_fd_sc_mcu9t5v0__aoi221_1
* cell instance $10167 m0 *1 1003.52,594.72
X$10167 4376 4254 4252 2674 4150 4266 4034 gf180mcu_fd_sc_mcu9t5v0__aoi22_1
* cell instance $10168 r0 *1 985.6,594.72
X$10168 4031 4375 4389 4266 4028 gf180mcu_fd_sc_mcu9t5v0__nand2_1
* cell instance $10169 m0 *1 1023.68,604.8
X$10169 4376 4523 4029 4389 4512 4522 gf180mcu_fd_sc_mcu9t5v0__mux2_1
* cell instance $10170 m0 *1 976.64,594.72
X$10170 2776 4155 4272 4150 4266 gf180mcu_fd_sc_mcu9t5v0__dffq_2
* cell instance $10171 m0 *1 1024.24,594.72
X$10171 3108 3917 4156 4150 4266 4035 gf180mcu_fd_sc_mcu9t5v0__mux2_1
* cell instance $10172 r0 *1 969.36,614.88
X$10172 4794 4903 gf180mcu_fd_sc_mcu9t5v0__filltie
* cell instance $10173 r0 *1 969.36,604.8
X$10173 4512 4667 gf180mcu_fd_sc_mcu9t5v0__filltie
* cell instance $10174 r0 *1 969.36,594.72
X$10174 4266 4389 gf180mcu_fd_sc_mcu9t5v0__filltie
* cell instance $10175 r0 *1 1018.64,604.8
X$10175 5418 4522 4376 4667 4512 gf180mcu_fd_sc_mcu9t5v0__dffq_2
* cell instance $10176 m0 *1 993.44,594.72
X$10176 2244 4150 4266 4032 gf180mcu_fd_sc_mcu9t5v0__clkinv_1
* cell instance $10177 r0 *1 988.4,594.72
X$10177 2140 4030 4389 4266 4031 gf180mcu_fd_sc_mcu9t5v0__nand2_1
* cell instance $10178 m0 *1 974.4,614.88
X$10178 4272 4555 4553 4554 4766 3233 4667 4794 4557
+ gf180mcu_fd_sc_mcu9t5v0__mux4_1
* cell instance $10179 r0 *1 970.48,554.4
X$10179 2783 2466 3342 3341 3337 3109 3334 3227 3232
+ gf180mcu_fd_sc_mcu9t5v0__mux4_1
* cell instance $10180 r0 *1 975.52,564.48
X$10180 2776 3452 3342 3558 3444 gf180mcu_fd_sc_mcu9t5v0__dffq_2
* cell instance $10181 m0 *1 1027.04,614.88
X$10181 4775 4774 4667 4794 4523 gf180mcu_fd_sc_mcu9t5v0__nand2_1
* cell instance $10182 r0 *1 969.36,584.64
X$10182 3907 4150 gf180mcu_fd_sc_mcu9t5v0__filltie
* cell instance $10183 r0 *1 972.72,604.8
X$10183 4557 3231 4556 4667 4512 5771 gf180mcu_fd_sc_mcu9t5v0__mux2_1
* cell instance $10184 m0 *1 998.48,614.88
X$10184 4376 4772 4771 4251 4766 3233 4667 4794 4558
+ gf180mcu_fd_sc_mcu9t5v0__mux4_1
* cell instance $10185 r0 *1 986.72,614.88
X$10185 4914 4769 4903 4794 4375 gf180mcu_fd_sc_mcu9t5v0__nand2_1
* cell instance $10186 r0 *1 996.24,564.48
X$10186 2784 3220 2674 2562 2987 3106 3558 3444 3567
+ gf180mcu_fd_sc_mcu9t5v0__mux4_1
* cell instance $10187 r0 *1 1022,564.48
X$10187 3235 3569 3340 3558 3444 3568 gf180mcu_fd_sc_mcu9t5v0__mux2_1
* cell instance $10188 r0 *1 989.52,584.64
X$10188 4032 4030 4031 4150 3907 3453 gf180mcu_fd_sc_mcu9t5v0__oai21_1
* cell instance $10189 m0 *1 1025.92,584.64
X$10189 2365 2366 4027 3796 3907 3917 gf180mcu_fd_sc_mcu9t5v0__mux2_1
* cell instance $10190 r0 *1 994.56,604.8
X$10190 4558 3454 4556 4667 4512 5773 gf180mcu_fd_sc_mcu9t5v0__mux2_1
* cell instance $10191 r0 *1 991.2,554.4
X$10191 2674 2562 2784 3220 3337 3109 3334 3227 3343
+ gf180mcu_fd_sc_mcu9t5v0__mux4_1
* cell instance $10192 r0 *1 969.36,554.4
X$10192 3227 3334 gf180mcu_fd_sc_mcu9t5v0__filltie
* cell instance $10193 r0 *1 999.04,594.72
X$10193 4376 4772 4771 4251 2987 3459 4389 4266 3916
+ gf180mcu_fd_sc_mcu9t5v0__mux4_1
* cell instance $10194 r0 *1 969.36,564.48
X$10194 3444 3558 gf180mcu_fd_sc_mcu9t5v0__filltie
* cell instance $10195 m0 *1 997.92,564.48
X$10195 3221 3343 3233 3334 3444 3454 gf180mcu_fd_sc_mcu9t5v0__mux2_1
* cell instance $10196 m0 *1 980.56,564.48
X$10196 3342 3453 3340 3334 3444 3452 gf180mcu_fd_sc_mcu9t5v0__mux2_1
* cell instance $10197 r0 *1 982.24,584.64
X$10197 4272 4028 4029 4150 3907 4155 gf180mcu_fd_sc_mcu9t5v0__mux2_1
* cell instance $10198 r0 *1 1007.44,584.64
X$10198 4545 4273 4034 4150 3907 4033 gf180mcu_fd_sc_mcu9t5v0__oai21_1
* cell instance $10199 r0 *1 1063.44,554.4
X$10199 3110 3236 3233 3334 3227 3344 gf180mcu_fd_sc_mcu9t5v0__mux2_1
* cell instance $10200 m0 *1 1055.04,594.72
X$10200 2245 4040 4274 4150 4266 gf180mcu_fd_sc_mcu9t5v0__dffq_2
* cell instance $10201 r0 *1 1084.16,584.64
X$10201 4041 4253 4150 3907 4042 gf180mcu_fd_sc_mcu9t5v0__nand2_1
* cell instance $10202 m0 *1 1043.28,594.72
X$10202 2370 4150 4266 4037 gf180mcu_fd_sc_mcu9t5v0__clkinv_1
* cell instance $10203 r0 *1 1039.92,554.4
X$10203 2677 2998 2884 2367 2987 3106 3334 3227 3570
+ gf180mcu_fd_sc_mcu9t5v0__mux4_1
* cell instance $10204 m0 *1 1039.92,574.56
X$10204 3806 3684 3571 3683 3558 3781 3682 gf180mcu_fd_sc_mcu9t5v0__oai31_1
* cell instance $10205 m0 *1 1038.8,604.8
X$10205 4395 4524 4389 4512 4525 gf180mcu_fd_sc_mcu9t5v0__nand2_1
* cell instance $10206 r0 *1 1047.2,584.64
X$10206 4037 4030 4038 4150 3907 4036 gf180mcu_fd_sc_mcu9t5v0__oai21_1
* cell instance $10207 m0 *1 1094.24,574.56
X$10207 3459 3458 3558 3781 3788 gf180mcu_fd_sc_mcu9t5v0__nor2_1
* cell instance $10208 m0 *1 1081.36,574.56
X$10208 3351 3685 3558 3781 3789 gf180mcu_fd_sc_mcu9t5v0__nor2_1
* cell instance $10209 r0 *1 1041.6,574.56
X$10209 3806 3813 3796 3781 3683 gf180mcu_fd_sc_mcu9t5v0__nand2_1
* cell instance $10210 r0 *1 1068.48,564.48
X$10210 3345 3456 3233 3558 3444 3572 gf180mcu_fd_sc_mcu9t5v0__mux2_1
* cell instance $10211 r0 *1 1041.04,564.48
X$10211 3351 3570 3558 3444 3571 gf180mcu_fd_sc_mcu9t5v0__nor2_1
* cell instance $10212 r0 *1 1053.36,594.72
X$10212 4038 4947 4389 4266 4039 gf180mcu_fd_sc_mcu9t5v0__nand2_1
* cell instance $10213 m0 *1 1089.2,574.56
X$10213 3781 3558 gf180mcu_fd_sc_mcu9t5v0__filltie
* cell instance $10214 r0 *1 1047.76,574.56
X$10214 2245 3787 3000 3796 3781 gf180mcu_fd_sc_mcu9t5v0__dffq_2
* cell instance $10215 m0 *1 1051.12,574.56
X$10215 3000 4036 3340 3558 3781 3787 gf180mcu_fd_sc_mcu9t5v0__mux2_1
* cell instance $10216 m0 *1 1089.2,564.48
X$10216 3444 3334 gf180mcu_fd_sc_mcu9t5v0__filltie
* cell instance $10217 m0 *1 1072.96,584.64
X$10217 3806 3918 3796 3907 3815 gf180mcu_fd_sc_mcu9t5v0__nand2_1
* cell instance $10218 r0 *1 1045.52,594.72
X$10218 4274 4254 4252 2884 4389 4266 4395 gf180mcu_fd_sc_mcu9t5v0__aoi22_1
* cell instance $10219 m0 *1 1046.08,604.8
X$10219 3001 4258 4275 4490 4389 4512 4524 gf180mcu_fd_sc_mcu9t5v0__aoi22_1
* cell instance $10220 r0 *1 1073.52,604.8
X$10220 4804 2786 4949 4377 4667 4512 4560 gf180mcu_fd_sc_mcu9t5v0__aoi22_1
* cell instance $10221 r0 *1 1075.2,574.56
X$10221 3806 3788 3789 3815 3796 3781 3814 gf180mcu_fd_sc_mcu9t5v0__oai31_1
* cell instance $10222 m0 *1 1089.2,584.64
X$10222 3907 3796 gf180mcu_fd_sc_mcu9t5v0__filltie
* cell instance $10223 m0 *1 1084.16,594.72
X$10223 4379 4254 4252 2132 4150 4266 4041 gf180mcu_fd_sc_mcu9t5v0__aoi22_1
* cell instance $10224 m0 *1 1079.12,594.72
X$10224 3237 4258 4275 4377 4150 4266 4253 gf180mcu_fd_sc_mcu9t5v0__aoi22_1
* cell instance $10225 r0 *1 1084.72,554.4
X$10225 2145 2569 3346 3237 3337 3109 3334 3227 3345
+ gf180mcu_fd_sc_mcu9t5v0__mux4_1
* cell instance $10226 r0 *1 1044.96,604.8
X$10226 3103 4559 4667 4512 4526 gf180mcu_fd_sc_mcu9t5v0__nand2_1
* cell instance $10227 m0 *1 1041.6,604.8
X$10227 3103 2887 4526 4389 4512 4485 gf180mcu_fd_sc_mcu9t5v0__oai21_1
* cell instance $10228 m0 *1 1050,594.72
X$10228 2252 4030 4150 4266 4038 gf180mcu_fd_sc_mcu9t5v0__nand2_1
* cell instance $10229 r0 *1 1065.68,614.88
X$10229 4379 4378 4804 4377 4766 3233 4903 4794 4777
+ gf180mcu_fd_sc_mcu9t5v0__mux4_1
* cell instance $10230 m0 *1 1089.2,594.72
X$10230 4266 4150 gf180mcu_fd_sc_mcu9t5v0__filltie
* cell instance $10231 m0 *1 1067.36,564.48
X$10231 2132 2371 3113 3455 3337 3109 3334 3444 3456
+ gf180mcu_fd_sc_mcu9t5v0__mux4_1
* cell instance $10232 m0 *1 1089.2,614.88
X$10232 4794 4667 gf180mcu_fd_sc_mcu9t5v0__filltie
* cell instance $10233 m0 *1 1064.56,614.88
X$10233 4777 3572 4556 4667 4794 4776 gf180mcu_fd_sc_mcu9t5v0__mux2_1
* cell instance $10234 r0 *1 1067.92,594.72
X$10234 4379 4378 4804 4377 2987 3459 4389 4266 3918
+ gf180mcu_fd_sc_mcu9t5v0__mux4_1
* cell instance $10235 m0 *1 1089.2,604.8
X$10235 4512 4389 gf180mcu_fd_sc_mcu9t5v0__filltie
* cell instance $10236 m0 *1 1090.32,614.88
X$10236 2891 4379 4667 4794 4779 gf180mcu_fd_sc_mcu9t5v0__nor2_1
* cell instance $10237 r0 *1 1040.48,614.88
X$10237 4274 5060 4944 4490 2987 3459 4903 4794 3813
+ gf180mcu_fd_sc_mcu9t5v0__mux4_1
* cell instance $10238 m0 *1 1083.04,614.88
X$10238 4497 4779 4778 4560 4667 4794 4561 gf180mcu_fd_sc_mcu9t5v0__oai31_1
* cell instance $10239 r0 *1 1057.84,584.64
X$10239 4274 4039 4029 4150 3907 4040 gf180mcu_fd_sc_mcu9t5v0__mux2_1
* cell instance $10240 r0 *1 1080.8,564.48
X$10240 3113 3455 2132 2371 2987 3106 3558 3444 3685
+ gf180mcu_fd_sc_mcu9t5v0__mux4_1
* cell instance $10241 r0 *1 1086.4,604.8
X$10241 3103 4561 3457 4930 4667 4512 4542 gf180mcu_fd_sc_mcu9t5v0__aoi211_1
* cell instance $10242 r0 *1 1044.4,564.48
X$10242 3459 2996 3558 3444 3684 gf180mcu_fd_sc_mcu9t5v0__nor2_1
* cell instance $10243 m0 *1 1079.68,614.88
X$10243 4529 4378 4667 4794 4778 gf180mcu_fd_sc_mcu9t5v0__nor2_1
* cell instance $10244 m45 *1 0,580
X$10244 4896 33813 33811 33809 33807 33805 33803 33801 33799 33797 33795 33793
+ 33791 33789 33787 33785 33783 33781 33779 33777 33775 33773 33771 33769 33767
+ 33765 33763 33761 33759 33757 33755 33753 33751 33749 33747 33745 33743 33741
+ 33739 33737 33735 33733 33731 33729 33727 33725 33723 33721 33719 33717 33715
+ 33713 33711 33709 33707 33705 33703 33701 33699 33697 33695 33693 33691 33689
+ 33687 33685 33683 33681 33679 33677 33675 33673 33671 3906 33669 33667 33665
+ 33663 33661 33659 3906 4790 gf180mcu_fd_io__in_c
* cell instance $10245 r0 *1 490,826.56
X$10245 10078 10188 gf180mcu_fd_sc_mcu9t5v0__filltie
* cell instance $10246 r0 *1 370.16,826.56
X$10246 10078 10188 gf180mcu_fd_sc_mcu9t5v0__endcap
* cell instance $10247 m45 *1 0,805
X$10247 10445 33813 33811 33809 33807 33805 33803 33801 33799 33797 33795 33793
+ 33791 33789 33787 33785 33783 33781 33779 33777 33775 33773 33771 33769 33767
+ 33765 33763 33761 33759 33757 33755 33753 33751 33749 33747 33745 33743 33741
+ 33739 33737 33735 33733 33731 33729 33727 33725 33723 33721 33719 33717 33715
+ 33713 33711 33709 33707 33705 33703 33701 33699 33697 33695 33693 33691 33689
+ 33687 33685 33683 33681 33679 33677 33675 33673 33671 9686 33669 33667 33665
+ 33663 33661 33659 9686 10446 gf180mcu_fd_io__in_c
* cell instance $10248 m45 *1 0,955
X$10248 14403 33813 33811 33809 33807 33805 33803 33801 33799 33797 33795 33793
+ 33791 33789 33787 33785 33783 33781 33779 33777 33775 33773 33771 33769 33767
+ 33765 33763 33761 33759 33757 33755 33753 33751 33749 33747 33745 33743 33741
+ 33739 33737 33735 33733 33731 33729 33727 33725 33723 33721 33719 33717 33715
+ 33713 33711 33709 33707 33705 33703 33701 33699 33697 33695 33693 33691 33689
+ 33687 33685 33683 33681 33679 33677 33675 33673 33671 13313 33669 33667 33665
+ 33663 33661 33659 13313 14438 gf180mcu_fd_io__in_c
* cell instance $10249 m45 *1 0,1030
X$10249 16637 33813 33811 33809 33807 33805 33803 33801 33799 33797 33795 33793
+ 33791 33789 33787 33785 33783 33781 33779 33777 33775 33773 33771 33769 33767
+ 33765 33763 33761 33759 33757 33755 33753 33751 33749 33747 33745 33743 33741
+ 33739 33737 33735 33733 33731 33729 33727 33725 33723 33721 33719 33717 33715
+ 33713 33711 33709 33707 33705 33703 33701 33699 33697 33695 33693 33691 33689
+ 33687 33685 33683 33681 33679 33677 33675 33673 33671 15387 33669 33667 33665
+ 33663 33661 33659 15387 16906 gf180mcu_fd_io__in_c
* cell instance $10250 m45 *1 0,880
X$10250 12376 33813 33811 33809 33807 33805 33803 33801 33799 33797 33795 33793
+ 33791 33789 33787 33785 33783 33781 33779 33777 33775 33773 33771 33769 33767
+ 33765 33763 33761 33759 33757 33755 33753 33751 33749 33747 33745 33743 33741
+ 33739 33737 33735 33733 33731 33729 33727 33725 33723 33721 33719 33717 33715
+ 33713 33711 33709 33707 33705 33703 33701 33699 33697 33695 33693 33691 33689
+ 33687 33685 33683 33681 33679 33677 33675 33673 33671 11459 33669 33667 33665
+ 33663 33661 33659 11459 12377 gf180mcu_fd_io__in_c
* cell instance $10251 m45 *1 0,655
X$10251 6660 33813 33811 33809 33807 33805 33803 33801 33799 33797 33795 33793
+ 33791 33789 33787 33785 33783 33781 33779 33777 33775 33773 33771 33769 33767
+ 33765 33763 33761 33759 33757 33755 33753 33751 33749 33747 33745 33743 33741
+ 33739 33737 33735 33733 33731 33729 33727 33725 33723 33721 33719 33717 33715
+ 33713 33711 33709 33707 33705 33703 33701 33699 33697 33695 33693 33691 33689
+ 33687 33685 33683 33681 33679 33677 33675 33673 33671 5790 33669 33667 33665
+ 33663 33661 33659 5790 6768 gf180mcu_fd_io__in_c
* cell instance $10252 m45 *1 0,730
X$10252 8574 33813 33811 33809 33807 33805 33803 33801 33799 33797 33795 33793
+ 33791 33789 33787 33785 33783 33781 33779 33777 33775 33773 33771 33769 33767
+ 33765 33763 33761 33759 33757 33755 33753 33751 33749 33747 33745 33743 33741
+ 33739 33737 33735 33733 33731 33729 33727 33725 33723 33721 33719 33717 33715
+ 33713 33711 33709 33707 33705 33703 33701 33699 33697 33695 33693 33691 33689
+ 33687 33685 33683 33681 33679 33677 33675 33673 33671 7663 33669 33667 33665
+ 33663 33661 33659 7663 8575 gf180mcu_fd_io__in_c
* cell instance $10253 r0 *1 400.4,952.56
X$10253 13420 13428 13318 13314 gf180mcu_fd_sc_mcu9t5v0__buf_8
* cell instance $10254 r0 *1 400.4,876.96
X$10254 11322 11461 11294 11323 gf180mcu_fd_sc_mcu9t5v0__buf_8
* cell instance $10255 m0 *1 370.16,967.68
X$10255 13719 13586 gf180mcu_fd_sc_mcu9t5v0__endcap
* cell instance $10256 r0 *1 400.4,1028.16
X$10256 15563 15576 15402 15388 gf180mcu_fd_sc_mcu9t5v0__buf_8
* cell instance $10257 m0 *1 476.56,1068.48
X$10257 15996 16494 16638 11958 16506 16653 gf180mcu_fd_sc_mcu9t5v0__dffrnq_2
* cell instance $10258 r0 *1 470.96,1048.32
X$10258 15996 15894 16182 11958 16194 16008 gf180mcu_fd_sc_mcu9t5v0__dffrnq_2
* cell instance $10259 r0 *1 480.48,1068.48
X$10259 16910 16779 16784 16653 16494 gf180mcu_fd_sc_mcu9t5v0__nor2_1
* cell instance $10260 m0 *1 482.16,1078.56
X$10260 4924 16784 16956 15996 gf180mcu_fd_sc_mcu9t5v0__clkbuf_8
* cell instance $10261 m0 *1 475.44,1038.24
X$10261 15996 15680 15564 11958 15576 15737 gf180mcu_fd_sc_mcu9t5v0__dffrnq_2
* cell instance $10262 m0 *1 495.6,1038.24
X$10262 15998 15681 15566 15576 15737 14993 gf180mcu_fd_sc_mcu9t5v0__nor3_1
* cell instance $10263 m0 *1 500.08,1038.24
X$10263 14994 15564 15515 15576 15737 15681 gf180mcu_fd_sc_mcu9t5v0__and3_1
* cell instance $10264 m0 *1 524.16,1038.24
X$10264 15730 15390 15576 15737 15733 gf180mcu_fd_sc_mcu9t5v0__nand2_1
* cell instance $10265 m0 *1 527.52,1038.24
X$10265 15682 15391 14994 15564 15576 15737 15732
+ gf180mcu_fd_sc_mcu9t5v0__nand4_1
* cell instance $10266 r0 *1 491.12,1098.72
X$10266 18092 16130 17560 17709 17521 17559 gf180mcu_fd_sc_mcu9t5v0__oai21_1
* cell instance $10267 r0 *1 485.52,1068.48
X$10267 16638 16639 16130 16784 16653 16779 gf180mcu_fd_sc_mcu9t5v0__oai21_1
* cell instance $10268 r0 *1 490,1098.72
X$10268 17521 17709 gf180mcu_fd_sc_mcu9t5v0__filltie
* cell instance $10269 r0 *1 485.52,1078.56
X$10269 16911 16780 16639 17123 16956 17075 gf180mcu_fd_sc_mcu9t5v0__aoi21_1
* cell instance $10270 r0 *1 510.72,1098.72
X$10270 16130 17561 17709 17521 17701 gf180mcu_fd_sc_mcu9t5v0__nand2_1
* cell instance $10271 r0 *1 490,1048.32
X$10271 16008 16194 gf180mcu_fd_sc_mcu9t5v0__filltie
* cell instance $10272 m0 *1 525.28,1068.48
X$10272 16300 15895 16506 16653 16435 gf180mcu_fd_sc_mcu9t5v0__nand2_1
* cell instance $10273 r0 *1 490,1078.56
X$10273 16956 17123 gf180mcu_fd_sc_mcu9t5v0__filltie
* cell instance $10274 m0 *1 509.6,1078.56
X$10274 16130 16780 16784 16956 16945 gf180mcu_fd_sc_mcu9t5v0__nand2_1
* cell instance $10275 m0 *1 519.12,1058.4
X$10275 15565 15567 16194 16309 15999 gf180mcu_fd_sc_mcu9t5v0__nand2_1
* cell instance $10276 r0 *1 526.96,1058.4
X$10276 16495 16435 16506 16309 15567 gf180mcu_fd_sc_mcu9t5v0__nand2_1
* cell instance $10277 r0 *1 514.08,1078.56
X$10277 16912 16946 17123 16956 17076 gf180mcu_fd_sc_mcu9t5v0__nor2_1
* cell instance $10278 r0 *1 529.76,1058.4
X$10278 16300 12241 15895 16506 16309 17562 gf180mcu_fd_sc_mcu9t5v0__nand3_1
* cell instance $10279 m0 *1 493.92,1058.4
X$10279 15996 16184 15730 11958 16194 16309 gf180mcu_fd_sc_mcu9t5v0__dffrnq_2
* cell instance $10280 r0 *1 490,1088.64
X$10280 17289 17398 gf180mcu_fd_sc_mcu9t5v0__filltie
* cell instance $10281 m0 *1 512.96,1058.4
X$10281 15998 16185 16194 16309 16434 gf180mcu_fd_sc_mcu9t5v0__nor2_1
* cell instance $10282 r0 *1 490,1058.4
X$10282 16309 16506 gf180mcu_fd_sc_mcu9t5v0__filltie
* cell instance $10283 r0 *1 490,1068.48
X$10283 16653 16784 gf180mcu_fd_sc_mcu9t5v0__filltie
* cell instance $10284 m0 *1 502.88,1048.32
X$10284 15568 15850 15898 16008 16184 gf180mcu_fd_sc_mcu9t5v0__nor2_1
* cell instance $10285 m0 *1 500.64,1078.56
X$10285 16944 16784 16956 16911 gf180mcu_fd_sc_mcu9t5v0__clkinv_1
* cell instance $10286 r0 *1 491.12,1078.56
X$10286 15996 17075 16944 11958 17123 16956 gf180mcu_fd_sc_mcu9t5v0__dffrnq_2
* cell instance $10287 r0 *1 510.72,1078.56
X$10287 16945 17076 17123 16956 17116 gf180mcu_fd_sc_mcu9t5v0__nor2_1
* cell instance $10288 m0 *1 496.72,1078.56
X$10288 16638 16784 16956 17390 gf180mcu_fd_sc_mcu9t5v0__clkinv_1
* cell instance $10289 r0 *1 484.96,1088.64
X$10289 17826 16911 17280 17390 17398 17289 17279
+ gf180mcu_fd_sc_mcu9t5v0__aoi22_1
* cell instance $10290 m0 *1 525.84,1048.32
X$10290 15895 15999 15851 15998 15898 16008 16000
+ gf180mcu_fd_sc_mcu9t5v0__aoi211_1
* cell instance $10291 m0 *1 513.52,1078.56
X$10291 16912 16946 16784 16956 16780 gf180mcu_fd_sc_mcu9t5v0__nand2_1
* cell instance $10292 m0 *1 486.08,1088.64
X$10292 15565 16780 16911 17390 17123 17289 16910
+ gf180mcu_fd_sc_mcu9t5v0__aoi211_1
* cell instance $10293 r0 *1 491.12,1068.48
X$10293 16130 16780 16911 16784 16653 16639 gf180mcu_fd_sc_mcu9t5v0__aoi21_1
* cell instance $10294 r0 *1 524.72,1098.72
X$10294 15996 17563 17703 11958 17709 17521 gf180mcu_fd_sc_mcu9t5v0__dffrnq_2
* cell instance $10295 m0 *1 544.88,1088.64
X$10295 17228 17227 17229 17123 17289 17281 gf180mcu_fd_sc_mcu9t5v0__mux2_1
* cell instance $10296 r0 *1 533.12,1088.64
X$10296 15996 17281 17229 11958 17398 17289 gf180mcu_fd_sc_mcu9t5v0__dffrnq_2
* cell instance $10297 r0 *1 507.92,1058.4
X$10297 15996 16434 16300 11958 16506 16309 gf180mcu_fd_sc_mcu9t5v0__dffrnq_2
* cell instance $10298 r0 *1 490,1038.24
X$10298 15737 15898 gf180mcu_fd_sc_mcu9t5v0__filltie
* cell instance $10299 r0 *1 525.84,1038.24
X$10299 15733 15732 15898 15737 15895 gf180mcu_fd_sc_mcu9t5v0__nor2_1
* cell instance $10300 m0 *1 521.92,1058.4
X$10300 15895 15999 16300 16194 16309 16185 gf180mcu_fd_sc_mcu9t5v0__aoi21_1
* cell instance $10301 r0 *1 507.92,1038.24
X$10301 15730 15681 15898 15737 15568 gf180mcu_fd_sc_mcu9t5v0__and2_1
* cell instance $10302 r0 *1 529.2,1038.24
X$10302 15391 15568 15682 15898 15737 15851 gf180mcu_fd_sc_mcu9t5v0__aoi21_1
* cell instance $10303 r0 *1 521.92,1098.72
X$10303 17702 17562 17709 17521 17561 gf180mcu_fd_sc_mcu9t5v0__nand2_1
* cell instance $10304 m0 *1 509.04,1088.64
X$10304 15996 17116 16912 11958 17123 17289 gf180mcu_fd_sc_mcu9t5v0__dffrnq_2
* cell instance $10305 r0 *1 503.44,1038.24
X$10305 15730 15681 15565 15898 15737 15850 gf180mcu_fd_sc_mcu9t5v0__oai21_1
* cell instance $10306 r0 *1 518.56,1078.56
X$10306 16912 17115 17123 16956 17077 gf180mcu_fd_sc_mcu9t5v0__and2_1
* cell instance $10307 r0 *1 539.84,1058.4
X$10307 16497 16300 12241 16506 16309 16496 gf180mcu_fd_sc_mcu9t5v0__mux2_1
* cell instance $10308 r0 *1 526.4,1078.56
X$10308 17077 16946 17123 16956 16495 gf180mcu_fd_sc_mcu9t5v0__and2_1
* cell instance $10309 m0 *1 529.2,1098.72
X$10309 17703 15564 12241 17398 17521 17563 gf180mcu_fd_sc_mcu9t5v0__mux2_1
* cell instance $10310 m0 *1 531.44,1048.32
X$10310 15131 16000 15682 11958 15898 16008 gf180mcu_fd_sc_mcu9t5v0__dffrnq_2
* cell instance $10311 m0 *1 527.52,1078.56
X$10311 16495 16784 16956 12241 gf180mcu_fd_sc_mcu9t5v0__buf_8
* cell instance $10312 r0 *1 479.36,1088.64
X$10312 17280 17390 17398 17289 17226 gf180mcu_fd_sc_mcu9t5v0__nor2_1
* cell instance $10313 m0 *1 468.72,1088.64
X$10313 17224 17279 17226 17225 16908 17123 17289 16943
+ gf180mcu_fd_sc_mcu9t5v0__oai32_1
* cell instance $10314 m0 *1 463.68,1058.4
X$10314 16129 16131 16181 16194 16309 16183 gf180mcu_fd_sc_mcu9t5v0__nand3_1
* cell instance $10315 m0 *1 477.68,1078.56
X$10315 15996 16784 16956 gf180mcu_fd_sc_mcu9t5v0__clkinv_3
* cell instance $10316 m0 *1 468.72,1058.4
X$10316 16182 16194 16309 16183 15997 gf180mcu_fd_sc_mcu9t5v0__xor2_1
* cell instance $10317 m0 *1 450.8,1048.32
X$10317 15996 15893 16131 11958 15898 16008 gf180mcu_fd_sc_mcu9t5v0__dffrnq_2
* cell instance $10318 m0 *1 475.44,1048.32
X$10318 15998 15997 15898 16008 15894 gf180mcu_fd_sc_mcu9t5v0__nor2_1
* cell instance $10319 m0 *1 465.92,1088.64
X$10319 16908 17225 17123 17289 17114 gf180mcu_fd_sc_mcu9t5v0__nand2_1
* cell instance $10320 r0 *1 465.36,1058.4
X$10320 16129 16942 16131 16182 16506 16309 16493
+ gf180mcu_fd_sc_mcu9t5v0__nor4_1
* cell instance $10321 m0 *1 459.2,1078.56
X$10321 16908 16942 17224 16910 16784 16956 16181
+ gf180mcu_fd_sc_mcu9t5v0__and4_1
* cell instance $10322 r0 *1 456.4,1048.32
X$10322 16131 16128 16132 16194 16008 15893 gf180mcu_fd_sc_mcu9t5v0__aoi21_1
* cell instance $10323 m0 *1 456.4,1088.64
X$10323 17224 16910 17123 17289 16909 gf180mcu_fd_sc_mcu9t5v0__and2_1
* cell instance $10324 r0 *1 446.32,1048.32
X$10324 16129 16181 16130 16194 16008 16127 gf180mcu_fd_sc_mcu9t5v0__oai21_1
* cell instance $10325 r0 *1 442.96,1048.32
X$10325 16128 16127 16194 16008 16126 gf180mcu_fd_sc_mcu9t5v0__nor2_1
* cell instance $10326 r0 *1 456.96,1088.64
X$10326 17224 16910 16130 17398 17289 17512 gf180mcu_fd_sc_mcu9t5v0__oai21_1
* cell instance $10327 r0 *1 470.96,1078.56
X$10327 16943 17114 16493 17123 16956 17115 gf180mcu_fd_sc_mcu9t5v0__nand3_1
* cell instance $10328 r0 *1 450.8,1098.72
X$10328 15996 17511 17224 11958 17709 17521 gf180mcu_fd_sc_mcu9t5v0__dffrnq_2
* cell instance $10329 r0 *1 450.24,1068.48
X$10329 15996 16778 16942 11958 16784 16653 gf180mcu_fd_sc_mcu9t5v0__dffrnq_2
* cell instance $10330 r0 *1 420,1098.72
X$10330 17709 17521 17699 gf180mcu_fd_sc_mcu9t5v0__tiel
* cell instance $10331 m0 *1 453.6,1098.72
X$10331 16909 17512 17398 17521 17511 gf180mcu_fd_sc_mcu9t5v0__nor2_1
* cell instance $10332 m0 *1 445.2,1078.56
X$10332 16908 16909 16784 16956 16940 gf180mcu_fd_sc_mcu9t5v0__and2_1
* cell instance $10333 m0 *1 450.24,1078.56
X$10333 16942 16940 16130 16784 16956 16777 gf180mcu_fd_sc_mcu9t5v0__oai21_1
* cell instance $10334 r0 *1 446.88,1068.48
X$10334 16181 16777 16784 16653 16778 gf180mcu_fd_sc_mcu9t5v0__nor2_1
* cell instance $10335 r0 *1 448,1078.56
X$10335 16908 16909 16130 17123 16956 16907 gf180mcu_fd_sc_mcu9t5v0__oai21_1
* cell instance $10336 m0 *1 440.72,1078.56
X$10336 16940 16907 16784 16956 16939 gf180mcu_fd_sc_mcu9t5v0__nor2_1
* cell instance $10337 m0 *1 431.2,1058.4
X$10337 15996 16126 16129 11958 16194 16309 gf180mcu_fd_sc_mcu9t5v0__dffrnq_2
* cell instance $10338 r0 *1 428.96,1078.56
X$10338 15996 16939 16908 11958 17123 16956 gf180mcu_fd_sc_mcu9t5v0__dffrnq_2
* cell instance $10339 m0 *1 450.24,1058.4
X$10339 16129 16181 16194 16309 16128 gf180mcu_fd_sc_mcu9t5v0__and2_1
* cell instance $10340 r0 *1 451.92,1048.32
X$10340 16131 16128 16130 16194 16008 16132 gf180mcu_fd_sc_mcu9t5v0__oai21_1
* cell instance $10341 m0 *1 420,1028.16
X$10341 15271 15402 15387 gf180mcu_fd_sc_mcu9t5v0__tiel
* cell instance $10342 r0 *1 490,977.76
X$10342 14009 14126 gf180mcu_fd_sc_mcu9t5v0__filltie
* cell instance $10343 r0 *1 490,967.68
X$10343 13719 13832 gf180mcu_fd_sc_mcu9t5v0__filltie
* cell instance $10344 r0 *1 490,1008
X$10344 14857 14967 gf180mcu_fd_sc_mcu9t5v0__filltie
* cell instance $10345 r0 *1 490,1018.08
X$10345 15138 15271 gf180mcu_fd_sc_mcu9t5v0__filltie
* cell instance $10346 r0 *1 490,997.92
X$10346 14448 14708 gf180mcu_fd_sc_mcu9t5v0__filltie
* cell instance $10347 m0 *1 492.8,1018.08
X$10347 15996 14993 14994 11958 14967 15138 gf180mcu_fd_sc_mcu9t5v0__dffrnq_2
* cell instance $10348 r0 *1 490,1028.16
X$10348 15402 15576 gf180mcu_fd_sc_mcu9t5v0__filltie
* cell instance $10349 r0 *1 518,1028.16
X$10349 15390 15576 15402 15516 gf180mcu_fd_sc_mcu9t5v0__clkinv_1
* cell instance $10350 r0 *1 511.28,1028.16
X$10350 15565 15567 15516 15576 15402 15515 gf180mcu_fd_sc_mcu9t5v0__aoi21_1
* cell instance $10351 r0 *1 496.16,1028.16
X$10351 15564 15515 14994 15576 15402 15566 gf180mcu_fd_sc_mcu9t5v0__aoi21_1
* cell instance $10352 r0 *1 491.12,1028.16
X$10352 15564 15515 15565 15576 15402 15389 gf180mcu_fd_sc_mcu9t5v0__oai21_1
* cell instance $10353 r0 *1 485.52,1028.16
X$10353 15564 15515 15389 15576 15402 15680 gf180mcu_fd_sc_mcu9t5v0__aoi21_1
* cell instance $10354 r0 *1 506.8,1028.16
X$10354 15516 15567 15515 15576 15402 15132 gf180mcu_fd_sc_mcu9t5v0__aoi21_1
* cell instance $10355 r0 *1 490,987.84
X$10355 14304 14406 gf180mcu_fd_sc_mcu9t5v0__filltie
* cell instance $10356 r0 *1 507.92,1018.08
X$10356 15131 15132 15390 11958 15271 15138 gf180mcu_fd_sc_mcu9t5v0__dffrnq_2
* cell instance $10357 m0 *1 529.2,1028.16
X$10357 15391 15568 15565 15271 15402 15262 gf180mcu_fd_sc_mcu9t5v0__oai21_1
* cell instance $10358 m0 *1 524.72,1028.16
X$10358 15391 15568 15262 15271 15402 14995 gf180mcu_fd_sc_mcu9t5v0__aoi21_1
* cell instance $10359 m0 *1 532,1008
X$10359 15131 14699 14700 11958 14708 14857 gf180mcu_fd_sc_mcu9t5v0__dffrnq_2
* cell instance $10360 m0 *1 527.52,1018.08
X$10360 15131 14995 15391 11958 14967 15138 gf180mcu_fd_sc_mcu9t5v0__dffrnq_2
* cell instance $10361 r0 *1 533.68,997.92
X$10361 14700 14994 12241 14708 14448 14699 gf180mcu_fd_sc_mcu9t5v0__mux2_1
* cell instance $10362 r0 *1 370.16,977.76
X$10362 14009 14126 gf180mcu_fd_sc_mcu9t5v0__endcap
* cell instance $10363 m0 *1 370.16,987.84
X$10363 14304 14126 gf180mcu_fd_sc_mcu9t5v0__endcap
* cell instance $10364 m0 *1 370.16,977.76
X$10364 14009 13832 gf180mcu_fd_sc_mcu9t5v0__endcap
* cell instance $10365 m0 *1 370.16,1008
X$10365 14857 14708 gf180mcu_fd_sc_mcu9t5v0__endcap
* cell instance $10366 r0 *1 370.16,1088.64
X$10366 17289 17398 gf180mcu_fd_sc_mcu9t5v0__endcap
* cell instance $10367 r0 *1 370.16,1068.48
X$10367 16653 16784 gf180mcu_fd_sc_mcu9t5v0__endcap
* cell instance $10368 r0 *1 370.16,1008
X$10368 14857 14967 gf180mcu_fd_sc_mcu9t5v0__endcap
* cell instance $10369 r0 *1 370.16,1078.56
X$10369 16956 17123 gf180mcu_fd_sc_mcu9t5v0__endcap
* cell instance $10370 m0 *1 370.16,1088.64
X$10370 17289 17123 gf180mcu_fd_sc_mcu9t5v0__endcap
* cell instance $10371 r0 *1 370.16,967.68
X$10371 13719 13832 gf180mcu_fd_sc_mcu9t5v0__endcap
* cell instance $10372 r0 *1 370.16,1028.16
X$10372 15402 15576 gf180mcu_fd_sc_mcu9t5v0__endcap
* cell instance $10373 r0 *1 370.16,1098.72
X$10373 17521 17709 gf180mcu_fd_sc_mcu9t5v0__endcap
* cell instance $10374 m0 *1 370.16,1018.08
X$10374 15138 14967 gf180mcu_fd_sc_mcu9t5v0__endcap
* cell instance $10375 m0 *1 370.16,1098.72
X$10375 17521 17398 gf180mcu_fd_sc_mcu9t5v0__endcap
* cell instance $10376 r0 *1 370.16,987.84
X$10376 14304 14406 gf180mcu_fd_sc_mcu9t5v0__endcap
* cell instance $10377 m0 *1 370.16,1038.24
X$10377 15737 15576 gf180mcu_fd_sc_mcu9t5v0__endcap
* cell instance $10378 r0 *1 370.16,1048.32
X$10378 16008 16194 gf180mcu_fd_sc_mcu9t5v0__endcap
* cell instance $10379 m0 *1 370.16,1078.56
X$10379 16956 16784 gf180mcu_fd_sc_mcu9t5v0__endcap
* cell instance $10380 m0 *1 370.16,997.92
X$10380 14448 14406 gf180mcu_fd_sc_mcu9t5v0__endcap
* cell instance $10381 r0 *1 370.16,1038.24
X$10381 15737 15898 gf180mcu_fd_sc_mcu9t5v0__endcap
* cell instance $10382 r0 *1 370.16,997.92
X$10382 14448 14708 gf180mcu_fd_sc_mcu9t5v0__endcap
* cell instance $10383 m0 *1 371.28,1068.48
X$10383 16906 16506 16653 15514 gf180mcu_fd_sc_mcu9t5v0__dlyc_1
* cell instance $10384 r0 *1 370.16,1018.08
X$10384 15138 15271 gf180mcu_fd_sc_mcu9t5v0__endcap
* cell instance $10385 m0 *1 370.16,1048.32
X$10385 16008 15898 gf180mcu_fd_sc_mcu9t5v0__endcap
* cell instance $10386 m0 *1 370.16,1028.16
X$10386 15402 15271 gf180mcu_fd_sc_mcu9t5v0__endcap
* cell instance $10387 r0 *1 375.2,1028.16
X$10387 15514 15576 15402 15563 gf180mcu_fd_sc_mcu9t5v0__buf_1
* cell instance $10388 m0 *1 371.28,997.92
X$10388 14438 14406 14448 14439 gf180mcu_fd_sc_mcu9t5v0__dlyc_1
* cell instance $10389 m0 *1 370.16,1058.4
X$10389 16309 16194 gf180mcu_fd_sc_mcu9t5v0__endcap
* cell instance $10390 r0 *1 370.16,1058.4
X$10390 16309 16506 gf180mcu_fd_sc_mcu9t5v0__endcap
* cell instance $10391 m0 *1 370.16,1068.48
X$10391 16653 16506 gf180mcu_fd_sc_mcu9t5v0__endcap
* cell instance $10392 r0 *1 370.16,957.6
X$10392 13428 13586 gf180mcu_fd_sc_mcu9t5v0__endcap
* cell instance $10393 r0 *1 370.16,876.96
X$10393 11294 11461 gf180mcu_fd_sc_mcu9t5v0__endcap
* cell instance $10394 m0 *1 370.16,887.04
X$10394 11600 11461 gf180mcu_fd_sc_mcu9t5v0__endcap
* cell instance $10395 r0 *1 370.16,887.04
X$10395 11600 11720 gf180mcu_fd_sc_mcu9t5v0__endcap
* cell instance $10396 m0 *1 370.16,927.36
X$10396 12646 12508 gf180mcu_fd_sc_mcu9t5v0__endcap
* cell instance $10397 r0 *1 370.16,907.2
X$10397 12019 12128 gf180mcu_fd_sc_mcu9t5v0__endcap
* cell instance $10398 m0 *1 370.16,917.28
X$10398 12253 12128 gf180mcu_fd_sc_mcu9t5v0__endcap
* cell instance $10399 r0 *1 370.16,917.28
X$10399 12253 12508 gf180mcu_fd_sc_mcu9t5v0__endcap
* cell instance $10400 m0 *1 370.16,856.8
X$10400 10714 10676 gf180mcu_fd_sc_mcu9t5v0__endcap
* cell instance $10401 r0 *1 371.28,917.28
X$10401 12377 12508 12253 11320 gf180mcu_fd_sc_mcu9t5v0__dlyc_1
* cell instance $10402 r0 *1 370.16,856.8
X$10402 10714 10833 gf180mcu_fd_sc_mcu9t5v0__endcap
* cell instance $10403 r0 *1 389.2,876.96
X$10403 11321 11461 11294 11322 gf180mcu_fd_sc_mcu9t5v0__dlyc_1
* cell instance $10404 m0 *1 370.16,866.88
X$10404 11079 10833 gf180mcu_fd_sc_mcu9t5v0__endcap
* cell instance $10405 m0 *1 370.16,897.12
X$10405 11860 11720 gf180mcu_fd_sc_mcu9t5v0__endcap
* cell instance $10406 r0 *1 370.16,897.12
X$10406 11860 11971 gf180mcu_fd_sc_mcu9t5v0__endcap
* cell instance $10407 r0 *1 370.16,927.36
X$10407 12646 12785 gf180mcu_fd_sc_mcu9t5v0__endcap
* cell instance $10408 m0 *1 370.16,937.44
X$10408 12900 12785 gf180mcu_fd_sc_mcu9t5v0__endcap
* cell instance $10409 r0 *1 375.2,876.96
X$10409 11320 11461 11294 11321 gf180mcu_fd_sc_mcu9t5v0__buf_1
* cell instance $10410 r0 *1 370.16,836.64
X$10410 10308 10338 gf180mcu_fd_sc_mcu9t5v0__endcap
* cell instance $10411 m0 *1 370.16,836.64
X$10411 10308 10188 gf180mcu_fd_sc_mcu9t5v0__endcap
* cell instance $10412 r0 *1 375.2,952.56
X$10412 14439 13428 13318 13420 gf180mcu_fd_sc_mcu9t5v0__buf_1
* cell instance $10413 r0 *1 370.16,937.44
X$10413 12900 13054 gf180mcu_fd_sc_mcu9t5v0__endcap
* cell instance $10414 m0 *1 370.16,947.52
X$10414 13160 13054 gf180mcu_fd_sc_mcu9t5v0__endcap
* cell instance $10415 m0 *1 370.16,846.72
X$10415 10570 10338 gf180mcu_fd_sc_mcu9t5v0__endcap
* cell instance $10416 r0 *1 370.16,947.52
X$10416 13160 13318 gf180mcu_fd_sc_mcu9t5v0__endcap
* cell instance $10417 m0 *1 370.16,907.2
X$10417 12019 11971 gf180mcu_fd_sc_mcu9t5v0__endcap
* cell instance $10418 m0 *1 371.28,846.72
X$10418 10446 10338 10570 10447 gf180mcu_fd_sc_mcu9t5v0__dlyc_1
* cell instance $10419 r0 *1 370.16,866.88
X$10419 11079 11181 gf180mcu_fd_sc_mcu9t5v0__endcap
* cell instance $10420 m0 *1 370.16,876.96
X$10420 11294 11181 gf180mcu_fd_sc_mcu9t5v0__endcap
* cell instance $10421 r0 *1 370.16,846.72
X$10421 10570 10676 gf180mcu_fd_sc_mcu9t5v0__endcap
* cell instance $10422 m0 *1 370.16,957.6
X$10422 13428 13318 gf180mcu_fd_sc_mcu9t5v0__endcap
* cell instance $10423 r0 *1 490,897.12
X$10423 11860 11971 gf180mcu_fd_sc_mcu9t5v0__filltie
* cell instance $10424 r0 *1 490,927.36
X$10424 12646 12785 gf180mcu_fd_sc_mcu9t5v0__filltie
* cell instance $10425 r0 *1 490,836.64
X$10425 10308 10338 gf180mcu_fd_sc_mcu9t5v0__filltie
* cell instance $10426 r0 *1 490,846.72
X$10426 10570 10676 gf180mcu_fd_sc_mcu9t5v0__filltie
* cell instance $10427 r0 *1 490,957.6
X$10427 13428 13586 gf180mcu_fd_sc_mcu9t5v0__filltie
* cell instance $10428 r0 *1 490,856.8
X$10428 10714 10833 gf180mcu_fd_sc_mcu9t5v0__filltie
* cell instance $10429 r0 *1 490,866.88
X$10429 11079 11181 gf180mcu_fd_sc_mcu9t5v0__filltie
* cell instance $10430 r0 *1 420,947.52
X$10430 13318 13160 13313 gf180mcu_fd_sc_mcu9t5v0__tiel
* cell instance $10431 r0 *1 490,876.96
X$10431 11294 11461 gf180mcu_fd_sc_mcu9t5v0__filltie
* cell instance $10432 r0 *1 420,876.96
X$10432 11461 11294 11459 gf180mcu_fd_sc_mcu9t5v0__tiel
* cell instance $10433 r0 *1 490,917.28
X$10433 12253 12508 gf180mcu_fd_sc_mcu9t5v0__filltie
* cell instance $10434 r0 *1 490,887.04
X$10434 11600 11720 gf180mcu_fd_sc_mcu9t5v0__filltie
* cell instance $10435 r0 *1 490,937.44
X$10435 12900 13054 gf180mcu_fd_sc_mcu9t5v0__filltie
* cell instance $10436 r0 *1 490,947.52
X$10436 13160 13318 gf180mcu_fd_sc_mcu9t5v0__filltie
* cell instance $10437 r0 *1 490,907.2
X$10437 12019 12128 gf180mcu_fd_sc_mcu9t5v0__filltie
* cell instance $10438 m0 *1 370.16,584.64
X$10438 3907 3796 gf180mcu_fd_sc_mcu9t5v0__endcap
* cell instance $10439 m0 *1 371.28,695.52
X$10439 6768 6664 6805 6661 gf180mcu_fd_sc_mcu9t5v0__dlyc_1
* cell instance $10440 r0 *1 370.16,584.64
X$10440 3907 4150 gf180mcu_fd_sc_mcu9t5v0__endcap
* cell instance $10441 r0 *1 490,705.6
X$10441 6943 7071 gf180mcu_fd_sc_mcu9t5v0__filltie
* cell instance $10442 r0 *1 490,816.48
X$10442 9810 9841 gf180mcu_fd_sc_mcu9t5v0__filltie
* cell instance $10443 r0 *1 490,735.84
X$10443 7814 7919 gf180mcu_fd_sc_mcu9t5v0__filltie
* cell instance $10444 r0 *1 490,786.24
X$10444 8961 9201 gf180mcu_fd_sc_mcu9t5v0__filltie
* cell instance $10445 r0 *1 490,715.68
X$10445 7195 7316 gf180mcu_fd_sc_mcu9t5v0__filltie
* cell instance $10446 r0 *1 490,756
X$10446 8204 8445 gf180mcu_fd_sc_mcu9t5v0__filltie
* cell instance $10447 r0 *1 490,806.4
X$10447 9575 9691 gf180mcu_fd_sc_mcu9t5v0__filltie
* cell instance $10448 r0 *1 490,725.76
X$10448 7558 7671 gf180mcu_fd_sc_mcu9t5v0__filltie
* cell instance $10449 r0 *1 420,725.76
X$10449 7671 7558 7663 gf180mcu_fd_sc_mcu9t5v0__tiel
* cell instance $10450 m0 *1 420,806.4
X$10450 9432 9575 9686 gf180mcu_fd_sc_mcu9t5v0__tiel
* cell instance $10451 r0 *1 490,766.08
X$10451 8582 8693 gf180mcu_fd_sc_mcu9t5v0__filltie
* cell instance $10452 r0 *1 490,796.32
X$10452 9315 9432 gf180mcu_fd_sc_mcu9t5v0__filltie
* cell instance $10453 r0 *1 490,695.52
X$10453 6805 6909 gf180mcu_fd_sc_mcu9t5v0__filltie
* cell instance $10454 r0 *1 490,745.92
X$10454 7948 8078 gf180mcu_fd_sc_mcu9t5v0__filltie
* cell instance $10455 r0 *1 490,776.16
X$10455 8818 8843 gf180mcu_fd_sc_mcu9t5v0__filltie
* cell instance $10456 r0 *1 370.16,756
X$10456 8204 8445 gf180mcu_fd_sc_mcu9t5v0__endcap
* cell instance $10457 m0 *1 370.16,816.48
X$10457 9810 9691 gf180mcu_fd_sc_mcu9t5v0__endcap
* cell instance $10458 m0 *1 370.16,766.08
X$10458 8582 8445 gf180mcu_fd_sc_mcu9t5v0__endcap
* cell instance $10459 r0 *1 370.16,766.08
X$10459 8582 8693 gf180mcu_fd_sc_mcu9t5v0__endcap
* cell instance $10460 m0 *1 370.16,776.16
X$10460 8818 8693 gf180mcu_fd_sc_mcu9t5v0__endcap
* cell instance $10461 r0 *1 370.16,776.16
X$10461 8818 8843 gf180mcu_fd_sc_mcu9t5v0__endcap
* cell instance $10462 r0 *1 370.16,816.48
X$10462 9810 9841 gf180mcu_fd_sc_mcu9t5v0__endcap
* cell instance $10463 r0 *1 370.16,695.52
X$10463 6805 6909 gf180mcu_fd_sc_mcu9t5v0__endcap
* cell instance $10464 m0 *1 370.16,705.6
X$10464 6943 6909 gf180mcu_fd_sc_mcu9t5v0__endcap
* cell instance $10465 r0 *1 370.16,685.44
X$10465 6425 6664 gf180mcu_fd_sc_mcu9t5v0__endcap
* cell instance $10466 r0 *1 375.2,725.76
X$10466 7664 7671 7558 7665 gf180mcu_fd_sc_mcu9t5v0__buf_1
* cell instance $10467 r0 *1 370.16,705.6
X$10467 6943 7071 gf180mcu_fd_sc_mcu9t5v0__endcap
* cell instance $10468 r0 *1 375.2,801.36
X$10468 10447 9575 9432 9538 gf180mcu_fd_sc_mcu9t5v0__buf_1
* cell instance $10469 m0 *1 370.16,786.24
X$10469 8961 8843 gf180mcu_fd_sc_mcu9t5v0__endcap
* cell instance $10470 m0 *1 370.16,715.68
X$10470 7195 7071 gf180mcu_fd_sc_mcu9t5v0__endcap
* cell instance $10471 r0 *1 370.16,715.68
X$10471 7195 7316 gf180mcu_fd_sc_mcu9t5v0__endcap
* cell instance $10472 m0 *1 370.16,725.76
X$10472 7558 7316 gf180mcu_fd_sc_mcu9t5v0__endcap
* cell instance $10473 r0 *1 370.16,786.24
X$10473 8961 9201 gf180mcu_fd_sc_mcu9t5v0__endcap
* cell instance $10474 m0 *1 370.16,796.32
X$10474 9315 9201 gf180mcu_fd_sc_mcu9t5v0__endcap
* cell instance $10475 r0 *1 370.16,725.76
X$10475 7558 7671 gf180mcu_fd_sc_mcu9t5v0__endcap
* cell instance $10476 r0 *1 370.16,796.32
X$10476 9315 9432 gf180mcu_fd_sc_mcu9t5v0__endcap
* cell instance $10477 m0 *1 370.16,735.84
X$10477 7814 7671 gf180mcu_fd_sc_mcu9t5v0__endcap
* cell instance $10478 m0 *1 370.16,806.4
X$10478 9575 9432 gf180mcu_fd_sc_mcu9t5v0__endcap
* cell instance $10479 r0 *1 370.16,735.84
X$10479 7814 7919 gf180mcu_fd_sc_mcu9t5v0__endcap
* cell instance $10480 m0 *1 370.16,826.56
X$10480 10078 9841 gf180mcu_fd_sc_mcu9t5v0__endcap
* cell instance $10481 r0 *1 370.16,806.4
X$10481 9575 9691 gf180mcu_fd_sc_mcu9t5v0__endcap
* cell instance $10482 m0 *1 370.16,745.92
X$10482 7948 7919 gf180mcu_fd_sc_mcu9t5v0__endcap
* cell instance $10483 r0 *1 370.16,745.92
X$10483 7948 8078 gf180mcu_fd_sc_mcu9t5v0__endcap
* cell instance $10484 r0 *1 371.28,766.08
X$10484 8575 8693 8582 7664 gf180mcu_fd_sc_mcu9t5v0__dlyc_1
* cell instance $10485 m0 *1 370.16,756
X$10485 8204 8078 gf180mcu_fd_sc_mcu9t5v0__endcap
* cell instance $10486 m0 *1 370.16,604.8
X$10486 4512 4389 gf180mcu_fd_sc_mcu9t5v0__endcap
* cell instance $10487 m0 *1 370.16,695.52
X$10487 6805 6664 gf180mcu_fd_sc_mcu9t5v0__endcap
* cell instance $10488 m0 *1 370.16,614.88
X$10488 4794 4667 gf180mcu_fd_sc_mcu9t5v0__endcap
* cell instance $10489 r0 *1 370.16,624.96
X$10489 5056 5183 gf180mcu_fd_sc_mcu9t5v0__endcap
* cell instance $10490 m0 *1 370.16,655.2
X$10490 5794 5665 gf180mcu_fd_sc_mcu9t5v0__endcap
* cell instance $10491 m0 *1 370.16,635.04
X$10491 5297 5183 gf180mcu_fd_sc_mcu9t5v0__endcap
* cell instance $10492 r0 *1 370.16,635.04
X$10492 5297 5390 gf180mcu_fd_sc_mcu9t5v0__endcap
* cell instance $10493 r0 *1 370.16,655.2
X$10493 5794 5920 gf180mcu_fd_sc_mcu9t5v0__endcap
* cell instance $10494 m0 *1 370.16,594.72
X$10494 4266 4150 gf180mcu_fd_sc_mcu9t5v0__endcap
* cell instance $10495 r0 *1 370.16,665.28
X$10495 6034 6144 gf180mcu_fd_sc_mcu9t5v0__endcap
* cell instance $10496 m0 *1 370.16,624.96
X$10496 5056 4903 gf180mcu_fd_sc_mcu9t5v0__endcap
* cell instance $10497 m0 *1 370.16,675.36
X$10497 6292 6144 gf180mcu_fd_sc_mcu9t5v0__endcap
* cell instance $10498 r0 *1 370.16,675.36
X$10498 6292 6392 gf180mcu_fd_sc_mcu9t5v0__endcap
* cell instance $10499 m0 *1 370.16,665.28
X$10499 6034 5920 gf180mcu_fd_sc_mcu9t5v0__endcap
* cell instance $10500 m0 *1 370.16,645.12
X$10500 5411 5390 gf180mcu_fd_sc_mcu9t5v0__endcap
* cell instance $10501 r0 *1 371.28,614.88
X$10501 4790 4903 4794 4791 gf180mcu_fd_sc_mcu9t5v0__dlyc_1
* cell instance $10502 r0 *1 370.16,604.8
X$10502 4512 4667 gf180mcu_fd_sc_mcu9t5v0__endcap
* cell instance $10503 m0 *1 389.2,655.2
X$10503 5757 5665 5794 5758 gf180mcu_fd_sc_mcu9t5v0__dlyc_1
* cell instance $10504 r0 *1 490,584.64
X$10504 3907 4150 gf180mcu_fd_sc_mcu9t5v0__filltie
* cell instance $10505 r0 *1 370.16,645.12
X$10505 5411 5665 gf180mcu_fd_sc_mcu9t5v0__endcap
* cell instance $10506 m0 *1 370.16,685.44
X$10506 6425 6392 gf180mcu_fd_sc_mcu9t5v0__endcap
* cell instance $10507 r0 *1 375.2,650.16
X$10507 6661 5794 5665 5757 gf180mcu_fd_sc_mcu9t5v0__buf_1
* cell instance $10508 r0 *1 370.16,594.72
X$10508 4266 4389 gf180mcu_fd_sc_mcu9t5v0__endcap
* cell instance $10509 r0 *1 400.4,650.16
X$10509 5758 5794 5665 5662 gf180mcu_fd_sc_mcu9t5v0__buf_8
* cell instance $10510 r0 *1 370.16,614.88
X$10510 4794 4903 gf180mcu_fd_sc_mcu9t5v0__endcap
* cell instance $10511 r0 *1 490,604.8
X$10511 4512 4667 gf180mcu_fd_sc_mcu9t5v0__filltie
* cell instance $10512 r0 *1 490,655.2
X$10512 5794 5920 gf180mcu_fd_sc_mcu9t5v0__filltie
* cell instance $10513 r0 *1 490,635.04
X$10513 5297 5390 gf180mcu_fd_sc_mcu9t5v0__filltie
* cell instance $10514 r0 *1 490,614.88
X$10514 4794 4903 gf180mcu_fd_sc_mcu9t5v0__filltie
* cell instance $10515 r0 *1 490,645.12
X$10515 5411 5665 gf180mcu_fd_sc_mcu9t5v0__filltie
* cell instance $10516 r0 *1 490,624.96
X$10516 5056 5183 gf180mcu_fd_sc_mcu9t5v0__filltie
* cell instance $10517 m0 *1 420,655.2
X$10517 5665 5794 5790 gf180mcu_fd_sc_mcu9t5v0__tiel
* cell instance $10518 r0 *1 490,594.72
X$10518 4266 4389 gf180mcu_fd_sc_mcu9t5v0__filltie
* cell instance $10519 r0 *1 490,665.28
X$10519 6034 6144 gf180mcu_fd_sc_mcu9t5v0__filltie
* cell instance $10520 r0 *1 400.4,725.76
X$10520 7665 7671 7558 7549 gf180mcu_fd_sc_mcu9t5v0__buf_8
* cell instance $10521 r0 *1 490,675.36
X$10521 6292 6392 gf180mcu_fd_sc_mcu9t5v0__filltie
* cell instance $10522 r0 *1 370.16,564.48
X$10522 3444 3558 gf180mcu_fd_sc_mcu9t5v0__endcap
* cell instance $10523 r0 *1 389.2,574.56
X$10523 3793 3796 3781 3794 gf180mcu_fd_sc_mcu9t5v0__dlyc_1
* cell instance $10524 r0 *1 375.2,574.56
X$10524 4791 3796 3781 3793 gf180mcu_fd_sc_mcu9t5v0__buf_1
* cell instance $10525 r0 *1 490,554.4
X$10525 3227 3334 gf180mcu_fd_sc_mcu9t5v0__filltie
* cell instance $10526 r0 *1 400.4,801.36
X$10526 9538 9575 9432 9539 gf180mcu_fd_sc_mcu9t5v0__buf_8
* cell instance $10527 r0 *1 490,685.44
X$10527 6425 6664 gf180mcu_fd_sc_mcu9t5v0__filltie
* cell instance $10528 r0 *1 490,564.48
X$10528 3444 3558 gf180mcu_fd_sc_mcu9t5v0__filltie
* cell instance $10529 r0 *1 420,574.56
X$10529 3796 3781 3906 gf180mcu_fd_sc_mcu9t5v0__tiel
* cell instance $10530 m0 *1 370.16,574.56
X$10530 3781 3558 gf180mcu_fd_sc_mcu9t5v0__endcap
* cell instance $10531 r0 *1 370.16,554.4
X$10531 3227 3334 gf180mcu_fd_sc_mcu9t5v0__endcap
* cell instance $10532 r0 *1 400.4,574.56
X$10532 3794 3796 3781 3795 gf180mcu_fd_sc_mcu9t5v0__buf_8
* cell instance $10533 r0 *1 490,574.56
X$10533 3781 3796 gf180mcu_fd_sc_mcu9t5v0__filltie
* cell instance $10534 r0 *1 370.16,574.56
X$10534 3781 3796 gf180mcu_fd_sc_mcu9t5v0__endcap
* cell instance $10535 m0 *1 370.16,564.48
X$10535 3444 3334 gf180mcu_fd_sc_mcu9t5v0__endcap
* cell instance $10536 r0 *1 490,393.12
X$10536 260 259 gf180mcu_fd_sc_mcu9t5v0__filltie
* cell instance $10537 m0 *1 370.16,524.16
X$10537 2561 2464 gf180mcu_fd_sc_mcu9t5v0__endcap
* cell instance $10538 r0 *1 490,383.04
X$10538 90 89 gf180mcu_fd_sc_mcu9t5v0__filltie
* cell instance $10539 m0 *1 370.16,403.2
X$10539 430 259 gf180mcu_fd_sc_mcu9t5v0__endcap
* cell instance $10540 r0 *1 490,403.2
X$10540 430 429 gf180mcu_fd_sc_mcu9t5v0__filltie
* cell instance $10541 m0 *1 370.16,393.12
X$10541 260 89 gf180mcu_fd_sc_mcu9t5v0__endcap
* cell instance $10542 r0 *1 490,433.44
X$10542 940 939 gf180mcu_fd_sc_mcu9t5v0__filltie
* cell instance $10543 r0 *1 490,443.52
X$10543 1110 1109 gf180mcu_fd_sc_mcu9t5v0__filltie
* cell instance $10544 r0 *1 370.16,433.44
X$10544 940 939 gf180mcu_fd_sc_mcu9t5v0__endcap
* cell instance $10545 r0 *1 490,483.84
X$10545 1790 1789 gf180mcu_fd_sc_mcu9t5v0__filltie
* cell instance $10546 r0 *1 370.16,393.12
X$10546 260 259 gf180mcu_fd_sc_mcu9t5v0__endcap
* cell instance $10547 m0 *1 420,504
X$10547 2130 2138 2242 gf180mcu_fd_sc_mcu9t5v0__tiel
* cell instance $10548 r0 *1 490,524.16
X$10548 2561 2668 gf180mcu_fd_sc_mcu9t5v0__filltie
* cell instance $10549 r0 *1 370.16,453.6
X$10549 1280 1279 gf180mcu_fd_sc_mcu9t5v0__endcap
* cell instance $10550 r0 *1 370.16,473.76
X$10550 1620 1619 gf180mcu_fd_sc_mcu9t5v0__endcap
* cell instance $10551 r0 *1 370.16,504
X$10551 2138 2243 gf180mcu_fd_sc_mcu9t5v0__endcap
* cell instance $10552 r0 *1 400.4,498.96
X$10552 2136 2138 2130 2137 gf180mcu_fd_sc_mcu9t5v0__buf_8
* cell instance $10553 r0 *1 375.2,498.96
X$10553 2560 2138 2130 2136 gf180mcu_fd_sc_mcu9t5v0__buf_1
* cell instance $10554 m0 *1 370.16,433.44
X$10554 940 769 gf180mcu_fd_sc_mcu9t5v0__endcap
* cell instance $10555 m0 *1 370.16,493.92
X$10555 1959 1789 gf180mcu_fd_sc_mcu9t5v0__endcap
* cell instance $10556 m0 *1 370.16,453.6
X$10556 1280 1109 gf180mcu_fd_sc_mcu9t5v0__endcap
* cell instance $10557 r0 *1 490,514.08
X$10557 2361 2464 gf180mcu_fd_sc_mcu9t5v0__filltie
* cell instance $10558 r0 *1 370.16,383.04
X$10558 90 89 gf180mcu_fd_sc_mcu9t5v0__endcap
* cell instance $10559 r0 *1 370.16,524.16
X$10559 2561 2668 gf180mcu_fd_sc_mcu9t5v0__endcap
* cell instance $10560 m0 *1 370.16,534.24
X$10560 2775 2668 gf180mcu_fd_sc_mcu9t5v0__endcap
* cell instance $10561 m0 *1 370.16,443.52
X$10561 1110 939 gf180mcu_fd_sc_mcu9t5v0__endcap
* cell instance $10562 m0 *1 370.16,383.04
X$10562 90 4 gf180mcu_fd_sc_mcu9t5v0__endcap
* cell instance $10563 r0 *1 0,0
X$10563 gf180mcu_fd_io__cor
* cell instance $10564 r0 *1 370.16,372.96
X$10564 2 4 gf180mcu_fd_sc_mcu9t5v0__endcap
* cell instance $10565 m0 *1 371.28,544.32
X$10565 2981 2876 3093 2560 gf180mcu_fd_sc_mcu9t5v0__dlyc_1
* cell instance $10566 m0 *1 370.16,473.76
X$10566 1620 1449 gf180mcu_fd_sc_mcu9t5v0__endcap
* cell instance $10567 m0 *1 370.16,483.84
X$10567 1790 1619 gf180mcu_fd_sc_mcu9t5v0__endcap
* cell instance $10568 r0 *1 370.16,534.24
X$10568 2775 2876 gf180mcu_fd_sc_mcu9t5v0__endcap
* cell instance $10569 r0 *1 490,534.24
X$10569 2775 2876 gf180mcu_fd_sc_mcu9t5v0__filltie
* cell instance $10570 r0 *1 370.16,403.2
X$10570 430 429 gf180mcu_fd_sc_mcu9t5v0__endcap
* cell instance $10571 m0 *1 370.16,423.36
X$10571 770 599 gf180mcu_fd_sc_mcu9t5v0__endcap
* cell instance $10572 r0 *1 490,372.96
X$10572 2 4 gf180mcu_fd_sc_mcu9t5v0__filltie
* cell instance $10573 r0 *1 370.16,443.52
X$10573 1110 1109 gf180mcu_fd_sc_mcu9t5v0__endcap
* cell instance $10574 r0 *1 490,453.6
X$10574 1280 1279 gf180mcu_fd_sc_mcu9t5v0__filltie
* cell instance $10575 m0 *1 370.16,544.32
X$10575 3093 2876 gf180mcu_fd_sc_mcu9t5v0__endcap
* cell instance $10576 r0 *1 490,544.32
X$10576 3093 3215 gf180mcu_fd_sc_mcu9t5v0__filltie
* cell instance $10577 r0 *1 490,473.76
X$10577 1620 1619 gf180mcu_fd_sc_mcu9t5v0__filltie
* cell instance $10578 r0 *1 370.16,493.92
X$10578 1959 2130 gf180mcu_fd_sc_mcu9t5v0__endcap
* cell instance $10579 r0 *1 370.16,544.32
X$10579 3093 3215 gf180mcu_fd_sc_mcu9t5v0__endcap
* cell instance $10580 r0 *1 370.16,463.68
X$10580 1450 1449 gf180mcu_fd_sc_mcu9t5v0__endcap
* cell instance $10581 r0 *1 490,413.28
X$10581 600 599 gf180mcu_fd_sc_mcu9t5v0__filltie
* cell instance $10582 m0 *1 370.16,504
X$10582 2138 2130 gf180mcu_fd_sc_mcu9t5v0__endcap
* cell instance $10583 r0 *1 370.16,413.28
X$10583 600 599 gf180mcu_fd_sc_mcu9t5v0__endcap
* cell instance $10584 r0 *1 370.16,483.84
X$10584 1790 1789 gf180mcu_fd_sc_mcu9t5v0__endcap
* cell instance $10585 r0 *1 370.16,514.08
X$10585 2361 2464 gf180mcu_fd_sc_mcu9t5v0__endcap
* cell instance $10586 r0 *1 490,463.68
X$10586 1450 1449 gf180mcu_fd_sc_mcu9t5v0__filltie
* cell instance $10587 r0 *1 490,423.36
X$10587 770 769 gf180mcu_fd_sc_mcu9t5v0__filltie
* cell instance $10588 r0 *1 490,504
X$10588 2138 2243 gf180mcu_fd_sc_mcu9t5v0__filltie
* cell instance $10589 m0 *1 370.16,514.08
X$10589 2361 2243 gf180mcu_fd_sc_mcu9t5v0__endcap
* cell instance $10590 r0 *1 370.16,423.36
X$10590 770 769 gf180mcu_fd_sc_mcu9t5v0__endcap
* cell instance $10591 m0 *1 370.16,463.68
X$10591 1450 1279 gf180mcu_fd_sc_mcu9t5v0__endcap
* cell instance $10592 r0 *1 490,493.92
X$10592 1959 2130 gf180mcu_fd_sc_mcu9t5v0__filltie
* cell instance $10593 m0 *1 370.16,413.28
X$10593 600 429 gf180mcu_fd_sc_mcu9t5v0__endcap
* cell instance $10594 r0 *1 1030,0
X$10594 gf180mcu_fd_io__dvss
* cell instance $10595 m0 *1 959.28,514.08
X$10595 2140 2244 2777 2243 2361 2362 gf180mcu_fd_sc_mcu9t5v0__mux2_2
* cell instance $10596 r0 *1 969.36,413.28
X$10596 600 599 gf180mcu_fd_sc_mcu9t5v0__filltie
* cell instance $10597 m0 *1 991.76,514.08
X$10597 2366 2365 2141 2243 2361 2364 gf180mcu_fd_sc_mcu9t5v0__mux2_1
* cell instance $10598 r0 *1 1044.4,504
X$10598 2245 2143 2253 2243 2138 gf180mcu_fd_sc_mcu9t5v0__dffq_2
* cell instance $10599 m0 *1 1072.4,504
X$10599 2245 2131 2132 2130 2138 gf180mcu_fd_sc_mcu9t5v0__dffq_2
* cell instance $10600 r0 *1 1081.36,493.92
X$10600 2133 2132 2134 2130 1959 2131 gf180mcu_fd_sc_mcu9t5v0__mux2_1
* cell instance $10601 m0 *1 1089.2,504
X$10601 2138 2130 gf180mcu_fd_sc_mcu9t5v0__filltie
* cell instance $10602 m0 *1 1048.32,504
X$10602 2252 2253 1961 2130 2138 2143 gf180mcu_fd_sc_mcu9t5v0__mux2_1
* cell instance $10603 m0 *1 1044.4,514.08
X$10603 2252 2370 2264 2243 2361 2369 gf180mcu_fd_sc_mcu9t5v0__mux2_1
* cell instance $10604 m0 *1 1089.2,514.08
X$10604 2361 2243 gf180mcu_fd_sc_mcu9t5v0__filltie
* cell instance $10605 m0 *1 1055.6,504
X$10605 2245 2144 2884 2130 2138 gf180mcu_fd_sc_mcu9t5v0__dffq_2
* cell instance $10606 m0 *1 1089.2,483.84
X$10606 1790 1619 gf180mcu_fd_sc_mcu9t5v0__filltie
* cell instance $10607 m0 *1 1089.2,473.76
X$10607 1620 1449 gf180mcu_fd_sc_mcu9t5v0__filltie
* cell instance $10608 r0 *1 1092.56,514.08
X$10608 2256 2257 2564 2464 2361 2570 gf180mcu_fd_sc_mcu9t5v0__mux2_2
* cell instance $10609 m0 *1 1089.2,493.92
X$10609 1959 1789 gf180mcu_fd_sc_mcu9t5v0__filltie
* cell instance $10610 r0 *1 1067.92,504
X$10610 2370 2252 2255 2243 2138 2254 gf180mcu_fd_sc_mcu9t5v0__mux2_1
* cell instance $10611 m0 *1 1063.44,514.08
X$10611 2254 2884 2134 2243 2361 2144 gf180mcu_fd_sc_mcu9t5v0__mux2_1
* cell instance $10612 r0 *1 1086.4,504
X$10612 2257 2256 2255 2243 2138 2133 gf180mcu_fd_sc_mcu9t5v0__mux2_1
* cell instance $10613 r0 *1 1097.6,493.92
X$10613 2256 2145 1961 2130 1959 2135 gf180mcu_fd_sc_mcu9t5v0__mux2_1
* cell instance $10614 m0 *1 1089.2,463.68
X$10614 1450 1279 gf180mcu_fd_sc_mcu9t5v0__filltie
* cell instance $10615 r0 *1 1053.36,524.16
X$10615 2253 2565 2891 2668 2561 2679 gf180mcu_fd_sc_mcu9t5v0__mux2_1
* cell instance $10616 r0 *1 969.36,534.24
X$10616 2775 2876 gf180mcu_fd_sc_mcu9t5v0__filltie
* cell instance $10617 m0 *1 1051.12,534.24
X$10617 2983 2679 2668 2775 2886 gf180mcu_fd_sc_mcu9t5v0__nand2_1
* cell instance $10618 r0 *1 1040.48,534.24
X$10618 2884 2786 2997 2367 2880 2876 2775 2885
+ gf180mcu_fd_sc_mcu9t5v0__aoi221_1
* cell instance $10619 r0 *1 1046.64,534.24
X$10619 2678 2999 2886 2885 2876 2775 2887 gf180mcu_fd_sc_mcu9t5v0__aoi22_1
* cell instance $10620 m0 *1 1089.2,534.24
X$10620 2775 2668 gf180mcu_fd_sc_mcu9t5v0__filltie
* cell instance $10621 r0 *1 1061.76,544.32
X$10621 2253 2565 3000 3001 3337 3109 3215 3093 3110
+ gf180mcu_fd_sc_mcu9t5v0__mux4_1
* cell instance $10622 m0 *1 1091.44,544.32
X$10622 2371 2997 2876 3093 3097 gf180mcu_fd_sc_mcu9t5v0__nand2_1
* cell instance $10623 r0 *1 1034.32,514.08
X$10623 2245 2368 2367 2464 2361 gf180mcu_fd_sc_mcu9t5v0__dffq_2
* cell instance $10624 m0 *1 1083.04,534.24
X$10624 2132 2786 2787 2983 2880 2668 2775 2888
+ gf180mcu_fd_sc_mcu9t5v0__aoi221_1
* cell instance $10625 m0 *1 999.6,514.08
X$10625 2245 2247 2248 2243 2361 gf180mcu_fd_sc_mcu9t5v0__dffq_2
* cell instance $10626 r0 *1 1083.6,544.32
X$10626 3455 2997 3215 3093 3111 gf180mcu_fd_sc_mcu9t5v0__nand2_1
* cell instance $10627 r0 *1 1086.4,544.32
X$10627 3113 2786 3112 2983 2992 3215 3093 3114
+ gf180mcu_fd_sc_mcu9t5v0__aoi221_1
* cell instance $10628 r0 *1 1092.56,544.32
X$10628 3097 2888 3111 3114 3103 3215 3093 3457
+ gf180mcu_fd_sc_mcu9t5v0__aoi221_1
* cell instance $10629 r0 *1 969.36,473.76
X$10629 1620 1619 gf180mcu_fd_sc_mcu9t5v0__filltie
* cell instance $10630 r0 *1 969.36,544.32
X$10630 3093 3215 gf180mcu_fd_sc_mcu9t5v0__filltie
* cell instance $10631 r0 *1 969.36,463.68
X$10631 1450 1449 gf180mcu_fd_sc_mcu9t5v0__filltie
* cell instance $10632 m0 *1 1089.2,544.32
X$10632 3093 2876 gf180mcu_fd_sc_mcu9t5v0__filltie
* cell instance $10633 m0 *1 1089.2,524.16
X$10633 2561 2464 gf180mcu_fd_sc_mcu9t5v0__filltie
* cell instance $10634 m0 *1 1036.56,534.24
X$10634 5901 2668 2775 2245 gf180mcu_fd_sc_mcu9t5v0__clkbuf_8
* cell instance $10635 m0 *1 1090.88,524.16
X$10635 2145 2569 2891 2464 2561 2787 gf180mcu_fd_sc_mcu9t5v0__mux2_1
* cell instance $10636 m0 *1 1057.28,544.32
X$10636 3000 3001 2253 2565 2987 3106 2876 3093 2996
+ gf180mcu_fd_sc_mcu9t5v0__mux4_1
* cell instance $10637 m0 *1 1068.48,524.16
X$10637 2252 2370 2564 2464 2561 2567 gf180mcu_fd_sc_mcu9t5v0__mux2_2
* cell instance $10638 r0 *1 969.36,504
X$10638 2138 2243 gf180mcu_fd_sc_mcu9t5v0__filltie
* cell instance $10639 m0 *1 1060.08,524.16
X$10639 2567 2565 2472 2464 2561 2566 gf180mcu_fd_sc_mcu9t5v0__mux2_2
* cell instance $10640 m0 *1 1080.8,524.16
X$10640 2570 2569 2472 2464 2561 2568 gf180mcu_fd_sc_mcu9t5v0__mux2_2
* cell instance $10641 m0 *1 1024.8,524.16
X$10641 2366 2365 2564 2464 2561 2563 gf180mcu_fd_sc_mcu9t5v0__mux2_2
* cell instance $10642 r0 *1 970.48,504
X$10642 2245 2246 2879 2243 2138 gf180mcu_fd_sc_mcu9t5v0__dffq_2
* cell instance $10643 m0 *1 975.52,514.08
X$10643 2139 2879 2363 2243 2361 2246 gf180mcu_fd_sc_mcu9t5v0__mux2_1
* cell instance $10644 r0 *1 969.36,493.92
X$10644 1959 2130 gf180mcu_fd_sc_mcu9t5v0__filltie
* cell instance $10645 r0 *1 1018.08,544.32
X$10645 2251 2785 3235 3108 3337 3109 3215 3093 3221
+ gf180mcu_fd_sc_mcu9t5v0__mux4_1
* cell instance $10646 r0 *1 1017.52,524.16
X$10646 2245 2676 2785 2668 2561 gf180mcu_fd_sc_mcu9t5v0__dffq_2
* cell instance $10647 r0 *1 969.36,514.08
X$10647 2361 2464 gf180mcu_fd_sc_mcu9t5v0__filltie
* cell instance $10648 r0 *1 969.36,453.6
X$10648 1280 1279 gf180mcu_fd_sc_mcu9t5v0__filltie
* cell instance $10649 m0 *1 967.68,544.32
X$10649 2248 2879 2779 2989 3337 3109 2876 3093 2990
+ gf180mcu_fd_sc_mcu9t5v0__mux4_1
* cell instance $10650 r0 *1 975.52,524.16
X$10650 2672 2784 2573 2668 2561 2671 gf180mcu_fd_sc_mcu9t5v0__mux2_2
* cell instance $10651 m0 *1 970.48,534.24
X$10651 2245 2671 2784 2668 2775 gf180mcu_fd_sc_mcu9t5v0__dffq_2
* cell instance $10652 r0 *1 981.12,514.08
X$10652 2245 2467 2562 2464 2361 gf180mcu_fd_sc_mcu9t5v0__dffq_2
* cell instance $10653 r0 *1 969.36,483.84
X$10653 1790 1789 gf180mcu_fd_sc_mcu9t5v0__filltie
* cell instance $10654 m0 *1 1021.44,544.32
X$10654 2251 2785 2891 2876 3093 2994 gf180mcu_fd_sc_mcu9t5v0__mux2_1
* cell instance $10655 m0 *1 1016.96,544.32
X$10655 2983 2994 2876 3093 3223 gf180mcu_fd_sc_mcu9t5v0__nand2_1
* cell instance $10656 m0 *1 992.88,544.32
X$10656 2674 2786 2997 2562 2880 2876 3093 3096
+ gf180mcu_fd_sc_mcu9t5v0__aoi221_1
* cell instance $10657 r0 *1 997.36,544.32
X$10657 3220 2997 3215 3093 3107 gf180mcu_fd_sc_mcu9t5v0__nand2_1
* cell instance $10658 m0 *1 999.04,544.32
X$10658 2784 2786 2991 2983 2992 2876 3093 2993
+ gf180mcu_fd_sc_mcu9t5v0__aoi221_1
* cell instance $10659 r0 *1 1000.16,544.32
X$10659 3223 3096 3107 2993 3103 3215 3093 3222
+ gf180mcu_fd_sc_mcu9t5v0__aoi221_1
* cell instance $10660 m0 *1 1034.32,534.24
X$10660 2245 2668 2775 33562 gf180mcu_fd_sc_mcu9t5v0__clkinv_1
* cell instance $10661 r0 *1 969.36,524.16
X$10661 2561 2668 gf180mcu_fd_sc_mcu9t5v0__filltie
* cell instance $10662 r0 *1 982.24,534.24
X$10662 2365 2366 2986 2876 2775 2672 gf180mcu_fd_sc_mcu9t5v0__mux2_1
* cell instance $10663 m0 *1 1037.12,514.08
X$10663 2369 2367 2363 2243 2361 2368 gf180mcu_fd_sc_mcu9t5v0__mux2_1
* cell instance $10664 r0 *1 1008.56,524.16
X$10664 2365 2366 2255 2668 2561 2675 gf180mcu_fd_sc_mcu9t5v0__mux2_1
* cell instance $10665 r0 *1 969.36,443.52
X$10665 1110 1109 gf180mcu_fd_sc_mcu9t5v0__filltie
* cell instance $10666 r0 *1 969.36,423.36
X$10666 770 769 gf180mcu_fd_sc_mcu9t5v0__filltie
* cell instance $10667 m0 *1 976.64,504
X$10667 2140 2244 2141 2130 2138 2139 gf180mcu_fd_sc_mcu9t5v0__mux2_1
* cell instance $10668 r0 *1 969.36,433.44
X$10668 940 939 gf180mcu_fd_sc_mcu9t5v0__filltie
* cell instance $10669 m0 *1 1089.2,423.36
X$10669 770 599 gf180mcu_fd_sc_mcu9t5v0__filltie
* cell instance $10670 m0 *1 1089.2,433.44
X$10670 940 769 gf180mcu_fd_sc_mcu9t5v0__filltie
* cell instance $10671 m0 *1 1089.2,453.6
X$10671 1280 1109 gf180mcu_fd_sc_mcu9t5v0__filltie
* cell instance $10672 m0 *1 1089.2,443.52
X$10672 1110 939 gf180mcu_fd_sc_mcu9t5v0__filltie
* cell instance $10673 r0 *1 1001.28,524.16
X$10673 2675 2674 2134 2668 2561 2673 gf180mcu_fd_sc_mcu9t5v0__mux2_1
* cell instance $10674 m0 *1 986.16,524.16
X$10674 2364 2562 2363 2464 2561 2467 gf180mcu_fd_sc_mcu9t5v0__mux2_1
* cell instance $10675 r0 *1 1083.6,524.16
X$10675 2245 2568 2569 2668 2561 gf180mcu_fd_sc_mcu9t5v0__dffq_2
* cell instance $10676 r0 *1 1060.64,524.16
X$10676 2245 2566 2565 2668 2561 gf180mcu_fd_sc_mcu9t5v0__dffq_2
* cell instance $10677 r0 *1 1045.52,524.16
X$10677 2677 2786 2668 2561 2678 gf180mcu_fd_sc_mcu9t5v0__nand2_1
* cell instance $10678 m0 *1 1048.32,544.32
X$10678 3000 3001 2891 2876 3093 2995 gf180mcu_fd_sc_mcu9t5v0__mux2_1
* cell instance $10679 m0 *1 1021.44,534.24
X$10679 2563 2785 2472 2668 2775 2676 gf180mcu_fd_sc_mcu9t5v0__mux2_2
* cell instance $10680 m0 *1 995.12,534.24
X$10680 2245 2673 2674 2668 2775 gf180mcu_fd_sc_mcu9t5v0__dffq_2
* cell instance $10681 m0 *1 1042.16,544.32
X$10681 2998 2997 2995 2983 2992 2876 3093 2999
+ gf180mcu_fd_sc_mcu9t5v0__aoi221_1
* cell instance $10682 r0 *1 1009.12,504
X$10682 2244 2140 2250 2243 2138 2249 gf180mcu_fd_sc_mcu9t5v0__mux2_1
* cell instance $10683 r0 *1 1001.84,504
X$10683 2249 2248 2134 2243 2138 2247 gf180mcu_fd_sc_mcu9t5v0__mux2_1
* cell instance $10684 m0 *1 1025.36,504
X$10684 2366 2251 1961 2130 2138 2142 gf180mcu_fd_sc_mcu9t5v0__mux2_1
* cell instance $10685 m0 *1 1000.16,493.92
X$10685 2140 2783 1961 1789 1959 1960 gf180mcu_fd_sc_mcu9t5v0__mux2_1
* cell instance $10686 r0 *1 993.44,493.92
X$10686 2245 1960 2783 2130 1959 gf180mcu_fd_sc_mcu9t5v0__dffq_2
* cell instance $10687 r0 *1 1020.88,504
X$10687 2245 2142 2251 2243 2138 gf180mcu_fd_sc_mcu9t5v0__dffq_2
* cell instance $10688 r0 *1 866.88,544.32
X$10688 3100 3099 2134 3215 3093 3216 gf180mcu_fd_sc_mcu9t5v0__mux2_1
* cell instance $10689 r0 *1 841.68,544.32
X$10689 3559 3094 2982 3215 3093 gf180mcu_fd_sc_mcu9t5v0__dffq_2
* cell instance $10690 m0 *1 899.36,544.32
X$10690 2985 2878 2891 2876 3093 2984 gf180mcu_fd_sc_mcu9t5v0__mux2_1
* cell instance $10691 m0 *1 889.28,544.32
X$10691 3561 2997 2984 2983 2880 2876 3093 3104
+ gf180mcu_fd_sc_mcu9t5v0__aoi221_1
* cell instance $10692 m0 *1 884.24,544.32
X$10692 3563 2997 2876 3093 3095 gf180mcu_fd_sc_mcu9t5v0__nand2_1
* cell instance $10693 m0 *1 849.52,473.76
X$10693 1620 1449 gf180mcu_fd_sc_mcu9t5v0__filltie
* cell instance $10694 m0 *1 948.08,544.32
X$10694 2779 2989 2248 2879 2987 3106 2876 3093 2988
+ gf180mcu_fd_sc_mcu9t5v0__mux4_1
* cell instance $10695 m0 *1 849.52,493.92
X$10695 1959 1789 gf180mcu_fd_sc_mcu9t5v0__filltie
* cell instance $10696 r0 *1 922.32,534.24
X$10696 2776 2778 2779 2876 2775 gf180mcu_fd_sc_mcu9t5v0__dffq_2
* cell instance $10697 m0 *1 849.52,534.24
X$10697 2775 2668 gf180mcu_fd_sc_mcu9t5v0__filltie
* cell instance $10698 m0 *1 849.52,524.16
X$10698 2561 2464 gf180mcu_fd_sc_mcu9t5v0__filltie
* cell instance $10699 m0 *1 849.52,463.68
X$10699 1450 1279 gf180mcu_fd_sc_mcu9t5v0__filltie
* cell instance $10700 m0 *1 849.52,433.44
X$10700 940 769 gf180mcu_fd_sc_mcu9t5v0__filltie
* cell instance $10701 m0 *1 849.52,514.08
X$10701 2361 2243 gf180mcu_fd_sc_mcu9t5v0__filltie
* cell instance $10702 m0 *1 849.52,443.52
X$10702 1110 939 gf180mcu_fd_sc_mcu9t5v0__filltie
* cell instance $10703 m0 *1 849.52,453.6
X$10703 1280 1109 gf180mcu_fd_sc_mcu9t5v0__filltie
* cell instance $10704 m0 *1 953.12,524.16
X$10704 2362 2466 2472 2464 2561 2465 gf180mcu_fd_sc_mcu9t5v0__mux2_2
* cell instance $10705 m0 *1 849.52,423.36
X$10705 770 599 gf180mcu_fd_sc_mcu9t5v0__filltie
* cell instance $10706 m0 *1 849.52,544.32
X$10706 3093 2876 gf180mcu_fd_sc_mcu9t5v0__filltie
* cell instance $10707 r0 *1 878.64,544.32
X$10707 2982 2786 3101 2983 2992 3215 3093 3102
+ gf180mcu_fd_sc_mcu9t5v0__aoi221_1
* cell instance $10708 r0 *1 954.24,534.24
X$10708 2779 2786 2876 2775 2883 gf180mcu_fd_sc_mcu9t5v0__nand2_1
* cell instance $10709 r0 *1 952.56,544.32
X$10709 2989 2997 3105 2983 2992 3215 3093 2882
+ gf180mcu_fd_sc_mcu9t5v0__aoi221_1
* cell instance $10710 m0 *1 950.32,534.24
X$10710 2783 2466 2891 2668 2775 2781 gf180mcu_fd_sc_mcu9t5v0__mux2_1
* cell instance $10711 m0 *1 947.52,534.24
X$10711 2983 2781 2668 2775 2782 gf180mcu_fd_sc_mcu9t5v0__nand2_1
* cell instance $10712 r0 *1 941.92,534.24
X$10712 2248 2786 2997 2879 2880 2876 2775 2881
+ gf180mcu_fd_sc_mcu9t5v0__aoi221_1
* cell instance $10713 r0 *1 948.08,534.24
X$10713 2883 2882 2782 2881 3103 2876 2775 2877
+ gf180mcu_fd_sc_mcu9t5v0__aoi221_1
* cell instance $10714 r0 *1 913.92,534.24
X$10714 3229 3230 2777 2876 2775 2670 gf180mcu_fd_sc_mcu9t5v0__mux2_2
* cell instance $10715 m0 *1 849.52,483.84
X$10715 1790 1619 gf180mcu_fd_sc_mcu9t5v0__filltie
* cell instance $10716 m0 *1 932.96,544.32
X$10716 2244 2140 2986 2876 3093 2780 gf180mcu_fd_sc_mcu9t5v0__mux2_1
* cell instance $10717 m0 *1 927.36,534.24
X$10717 2780 2779 2573 2668 2775 2778 gf180mcu_fd_sc_mcu9t5v0__mux2_2
* cell instance $10718 m0 *1 850.64,544.32
X$10718 3228 2982 2573 2876 3093 3094 gf180mcu_fd_sc_mcu9t5v0__mux2_2
* cell instance $10719 r0 *1 904.96,544.32
X$10719 3229 2985 3446 3215 3093 3219 gf180mcu_fd_sc_mcu9t5v0__mux2_1
* cell instance $10720 r0 *1 884.8,544.32
X$10720 3218 3104 3095 3102 3103 3215 3093 3217
+ gf180mcu_fd_sc_mcu9t5v0__aoi221_1
* cell instance $10721 m0 *1 903.84,534.24
X$10721 2776 2669 2878 2668 2775 gf180mcu_fd_sc_mcu9t5v0__dffq_2
* cell instance $10722 m0 *1 849.52,504
X$10722 2138 2130 gf180mcu_fd_sc_mcu9t5v0__filltie
* cell instance $10723 r0 *1 907.76,524.16
X$10723 2670 2878 2472 2668 2561 2669 gf180mcu_fd_sc_mcu9t5v0__mux2_2
* cell instance $10724 r0 *1 949.2,514.08
X$10724 2776 2465 2466 2464 2361 gf180mcu_fd_sc_mcu9t5v0__dffq_2
* cell instance $10725 r0 *1 890.96,544.32
X$10725 3099 2786 3215 3093 3218 gf180mcu_fd_sc_mcu9t5v0__nand2_1
* cell instance $10726 m0 *1 849.52,393.12
X$10726 260 89 gf180mcu_fd_sc_mcu9t5v0__filltie
* cell instance $10727 m0 *1 849.52,383.04
X$10727 90 4 gf180mcu_fd_sc_mcu9t5v0__filltie
* cell instance $10728 r0 *1 849.52,372.96
X$10728 2 4 gf180mcu_fd_sc_mcu9t5v0__filltie
* cell instance $10729 m0 *1 849.52,413.28
X$10729 600 429 gf180mcu_fd_sc_mcu9t5v0__filltie
* cell instance $10730 m0 *1 849.52,403.2
X$10730 430 259 gf180mcu_fd_sc_mcu9t5v0__filltie
* cell instance $10731 m0 *1 1089.2,413.28
X$10731 600 429 gf180mcu_fd_sc_mcu9t5v0__filltie
* cell instance $10732 r0 *1 969.36,372.96
X$10732 2 4 gf180mcu_fd_sc_mcu9t5v0__filltie
* cell instance $10733 m0 *1 1089.2,383.04
X$10733 90 4 gf180mcu_fd_sc_mcu9t5v0__filltie
* cell instance $10734 r0 *1 969.36,383.04
X$10734 90 89 gf180mcu_fd_sc_mcu9t5v0__filltie
* cell instance $10735 m0 *1 1089.2,393.12
X$10735 260 89 gf180mcu_fd_sc_mcu9t5v0__filltie
* cell instance $10736 r0 *1 1089.2,372.96
X$10736 2 4 gf180mcu_fd_sc_mcu9t5v0__filltie
* cell instance $10737 m0 *1 1089.2,403.2
X$10737 430 259 gf180mcu_fd_sc_mcu9t5v0__filltie
* cell instance $10738 r0 *1 969.36,393.12
X$10738 260 259 gf180mcu_fd_sc_mcu9t5v0__filltie
* cell instance $10739 r0 *1 969.36,403.2
X$10739 430 429 gf180mcu_fd_sc_mcu9t5v0__filltie
* cell instance $10740 r0 *1 729.68,544.32
X$10740 3093 3215 gf180mcu_fd_sc_mcu9t5v0__filltie
* cell instance $10741 m0 *1 609.84,393.12
X$10741 260 89 gf180mcu_fd_sc_mcu9t5v0__filltie
* cell instance $10742 r0 *1 729.68,524.16
X$10742 2561 2668 gf180mcu_fd_sc_mcu9t5v0__filltie
* cell instance $10743 r0 *1 729.68,463.68
X$10743 1450 1449 gf180mcu_fd_sc_mcu9t5v0__filltie
* cell instance $10744 r0 *1 729.68,534.24
X$10744 2775 2876 gf180mcu_fd_sc_mcu9t5v0__filltie
* cell instance $10745 r0 *1 729.68,403.2
X$10745 430 429 gf180mcu_fd_sc_mcu9t5v0__filltie
* cell instance $10746 m0 *1 609.84,463.68
X$10746 1450 1279 gf180mcu_fd_sc_mcu9t5v0__filltie
* cell instance $10747 r0 *1 729.68,493.92
X$10747 1959 2130 gf180mcu_fd_sc_mcu9t5v0__filltie
* cell instance $10748 m0 *1 609.84,504
X$10748 2138 2130 gf180mcu_fd_sc_mcu9t5v0__filltie
* cell instance $10749 m0 *1 609.84,403.2
X$10749 430 259 gf180mcu_fd_sc_mcu9t5v0__filltie
* cell instance $10750 m0 *1 609.84,534.24
X$10750 2775 2668 gf180mcu_fd_sc_mcu9t5v0__filltie
* cell instance $10751 r0 *1 609.84,372.96
X$10751 2 4 gf180mcu_fd_sc_mcu9t5v0__filltie
* cell instance $10752 m0 *1 609.84,423.36
X$10752 770 599 gf180mcu_fd_sc_mcu9t5v0__filltie
* cell instance $10753 r0 *1 729.68,443.52
X$10753 1110 1109 gf180mcu_fd_sc_mcu9t5v0__filltie
* cell instance $10754 r0 *1 729.68,433.44
X$10754 940 939 gf180mcu_fd_sc_mcu9t5v0__filltie
* cell instance $10755 r0 *1 729.68,504
X$10755 2138 2243 gf180mcu_fd_sc_mcu9t5v0__filltie
* cell instance $10756 m0 *1 609.84,453.6
X$10756 1280 1109 gf180mcu_fd_sc_mcu9t5v0__filltie
* cell instance $10757 r0 *1 729.68,473.76
X$10757 1620 1619 gf180mcu_fd_sc_mcu9t5v0__filltie
* cell instance $10758 m0 *1 609.84,524.16
X$10758 2561 2464 gf180mcu_fd_sc_mcu9t5v0__filltie
* cell instance $10759 m0 *1 609.84,493.92
X$10759 1959 1789 gf180mcu_fd_sc_mcu9t5v0__filltie
* cell instance $10760 r0 *1 729.68,393.12
X$10760 260 259 gf180mcu_fd_sc_mcu9t5v0__filltie
* cell instance $10761 r0 *1 729.68,483.84
X$10761 1790 1789 gf180mcu_fd_sc_mcu9t5v0__filltie
* cell instance $10762 m0 *1 609.84,473.76
X$10762 1620 1449 gf180mcu_fd_sc_mcu9t5v0__filltie
* cell instance $10763 m0 *1 609.84,514.08
X$10763 2361 2243 gf180mcu_fd_sc_mcu9t5v0__filltie
* cell instance $10764 r0 *1 729.68,383.04
X$10764 90 89 gf180mcu_fd_sc_mcu9t5v0__filltie
* cell instance $10765 r0 *1 729.68,453.6
X$10765 1280 1279 gf180mcu_fd_sc_mcu9t5v0__filltie
* cell instance $10766 m0 *1 609.84,443.52
X$10766 1110 939 gf180mcu_fd_sc_mcu9t5v0__filltie
* cell instance $10767 m0 *1 609.84,483.84
X$10767 1790 1619 gf180mcu_fd_sc_mcu9t5v0__filltie
* cell instance $10768 r0 *1 729.68,423.36
X$10768 770 769 gf180mcu_fd_sc_mcu9t5v0__filltie
* cell instance $10769 m0 *1 609.84,413.28
X$10769 600 429 gf180mcu_fd_sc_mcu9t5v0__filltie
* cell instance $10770 m0 *1 609.84,544.32
X$10770 3093 2876 gf180mcu_fd_sc_mcu9t5v0__filltie
* cell instance $10771 m0 *1 609.84,383.04
X$10771 90 4 gf180mcu_fd_sc_mcu9t5v0__filltie
* cell instance $10772 r0 *1 729.68,413.28
X$10772 600 599 gf180mcu_fd_sc_mcu9t5v0__filltie
* cell instance $10773 m0 *1 609.84,433.44
X$10773 940 769 gf180mcu_fd_sc_mcu9t5v0__filltie
* cell instance $10774 r0 *1 729.68,514.08
X$10774 2361 2464 gf180mcu_fd_sc_mcu9t5v0__filltie
* cell instance $10775 r0 *1 729.68,372.96
X$10775 2 4 gf180mcu_fd_sc_mcu9t5v0__filltie
* cell instance $10776 r0 *1 1647.52,1058.4
X$10776 16485 16340 16506 16309 15891 16487 gf180mcu_fd_sc_mcu9t5v0__xnor3_1
* cell instance $10777 m0 *1 1639.68,1078.56
X$10777 15043 16819 16487 14696 16784 16956 gf180mcu_fd_sc_mcu9t5v0__dffrnq_2
* cell instance $10778 r0 *1 1642.48,1098.72
X$10778 15043 17555 17556 14696 17709 17521 gf180mcu_fd_sc_mcu9t5v0__dffrnq_2
* cell instance $10779 m0 *1 1654.24,1048.32
X$10779 15043 15910 15761 14696 15898 16008 gf180mcu_fd_sc_mcu9t5v0__dffrnq_2
* cell instance $10780 r0 *1 1657.04,1078.56
X$10780 15043 17112 13737 14696 17123 16956 gf180mcu_fd_sc_mcu9t5v0__dffrnq_2
* cell instance $10781 m0 *1 1655.36,1058.4
X$10781 16341 16211 16194 16309 16342 gf180mcu_fd_sc_mcu9t5v0__nor2_1
* cell instance $10782 m0 *1 1657.04,1038.24
X$10782 15594 15576 15737 15171 gf180mcu_fd_sc_mcu9t5v0__clkinv_1
* cell instance $10783 m0 *1 1655.92,1028.16
X$10783 15425 15171 15271 15402 15174 gf180mcu_fd_sc_mcu9t5v0__nor2_1
* cell instance $10784 r0 *1 1654.24,1018.08
X$10784 15172 15173 15174 15271 15138 15045 gf180mcu_fd_sc_mcu9t5v0__aoi21_1
* cell instance $10785 m0 *1 1639.68,997.92
X$10785 15043 14697 13183 14696 14406 14448 gf180mcu_fd_sc_mcu9t5v0__dffrnq_2
* cell instance $10786 m0 *1 1654.8,1018.08
X$10786 15046 15045 14967 15138 14698 gf180mcu_fd_sc_mcu9t5v0__xnor2_1
* cell instance $10787 m0 *1 1568.56,554.4
X$10787 3227 3215 gf180mcu_fd_sc_mcu9t5v0__filltie
* cell instance $10788 m0 *1 1263.92,554.4
X$10788 3464 3127 2273 2471 2987 3106 3215 3227 3466
+ gf180mcu_fd_sc_mcu9t5v0__mux4_1
* cell instance $10789 m0 *1 1234.8,554.4
X$10789 2684 3122 3225 2469 2987 3106 3215 3227 3246
+ gf180mcu_fd_sc_mcu9t5v0__mux4_1
* cell instance $10790 m0 *1 1285.76,554.4
X$10790 2791 2275 3128 3247 3120 3121 3215 3227 3248
+ gf180mcu_fd_sc_mcu9t5v0__mux4_1
* cell instance $10791 m0 *1 1328.88,554.4
X$10791 3227 3215 gf180mcu_fd_sc_mcu9t5v0__filltie
* cell instance $10792 m0 *1 1308.72,554.4
X$10792 3459 3130 3215 3227 3249 gf180mcu_fd_sc_mcu9t5v0__nand2_1
* cell instance $10793 m0 *1 1155.84,554.4
X$10793 3118 3238 2154 2789 2987 3106 3215 3227 3240
+ gf180mcu_fd_sc_mcu9t5v0__mux4_1
* cell instance $10794 m0 *1 1209.6,554.4
X$10794 3578 3242 2268 2681 2987 3106 3215 3227 3243
+ gf180mcu_fd_sc_mcu9t5v0__mux4_1
* cell instance $10795 m0 *1 1174.88,554.4
X$10795 2580 3119 2375 2468 2987 3106 3215 3227 3241
+ gf180mcu_fd_sc_mcu9t5v0__mux4_1
* cell instance $10796 m0 *1 1192.24,554.4
X$10796 2268 2681 3578 3242 3120 3121 3215 3227 3357
+ gf180mcu_fd_sc_mcu9t5v0__mux4_1
* cell instance $10797 m0 *1 1226.96,554.4
X$10797 3245 3123 3239 3215 3227 3244 gf180mcu_fd_sc_mcu9t5v0__mux2_1
* cell instance $10798 m0 *1 1137.36,554.4
X$10798 2789 2260 3238 3116 3239 3109 3215 3227 3350
+ gf180mcu_fd_sc_mcu9t5v0__mux4_1
* cell instance $10799 m0 *1 1113.84,554.4
X$10799 2257 2256 2788 3215 3227 3003 gf180mcu_fd_sc_mcu9t5v0__mux2_1
* cell instance $10800 r180 *1 1864.8,554.4
X$10800 33934 33830 gf180mcu_fd_sc_mcu9t5v0__endcap
* cell instance $10801 m0 *1 1808.24,554.4
X$10801 3227 3215 gf180mcu_fd_sc_mcu9t5v0__filltie
* cell instance $10802 r90 *1 2210,505
X$10802 3008 33658 33657 33656 33655 33654 33653 33652 33651 33650 33649 33648
+ 33647 33646 33645 33644 33643 33642 33641 33640 33639 33638 33637 33636 33635
+ 33634 33633 33632 33631 33630 33629 33628 33627 33626 33625 33624 33623 33622
+ 33621 33620 33619 33618 33617 33616 33615 33614 33613 2379 33612 33611 33610
+ 33609 33608 33607 33606 33605 33604 33603 33602 33601 33600 33599 33598 33597
+ 33596 33595 33594 33593 33592 33591 33590 33589 33588 33587 33586 33585 33584
+ 2378 33583 33582 33581 2379 2378 2378 2378 2378 3797 2379 gf180mcu_fd_io__bi_t
* cell instance $10803 r90 *1 2210,580
X$10803 4919 33658 33657 33656 33655 33654 33653 33652 33651 33650 33649 33648
+ 33647 33646 33645 33644 33643 33642 33641 33640 33639 33638 33637 33636 33635
+ 33634 33633 33632 33631 33630 33629 33628 33627 33626 33625 33624 33623 33622
+ 33621 33620 33619 33618 33617 33616 33615 33614 33613 4161 33612 33611 33610
+ 33609 33608 33607 33606 33605 33604 33603 33602 33601 33600 33599 33598 33597
+ 33596 33595 33594 33593 33592 33591 33590 33589 33588 33587 33586 33585 33584
+ 4062 33583 33582 33581 4161 4062 4062 4062 4062 5672 4161 gf180mcu_fd_io__bi_t
* cell instance $10804 r90 *1 2210,1030
X$10804 16692 33658 33657 33656 33655 33654 33653 33652 33651 33650 33649 33648
+ 33647 33646 33645 33644 33643 33642 33641 33640 33639 33638 33637 33636 33635
+ 33634 33633 33632 33631 33630 33629 33628 33627 33626 33625 33624 33623 33622
+ 33621 33620 33619 33618 33617 33616 33615 33614 33613 15765 33612 33611 33610
+ 33609 33608 33607 33606 33605 33604 33603 33602 33601 33600 33599 33598 33597
+ 33596 33595 33594 33593 33592 33591 33590 33589 33588 33587 33586 33585 33584
+ 15764 33583 33582 33581 15765 15764 15764 15764 15764 17595 15765
+ gf180mcu_fd_io__bi_t
* cell instance $10805 r90 *1 2210,880
X$10805 12418 33658 33657 33656 33655 33654 33653 33652 33651 33650 33649 33648
+ 33647 33646 33645 33644 33643 33642 33641 33640 33639 33638 33637 33636 33635
+ 33634 33633 33632 33631 33630 33629 33628 33627 33626 33625 33624 33623 33622
+ 33621 33620 33619 33618 33617 33616 33615 33614 33613 13228 33612 33611 33610
+ 33609 33608 33607 33606 33605 33604 33603 33602 33601 33600 33599 33598 33597
+ 33596 33595 33594 33593 33592 33591 33590 33589 33588 33587 33586 33585 33584
+ 11624 33583 33582 33581 13228 11624 11624 11624 11624 13436 13228
+ gf180mcu_fd_io__bi_t
* cell instance $10806 r90 *1 2210,955
X$10806 14437 33658 33657 33656 33655 33654 33653 33652 33651 33650 33649 33648
+ 33647 33646 33645 33644 33643 33642 33641 33640 33639 33638 33637 33636 33635
+ 33634 33633 33632 33631 33630 33629 33628 33627 33626 33625 33624 33623 33622
+ 33621 33620 33619 33618 33617 33616 33615 33614 33613 13600 33612 33611 33610
+ 33609 33608 33607 33606 33605 33604 33603 33602 33601 33600 33599 33598 33597
+ 33596 33595 33594 33593 33592 33591 33590 33589 33588 33587 33586 33585 33584
+ 13498 33583 33582 33581 13600 13498 13498 13498 13498 15267 13600
+ gf180mcu_fd_io__bi_t
* cell instance $10807 r90 *1 2210,805
X$10807 10480 33658 33657 33656 33655 33654 33653 33652 33651 33650 33649 33648
+ 33647 33646 33645 33644 33643 33642 33641 33640 33639 33638 33637 33636 33635
+ 33634 33633 33632 33631 33630 33629 33628 33627 33626 33625 33624 33623 33622
+ 33621 33620 33619 33618 33617 33616 33615 33614 33613 9835 33612 33611 33610
+ 33609 33608 33607 33606 33605 33604 33603 33602 33601 33600 33599 33598 33597
+ 33596 33595 33594 33593 33592 33591 33590 33589 33588 33587 33586 33585 33584
+ 9716 33583 33582 33581 9835 9716 9716 9716 9716 11319 9835
+ gf180mcu_fd_io__bi_t
* cell instance $10808 r90 *1 2210,655
X$10808 6683 33658 33657 33656 33655 33654 33653 33652 33651 33650 33649 33648
+ 33647 33646 33645 33644 33643 33642 33641 33640 33639 33638 33637 33636 33635
+ 33634 33633 33632 33631 33630 33629 33628 33627 33626 33625 33624 33623 33622
+ 33621 33620 33619 33618 33617 33616 33615 33614 33613 6031 33612 33611 33610
+ 33609 33608 33607 33606 33605 33604 33603 33602 33601 33600 33599 33598 33597
+ 33596 33595 33594 33593 33592 33591 33590 33589 33588 33587 33586 33585 33584
+ 5932 33583 33582 33581 6031 5932 5932 5932 5932 7569 6031 gf180mcu_fd_io__bi_t
* cell instance $10809 r90 *1 2210,730
X$10809 8601 33658 33657 33656 33655 33654 33653 33652 33651 33650 33649 33648
+ 33647 33646 33645 33644 33643 33642 33641 33640 33639 33638 33637 33636 33635
+ 33634 33633 33632 33631 33630 33629 33628 33627 33626 33625 33624 33623 33622
+ 33621 33620 33619 33618 33617 33616 33615 33614 33613 7943 33612 33611 33610
+ 33609 33608 33607 33606 33605 33604 33603 33602 33601 33600 33599 33598 33597
+ 33596 33595 33594 33593 33592 33591 33590 33589 33588 33587 33586 33585 33584
+ 7831 33583 33582 33581 7943 7831 7831 7831 7831 9453 7943 gf180mcu_fd_io__bi_t
* cell instance $10810 m90 *1 1864.8,826.56
X$10810 33948 33838 gf180mcu_fd_sc_mcu9t5v0__endcap
* cell instance $10811 r0 *1 1688.4,826.56
X$10811 10078 10188 gf180mcu_fd_sc_mcu9t5v0__filltie
* cell instance $10812 r180 *1 1864.8,967.68
X$10812 33935 33864 gf180mcu_fd_sc_mcu9t5v0__endcap
* cell instance $10813 m0 *1 1808.24,967.68
X$10813 13719 13586 gf180mcu_fd_sc_mcu9t5v0__filltie
* cell instance $10814 m90 *1 1864.8,1038.24
X$10814 33938 33865 gf180mcu_fd_sc_mcu9t5v0__endcap
* cell instance $10815 m0 *1 1808.24,1048.32
X$10815 16008 15898 gf180mcu_fd_sc_mcu9t5v0__filltie
* cell instance $10816 r180 *1 1864.8,1048.32
X$10816 33936 33865 gf180mcu_fd_sc_mcu9t5v0__endcap
* cell instance $10817 m90 *1 1864.8,1048.32
X$10817 33936 33837 gf180mcu_fd_sc_mcu9t5v0__endcap
* cell instance $10818 m0 *1 1808.24,1058.4
X$10818 16309 16194 gf180mcu_fd_sc_mcu9t5v0__filltie
* cell instance $10819 m0 *1 1808.24,1068.48
X$10819 16653 16506 gf180mcu_fd_sc_mcu9t5v0__filltie
* cell instance $10820 r180 *1 1864.8,1058.4
X$10820 33888 33837 gf180mcu_fd_sc_mcu9t5v0__endcap
* cell instance $10821 m0 *1 1808.24,1008
X$10821 14857 14708 gf180mcu_fd_sc_mcu9t5v0__filltie
* cell instance $10822 r180 *1 1864.8,1028.16
X$10822 33937 33824 gf180mcu_fd_sc_mcu9t5v0__endcap
* cell instance $10823 m0 *1 1808.24,1018.08
X$10823 15138 14967 gf180mcu_fd_sc_mcu9t5v0__filltie
* cell instance $10824 m0 *1 1808.24,1028.16
X$10824 15402 15271 gf180mcu_fd_sc_mcu9t5v0__filltie
* cell instance $10825 m90 *1 1864.8,1028.16
X$10825 33937 33866 gf180mcu_fd_sc_mcu9t5v0__endcap
* cell instance $10826 r180 *1 1864.8,1038.24
X$10826 33938 33866 gf180mcu_fd_sc_mcu9t5v0__endcap
* cell instance $10827 r180 *1 1864.8,997.92
X$10827 33889 33867 gf180mcu_fd_sc_mcu9t5v0__endcap
* cell instance $10828 r180 *1 1864.8,1008
X$10828 33939 33868 gf180mcu_fd_sc_mcu9t5v0__endcap
* cell instance $10829 m90 *1 1864.8,997.92
X$10829 33889 33868 gf180mcu_fd_sc_mcu9t5v0__endcap
* cell instance $10830 r180 *1 1864.8,987.84
X$10830 33940 33869 gf180mcu_fd_sc_mcu9t5v0__endcap
* cell instance $10831 m0 *1 1808.24,997.92
X$10831 14448 14406 gf180mcu_fd_sc_mcu9t5v0__filltie
* cell instance $10832 m90 *1 1864.8,1018.08
X$10832 33941 33824 gf180mcu_fd_sc_mcu9t5v0__endcap
* cell instance $10833 m90 *1 1864.8,1008
X$10833 33939 33823 gf180mcu_fd_sc_mcu9t5v0__endcap
* cell instance $10834 m90 *1 1864.8,967.68
X$10834 33935 33822 gf180mcu_fd_sc_mcu9t5v0__endcap
* cell instance $10835 m0 *1 1808.24,1088.64
X$10835 17289 17123 gf180mcu_fd_sc_mcu9t5v0__filltie
* cell instance $10836 m0 *1 1808.24,1038.24
X$10836 15737 15576 gf180mcu_fd_sc_mcu9t5v0__filltie
* cell instance $10837 m0 *1 1808.24,987.84
X$10837 14304 14126 gf180mcu_fd_sc_mcu9t5v0__filltie
* cell instance $10838 r180 *1 1864.8,1018.08
X$10838 33941 33823 gf180mcu_fd_sc_mcu9t5v0__endcap
* cell instance $10839 r180 *1 1864.8,977.76
X$10839 33942 33822 gf180mcu_fd_sc_mcu9t5v0__endcap
* cell instance $10840 m0 *1 1808.24,977.76
X$10840 14009 13832 gf180mcu_fd_sc_mcu9t5v0__filltie
* cell instance $10841 m90 *1 1864.8,1058.4
X$10841 33888 33870 gf180mcu_fd_sc_mcu9t5v0__endcap
* cell instance $10842 m0 *1 1808.24,1098.72
X$10842 17521 17398 gf180mcu_fd_sc_mcu9t5v0__filltie
* cell instance $10843 r180 *1 1864.8,1068.48
X$10843 33887 33870 gf180mcu_fd_sc_mcu9t5v0__endcap
* cell instance $10844 m90 *1 1864.8,1068.48
X$10844 33887 33821 gf180mcu_fd_sc_mcu9t5v0__endcap
* cell instance $10845 r180 *1 1864.8,1078.56
X$10845 33943 33821 gf180mcu_fd_sc_mcu9t5v0__endcap
* cell instance $10846 m0 *1 1808.24,1078.56
X$10846 16956 16784 gf180mcu_fd_sc_mcu9t5v0__filltie
* cell instance $10847 m90 *1 1864.8,987.84
X$10847 33940 33867 gf180mcu_fd_sc_mcu9t5v0__endcap
* cell instance $10848 m90 *1 1864.8,1078.56
X$10848 33943 33871 gf180mcu_fd_sc_mcu9t5v0__endcap
* cell instance $10849 r180 *1 1864.8,1088.64
X$10849 33944 33871 gf180mcu_fd_sc_mcu9t5v0__endcap
* cell instance $10850 m90 *1 1864.8,1088.64
X$10850 33944 33872 gf180mcu_fd_sc_mcu9t5v0__endcap
* cell instance $10851 m90 *1 1864.8,977.76
X$10851 33942 33869 gf180mcu_fd_sc_mcu9t5v0__endcap
* cell instance $10852 r180 *1 1864.8,1098.72
X$10852 33945 33872 gf180mcu_fd_sc_mcu9t5v0__endcap
* cell instance $10853 m90 *1 1864.8,1098.72
X$10853 33945 33829 gf180mcu_fd_sc_mcu9t5v0__endcap
* cell instance $10854 m0 *1 1724.8,1058.4
X$10854 16215 16348 16346 16194 16309 16349 gf180mcu_fd_sc_mcu9t5v0__and3_1
* cell instance $10855 r0 *1 1688.4,1078.56
X$10855 16956 17123 gf180mcu_fd_sc_mcu9t5v0__filltie
* cell instance $10856 m0 *1 1722.56,1058.4
X$10856 16347 16194 16309 16348 gf180mcu_fd_sc_mcu9t5v0__clkinv_1
* cell instance $10857 r0 *1 1713.04,1058.4
X$10857 16215 16491 16506 16309 16213 gf180mcu_fd_sc_mcu9t5v0__nand2_1
* cell instance $10858 m0 *1 1706.88,1068.48
X$10858 16215 16551 16506 16653 16345 gf180mcu_fd_sc_mcu9t5v0__nand2_1
* cell instance $10859 m0 *1 1734.88,1078.56
X$10859 16690 16821 16938 16784 16956 16990 gf180mcu_fd_sc_mcu9t5v0__aoi21_1
* cell instance $10860 m0 *1 1724.8,1068.48
X$10860 16215 16348 16346 16506 16653 16691 gf180mcu_fd_sc_mcu9t5v0__nor3_1
* cell instance $10861 r0 *1 1701.28,1098.72
X$10861 16215 17709 17521 17613 17612 gf180mcu_fd_sc_mcu9t5v0__xor2_1
* cell instance $10862 m0 *1 1709.68,1068.48
X$10862 16214 16506 16653 16212 gf180mcu_fd_sc_mcu9t5v0__clkinv_1
* cell instance $10863 r0 *1 1701.84,1058.4
X$10863 16344 16212 16343 16506 16309 15763 gf180mcu_fd_sc_mcu9t5v0__oai21_1
* cell instance $10864 r0 *1 1706.88,1048.32
X$10864 16213 15763 16194 16008 16179 gf180mcu_fd_sc_mcu9t5v0__nand2_1
* cell instance $10865 r0 *1 1700.16,1048.32
X$10865 16550 16194 16008 16179 15429 gf180mcu_fd_sc_mcu9t5v0__xor2_1
* cell instance $10866 r0 *1 1706.32,1058.4
X$10866 16215 16506 16309 16491 16343 gf180mcu_fd_sc_mcu9t5v0__xor2_1
* cell instance $10867 m0 *1 1700.16,1068.48
X$10867 16215 16506 16653 16551 16550 gf180mcu_fd_sc_mcu9t5v0__xor2_1
* cell instance $10868 r0 *1 1697.92,1058.4
X$10868 16344 16343 16550 16506 16309 16490 gf180mcu_fd_sc_mcu9t5v0__nand3_1
* cell instance $10869 r0 *1 1708,1098.72
X$10869 17736 17613 16215 17709 17521 16214 gf180mcu_fd_sc_mcu9t5v0__oai21_1
* cell instance $10870 m0 *1 1705.2,1058.4
X$10870 16213 16345 16490 16214 16194 16309 16346
+ gf180mcu_fd_sc_mcu9t5v0__and4_1
* cell instance $10871 r0 *1 1718.64,1058.4
X$10871 16215 16346 16506 16309 15892 16347 gf180mcu_fd_sc_mcu9t5v0__xnor3_1
* cell instance $10872 m0 *1 1700.72,1058.4
X$10872 16344 16343 16212 16194 16309 15728 gf180mcu_fd_sc_mcu9t5v0__nor3_1
* cell instance $10873 r0 *1 1688.4,1088.64
X$10873 17289 17398 gf180mcu_fd_sc_mcu9t5v0__filltie
* cell instance $10874 r0 *1 1700.16,1078.56
X$10874 15043 16989 16491 14696 17123 16956 gf180mcu_fd_sc_mcu9t5v0__dffrnq_2
* cell instance $10875 r0 *1 1691.2,1098.72
X$10875 17612 17737 17709 17521 17305 gf180mcu_fd_sc_mcu9t5v0__xnor2_1
* cell instance $10876 r0 *1 1689.52,1088.64
X$10876 17425 17305 15890 17398 17289 17558 gf180mcu_fd_sc_mcu9t5v0__mux2_1
* cell instance $10877 r0 *1 1731.52,1058.4
X$10877 16349 16691 16506 16309 16552 gf180mcu_fd_sc_mcu9t5v0__nor2_1
* cell instance $10878 r0 *1 1675.52,1068.48
X$10878 16489 16818 16784 16653 16820 gf180mcu_fd_sc_mcu9t5v0__nand2_1
* cell instance $10879 r0 *1 1671.04,1068.48
X$10879 16690 16818 16820 16784 16653 16549 gf180mcu_fd_sc_mcu9t5v0__oai21_1
* cell instance $10880 r0 *1 1673.84,1058.4
X$10880 16489 16342 16506 16309 16039 gf180mcu_fd_sc_mcu9t5v0__xnor2_1
* cell instance $10881 m0 *1 1661.52,1078.56
X$10881 13737 14872 16784 16956 16988 gf180mcu_fd_sc_mcu9t5v0__nand2_1
* cell instance $10882 m0 *1 1677.76,1048.32
X$10882 16040 16039 15890 15898 16008 15911 gf180mcu_fd_sc_mcu9t5v0__mux2_1
* cell instance $10883 r0 *1 1789.76,1098.72
X$10883 17709 17521 15765 gf180mcu_fd_sc_mcu9t5v0__tieh
* cell instance $10884 m0 *1 1664.88,1098.72
X$10884 17425 17398 17521 17424 gf180mcu_fd_sc_mcu9t5v0__clkinv_1
* cell instance $10885 m0 *1 1663.2,1088.64
X$10885 14872 17277 17278 16988 17123 17289 17112
+ gf180mcu_fd_sc_mcu9t5v0__oai31_1
* cell instance $10886 m0 *1 1666.56,1068.48
X$10886 15043 16549 16489 14696 16506 16653 gf180mcu_fd_sc_mcu9t5v0__dffrnq_2
* cell instance $10887 m0 *1 1667.12,1098.72
X$10887 17425 17556 17398 17521 17557 gf180mcu_fd_sc_mcu9t5v0__xnor2_1
* cell instance $10888 r0 *1 1780.24,1098.72
X$10888 17709 17521 15764 gf180mcu_fd_sc_mcu9t5v0__tiel
* cell instance $10889 m0 *1 1673.84,1098.72
X$10889 17557 17426 17398 17521 17278 gf180mcu_fd_sc_mcu9t5v0__nor2_1
* cell instance $10890 r0 *1 1668.24,1098.72
X$10890 17425 17709 17521 17556 17611 gf180mcu_fd_sc_mcu9t5v0__xor2_1
* cell instance $10891 r0 *1 1662.64,1088.64
X$10891 17424 17556 17277 17398 17289 15173 gf180mcu_fd_sc_mcu9t5v0__aoi21_1
* cell instance $10892 m0 *1 1789.76,1028.16
X$10892 15271 15402 13600 gf180mcu_fd_sc_mcu9t5v0__tieh
* cell instance $10893 m0 *1 1780.24,1028.16
X$10893 15271 15402 13498 gf180mcu_fd_sc_mcu9t5v0__tiel
* cell instance $10894 m0 *1 1683.36,1078.56
X$10894 15043 16936 16551 14696 16784 16956 gf180mcu_fd_sc_mcu9t5v0__dffrnq_2
* cell instance $10895 m0 *1 1686.16,1038.24
X$10895 16040 15595 15576 15737 14842 15726 gf180mcu_fd_sc_mcu9t5v0__xnor3_1
* cell instance $10896 r0 *1 1681.68,1028.16
X$10896 15562 15762 15427 15576 15402 15595 gf180mcu_fd_sc_mcu9t5v0__oai21_1
* cell instance $10897 r0 *1 1668.8,1028.16
X$10897 15593 15576 15402 15426 gf180mcu_fd_sc_mcu9t5v0__clkinv_1
* cell instance $10898 r0 *1 1658.16,1038.24
X$10898 15761 15891 15890 15898 15737 15910 gf180mcu_fd_sc_mcu9t5v0__mux2_1
* cell instance $10899 m0 *1 1671.6,1028.16
X$10899 15426 15301 15271 15402 15302 gf180mcu_fd_sc_mcu9t5v0__nor2_1
* cell instance $10900 m0 *1 1682.8,1038.24
X$10900 15761 15576 15737 15562 gf180mcu_fd_sc_mcu9t5v0__clkinv_1
* cell instance $10901 r0 *1 1674.96,1018.08
X$10901 15302 15175 15176 15271 15138 15177 gf180mcu_fd_sc_mcu9t5v0__or3_1
* cell instance $10902 r0 *1 1681.12,1018.08
X$10902 15427 15177 14872 15271 15138 15163 gf180mcu_fd_sc_mcu9t5v0__aoi21_1
* cell instance $10903 m0 *1 1663.2,1028.16
X$10903 15593 15271 15402 15301 15046 gf180mcu_fd_sc_mcu9t5v0__xor2_1
* cell instance $10904 r0 *1 1658.72,1018.08
X$10904 15172 15173 15174 15046 15271 15138 15175
+ gf180mcu_fd_sc_mcu9t5v0__aoi211_1
* cell instance $10905 m0 *1 1676.08,1038.24
X$10905 15761 15762 15576 15737 15176 gf180mcu_fd_sc_mcu9t5v0__xnor2_1
* cell instance $10906 m0 *1 1675.52,1028.16
X$10906 15302 15175 15176 15271 15402 15427 gf180mcu_fd_sc_mcu9t5v0__oai21_1
* cell instance $10907 m0 *1 1699.04,1038.24
X$10907 15171 15890 15728 15727 15576 15737 15725
+ gf180mcu_fd_sc_mcu9t5v0__oai22_1
* cell instance $10908 m0 *1 1690.64,1008
X$10908 14842 14841 14872 14708 14857 14874 gf180mcu_fd_sc_mcu9t5v0__mux2_1
* cell instance $10909 r0 *1 1688.4,1028.16
X$10909 15402 15576 gf180mcu_fd_sc_mcu9t5v0__filltie
* cell instance $10910 r0 *1 1688.4,987.84
X$10910 14304 14406 gf180mcu_fd_sc_mcu9t5v0__filltie
* cell instance $10911 r0 *1 1688.4,977.76
X$10911 14009 14126 gf180mcu_fd_sc_mcu9t5v0__filltie
* cell instance $10912 r0 *1 1689.52,1008
X$10912 5293 14874 14841 14696 14967 14857 gf180mcu_fd_sc_mcu9t5v0__dffrnq_2
* cell instance $10913 r0 *1 1688.4,1018.08
X$10913 15138 15271 gf180mcu_fd_sc_mcu9t5v0__filltie
* cell instance $10914 r0 *1 1688.4,1008
X$10914 14857 14967 gf180mcu_fd_sc_mcu9t5v0__filltie
* cell instance $10915 r0 *1 1696.8,1028.16
X$10915 15043 15428 15301 14696 15576 15402 gf180mcu_fd_sc_mcu9t5v0__dffrnq_2
* cell instance $10916 m0 *1 1713.6,1038.24
X$10916 15043 15729 15762 14696 15576 15737 gf180mcu_fd_sc_mcu9t5v0__dffrnq_2
* cell instance $10917 m0 *1 1701.28,1028.16
X$10917 15301 15429 15890 15271 15402 15428 gf180mcu_fd_sc_mcu9t5v0__mux2_1
* cell instance $10918 r0 *1 1688.4,997.92
X$10918 14448 14708 gf180mcu_fd_sc_mcu9t5v0__filltie
* cell instance $10919 r0 *1 1688.4,967.68
X$10919 13719 13832 gf180mcu_fd_sc_mcu9t5v0__filltie
* cell instance $10920 m0 *1 1685.6,1068.48
X$10920 3930 16506 16653 15043 gf180mcu_fd_sc_mcu9t5v0__clkbuf_8
* cell instance $10921 m0 *1 1680.56,1098.72
X$10921 15043 17558 17425 14696 17398 17521 gf180mcu_fd_sc_mcu9t5v0__dffrnq_2
* cell instance $10922 r0 *1 1720.88,1038.24
X$10922 15762 15892 15890 15898 15737 15729 gf180mcu_fd_sc_mcu9t5v0__mux2_1
* cell instance $10923 r0 *1 1669.36,1048.32
X$10923 15043 15911 16040 14696 16194 16008 gf180mcu_fd_sc_mcu9t5v0__dffrnq_2
* cell instance $10924 r0 *1 1688.4,1038.24
X$10924 15737 15898 gf180mcu_fd_sc_mcu9t5v0__filltie
* cell instance $10925 r0 *1 1685.6,1058.4
X$10925 15043 16506 16309 33575 gf180mcu_fd_sc_mcu9t5v0__clkinv_1
* cell instance $10926 r0 *1 1700.16,1038.24
X$10926 15890 15763 15898 15737 15727 gf180mcu_fd_sc_mcu9t5v0__nand2_1
* cell instance $10927 m0 *1 1736,1048.32
X$10927 15043 16041 15726 14696 15898 16008 gf180mcu_fd_sc_mcu9t5v0__dffrnq_2
* cell instance $10928 r0 *1 1688.4,1048.32
X$10928 16008 16194 gf180mcu_fd_sc_mcu9t5v0__filltie
* cell instance $10929 m0 *1 1713.6,1078.56
X$10929 15043 16937 16347 14696 16784 16956 gf180mcu_fd_sc_mcu9t5v0__dffrnq_2
* cell instance $10930 r0 *1 1730.4,1078.56
X$10930 15043 16990 16492 14696 17123 16956 gf180mcu_fd_sc_mcu9t5v0__dffrnq_2
* cell instance $10931 r0 *1 1688.4,1098.72
X$10931 17521 17709 gf180mcu_fd_sc_mcu9t5v0__filltie
* cell instance $10932 r0 *1 1719.2,1078.56
X$10932 16347 16689 16821 17123 16956 16937 gf180mcu_fd_sc_mcu9t5v0__mux2_1
* cell instance $10933 r0 *1 1689.52,1068.48
X$10933 16551 16688 16821 16784 16653 16936 gf180mcu_fd_sc_mcu9t5v0__mux2_1
* cell instance $10934 m0 *1 1705.2,1078.56
X$10934 16491 16935 16821 16784 16956 16989 gf180mcu_fd_sc_mcu9t5v0__mux2_1
* cell instance $10935 r0 *1 1720.32,1098.72
X$10935 17614 16208 14872 17709 17521 17739 gf180mcu_fd_sc_mcu9t5v0__mux2_1
* cell instance $10936 r0 *1 1738.24,1058.4
X$10936 16492 16552 16506 16309 16180 gf180mcu_fd_sc_mcu9t5v0__xnor2_1
* cell instance $10937 m0 *1 1739.36,1078.56
X$10937 16492 16821 16784 16956 16938 gf180mcu_fd_sc_mcu9t5v0__nor2_1
* cell instance $10938 r0 *1 1688.4,1058.4
X$10938 16309 16506 gf180mcu_fd_sc_mcu9t5v0__filltie
* cell instance $10939 r0 *1 1740.48,1048.32
X$10939 15726 16180 15890 16194 16008 16041 gf180mcu_fd_sc_mcu9t5v0__mux2_1
* cell instance $10940 r0 *1 1688.4,1068.48
X$10940 16653 16784 gf180mcu_fd_sc_mcu9t5v0__filltie
* cell instance $10941 r0 *1 1688.4,957.6
X$10941 13428 13586 gf180mcu_fd_sc_mcu9t5v0__filltie
* cell instance $10942 r0 *1 1688.4,927.36
X$10942 12646 12785 gf180mcu_fd_sc_mcu9t5v0__filltie
* cell instance $10943 r0 *1 1688.4,887.04
X$10943 11600 11720 gf180mcu_fd_sc_mcu9t5v0__filltie
* cell instance $10944 r0 *1 1688.4,937.44
X$10944 12900 13054 gf180mcu_fd_sc_mcu9t5v0__filltie
* cell instance $10945 r0 *1 1688.4,897.12
X$10945 11860 11971 gf180mcu_fd_sc_mcu9t5v0__filltie
* cell instance $10946 r0 *1 1688.4,907.2
X$10946 12019 12128 gf180mcu_fd_sc_mcu9t5v0__filltie
* cell instance $10947 r0 *1 1688.4,917.28
X$10947 12253 12508 gf180mcu_fd_sc_mcu9t5v0__filltie
* cell instance $10948 r0 *1 1688.4,856.8
X$10948 10714 10833 gf180mcu_fd_sc_mcu9t5v0__filltie
* cell instance $10949 r0 *1 1780.24,876.96
X$10949 11461 11294 9716 gf180mcu_fd_sc_mcu9t5v0__tiel
* cell instance $10950 r0 *1 1688.4,947.52
X$10950 13160 13318 gf180mcu_fd_sc_mcu9t5v0__filltie
* cell instance $10951 r0 *1 1789.76,947.52
X$10951 13318 13160 13228 gf180mcu_fd_sc_mcu9t5v0__tieh
* cell instance $10952 r0 *1 1780.24,947.52
X$10952 13318 13160 11624 gf180mcu_fd_sc_mcu9t5v0__tiel
* cell instance $10953 r0 *1 1688.4,876.96
X$10953 11294 11461 gf180mcu_fd_sc_mcu9t5v0__filltie
* cell instance $10954 r0 *1 1688.4,846.72
X$10954 10570 10676 gf180mcu_fd_sc_mcu9t5v0__filltie
* cell instance $10955 r0 *1 1789.76,876.96
X$10955 11461 11294 9835 gf180mcu_fd_sc_mcu9t5v0__tieh
* cell instance $10956 r0 *1 1688.4,866.88
X$10956 11079 11181 gf180mcu_fd_sc_mcu9t5v0__filltie
* cell instance $10957 r0 *1 1688.4,836.64
X$10957 10308 10338 gf180mcu_fd_sc_mcu9t5v0__filltie
* cell instance $10958 r180 *1 1864.8,876.96
X$10958 33911 33841 gf180mcu_fd_sc_mcu9t5v0__endcap
* cell instance $10959 r180 *1 1864.8,937.44
X$10959 33908 33840 gf180mcu_fd_sc_mcu9t5v0__endcap
* cell instance $10960 m0 *1 1808.24,846.72
X$10960 10570 10338 gf180mcu_fd_sc_mcu9t5v0__filltie
* cell instance $10961 m90 *1 1864.8,917.28
X$10961 33904 33839 gf180mcu_fd_sc_mcu9t5v0__endcap
* cell instance $10962 r180 *1 1864.8,917.28
X$10962 33904 33857 gf180mcu_fd_sc_mcu9t5v0__endcap
* cell instance $10963 m0 *1 1808.24,907.2
X$10963 12019 11971 gf180mcu_fd_sc_mcu9t5v0__filltie
* cell instance $10964 m90 *1 1864.8,947.52
X$10964 33905 33858 gf180mcu_fd_sc_mcu9t5v0__endcap
* cell instance $10965 m0 *1 1808.24,957.6
X$10965 13428 13318 gf180mcu_fd_sc_mcu9t5v0__filltie
* cell instance $10966 m90 *1 1864.8,907.2
X$10966 33930 33857 gf180mcu_fd_sc_mcu9t5v0__endcap
* cell instance $10967 m90 *1 1864.8,927.36
X$10967 33906 33840 gf180mcu_fd_sc_mcu9t5v0__endcap
* cell instance $10968 r180 *1 1864.8,947.52
X$10968 33905 33842 gf180mcu_fd_sc_mcu9t5v0__endcap
* cell instance $10969 m90 *1 1864.8,876.96
X$10969 33911 33843 gf180mcu_fd_sc_mcu9t5v0__endcap
* cell instance $10970 m0 *1 1808.24,917.28
X$10970 12253 12128 gf180mcu_fd_sc_mcu9t5v0__filltie
* cell instance $10971 m0 *1 1808.24,947.52
X$10971 13160 13054 gf180mcu_fd_sc_mcu9t5v0__filltie
* cell instance $10972 m90 *1 1864.8,887.04
X$10972 33907 33861 gf180mcu_fd_sc_mcu9t5v0__endcap
* cell instance $10973 m0 *1 1808.24,856.8
X$10973 10714 10676 gf180mcu_fd_sc_mcu9t5v0__filltie
* cell instance $10974 m0 *1 1808.24,927.36
X$10974 12646 12508 gf180mcu_fd_sc_mcu9t5v0__filltie
* cell instance $10975 m0 *1 1808.24,836.64
X$10975 10308 10188 gf180mcu_fd_sc_mcu9t5v0__filltie
* cell instance $10976 m90 *1 1864.8,836.64
X$10976 33929 33860 gf180mcu_fd_sc_mcu9t5v0__endcap
* cell instance $10977 r180 *1 1864.8,836.64
X$10977 33929 33838 gf180mcu_fd_sc_mcu9t5v0__endcap
* cell instance $10978 m0 *1 1808.24,866.88
X$10978 11079 10833 gf180mcu_fd_sc_mcu9t5v0__filltie
* cell instance $10979 m90 *1 1864.8,937.44
X$10979 33908 33842 gf180mcu_fd_sc_mcu9t5v0__endcap
* cell instance $10980 r180 *1 1864.8,907.2
X$10980 33930 33859 gf180mcu_fd_sc_mcu9t5v0__endcap
* cell instance $10981 r180 *1 1864.8,887.04
X$10981 33907 33843 gf180mcu_fd_sc_mcu9t5v0__endcap
* cell instance $10982 r180 *1 1864.8,846.72
X$10982 33931 33860 gf180mcu_fd_sc_mcu9t5v0__endcap
* cell instance $10983 m0 *1 1808.24,887.04
X$10983 11600 11461 gf180mcu_fd_sc_mcu9t5v0__filltie
* cell instance $10984 m0 *1 1808.24,876.96
X$10984 11294 11181 gf180mcu_fd_sc_mcu9t5v0__filltie
* cell instance $10985 r180 *1 1864.8,897.12
X$10985 33909 33861 gf180mcu_fd_sc_mcu9t5v0__endcap
* cell instance $10986 m90 *1 1864.8,897.12
X$10986 33909 33859 gf180mcu_fd_sc_mcu9t5v0__endcap
* cell instance $10987 m90 *1 1864.8,846.72
X$10987 33931 33862 gf180mcu_fd_sc_mcu9t5v0__endcap
* cell instance $10988 m0 *1 1808.24,897.12
X$10988 11860 11720 gf180mcu_fd_sc_mcu9t5v0__filltie
* cell instance $10989 r180 *1 1864.8,856.8
X$10989 33932 33862 gf180mcu_fd_sc_mcu9t5v0__endcap
* cell instance $10990 r180 *1 1864.8,927.36
X$10990 33906 33839 gf180mcu_fd_sc_mcu9t5v0__endcap
* cell instance $10991 m90 *1 1864.8,856.8
X$10991 33932 33863 gf180mcu_fd_sc_mcu9t5v0__endcap
* cell instance $10992 m0 *1 1808.24,937.44
X$10992 12900 12785 gf180mcu_fd_sc_mcu9t5v0__filltie
* cell instance $10993 m90 *1 1864.8,957.6
X$10993 33910 33864 gf180mcu_fd_sc_mcu9t5v0__endcap
* cell instance $10994 r180 *1 1864.8,866.88
X$10994 33933 33863 gf180mcu_fd_sc_mcu9t5v0__endcap
* cell instance $10995 r180 *1 1864.8,957.6
X$10995 33910 33858 gf180mcu_fd_sc_mcu9t5v0__endcap
* cell instance $10996 m90 *1 1864.8,866.88
X$10996 33933 33841 gf180mcu_fd_sc_mcu9t5v0__endcap
* cell instance $10997 r0 *1 1688.4,685.44
X$10997 6425 6664 gf180mcu_fd_sc_mcu9t5v0__filltie
* cell instance $10998 m90 *1 1864.8,685.44
X$10998 33897 33833 gf180mcu_fd_sc_mcu9t5v0__endcap
* cell instance $10999 r180 *1 1864.8,695.52
X$10999 33952 33833 gf180mcu_fd_sc_mcu9t5v0__endcap
* cell instance $11000 m0 *1 1808.24,695.52
X$11000 6805 6664 gf180mcu_fd_sc_mcu9t5v0__filltie
* cell instance $11001 r180 *1 1864.8,725.76
X$11001 33898 33834 gf180mcu_fd_sc_mcu9t5v0__endcap
* cell instance $11002 r180 *1 1864.8,786.24
X$11002 33899 33883 gf180mcu_fd_sc_mcu9t5v0__endcap
* cell instance $11003 m90 *1 1864.8,725.76
X$11003 33898 33873 gf180mcu_fd_sc_mcu9t5v0__endcap
* cell instance $11004 m90 *1 1864.8,786.24
X$11004 33899 33878 gf180mcu_fd_sc_mcu9t5v0__endcap
* cell instance $11005 m0 *1 1808.24,786.24
X$11005 8961 8843 gf180mcu_fd_sc_mcu9t5v0__filltie
* cell instance $11006 r180 *1 1864.8,796.32
X$11006 33949 33878 gf180mcu_fd_sc_mcu9t5v0__endcap
* cell instance $11007 r180 *1 1864.8,735.84
X$11007 33946 33873 gf180mcu_fd_sc_mcu9t5v0__endcap
* cell instance $11008 m0 *1 1808.24,796.32
X$11008 9315 9201 gf180mcu_fd_sc_mcu9t5v0__filltie
* cell instance $11009 m90 *1 1864.8,796.32
X$11009 33949 33874 gf180mcu_fd_sc_mcu9t5v0__endcap
* cell instance $11010 r180 *1 1864.8,806.4
X$11010 33900 33874 gf180mcu_fd_sc_mcu9t5v0__endcap
* cell instance $11011 m90 *1 1864.8,735.84
X$11011 33946 33875 gf180mcu_fd_sc_mcu9t5v0__endcap
* cell instance $11012 m0 *1 1808.24,806.4
X$11012 9575 9432 gf180mcu_fd_sc_mcu9t5v0__filltie
* cell instance $11013 r180 *1 1864.8,745.92
X$11013 33896 33875 gf180mcu_fd_sc_mcu9t5v0__endcap
* cell instance $11014 m90 *1 1864.8,715.68
X$11014 33947 33834 gf180mcu_fd_sc_mcu9t5v0__endcap
* cell instance $11015 m0 *1 1808.24,816.48
X$11015 9810 9691 gf180mcu_fd_sc_mcu9t5v0__filltie
* cell instance $11016 m0 *1 1808.24,766.08
X$11016 8582 8445 gf180mcu_fd_sc_mcu9t5v0__filltie
* cell instance $11017 r180 *1 1864.8,715.68
X$11017 33947 33876 gf180mcu_fd_sc_mcu9t5v0__endcap
* cell instance $11018 m90 *1 1864.8,695.52
X$11018 33952 33882 gf180mcu_fd_sc_mcu9t5v0__endcap
* cell instance $11019 m0 *1 1808.24,705.6
X$11019 6943 6909 gf180mcu_fd_sc_mcu9t5v0__filltie
* cell instance $11020 m0 *1 1808.24,776.16
X$11020 8818 8693 gf180mcu_fd_sc_mcu9t5v0__filltie
* cell instance $11021 m0 *1 1808.24,715.68
X$11021 7195 7071 gf180mcu_fd_sc_mcu9t5v0__filltie
* cell instance $11022 m90 *1 1864.8,776.16
X$11022 33901 33883 gf180mcu_fd_sc_mcu9t5v0__endcap
* cell instance $11023 r180 *1 1864.8,826.56
X$11023 33948 33877 gf180mcu_fd_sc_mcu9t5v0__endcap
* cell instance $11024 r180 *1 1864.8,705.6
X$11024 33890 33882 gf180mcu_fd_sc_mcu9t5v0__endcap
* cell instance $11025 m90 *1 1864.8,705.6
X$11025 33890 33876 gf180mcu_fd_sc_mcu9t5v0__endcap
* cell instance $11026 m90 *1 1864.8,745.92
X$11026 33896 33879 gf180mcu_fd_sc_mcu9t5v0__endcap
* cell instance $11027 m0 *1 1808.24,725.76
X$11027 7558 7316 gf180mcu_fd_sc_mcu9t5v0__filltie
* cell instance $11028 r180 *1 1864.8,756
X$11028 33903 33879 gf180mcu_fd_sc_mcu9t5v0__endcap
* cell instance $11029 m0 *1 1808.24,735.84
X$11029 7814 7671 gf180mcu_fd_sc_mcu9t5v0__filltie
* cell instance $11030 m90 *1 1864.8,756
X$11030 33903 33880 gf180mcu_fd_sc_mcu9t5v0__endcap
* cell instance $11031 m90 *1 1864.8,806.4
X$11031 33900 33881 gf180mcu_fd_sc_mcu9t5v0__endcap
* cell instance $11032 r180 *1 1864.8,766.08
X$11032 33950 33880 gf180mcu_fd_sc_mcu9t5v0__endcap
* cell instance $11033 m0 *1 1808.24,826.56
X$11033 10078 9841 gf180mcu_fd_sc_mcu9t5v0__filltie
* cell instance $11034 m0 *1 1808.24,745.92
X$11034 7948 7919 gf180mcu_fd_sc_mcu9t5v0__filltie
* cell instance $11035 r180 *1 1864.8,816.48
X$11035 33951 33881 gf180mcu_fd_sc_mcu9t5v0__endcap
* cell instance $11036 m90 *1 1864.8,816.48
X$11036 33951 33877 gf180mcu_fd_sc_mcu9t5v0__endcap
* cell instance $11037 m90 *1 1864.8,766.08
X$11037 33950 33836 gf180mcu_fd_sc_mcu9t5v0__endcap
* cell instance $11038 m0 *1 1808.24,756
X$11038 8204 8078 gf180mcu_fd_sc_mcu9t5v0__filltie
* cell instance $11039 r180 *1 1864.8,776.16
X$11039 33901 33836 gf180mcu_fd_sc_mcu9t5v0__endcap
* cell instance $11040 r0 *1 1688.4,725.76
X$11040 7558 7671 gf180mcu_fd_sc_mcu9t5v0__filltie
* cell instance $11041 r0 *1 1688.4,776.16
X$11041 8818 8843 gf180mcu_fd_sc_mcu9t5v0__filltie
* cell instance $11042 r0 *1 1688.4,715.68
X$11042 7195 7316 gf180mcu_fd_sc_mcu9t5v0__filltie
* cell instance $11043 r0 *1 1688.4,735.84
X$11043 7814 7919 gf180mcu_fd_sc_mcu9t5v0__filltie
* cell instance $11044 r0 *1 1688.4,786.24
X$11044 8961 9201 gf180mcu_fd_sc_mcu9t5v0__filltie
* cell instance $11045 r0 *1 1688.4,766.08
X$11045 8582 8693 gf180mcu_fd_sc_mcu9t5v0__filltie
* cell instance $11046 r0 *1 1688.4,816.48
X$11046 9810 9841 gf180mcu_fd_sc_mcu9t5v0__filltie
* cell instance $11047 r0 *1 1789.76,725.76
X$11047 7671 7558 6031 gf180mcu_fd_sc_mcu9t5v0__tieh
* cell instance $11048 r0 *1 1688.4,705.6
X$11048 6943 7071 gf180mcu_fd_sc_mcu9t5v0__filltie
* cell instance $11049 r0 *1 1688.4,695.52
X$11049 6805 6909 gf180mcu_fd_sc_mcu9t5v0__filltie
* cell instance $11050 m0 *1 1789.76,806.4
X$11050 9432 9575 7943 gf180mcu_fd_sc_mcu9t5v0__tieh
* cell instance $11051 m0 *1 1780.24,806.4
X$11051 9432 9575 7831 gf180mcu_fd_sc_mcu9t5v0__tiel
* cell instance $11052 r0 *1 1688.4,756
X$11052 8204 8445 gf180mcu_fd_sc_mcu9t5v0__filltie
* cell instance $11053 r0 *1 1688.4,796.32
X$11053 9315 9432 gf180mcu_fd_sc_mcu9t5v0__filltie
* cell instance $11054 r0 *1 1688.4,745.92
X$11054 7948 8078 gf180mcu_fd_sc_mcu9t5v0__filltie
* cell instance $11055 r0 *1 1780.24,725.76
X$11055 7671 7558 5932 gf180mcu_fd_sc_mcu9t5v0__tiel
* cell instance $11056 r0 *1 1688.4,806.4
X$11056 9575 9691 gf180mcu_fd_sc_mcu9t5v0__filltie
* cell instance $11057 m0 *1 1789.76,655.2
X$11057 5665 5794 4161 gf180mcu_fd_sc_mcu9t5v0__tieh
* cell instance $11058 r0 *1 1688.4,594.72
X$11058 4266 4389 gf180mcu_fd_sc_mcu9t5v0__filltie
* cell instance $11059 r0 *1 1688.4,655.2
X$11059 5794 5920 gf180mcu_fd_sc_mcu9t5v0__filltie
* cell instance $11060 r0 *1 1688.4,675.36
X$11060 6292 6392 gf180mcu_fd_sc_mcu9t5v0__filltie
* cell instance $11061 r0 *1 1688.4,604.8
X$11061 4512 4667 gf180mcu_fd_sc_mcu9t5v0__filltie
* cell instance $11062 r0 *1 1688.4,635.04
X$11062 5297 5390 gf180mcu_fd_sc_mcu9t5v0__filltie
* cell instance $11063 r0 *1 1688.4,645.12
X$11063 5411 5665 gf180mcu_fd_sc_mcu9t5v0__filltie
* cell instance $11064 r0 *1 1688.4,614.88
X$11064 4794 4903 gf180mcu_fd_sc_mcu9t5v0__filltie
* cell instance $11065 m0 *1 1780.24,655.2
X$11065 5665 5794 4062 gf180mcu_fd_sc_mcu9t5v0__tiel
* cell instance $11066 r0 *1 1688.4,564.48
X$11066 3444 3558 gf180mcu_fd_sc_mcu9t5v0__filltie
* cell instance $11067 r0 *1 1688.4,665.28
X$11067 6034 6144 gf180mcu_fd_sc_mcu9t5v0__filltie
* cell instance $11068 r0 *1 1688.4,574.56
X$11068 3781 3796 gf180mcu_fd_sc_mcu9t5v0__filltie
* cell instance $11069 r0 *1 1789.76,574.56
X$11069 3796 3781 2379 gf180mcu_fd_sc_mcu9t5v0__tieh
* cell instance $11070 r0 *1 1780.24,574.56
X$11070 3796 3781 2378 gf180mcu_fd_sc_mcu9t5v0__tiel
* cell instance $11071 r0 *1 1688.4,584.64
X$11071 3907 4150 gf180mcu_fd_sc_mcu9t5v0__filltie
* cell instance $11072 r0 *1 1688.4,624.96
X$11072 5056 5183 gf180mcu_fd_sc_mcu9t5v0__filltie
* cell instance $11073 r0 *1 1688.4,554.4
X$11073 3227 3334 gf180mcu_fd_sc_mcu9t5v0__filltie
* cell instance $11074 m90 *1 1864.8,604.8
X$11074 33923 33832 gf180mcu_fd_sc_mcu9t5v0__endcap
* cell instance $11075 m0 *1 1808.24,604.8
X$11075 4512 4389 gf180mcu_fd_sc_mcu9t5v0__filltie
* cell instance $11076 r180 *1 1864.8,645.12
X$11076 33891 33884 gf180mcu_fd_sc_mcu9t5v0__endcap
* cell instance $11077 m0 *1 1808.24,645.12
X$11077 5411 5390 gf180mcu_fd_sc_mcu9t5v0__filltie
* cell instance $11078 r180 *1 1864.8,604.8
X$11078 33923 33851 gf180mcu_fd_sc_mcu9t5v0__endcap
* cell instance $11079 m0 *1 1808.24,614.88
X$11079 4794 4667 gf180mcu_fd_sc_mcu9t5v0__filltie
* cell instance $11080 m90 *1 1864.8,655.2
X$11080 33919 33828 gf180mcu_fd_sc_mcu9t5v0__endcap
* cell instance $11081 r180 *1 1864.8,614.88
X$11081 33885 33832 gf180mcu_fd_sc_mcu9t5v0__endcap
* cell instance $11082 m90 *1 1864.8,665.28
X$11082 33894 33827 gf180mcu_fd_sc_mcu9t5v0__endcap
* cell instance $11083 m90 *1 1864.8,584.64
X$11083 33917 33826 gf180mcu_fd_sc_mcu9t5v0__endcap
* cell instance $11084 r180 *1 1864.8,594.72
X$11084 33892 33826 gf180mcu_fd_sc_mcu9t5v0__endcap
* cell instance $11085 m0 *1 1808.24,594.72
X$11085 4266 4150 gf180mcu_fd_sc_mcu9t5v0__filltie
* cell instance $11086 m90 *1 1864.8,624.96
X$11086 33893 33825 gf180mcu_fd_sc_mcu9t5v0__endcap
* cell instance $11087 r180 *1 1864.8,685.44
X$11087 33897 33831 gf180mcu_fd_sc_mcu9t5v0__endcap
* cell instance $11088 m90 *1 1864.8,594.72
X$11088 33892 33851 gf180mcu_fd_sc_mcu9t5v0__endcap
* cell instance $11089 m0 *1 1808.24,655.2
X$11089 5794 5665 gf180mcu_fd_sc_mcu9t5v0__filltie
* cell instance $11090 m0 *1 1808.24,665.28
X$11090 6034 5920 gf180mcu_fd_sc_mcu9t5v0__filltie
* cell instance $11091 m90 *1 1864.8,645.12
X$11091 33891 33849 gf180mcu_fd_sc_mcu9t5v0__endcap
* cell instance $11092 m0 *1 1808.24,624.96
X$11092 5056 4903 gf180mcu_fd_sc_mcu9t5v0__filltie
* cell instance $11093 r180 *1 1864.8,635.04
X$11093 33918 33825 gf180mcu_fd_sc_mcu9t5v0__endcap
* cell instance $11094 m90 *1 1864.8,635.04
X$11094 33918 33884 gf180mcu_fd_sc_mcu9t5v0__endcap
* cell instance $11095 m90 *1 1864.8,675.36
X$11095 33895 33831 gf180mcu_fd_sc_mcu9t5v0__endcap
* cell instance $11096 m90 *1 1864.8,564.48
X$11096 33921 33817 gf180mcu_fd_sc_mcu9t5v0__endcap
* cell instance $11097 r180 *1 1864.8,665.28
X$11097 33894 33828 gf180mcu_fd_sc_mcu9t5v0__endcap
* cell instance $11098 m90 *1 1864.8,554.4
X$11098 33934 33818 gf180mcu_fd_sc_mcu9t5v0__endcap
* cell instance $11099 m0 *1 1808.24,675.36
X$11099 6292 6144 gf180mcu_fd_sc_mcu9t5v0__filltie
* cell instance $11100 m90 *1 1864.8,614.88
X$11100 33885 33819 gf180mcu_fd_sc_mcu9t5v0__endcap
* cell instance $11101 m90 *1 1864.8,574.56
X$11101 33920 33848 gf180mcu_fd_sc_mcu9t5v0__endcap
* cell instance $11102 r180 *1 1864.8,675.36
X$11102 33895 33827 gf180mcu_fd_sc_mcu9t5v0__endcap
* cell instance $11103 m0 *1 1808.24,574.56
X$11103 3781 3558 gf180mcu_fd_sc_mcu9t5v0__filltie
* cell instance $11104 m0 *1 1808.24,584.64
X$11104 3907 3796 gf180mcu_fd_sc_mcu9t5v0__filltie
* cell instance $11105 m0 *1 1808.24,564.48
X$11105 3444 3334 gf180mcu_fd_sc_mcu9t5v0__filltie
* cell instance $11106 r180 *1 1864.8,624.96
X$11106 33893 33819 gf180mcu_fd_sc_mcu9t5v0__endcap
* cell instance $11107 r180 *1 1864.8,564.48
X$11107 33921 33818 gf180mcu_fd_sc_mcu9t5v0__endcap
* cell instance $11108 r180 *1 1864.8,574.56
X$11108 33920 33817 gf180mcu_fd_sc_mcu9t5v0__endcap
* cell instance $11109 m0 *1 1808.24,685.44
X$11109 6425 6392 gf180mcu_fd_sc_mcu9t5v0__filltie
* cell instance $11110 r180 *1 1864.8,655.2
X$11110 33919 33849 gf180mcu_fd_sc_mcu9t5v0__endcap
* cell instance $11111 r180 *1 1864.8,584.64
X$11111 33917 33848 gf180mcu_fd_sc_mcu9t5v0__endcap
* cell instance $11112 m0 *1 1808.24,635.04
X$11112 5297 5183 gf180mcu_fd_sc_mcu9t5v0__filltie
* cell instance $11113 r0 *1 1378.16,584.64
X$11113 2377 3933 4575 4150 3907 gf180mcu_fd_sc_mcu9t5v0__dffq_2
* cell instance $11114 m0 *1 1377.04,846.72
X$11114 9709 9826 2255 10338 10570 10475 gf180mcu_fd_sc_mcu9t5v0__mux2_1
* cell instance $11115 m0 *1 1363.04,967.68
X$11115 13028 13730 9859 13180 13586 13719 gf180mcu_fd_sc_mcu9t5v0__dffrnq_2
* cell instance $11116 r0 *1 1379.28,1038.24
X$11116 15755 15292 15898 15737 15547 gf180mcu_fd_sc_mcu9t5v0__nor2_1
* cell instance $11117 m0 *1 1377.6,1098.72
X$11117 17545 15755 14872 17398 17521 17599 gf180mcu_fd_sc_mcu9t5v0__mux2_1
* cell instance $11118 m0 *1 1377.04,1068.48
X$11118 16533 16203 16535 16506 16653 16534 gf180mcu_fd_sc_mcu9t5v0__oai21_1
* cell instance $11119 r0 *1 1380.96,1078.56
X$11119 17103 17104 17123 16956 13914 17102 gf180mcu_fd_sc_mcu9t5v0__xnor3_1
* cell instance $11120 r0 *1 1371.44,1098.72
X$11120 13699 17599 15755 13180 17709 17521 gf180mcu_fd_sc_mcu9t5v0__dffrnq_2
* cell instance $11121 r0 *1 1375.36,1058.4
X$11121 16467 16468 16506 16309 14202 16534 gf180mcu_fd_sc_mcu9t5v0__xnor3_1
* cell instance $11122 m0 *1 1370.32,1058.4
X$11122 15755 16203 16194 16309 15291 16466 gf180mcu_fd_sc_mcu9t5v0__xnor3_1
* cell instance $11123 m0 *1 1377.6,1008
X$11123 14832 14833 14202 14708 14857 14683 gf180mcu_fd_sc_mcu9t5v0__aoi21_1
* cell instance $11124 m0 *1 1375.92,1038.24
X$11124 15755 15753 15576 15737 15293 15292 gf180mcu_fd_sc_mcu9t5v0__xnor3_1
* cell instance $11125 m0 *1 1378.16,997.92
X$11125 11363 12632 14471 14472 14406 14448 14426
+ gf180mcu_fd_sc_mcu9t5v0__aoi22_1
* cell instance $11126 r0 *1 1377.04,987.84
X$11126 13028 14426 8823 13180 14406 14304 gf180mcu_fd_sc_mcu9t5v0__dffrnq_2
* cell instance $11127 r0 *1 1380.4,1028.16
X$11127 15547 15753 15710 15576 15402 15590 gf180mcu_fd_sc_mcu9t5v0__oai21_1
* cell instance $11128 r0 *1 1372.56,947.52
X$11128 12411 13178 11848 12282 2987 3459 13318 13160 13217
+ gf180mcu_fd_sc_mcu9t5v0__mux4_1
* cell instance $11129 r0 *1 1379.84,967.68
X$11129 13028 13913 13595 13180 13832 13719 gf180mcu_fd_sc_mcu9t5v0__dffrnq_2
* cell instance $11130 m0 *1 1365.28,947.52
X$11130 12411 13178 11848 12282 3120 3239 13054 13160 13034
+ gf180mcu_fd_sc_mcu9t5v0__mux4_1
* cell instance $11131 r0 *1 1380.4,927.36
X$11131 12152 10474 11369 10065 3239 3121 12785 12646 12761
+ gf180mcu_fd_sc_mcu9t5v0__mux4_1
* cell instance $11132 m0 *1 1373.12,927.36
X$11132 10703 11315 9827 9830 3239 3121 12508 12646 12657
+ gf180mcu_fd_sc_mcu9t5v0__mux4_1
* cell instance $11133 m0 *1 1378.16,887.04
X$11133 10065 4765 2997 9830 11367 11461 11600 11583
+ gf180mcu_fd_sc_mcu9t5v0__aoi221_1
* cell instance $11134 m0 *1 1379.84,897.12
X$11134 11735 11857 11583 2880 11720 11860 11856
+ gf180mcu_fd_sc_mcu9t5v0__aoi22_1
* cell instance $11135 r0 *1 1380.4,876.96
X$11135 2891 11369 11461 11294 11368 gf180mcu_fd_sc_mcu9t5v0__nor2_1
* cell instance $11136 r0 *1 1372,846.72
X$11136 9591 10586 10474 10676 10570 gf180mcu_fd_sc_mcu9t5v0__dffq_2
* cell instance $11137 r0 *1 1380.96,887.04
X$11137 10474 4765 11720 11600 11735 gf180mcu_fd_sc_mcu9t5v0__nand2_1
* cell instance $11138 r0 *1 1282.4,826.56
X$11138 9591 10090 10208 10188 10078 gf180mcu_fd_sc_mcu9t5v0__dffq_2
* cell instance $11139 r0 *1 1299.2,826.56
X$11139 2891 9570 10188 10078 10063 gf180mcu_fd_sc_mcu9t5v0__nor2_1
* cell instance $11140 r0 *1 1302.56,826.56
X$11140 9570 10208 10060 10207 2987 3459 10188 10078 10209
+ gf180mcu_fd_sc_mcu9t5v0__mux4_1
* cell instance $11141 r0 *1 1341.76,826.56
X$11141 2891 10213 10188 10078 10092 gf180mcu_fd_sc_mcu9t5v0__nor2_1
* cell instance $11142 r0 *1 1330,826.56
X$11142 4497 10092 10093 10211 10188 10078 9825 gf180mcu_fd_sc_mcu9t5v0__oai31_1
* cell instance $11143 r0 *1 1319.92,826.56
X$11143 3462 10209 8717 4952 10188 10078 10210 gf180mcu_fd_sc_mcu9t5v0__oai211_1
* cell instance $11144 r0 *1 1245.44,826.56
X$11144 10578 10059 10060 10188 10078 gf180mcu_fd_sc_mcu9t5v0__dffq_2
* cell instance $11145 r0 *1 1266.16,826.56
X$11145 10060 4765 2997 10207 10089 10188 10078 10189
+ gf180mcu_fd_sc_mcu9t5v0__aoi221_1
* cell instance $11146 r0 *1 1239.84,826.56
X$11146 10061 5766 10188 10078 10057 gf180mcu_fd_sc_mcu9t5v0__nand2_1
* cell instance $11147 r0 *1 1153.04,826.56
X$11147 10578 10086 9703 10188 10078 gf180mcu_fd_sc_mcu9t5v0__dffq_2
* cell instance $11148 r0 *1 1184.4,826.56
X$11148 9584 10188 10078 10205 gf180mcu_fd_sc_mcu9t5v0__clkinv_1
* cell instance $11149 r0 *1 1192.24,826.56
X$11149 10578 10088 9704 10188 10078 gf180mcu_fd_sc_mcu9t5v0__dffq_2
* cell instance $11150 r0 *1 1209.04,826.56
X$11150 10078 10188 gf180mcu_fd_sc_mcu9t5v0__filltie
* cell instance $11151 r0 *1 1127.28,826.56
X$11151 10578 10085 10047 10188 10078 gf180mcu_fd_sc_mcu9t5v0__dffq_2
* cell instance $11152 r0 *1 1109.36,826.56
X$11152 8974 10188 10078 8217 gf180mcu_fd_sc_mcu9t5v0__buf_8
* cell instance $11153 m0 *1 1377.6,786.24
X$11153 8104 8862 8864 8843 8961 gf180mcu_fd_sc_mcu9t5v0__dffq_2
* cell instance $11154 r0 *1 1422.96,826.56
X$11154 10095 10214 3239 10188 10078 10212 gf180mcu_fd_sc_mcu9t5v0__mux2_1
* cell instance $11155 r0 *1 1448.72,826.56
X$11155 10078 10188 gf180mcu_fd_sc_mcu9t5v0__filltie
* cell instance $11156 r0 *1 1464.4,826.56
X$11156 9571 4048 10188 10078 9833 gf180mcu_fd_sc_mcu9t5v0__nand2_1
* cell instance $11157 r0 *1 1477.28,826.56
X$11157 10213 10215 4493 10188 10078 10216 gf180mcu_fd_sc_mcu9t5v0__mux2_1
* cell instance $11158 r0 *1 1374.8,816.48
X$11158 9830 9710 5299 9841 9810 9829 gf180mcu_fd_sc_mcu9t5v0__mux2_1
* cell instance $11159 m0 *1 1370.88,816.48
X$11159 8104 9829 9830 9691 9810 gf180mcu_fd_sc_mcu9t5v0__dffq_2
* cell instance $11160 r0 *1 1399.44,826.56
X$11160 8104 10067 10068 10188 10078 gf180mcu_fd_sc_mcu9t5v0__dffq_2
* cell instance $11161 r0 *1 1380.4,796.32
X$11161 8104 9341 9216 9432 9315 gf180mcu_fd_sc_mcu9t5v0__dffq_2
* cell instance $11162 r0 *1 1380.96,826.56
X$11162 8104 10094 10065 10188 10078 gf180mcu_fd_sc_mcu9t5v0__dffq_2
* cell instance $11163 r0 *1 1377.04,806.4
X$11163 9709 9826 6030 9691 9575 9710 gf180mcu_fd_sc_mcu9t5v0__mux2_1
* cell instance $11164 m0 *1 1364.72,725.76
X$11164 6791 6792 6815 6930 3120 3239 7316 7558 7347
+ gf180mcu_fd_sc_mcu9t5v0__mux4_1
* cell instance $11165 r0 *1 1374.8,735.84
X$11165 7670 7349 2255 7919 7814 7939 gf180mcu_fd_sc_mcu9t5v0__mux2_1
* cell instance $11166 m0 *1 1368.64,745.92
X$11166 8104 7980 7981 7919 7948 gf180mcu_fd_sc_mcu9t5v0__dffq_2
* cell instance $11167 r0 *1 1377.04,766.08
X$11167 8104 8596 8571 8693 8582 gf180mcu_fd_sc_mcu9t5v0__dffq_2
* cell instance $11168 m0 *1 1373.12,614.88
X$11168 4575 4576 4573 4572 3120 3121 4667 4794 4811
+ gf180mcu_fd_sc_mcu9t5v0__mux4_1
* cell instance $11169 r0 *1 1366.96,705.6
X$11169 6791 6792 6815 6930 2987 3459 7071 6943 7099
+ gf180mcu_fd_sc_mcu9t5v0__mux4_1
* cell instance $11170 r0 *1 1367.52,604.8
X$11170 4573 4572 4575 4576 2987 3106 4667 4512 4506
+ gf180mcu_fd_sc_mcu9t5v0__mux4_1
* cell instance $11171 m0 *1 1369.2,635.04
X$11171 2377 5292 5405 5183 5297 gf180mcu_fd_sc_mcu9t5v0__dffq_2
* cell instance $11172 r0 *1 1379.28,594.72
X$11172 3469 3470 3677 4389 4266 4386 gf180mcu_fd_sc_mcu9t5v0__mux2_2
* cell instance $11173 m0 *1 1380.96,655.2
X$11173 5441 5785 5299 5665 5794 5804 gf180mcu_fd_sc_mcu9t5v0__mux2_1
* cell instance $11174 r0 *1 1378.72,675.36
X$11174 5290 6299 6681 6392 6292 gf180mcu_fd_sc_mcu9t5v0__dffq_2
* cell instance $11175 r0 *1 1374.24,624.96
X$11175 4967 5064 2255 5183 5056 5179 gf180mcu_fd_sc_mcu9t5v0__mux2_1
* cell instance $11176 m0 *1 1369.2,685.44
X$11176 3930 6392 6425 5290 gf180mcu_fd_sc_mcu9t5v0__clkbuf_8
* cell instance $11177 r0 *1 1375.92,655.2
X$11177 5290 5804 5441 5920 5794 gf180mcu_fd_sc_mcu9t5v0__dffq_2
* cell instance $11178 m0 *1 1378.16,564.48
X$11178 3469 3470 2141 3334 3444 3473 gf180mcu_fd_sc_mcu9t5v0__mux2_1
* cell instance $11179 r0 *1 1366.96,564.48
X$11179 2377 3592 3932 3558 3444 gf180mcu_fd_sc_mcu9t5v0__dffq_2
* cell instance $11180 r0 *1 1515.36,1038.24
X$11180 15757 15883 15885 15898 15737 15556 gf180mcu_fd_sc_mcu9t5v0__oai21_1
* cell instance $11181 r0 *1 1513.12,1098.72
X$11181 16815 17550 17709 17521 17604 gf180mcu_fd_sc_mcu9t5v0__xnor2_1
* cell instance $11182 m0 *1 1518.72,1098.72
X$11182 16815 17550 17549 17398 17521 15886 gf180mcu_fd_sc_mcu9t5v0__aoi21_1
* cell instance $11183 r0 *1 1502.48,1048.32
X$11183 13915 16172 13700 13180 16194 16008 gf180mcu_fd_sc_mcu9t5v0__dffrnq_2
* cell instance $11184 m0 *1 1517.6,1088.64
X$11184 17269 17270 17123 17289 17138 gf180mcu_fd_sc_mcu9t5v0__nand2_1
* cell instance $11185 m0 *1 1519.28,1078.56
X$11185 16983 17269 16784 16956 16687 gf180mcu_fd_sc_mcu9t5v0__nand2_1
* cell instance $11186 r0 *1 1517.04,1068.48
X$11186 16687 16685 16814 16784 16653 16686 gf180mcu_fd_sc_mcu9t5v0__aoi21_1
* cell instance $11187 r0 *1 1519.28,1058.4
X$11187 12632 16482 16506 16309 16207 gf180mcu_fd_sc_mcu9t5v0__nor2_1
* cell instance $11188 r0 *1 1516.48,1028.16
X$11188 15557 15556 15576 15402 15165 gf180mcu_fd_sc_mcu9t5v0__and2_1
* cell instance $11189 r0 *1 1506.96,987.84
X$11189 13707 14476 14406 14304 14428 14206 gf180mcu_fd_sc_mcu9t5v0__xnor3_1
* cell instance $11190 m0 *1 1508.08,1018.08
X$11190 13915 15040 10061 13180 14967 15138 gf180mcu_fd_sc_mcu9t5v0__dffrnq_2
* cell instance $11191 m0 *1 1506.96,1008
X$11191 3930 14708 14857 13915 gf180mcu_fd_sc_mcu9t5v0__clkbuf_8
* cell instance $11192 m0 *1 1422.4,967.68
X$11192 13028 13597 13693 13180 13586 13719 gf180mcu_fd_sc_mcu9t5v0__dffrnq_2
* cell instance $11193 m0 *1 1478.96,967.68
X$11193 13854 13734 13586 13719 13488 gf180mcu_fd_sc_mcu9t5v0__xnor2_1
* cell instance $11194 m0 *1 1466.08,967.68
X$11194 13850 13733 13586 13719 13037 13849 gf180mcu_fd_sc_mcu9t5v0__xnor3_1
* cell instance $11195 m0 *1 1400.56,967.68
X$11195 13481 12632 13586 13719 13703 gf180mcu_fd_sc_mcu9t5v0__nand2_1
* cell instance $11196 m0 *1 1397.76,967.68
X$11196 13703 13702 13586 13719 13485 gf180mcu_fd_sc_mcu9t5v0__nand2_1
* cell instance $11197 m0 *1 1403.36,967.68
X$11197 13028 13732 5899 13180 13586 13719 gf180mcu_fd_sc_mcu9t5v0__dffrnq_2
* cell instance $11198 m0 *1 1382.08,967.68
X$11198 3930 13586 13719 13028 gf180mcu_fd_sc_mcu9t5v0__clkbuf_8
* cell instance $11199 r0 *1 1500.8,917.28
X$11199 10734 12289 10699 13180 12508 12253 gf180mcu_fd_sc_mcu9t5v0__dffrnq_2
* cell instance $11200 m0 *1 1561.84,967.68
X$11200 13862 13711 13586 13719 13497 gf180mcu_fd_sc_mcu9t5v0__xnor2_1
* cell instance $11201 m0 *1 1513.68,947.52
X$11201 13183 13041 13054 13160 12636 gf180mcu_fd_sc_mcu9t5v0__xnor2_1
* cell instance $11202 m0 *1 1512,967.68
X$11202 13707 13586 13719 13706 gf180mcu_fd_sc_mcu9t5v0__clkinv_1
* cell instance $11203 m0 *1 1503.04,967.68
X$11203 13706 13705 13586 13719 13735 gf180mcu_fd_sc_mcu9t5v0__nor2_1
* cell instance $11204 m0 *1 1518.16,967.68
X$11204 13706 13183 13586 13719 13736 gf180mcu_fd_sc_mcu9t5v0__nor2_1
* cell instance $11205 r0 *1 1519.28,967.68
X$11205 13736 13858 13859 13832 13719 13704 gf180mcu_fd_sc_mcu9t5v0__oai21_1
* cell instance $11206 m0 *1 1541.68,967.68
X$11206 13492 14685 13586 13719 13489 gf180mcu_fd_sc_mcu9t5v0__nand2_1
* cell instance $11207 m0 *1 1521.52,967.68
X$11207 13736 13598 13586 13719 13708 gf180mcu_fd_sc_mcu9t5v0__nor2_1
* cell instance $11208 m0 *1 1526.56,967.68
X$11208 13858 13708 13586 13719 13709 gf180mcu_fd_sc_mcu9t5v0__nor2_1
* cell instance $11209 m0 *1 1529.92,967.68
X$11209 13489 13709 13586 13719 13493 gf180mcu_fd_sc_mcu9t5v0__nor2_1
* cell instance $11210 r0 *1 1515.36,927.36
X$11210 12636 12635 12771 12785 12646 12769 gf180mcu_fd_sc_mcu9t5v0__aoi21_1
* cell instance $11211 m0 *1 1544.48,967.68
X$11211 14685 13599 13710 13492 13586 13719 13702
+ gf180mcu_fd_sc_mcu9t5v0__oai211_1
* cell instance $11212 m0 *1 1516.48,927.36
X$11212 12636 12635 12637 12508 12646 12288 gf180mcu_fd_sc_mcu9t5v0__oai21_1
* cell instance $11213 m0 *1 1558.48,967.68
X$11213 13737 13711 13586 13719 13049 gf180mcu_fd_sc_mcu9t5v0__nor2_1
* cell instance $11214 m0 *1 1568.56,967.68
X$11214 13719 13586 gf180mcu_fd_sc_mcu9t5v0__filltie
* cell instance $11215 m0 *1 1518.72,977.76
X$11215 13706 13183 13832 14009 13859 gf180mcu_fd_sc_mcu9t5v0__nand2_1
* cell instance $11216 m0 *1 1485.68,967.68
X$11216 13850 13704 13586 13719 13490 13036 gf180mcu_fd_sc_mcu9t5v0__xnor3_1
* cell instance $11217 m0 *1 1585.92,1068.48
X$11217 14872 16545 16546 16506 16653 16484 gf180mcu_fd_sc_mcu9t5v0__oai21_1
* cell instance $11218 r0 *1 1582,1078.56
X$11218 16986 15027 14872 17123 16956 16934 gf180mcu_fd_sc_mcu9t5v0__mux2_1
* cell instance $11219 r0 *1 1582,1098.72
X$11219 17605 15546 14872 17709 17521 17423 gf180mcu_fd_sc_mcu9t5v0__mux2_1
* cell instance $11220 r0 *1 1579.76,1038.24
X$11220 15420 15909 15898 15737 15559 15422 gf180mcu_fd_sc_mcu9t5v0__xnor3_1
* cell instance $11221 m0 *1 1527.68,1038.24
X$11221 15720 15719 15576 15737 15758 gf180mcu_fd_sc_mcu9t5v0__nand2_1
* cell instance $11222 r0 *1 1584.8,1018.08
X$11222 13480 13492 14473 15169 15271 15138 15170
+ gf180mcu_fd_sc_mcu9t5v0__oai22_1
* cell instance $11223 m0 *1 1562.4,1038.24
X$11223 15557 15556 15889 15576 15737 14837 gf180mcu_fd_sc_mcu9t5v0__aoi21_1
* cell instance $11224 r0 *1 1576.4,997.92
X$11224 14695 14719 11611 14696 14708 14448 gf180mcu_fd_sc_mcu9t5v0__dffrnq_2
* cell instance $11225 m0 *1 1569.68,1038.24
X$11225 15759 15576 15737 15299 gf180mcu_fd_sc_mcu9t5v0__clkinv_1
* cell instance $11226 m0 *1 1575.84,1038.24
X$11226 15420 15042 15576 15737 15721 gf180mcu_fd_sc_mcu9t5v0__nor2_1
* cell instance $11227 m0 *1 1579.2,1038.24
X$11227 15721 16176 16036 15592 15576 15737 13863
+ gf180mcu_fd_sc_mcu9t5v0__oai31_1
* cell instance $11228 r0 *1 1585.36,977.76
X$11228 13047 14208 14126 14009 14147 gf180mcu_fd_sc_mcu9t5v0__xnor2_1
* cell instance $11229 m0 *1 1568.56,1038.24
X$11229 15737 15576 gf180mcu_fd_sc_mcu9t5v0__filltie
* cell instance $11230 r0 *1 1588.16,1028.16
X$11230 13489 15559 15576 15402 15424 gf180mcu_fd_sc_mcu9t5v0__nor2_1
* cell instance $11231 m0 *1 1569.68,1098.72
X$11231 14695 17422 15420 14696 17398 17521 gf180mcu_fd_sc_mcu9t5v0__dffrnq_2
* cell instance $11232 r0 *1 1579.76,1088.64
X$11232 14695 17423 15546 14696 17398 17289 gf180mcu_fd_sc_mcu9t5v0__dffrnq_2
* cell instance $11233 r0 *1 1583.12,967.68
X$11233 13484 13492 13489 13864 13832 13719 13335
+ gf180mcu_fd_sc_mcu9t5v0__oai22_1
* cell instance $11234 m0 *1 1578.08,1078.56
X$11234 14695 16934 15027 14696 16784 16956 gf180mcu_fd_sc_mcu9t5v0__dffrnq_2
* cell instance $11235 r0 *1 1582.56,1058.4
X$11235 14695 16484 15159 14696 16506 16309 gf180mcu_fd_sc_mcu9t5v0__dffrnq_2
* cell instance $11236 m0 *1 1583.12,977.76
X$11236 14147 13921 13832 14009 13864 gf180mcu_fd_sc_mcu9t5v0__xnor2_1
* cell instance $11237 m0 *1 1638,1038.24
X$11237 15043 15725 15594 14696 15576 15737 gf180mcu_fd_sc_mcu9t5v0__dffrnq_2
* cell instance $11238 m0 *1 1624.56,1038.24
X$11238 15593 15722 15890 15576 15737 15560 gf180mcu_fd_sc_mcu9t5v0__mux2_1
* cell instance $11239 m0 *1 1632.4,1038.24
X$11239 15561 15890 15724 15723 15576 15737 15044
+ gf180mcu_fd_sc_mcu9t5v0__oai22_1
* cell instance $11240 r0 *1 1631.28,1098.72
X$11240 16485 17709 17521 17552 17304 gf180mcu_fd_sc_mcu9t5v0__xor2_1
* cell instance $11241 m0 *1 1634.08,1058.4
X$11241 16338 16178 16336 16194 16309 16177 gf180mcu_fd_sc_mcu9t5v0__oai21_1
* cell instance $11242 r0 *1 1627.36,1048.32
X$11242 16339 16177 16194 16008 16038 gf180mcu_fd_sc_mcu9t5v0__nand2_1
* cell instance $11243 m0 *1 1622.88,1048.32
X$11243 16335 15898 16008 16038 15722 gf180mcu_fd_sc_mcu9t5v0__xor2_1
* cell instance $11244 r0 *1 1633.52,1088.64
X$11244 17609 17304 17398 17289 16338 gf180mcu_fd_sc_mcu9t5v0__and2_1
* cell instance $11245 r0 *1 1631.28,1048.32
X$11245 16338 16336 16178 16194 16008 15724 gf180mcu_fd_sc_mcu9t5v0__nor3_1
* cell instance $11246 r0 *1 1597.12,1078.56
X$11246 14695 17111 16927 14696 17123 16956 gf180mcu_fd_sc_mcu9t5v0__dffrnq_2
* cell instance $11247 r0 *1 1610,1068.48
X$11247 16688 16548 16818 16784 16653 16547 gf180mcu_fd_sc_mcu9t5v0__mux2_1
* cell instance $11248 m0 *1 1597.12,1048.32
X$11248 14695 16037 15422 14696 15898 16008 gf180mcu_fd_sc_mcu9t5v0__dffrnq_2
* cell instance $11249 r0 *1 1615.04,1058.4
X$11249 16485 16506 16309 16548 16335 gf180mcu_fd_sc_mcu9t5v0__xor2_1
* cell instance $11250 r0 *1 1595.44,1068.48
X$11250 3930 16784 16653 14695 gf180mcu_fd_sc_mcu9t5v0__clkbuf_8
* cell instance $11251 r0 *1 1612.24,1098.72
X$11251 14695 17607 17552 14696 17709 17521 gf180mcu_fd_sc_mcu9t5v0__dffrnq_2
* cell instance $11252 r0 *1 1625.68,1058.4
X$11252 16485 16486 16506 16309 16339 gf180mcu_fd_sc_mcu9t5v0__nand2_1
* cell instance $11253 r0 *1 1590.4,1098.72
X$11253 15754 14872 17709 17521 17733 gf180mcu_fd_sc_mcu9t5v0__nand2_1
* cell instance $11254 m0 *1 1590.4,1068.48
X$11254 15159 14872 16506 16653 16546 gf180mcu_fd_sc_mcu9t5v0__nand2_1
* cell instance $11255 m0 *1 1597.12,1078.56
X$11255 14695 16784 16956 gf180mcu_fd_sc_mcu9t5v0__clkbuf_4
* cell instance $11256 m0 *1 1603.28,1088.64
X$11256 17276 16927 14872 17123 17289 17111 gf180mcu_fd_sc_mcu9t5v0__mux2_1
* cell instance $11257 m0 *1 1599.92,1068.48
X$11257 14695 16547 16548 14696 16506 16653 gf180mcu_fd_sc_mcu9t5v0__dffrnq_2
* cell instance $11258 r0 *1 1593.2,1098.72
X$11258 14695 17606 15754 14696 17709 17521 gf180mcu_fd_sc_mcu9t5v0__dffrnq_2
* cell instance $11259 r0 *1 1604.4,1038.24
X$11259 15760 15422 14872 15898 15737 16037 gf180mcu_fd_sc_mcu9t5v0__mux2_1
* cell instance $11260 r0 *1 1619.52,1078.56
X$11260 14695 16987 16486 14696 17123 16956 gf180mcu_fd_sc_mcu9t5v0__dffrnq_2
* cell instance $11261 m0 *1 1619.52,1098.72
X$11261 17553 17552 16818 17398 17521 17607 gf180mcu_fd_sc_mcu9t5v0__mux2_1
* cell instance $11262 r0 *1 1621.76,1058.4
X$11262 16485 16548 16506 16309 16209 gf180mcu_fd_sc_mcu9t5v0__nand2_1
* cell instance $11263 r0 *1 1628.48,1058.4
X$11263 16485 16506 16309 16486 16336 gf180mcu_fd_sc_mcu9t5v0__xor2_1
* cell instance $11264 m0 *1 1624,1058.4
X$11264 16338 16335 16336 16194 16309 16337 gf180mcu_fd_sc_mcu9t5v0__nand3_1
* cell instance $11265 r0 *1 1638,1098.72
X$11265 16485 17608 17609 17709 17521 17610 gf180mcu_fd_sc_mcu9t5v0__aoi21_1
* cell instance $11266 m0 *1 1635.76,1098.72
X$11266 17304 17610 17398 17521 17554 gf180mcu_fd_sc_mcu9t5v0__xnor2_1
* cell instance $11267 m0 *1 1645.28,1098.72
X$11267 17556 17554 15890 17398 17521 17555 gf180mcu_fd_sc_mcu9t5v0__mux2_1
* cell instance $11268 m0 *1 1630.72,1098.72
X$11268 17552 17608 16485 17398 17521 16210 gf180mcu_fd_sc_mcu9t5v0__oai21_1
* cell instance $11269 m0 *1 1627.92,1058.4
X$11269 16209 16339 16337 16210 16194 16309 16340
+ gf180mcu_fd_sc_mcu9t5v0__and4_1
* cell instance $11270 r0 *1 1645.28,1058.4
X$11270 16487 16506 16309 16488 gf180mcu_fd_sc_mcu9t5v0__clkinv_1
* cell instance $11271 m0 *1 1649.76,1058.4
X$11271 16485 16488 16340 16194 16309 16341 gf180mcu_fd_sc_mcu9t5v0__and3_1
* cell instance $11272 m0 *1 1650.32,1068.48
X$11272 16485 16488 16340 16506 16653 16211 gf180mcu_fd_sc_mcu9t5v0__nor3_1
* cell instance $11273 r0 *1 1630.72,1038.24
X$11273 15890 16177 15898 15737 15723 gf180mcu_fd_sc_mcu9t5v0__nand2_1
* cell instance $11274 r0 *1 1645.84,1068.48
X$11274 16689 16487 16818 16784 16653 16819 gf180mcu_fd_sc_mcu9t5v0__mux2_1
* cell instance $11275 m0 *1 1625.68,1078.56
X$11275 16935 16486 16818 16784 16956 16987 gf180mcu_fd_sc_mcu9t5v0__mux2_1
* cell instance $11276 r0 *1 1635.2,1058.4
X$11276 16210 16506 16309 16178 gf180mcu_fd_sc_mcu9t5v0__clkinv_1
* cell instance $11277 r0 *1 1539.44,1058.4
X$11277 15908 16334 16506 16309 16173 16175 gf180mcu_fd_sc_mcu9t5v0__xnor3_1
* cell instance $11278 r0 *1 1568.56,1088.64
X$11278 17978 15420 14872 17398 17289 17422 gf180mcu_fd_sc_mcu9t5v0__mux2_1
* cell instance $11279 r0 *1 1546.72,1048.32
X$11279 14685 16173 16194 16008 15888 gf180mcu_fd_sc_mcu9t5v0__nand2_1
* cell instance $11280 r0 *1 1526,1078.56
X$11280 17137 17267 17138 17123 16956 17139 gf180mcu_fd_sc_mcu9t5v0__oai21_1
* cell instance $11281 m0 *1 1529.36,1088.64
X$11281 17272 17123 17289 17139 16544 gf180mcu_fd_sc_mcu9t5v0__xor2_1
* cell instance $11282 r0 *1 1568,1058.4
X$11282 16815 16333 16035 15908 16483 16506 16309 16036
+ gf180mcu_fd_sc_mcu9t5v0__aoi221_1
* cell instance $11283 m0 *1 1568.56,1078.56
X$11283 16956 16784 gf180mcu_fd_sc_mcu9t5v0__filltie
* cell instance $11284 m0 *1 1523.76,1058.4
X$11284 16208 16544 16194 16309 15885 gf180mcu_fd_sc_mcu9t5v0__or2_1
* cell instance $11285 m0 *1 1540,1088.64
X$11285 17273 17123 17289 17274 gf180mcu_fd_sc_mcu9t5v0__clkinv_1
* cell instance $11286 m0 *1 1582.56,1048.32
X$11286 16176 16036 15898 16008 15909 gf180mcu_fd_sc_mcu9t5v0__nor2_1
* cell instance $11287 r0 *1 1543.92,1048.32
X$11287 16033 16206 16194 16008 16034 gf180mcu_fd_sc_mcu9t5v0__nand2_1
* cell instance $11288 r0 *1 1564.08,1048.32
X$11288 16035 16174 16194 16008 15557 gf180mcu_fd_sc_mcu9t5v0__xnor2_1
* cell instance $11289 m0 *1 1543.36,1048.32
X$11289 16034 15557 15898 16008 15887 gf180mcu_fd_sc_mcu9t5v0__xnor2_1
* cell instance $11290 m0 *1 1565.2,1078.56
X$11290 15908 16933 16784 16956 16816 gf180mcu_fd_sc_mcu9t5v0__nand2_1
* cell instance $11291 m0 *1 1547.28,1058.4
X$11291 16815 16333 16483 16194 16309 16334 gf180mcu_fd_sc_mcu9t5v0__aoi21_1
* cell instance $11292 m0 *1 1544.48,1068.48
X$11292 16333 16544 16506 16653 16033 gf180mcu_fd_sc_mcu9t5v0__or2_1
* cell instance $11293 m0 *1 1537.76,1078.56
X$11293 16175 17273 14205 16784 16956 16032 gf180mcu_fd_sc_mcu9t5v0__mux2_1
* cell instance $11294 m0 *1 1568.56,1088.64
X$11294 17289 17123 gf180mcu_fd_sc_mcu9t5v0__filltie
* cell instance $11295 r0 *1 1560.72,1068.48
X$11295 16816 17110 16784 16653 16817 gf180mcu_fd_sc_mcu9t5v0__and2_1
* cell instance $11296 m0 *1 1559.6,1078.56
X$11296 16985 16984 16817 16932 16784 16956 14143
+ gf180mcu_fd_sc_mcu9t5v0__oai31_1
* cell instance $11297 r0 *1 1560.16,1078.56
X$11297 16816 17110 16984 17123 16956 15298 gf180mcu_fd_sc_mcu9t5v0__aoi21_1
* cell instance $11298 m0 *1 1572.48,1058.4
X$11298 16175 16194 16309 16035 gf180mcu_fd_sc_mcu9t5v0__clkinv_1
* cell instance $11299 m0 *1 1568.56,1068.48
X$11299 16653 16506 gf180mcu_fd_sc_mcu9t5v0__filltie
* cell instance $11300 m0 *1 1564.08,1048.32
X$11300 16035 16174 15898 16008 15759 gf180mcu_fd_sc_mcu9t5v0__or2_1
* cell instance $11301 m0 *1 1568.56,1048.32
X$11301 16008 15898 gf180mcu_fd_sc_mcu9t5v0__filltie
* cell instance $11302 r0 *1 1574.16,1058.4
X$11302 16208 16506 16309 16333 gf180mcu_fd_sc_mcu9t5v0__clkinv_1
* cell instance $11303 r0 *1 1570.8,1048.32
X$11303 16175 16174 16194 16008 15889 gf180mcu_fd_sc_mcu9t5v0__nor2_1
* cell instance $11304 m0 *1 1568.56,1098.72
X$11304 17521 17398 gf180mcu_fd_sc_mcu9t5v0__filltie
* cell instance $11305 m0 *1 1568.56,1058.4
X$11305 16309 16194 gf180mcu_fd_sc_mcu9t5v0__filltie
* cell instance $11306 m0 *1 1526.56,1068.48
X$11306 14205 16483 16686 16506 16653 16482 gf180mcu_fd_sc_mcu9t5v0__nor3_1
* cell instance $11307 m0 *1 1542.24,1088.64
X$11307 16815 17274 17123 17289 17275 gf180mcu_fd_sc_mcu9t5v0__nand2_1
* cell instance $11308 m0 *1 1520.4,1088.64
X$11308 17269 17270 17123 17289 17137 gf180mcu_fd_sc_mcu9t5v0__nor2_1
* cell instance $11309 m0 *1 1534.96,1048.32
X$11309 15908 16032 15898 16008 15168 gf180mcu_fd_sc_mcu9t5v0__nor2_1
* cell instance $11310 r0 *1 1519.84,1038.24
X$11310 15886 15898 15737 15758 15756 gf180mcu_fd_sc_mcu9t5v0__xor2_1
* cell instance $11311 r0 *1 1545.6,1098.72
X$11311 14695 17551 14990 14696 17709 17521 gf180mcu_fd_sc_mcu9t5v0__dffrnq_2
* cell instance $11312 r0 *1 1556.8,1078.56
X$11312 15420 17109 17123 16956 16985 gf180mcu_fd_sc_mcu9t5v0__nor2_1
* cell instance $11313 m0 *1 1556.8,1088.64
X$11313 15558 17123 17289 16933 gf180mcu_fd_sc_mcu9t5v0__clkinv_1
* cell instance $11314 m0 *1 1556.24,1078.56
X$11314 15908 16933 16784 16956 16984 gf180mcu_fd_sc_mcu9t5v0__nor2_1
* cell instance $11315 r0 *1 1543.92,1038.24
X$11315 14685 15887 15888 13492 15898 15737 15712
+ gf180mcu_fd_sc_mcu9t5v0__oai211_1
* cell instance $11316 r0 *1 1528.8,1038.24
X$11316 15720 15886 15898 15737 15421 gf180mcu_fd_sc_mcu9t5v0__and2_1
* cell instance $11317 r0 *1 1533.28,1038.24
X$11317 15168 15898 15737 15719 gf180mcu_fd_sc_mcu9t5v0__clkinv_1
* cell instance $11318 m0 *1 1532.16,1048.32
X$11318 15908 16032 15898 16008 15720 gf180mcu_fd_sc_mcu9t5v0__nand2_1
* cell instance $11319 m0 *1 1523.76,1088.64
X$11319 17137 17267 17138 17272 17123 17289 17271
+ gf180mcu_fd_sc_mcu9t5v0__oai211_1
* cell instance $11320 m0 *1 1545.04,1088.64
X$11320 17275 17271 17123 17289 17110 gf180mcu_fd_sc_mcu9t5v0__and2_1
* cell instance $11321 r0 *1 1519.84,1098.72
X$11321 16208 17270 14205 17709 17521 17550 gf180mcu_fd_sc_mcu9t5v0__mux2_1
* cell instance $11322 r0 *1 1554,1078.56
X$11322 15420 17109 17123 16956 16932 gf180mcu_fd_sc_mcu9t5v0__nand2_1
* cell instance $11323 r0 *1 1530.48,1088.64
X$11323 16815 17273 17398 17289 17272 gf180mcu_fd_sc_mcu9t5v0__xnor2_1
* cell instance $11324 m0 *1 1551.2,1048.32
X$11324 16033 16206 15557 15898 16008 15297 gf180mcu_fd_sc_mcu9t5v0__aoi21_1
* cell instance $11325 r0 *1 1551.76,1078.56
X$11325 14991 17123 16956 17109 gf180mcu_fd_sc_mcu9t5v0__clkinv_1
* cell instance $11326 r0 *1 1521.52,1068.48
X$11326 16815 16208 16784 16653 16814 gf180mcu_fd_sc_mcu9t5v0__xnor2_1
* cell instance $11327 r0 *1 1522.64,1058.4
X$11327 16208 16544 16506 16309 15757 gf180mcu_fd_sc_mcu9t5v0__xnor2_1
* cell instance $11328 m0 *1 1520.96,1068.48
X$11328 16814 16687 16685 16506 16653 16483 gf180mcu_fd_sc_mcu9t5v0__and3_1
* cell instance $11329 r0 *1 1555.12,1058.4
X$11329 15908 17110 16506 16309 16174 15558 gf180mcu_fd_sc_mcu9t5v0__xnor3_1
* cell instance $11330 r0 *1 1574.16,1048.32
X$11330 15908 16035 16194 16008 16176 gf180mcu_fd_sc_mcu9t5v0__nor2_1
* cell instance $11331 m0 *1 1546.16,1098.72
X$11331 17732 14990 14872 17398 17521 17551 gf180mcu_fd_sc_mcu9t5v0__mux2_1
* cell instance $11332 r0 *1 1567.44,997.92
X$11332 11611 12632 14708 14448 14692 gf180mcu_fd_sc_mcu9t5v0__nand2_1
* cell instance $11333 m0 *1 1532.16,1028.16
X$11333 15420 15296 15271 15402 15295 15039 gf180mcu_fd_sc_mcu9t5v0__xor3_1
* cell instance $11334 r0 *1 1570.8,997.92
X$11334 14473 14693 14694 14692 14708 14448 14719
+ gf180mcu_fd_sc_mcu9t5v0__oai31_1
* cell instance $11335 m0 *1 1568.56,1018.08
X$11335 15138 14967 gf180mcu_fd_sc_mcu9t5v0__filltie
* cell instance $11336 m0 *1 1568.56,1028.16
X$11336 15402 15271 gf180mcu_fd_sc_mcu9t5v0__filltie
* cell instance $11337 m0 *1 1569.68,1008
X$11337 14838 14837 14839 14708 14857 12773 gf180mcu_fd_sc_mcu9t5v0__oai21_1
* cell instance $11338 m0 *1 1568.56,1008
X$11338 14857 14708 gf180mcu_fd_sc_mcu9t5v0__filltie
* cell instance $11339 r0 *1 1563.52,1018.08
X$11339 15299 15297 14838 15271 15138 13496 gf180mcu_fd_sc_mcu9t5v0__oai21_1
* cell instance $11340 m0 *1 1582,987.84
X$11340 14145 13863 14146 14126 14304 13921 gf180mcu_fd_sc_mcu9t5v0__oai21_1
* cell instance $11341 r0 *1 1579.2,1028.16
X$11341 15420 15042 15576 15402 15592 gf180mcu_fd_sc_mcu9t5v0__nand2_1
* cell instance $11342 m0 *1 1571.92,1018.08
X$11342 15042 15041 14967 15138 14839 gf180mcu_fd_sc_mcu9t5v0__nand2_1
* cell instance $11343 r0 *1 1571.36,1008
X$11343 14838 14837 14967 14857 14693 gf180mcu_fd_sc_mcu9t5v0__nor2_1
* cell instance $11344 m0 *1 1574.16,1008
X$11344 14838 14837 14708 14857 14694 gf180mcu_fd_sc_mcu9t5v0__and2_1
* cell instance $11345 m0 *1 1568.56,987.84
X$11345 14304 14126 gf180mcu_fd_sc_mcu9t5v0__filltie
* cell instance $11346 r0 *1 1551.76,987.84
X$11346 14034 14435 14406 14304 14033 gf180mcu_fd_sc_mcu9t5v0__nor2_1
* cell instance $11347 m0 *1 1537.76,987.84
X$11347 14208 14207 14126 14304 14209 gf180mcu_fd_sc_mcu9t5v0__xnor2_1
* cell instance $11348 r0 *1 1576.4,977.76
X$11348 14034 13737 14126 14009 14145 gf180mcu_fd_sc_mcu9t5v0__nor2_1
* cell instance $11349 r0 *1 1579.76,977.76
X$11349 14145 13863 14146 14147 14126 14009 13920
+ gf180mcu_fd_sc_mcu9t5v0__oai211_1
* cell instance $11350 m0 *1 1569.68,1028.16
X$11350 15299 15297 15271 15402 15423 gf180mcu_fd_sc_mcu9t5v0__or2_1
* cell instance $11351 r0 *1 1578.08,1018.08
X$11351 15423 15271 15138 14838 15169 gf180mcu_fd_sc_mcu9t5v0__xor2_1
* cell instance $11352 r0 *1 1527.12,967.68
X$11352 13858 13708 13832 13719 13494 gf180mcu_fd_sc_mcu9t5v0__nand2_1
* cell instance $11353 r0 *1 1563.52,967.68
X$11353 14990 13863 13832 13719 13860 13862 gf180mcu_fd_sc_mcu9t5v0__xnor3_1
* cell instance $11354 m0 *1 1562.4,987.84
X$11354 14990 14126 14304 14034 gf180mcu_fd_sc_mcu9t5v0__clkinv_1
* cell instance $11355 r0 *1 1557.92,967.68
X$11355 13861 13832 13719 13334 gf180mcu_fd_sc_mcu9t5v0__clkinv_1
* cell instance $11356 r0 *1 1560.16,967.68
X$11356 13862 13711 13832 13719 13185 gf180mcu_fd_sc_mcu9t5v0__nor2_1
* cell instance $11357 m0 *1 1579.76,1028.16
X$11357 15422 15271 15402 15042 gf180mcu_fd_sc_mcu9t5v0__clkinv_1
* cell instance $11358 r0 *1 1547.84,967.68
X$11358 14685 13860 13832 13719 13710 gf180mcu_fd_sc_mcu9t5v0__nand2_1
* cell instance $11359 m0 *1 1568.56,977.76
X$11359 14009 13832 gf180mcu_fd_sc_mcu9t5v0__filltie
* cell instance $11360 m0 *1 1580.32,977.76
X$11360 14034 13737 13832 14009 14146 gf180mcu_fd_sc_mcu9t5v0__nand2_1
* cell instance $11361 m0 *1 1537.76,977.76
X$11361 13047 14032 13920 13832 14009 13858 gf180mcu_fd_sc_mcu9t5v0__oai21_1
* cell instance $11362 m0 *1 1563.52,977.76
X$11362 13737 13832 14009 13862 gf180mcu_fd_sc_mcu9t5v0__clkinv_1
* cell instance $11363 r0 *1 1571.36,1018.08
X$11363 15042 15041 15271 15138 14838 gf180mcu_fd_sc_mcu9t5v0__xnor2_1
* cell instance $11364 r0 *1 1548.4,1028.16
X$11364 15422 15558 14205 15576 15402 15295 gf180mcu_fd_sc_mcu9t5v0__mux2_1
* cell instance $11365 m0 *1 1529.36,1008
X$11365 14717 14690 14708 14857 14836 gf180mcu_fd_sc_mcu9t5v0__xnor2_1
* cell instance $11366 r0 *1 1535.52,977.76
X$11366 14032 14207 14142 14126 14009 13857 gf180mcu_fd_sc_mcu9t5v0__oai21_1
* cell instance $11367 r0 *1 1552.32,977.76
X$11367 14033 14143 14144 14126 14009 14210 gf180mcu_fd_sc_mcu9t5v0__oai21_1
* cell instance $11368 r0 *1 1538.88,1008
X$11368 14989 14718 14967 14857 14988 gf180mcu_fd_sc_mcu9t5v0__nand2_1
* cell instance $11369 m0 *1 1561.28,1018.08
X$11369 15422 15041 14967 15138 13861 gf180mcu_fd_sc_mcu9t5v0__and2_1
* cell instance $11370 m0 *1 1568.56,997.92
X$11370 14448 14406 gf180mcu_fd_sc_mcu9t5v0__filltie
* cell instance $11371 m0 *1 1547.28,987.84
X$11371 14209 14126 14304 14210 13048 gf180mcu_fd_sc_mcu9t5v0__xor2_1
* cell instance $11372 r0 *1 1540,977.76
X$11372 14208 14126 14009 14032 gf180mcu_fd_sc_mcu9t5v0__clkinv_1
* cell instance $11373 r0 *1 1533.28,1028.16
X$11373 15420 15295 15576 15402 15167 gf180mcu_fd_sc_mcu9t5v0__nand2_1
* cell instance $11374 m0 *1 1555.12,997.92
X$11374 14034 14435 14406 14448 14144 gf180mcu_fd_sc_mcu9t5v0__nand2_1
* cell instance $11375 m0 *1 1554,987.84
X$11375 14033 14143 14144 14209 14126 14304 14142
+ gf180mcu_fd_sc_mcu9t5v0__oai211_1
* cell instance $11376 r0 *1 1555.12,987.84
X$11376 14034 14143 14406 14304 13711 14435 gf180mcu_fd_sc_mcu9t5v0__xnor3_1
* cell instance $11377 m0 *1 1553.44,1028.16
X$11377 15420 15298 15271 15402 15041 14991 gf180mcu_fd_sc_mcu9t5v0__xnor3_1
* cell instance $11378 r0 *1 1550.64,1008
X$11378 13737 14991 14205 14967 14857 14871 gf180mcu_fd_sc_mcu9t5v0__mux2_1
* cell instance $11379 r0 *1 1531.6,1008
X$11379 14689 14988 14967 14857 14869 gf180mcu_fd_sc_mcu9t5v0__xnor2_1
* cell instance $11380 r0 *1 1533.84,1018.08
X$11380 15166 15168 15421 15167 15271 15138 14689
+ gf180mcu_fd_sc_mcu9t5v0__oai31_1
* cell instance $11381 m0 *1 1528.8,1028.16
X$11381 15420 15295 15271 15402 15166 gf180mcu_fd_sc_mcu9t5v0__nor2_1
* cell instance $11382 r0 *1 1546.16,1008
X$11382 14990 14871 14967 14857 14718 gf180mcu_fd_sc_mcu9t5v0__or2_1
* cell instance $11383 r0 *1 1534.4,987.84
X$11383 13047 14435 14205 14406 14304 14436 gf180mcu_fd_sc_mcu9t5v0__mux2_1
* cell instance $11384 r0 *1 1531.6,987.84
X$11384 14208 14436 14406 14304 14434 gf180mcu_fd_sc_mcu9t5v0__nand2_1
* cell instance $11385 m0 *1 1531.04,997.92
X$11385 14208 14436 14406 14448 14478 gf180mcu_fd_sc_mcu9t5v0__xnor2_1
* cell instance $11386 r0 *1 1543.36,1008
X$11386 14990 14871 14967 14857 14989 gf180mcu_fd_sc_mcu9t5v0__nand2_1
* cell instance $11387 r0 *1 1536.08,1028.16
X$11387 15168 15421 15576 15402 15296 gf180mcu_fd_sc_mcu9t5v0__nor2_1
* cell instance $11388 m0 *1 1539.44,1018.08
X$11388 14989 14967 15138 14691 gf180mcu_fd_sc_mcu9t5v0__clkinv_1
* cell instance $11389 r0 *1 1531.6,997.92
X$11389 14478 14708 14448 14717 gf180mcu_fd_sc_mcu9t5v0__clkinv_1
* cell instance $11390 m0 *1 1536.08,1008
X$11390 14691 14689 14718 14717 14708 14857 14477
+ gf180mcu_fd_sc_mcu9t5v0__oai211_1
* cell instance $11391 m0 *1 1526.56,997.92
X$11391 14434 14477 14406 14448 14476 gf180mcu_fd_sc_mcu9t5v0__and2_1
* cell instance $11392 r0 *1 1533.84,997.92
X$11392 14691 14689 14718 14708 14448 14690 gf180mcu_fd_sc_mcu9t5v0__oai21_1
* cell instance $11393 r0 *1 1644.16,1028.16
X$11393 15561 15173 15576 15402 14873 15594 gf180mcu_fd_sc_mcu9t5v0__xnor3_1
* cell instance $11394 r0 *1 1590.96,1018.08
X$11394 14695 15300 13480 14696 15271 15138 gf180mcu_fd_sc_mcu9t5v0__dffrnq_2
* cell instance $11395 r0 *1 1591.52,1008
X$11395 18123 14208 14872 14967 14857 14840 gf180mcu_fd_sc_mcu9t5v0__mux2_1
* cell instance $11396 m0 *1 1589.84,1008
X$11396 14695 14840 14208 14696 14708 14857 gf180mcu_fd_sc_mcu9t5v0__dffrnq_2
* cell instance $11397 m0 *1 1605.52,1018.08
X$11397 14695 14992 13047 14696 14967 15138 gf180mcu_fd_sc_mcu9t5v0__dffrnq_2
* cell instance $11398 r0 *1 1613.92,1008
X$11398 14873 13047 14872 14967 14857 14992 gf180mcu_fd_sc_mcu9t5v0__mux2_1
* cell instance $11399 m0 *1 1589.28,1028.16
X$11399 15424 15170 15271 15402 15300 gf180mcu_fd_sc_mcu9t5v0__nor2_1
* cell instance $11400 m0 *1 1631.28,1018.08
X$11400 15043 15044 15425 14696 14967 15138 gf180mcu_fd_sc_mcu9t5v0__dffrnq_2
* cell instance $11401 r0 *1 1617.28,1028.16
X$11401 14695 15560 15593 14696 15576 15402 gf180mcu_fd_sc_mcu9t5v0__dffrnq_2
* cell instance $11402 r0 *1 1649.2,997.92
X$11402 14698 13183 14872 14708 14448 14697 gf180mcu_fd_sc_mcu9t5v0__mux2_1
* cell instance $11403 m0 *1 1645.28,1028.16
X$11403 15425 15271 15402 15561 gf180mcu_fd_sc_mcu9t5v0__clkinv_1
* cell instance $11404 r0 *1 1651.44,1018.08
X$11404 15425 15171 15271 15138 15172 gf180mcu_fd_sc_mcu9t5v0__nand2_1
* cell instance $11405 m0 *1 1421.28,1038.24
X$11405 13477 12632 15576 15737 15711 gf180mcu_fd_sc_mcu9t5v0__nand2_1
* cell instance $11406 m0 *1 1424.08,1038.24
X$11406 15712 15711 15576 15737 15548 gf180mcu_fd_sc_mcu9t5v0__nand2_1
* cell instance $11407 m0 *1 1450.4,1038.24
X$11407 15715 15714 15716 15576 15737 13223 gf180mcu_fd_sc_mcu9t5v0__oai21_1
* cell instance $11408 m0 *1 1486.8,1038.24
X$11408 10979 12632 15576 15737 15553 gf180mcu_fd_sc_mcu9t5v0__nand2_1
* cell instance $11409 m0 *1 1443.68,997.92
X$11409 12763 14406 14448 14473 gf180mcu_fd_sc_mcu9t5v0__buf_8
* cell instance $11410 m0 *1 1449.84,1008
X$11410 13915 14835 4770 13180 14708 14857 gf180mcu_fd_sc_mcu9t5v0__dffrnq_2
* cell instance $11411 m0 *1 1473.36,1038.24
X$11411 15717 15718 15576 15737 15551 gf180mcu_fd_sc_mcu9t5v0__and2_1
* cell instance $11412 m0 *1 1430.24,1038.24
X$11412 14427 15713 15413 13180 15576 15737 gf180mcu_fd_sc_mcu9t5v0__dffrnq_2
* cell instance $11413 m0 *1 1438.08,1018.08
X$11413 13915 15038 4946 13180 14967 15138 gf180mcu_fd_sc_mcu9t5v0__dffrnq_2
* cell instance $11414 m0 *1 1477.84,1038.24
X$11414 15717 15718 15576 15737 15552 gf180mcu_fd_sc_mcu9t5v0__nor2_1
* cell instance $11415 r0 *1 1449.84,967.68
X$11415 14027 13848 13492 13832 13719 13916 gf180mcu_fd_sc_mcu9t5v0__mux2_1
* cell instance $11416 m0 *1 1489.6,1038.24
X$11416 13915 15591 10979 13180 15576 15737 gf180mcu_fd_sc_mcu9t5v0__dffrnq_2
* cell instance $11417 m0 *1 1439.2,977.76
X$11417 13915 13916 14027 13180 13832 14009 gf180mcu_fd_sc_mcu9t5v0__dffrnq_2
* cell instance $11418 m0 *1 1448.72,1088.64
X$11418 17262 17123 17289 16929 gf180mcu_fd_sc_mcu9t5v0__clkinv_1
* cell instance $11419 r0 *1 1449.84,1088.64
X$11419 17263 17420 17265 17303 17398 17289 17264
+ gf180mcu_fd_sc_mcu9t5v0__aoi211_1
* cell instance $11420 m0 *1 1446.48,1068.48
X$11420 16682 16540 15715 16506 16653 16539 gf180mcu_fd_sc_mcu9t5v0__nand3_1
* cell instance $11421 r0 *1 1449.84,1058.4
X$11421 14685 16473 16506 16309 16472 gf180mcu_fd_sc_mcu9t5v0__nor2_1
* cell instance $11422 r0 *1 1455.44,1088.64
X$11422 17303 17398 17289 17135 16474 gf180mcu_fd_sc_mcu9t5v0__xor2_1
* cell instance $11423 r0 *1 1494.08,1098.72
X$11423 17268 17729 17709 17521 17547 gf180mcu_fd_sc_mcu9t5v0__or2_1
* cell instance $11424 m0 *1 1498,1078.56
X$11424 16983 16931 16784 16956 15884 gf180mcu_fd_sc_mcu9t5v0__nor2_1
* cell instance $11425 m0 *1 1503.6,1098.72
X$11425 17603 17727 17548 17604 17398 17521 17549
+ gf180mcu_fd_sc_mcu9t5v0__aoi211_1
* cell instance $11426 r0 *1 1508.64,1078.56
X$11426 16983 17269 17136 17123 16956 16685 gf180mcu_fd_sc_mcu9t5v0__oai21_1
* cell instance $11427 m0 *1 1501.36,1088.64
X$11427 17268 17123 17289 17269 gf180mcu_fd_sc_mcu9t5v0__clkinv_1
* cell instance $11428 m0 *1 1501.36,1098.72
X$11428 17547 17398 17521 17548 gf180mcu_fd_sc_mcu9t5v0__clkinv_1
* cell instance $11429 r0 *1 1502.48,1098.72
X$11429 17604 17730 17709 17521 15882 gf180mcu_fd_sc_mcu9t5v0__xnor2_1
* cell instance $11430 r0 *1 1498.56,1098.72
X$11430 17603 17547 17709 17521 17602 gf180mcu_fd_sc_mcu9t5v0__nand2_1
* cell instance $11431 r0 *1 1495.76,1068.48
X$11431 16930 16931 16784 16653 16480 gf180mcu_fd_sc_mcu9t5v0__nor2_1
* cell instance $11432 m0 *1 1496.32,1088.64
X$11432 16983 17123 17289 16930 gf180mcu_fd_sc_mcu9t5v0__clkinv_1
* cell instance $11433 m0 *1 1509.76,1058.4
X$11433 13700 16194 16309 16332 gf180mcu_fd_sc_mcu9t5v0__clkinv_1
* cell instance $11434 m0 *1 1503.6,1088.64
X$11434 17269 17267 17123 17289 16931 17270 gf180mcu_fd_sc_mcu9t5v0__xnor3_1
* cell instance $11435 r0 *1 1496.88,1058.4
X$11435 16480 16479 15757 16506 16309 16481 gf180mcu_fd_sc_mcu9t5v0__or3_1
* cell instance $11436 r0 *1 1503.04,1058.4
X$11436 14205 16206 16481 16506 16309 16331 gf180mcu_fd_sc_mcu9t5v0__nand3_1
* cell instance $11437 r0 *1 1452.64,1038.24
X$11437 15715 15714 14473 15898 15737 15716 gf180mcu_fd_sc_mcu9t5v0__aoi21_1
* cell instance $11438 r0 *1 1468.88,1038.24
X$11438 15550 15549 16541 15898 15737 15718 gf180mcu_fd_sc_mcu9t5v0__oai21_1
* cell instance $11439 r0 *1 1457.68,1058.4
X$11439 16475 16329 16474 14205 16506 16309 16030
+ gf180mcu_fd_sc_mcu9t5v0__oai22_1
* cell instance $11440 r0 *1 1478.4,1078.56
X$11440 17107 17106 17123 16956 16541 gf180mcu_fd_sc_mcu9t5v0__nand2_1
* cell instance $11441 r0 *1 1489.04,1038.24
X$11441 15717 15718 15884 15898 15737 15883 gf180mcu_fd_sc_mcu9t5v0__aoi21_1
* cell instance $11442 r0 *1 1486.8,1098.72
X$11442 17727 17709 17521 17602 16681 gf180mcu_fd_sc_mcu9t5v0__xor2_1
* cell instance $11443 m0 *1 1491.28,1078.56
X$11443 16930 16931 16784 16956 15717 gf180mcu_fd_sc_mcu9t5v0__xnor2_1
* cell instance $11444 r0 *1 1488.48,1078.56
X$11444 16930 17136 17123 16956 17108 17268 gf180mcu_fd_sc_mcu9t5v0__xnor3_1
* cell instance $11445 m0 *1 1472.24,1098.72
X$11445 17600 17726 17398 17521 17106 gf180mcu_fd_sc_mcu9t5v0__xnor2_1
* cell instance $11446 m0 *1 1473.92,1088.64
X$11446 17266 17106 17123 17289 16542 gf180mcu_fd_sc_mcu9t5v0__nand2_1
* cell instance $11447 m0 *1 1458.24,1078.56
X$11447 16929 16928 16784 16956 16813 gf180mcu_fd_sc_mcu9t5v0__or2_1
* cell instance $11448 r0 *1 1461.04,1068.48
X$11448 16813 16784 16653 16683 gf180mcu_fd_sc_mcu9t5v0__clkinv_1
* cell instance $11449 m0 *1 1451.52,1078.56
X$11449 16929 16928 16784 16956 15715 gf180mcu_fd_sc_mcu9t5v0__xnor2_1
* cell instance $11450 r0 *1 1471.68,1078.56
X$11450 17107 17106 17123 16956 15550 gf180mcu_fd_sc_mcu9t5v0__xnor2_1
* cell instance $11451 m0 *1 1462.16,1068.48
X$11451 16683 16473 15550 16506 16653 16476 gf180mcu_fd_sc_mcu9t5v0__oai21_1
* cell instance $11452 m0 *1 1478.4,1068.48
X$11452 16542 16476 15717 16506 16653 16479 gf180mcu_fd_sc_mcu9t5v0__aoi21_1
* cell instance $11453 m0 *1 1450.4,1068.48
X$11453 16682 16540 15715 16506 16653 16473 gf180mcu_fd_sc_mcu9t5v0__aoi21_1
* cell instance $11454 m0 *1 1450.96,1098.72
X$11454 16929 17968 17398 17521 17265 gf180mcu_fd_sc_mcu9t5v0__nor2_1
* cell instance $11455 r0 *1 1467.76,1088.64
X$11455 17421 17398 17289 17266 17303 gf180mcu_fd_sc_mcu9t5v0__xor2_1
* cell instance $11456 r0 *1 1500.24,1038.24
X$11456 15757 15883 15898 15737 15554 gf180mcu_fd_sc_mcu9t5v0__nor2_1
* cell instance $11457 r0 *1 1495.76,1038.24
X$11457 15757 15883 15898 15737 15555 gf180mcu_fd_sc_mcu9t5v0__and2_1
* cell instance $11458 m0 *1 1504.72,1058.4
X$11458 16332 12632 16331 16207 16194 16309 16172
+ gf180mcu_fd_sc_mcu9t5v0__aoi22_1
* cell instance $11459 m0 *1 1476.72,1088.64
X$11459 17421 17107 17264 17123 17289 17136 gf180mcu_fd_sc_mcu9t5v0__aoi21_1
* cell instance $11460 r0 *1 1457.12,1078.56
X$11460 17262 16928 17123 16956 16031 gf180mcu_fd_sc_mcu9t5v0__nor2_1
* cell instance $11461 m0 *1 1455.44,1048.32
X$11461 15715 15714 16031 15898 16008 15549 gf180mcu_fd_sc_mcu9t5v0__aoi21_1
* cell instance $11462 r0 *1 1466.64,1048.32
X$11462 13915 16171 13482 13180 16194 16008 gf180mcu_fd_sc_mcu9t5v0__dffrnq_2
* cell instance $11463 r0 *1 1473.36,1098.72
X$11463 17421 17849 17709 17521 17600 gf180mcu_fd_sc_mcu9t5v0__xnor2_1
* cell instance $11464 r0 *1 1471.12,1098.72
X$11464 17600 17709 17521 17601 gf180mcu_fd_sc_mcu9t5v0__clkinv_1
* cell instance $11465 r0 *1 1480.08,1098.72
X$11465 17601 17726 17728 17709 17521 17267 gf180mcu_fd_sc_mcu9t5v0__oai21_1
* cell instance $11466 m0 *1 1497.44,1058.4
X$11466 16480 16479 15757 16194 16309 16206 gf180mcu_fd_sc_mcu9t5v0__oai21_1
* cell instance $11467 m0 *1 1452.08,1088.64
X$11467 17263 17420 17265 17123 17289 17135 gf180mcu_fd_sc_mcu9t5v0__aoi21_1
* cell instance $11468 m0 *1 1481.76,1058.4
X$11468 13482 16194 16309 16330 gf180mcu_fd_sc_mcu9t5v0__clkinv_1
* cell instance $11469 r0 *1 1485.68,1078.56
X$11469 14685 17108 17123 16956 16684 gf180mcu_fd_sc_mcu9t5v0__nand2_1
* cell instance $11470 m0 *1 1474.48,1068.48
X$11470 16542 16476 15717 16506 16653 16543 gf180mcu_fd_sc_mcu9t5v0__nand3_1
* cell instance $11471 r0 *1 1485.68,1058.4
X$11471 14685 16479 16506 16309 16477 gf180mcu_fd_sc_mcu9t5v0__nor2_1
* cell instance $11472 r0 *1 1476.16,1058.4
X$11472 16543 16477 12632 16506 16309 16478 gf180mcu_fd_sc_mcu9t5v0__aoi21_1
* cell instance $11473 r0 *1 1480.64,1058.4
X$11473 16330 12632 16684 16478 16506 16309 16171
+ gf180mcu_fd_sc_mcu9t5v0__aoi22_1
* cell instance $11474 m0 *1 1457.68,1068.48
X$11474 16683 16473 15550 16506 16653 16475 gf180mcu_fd_sc_mcu9t5v0__nor3_1
* cell instance $11475 r0 *1 1463.84,1058.4
X$11475 14205 16476 16506 16309 16329 gf180mcu_fd_sc_mcu9t5v0__nand2_1
* cell instance $11476 m0 *1 1406.16,1068.48
X$11476 16678 16679 16506 16653 16538 gf180mcu_fd_sc_mcu9t5v0__nand2_1
* cell instance $11477 r0 *1 1399.44,1088.64
X$11477 14427 17418 15407 13180 17398 17289 gf180mcu_fd_sc_mcu9t5v0__dffrnq_2
* cell instance $11478 r0 *1 1400,1068.48
X$11478 14427 16538 4939 13180 16784 16653 gf180mcu_fd_sc_mcu9t5v0__dffrnq_2
* cell instance $11479 r0 *1 1408.96,1048.32
X$11479 14427 16029 13728 13180 16194 16008 gf180mcu_fd_sc_mcu9t5v0__dffrnq_2
* cell instance $11480 r0 *1 1448.72,1058.4
X$11480 16309 16506 gf180mcu_fd_sc_mcu9t5v0__filltie
* cell instance $11481 r0 *1 1448.72,1068.48
X$11481 16653 16784 gf180mcu_fd_sc_mcu9t5v0__filltie
* cell instance $11482 m0 *1 1443.12,1058.4
X$11482 13897 16194 16309 16471 gf180mcu_fd_sc_mcu9t5v0__clkinv_1
* cell instance $11483 m0 *1 1435.84,1088.64
X$11483 16929 17420 17123 17289 17105 17968 gf180mcu_fd_sc_mcu9t5v0__xnor3_1
* cell instance $11484 r0 *1 1440.88,1078.56
X$11484 14685 17105 17123 16956 16470 gf180mcu_fd_sc_mcu9t5v0__nand2_1
* cell instance $11485 m0 *1 1391.6,1048.32
X$11485 14427 15907 15414 13180 15898 16008 gf180mcu_fd_sc_mcu9t5v0__dffrnq_2
* cell instance $11486 m0 *1 1401.12,1058.4
X$11486 15543 12632 16194 16309 16328 gf180mcu_fd_sc_mcu9t5v0__nand2_1
* cell instance $11487 m0 *1 1413.44,1078.56
X$11487 13912 16982 16784 16956 16678 gf180mcu_fd_sc_mcu9t5v0__nand2_1
* cell instance $11488 m0 *1 1400,1068.48
X$11488 13489 16537 16328 16678 16506 16653 16536
+ gf180mcu_fd_sc_mcu9t5v0__oai211_1
* cell instance $11489 m0 *1 1384.32,1068.48
X$11489 16677 16506 16653 16466 gf180mcu_fd_sc_mcu9t5v0__clkinv_1
* cell instance $11490 r0 *1 1445.92,1088.64
X$11490 16929 17968 17398 17289 17263 gf180mcu_fd_sc_mcu9t5v0__nand2_1
* cell instance $11491 m0 *1 1381.52,1068.48
X$11491 15755 16466 16506 16653 16535 gf180mcu_fd_sc_mcu9t5v0__nand2_1
* cell instance $11492 r0 *1 1393.84,1078.56
X$11492 16677 16927 14685 17123 16956 17104 gf180mcu_fd_sc_mcu9t5v0__mux2_1
* cell instance $11493 m0 *1 1407.28,1098.72
X$11493 15407 12632 17398 17521 17261 gf180mcu_fd_sc_mcu9t5v0__nand2_1
* cell instance $11494 m0 *1 1386.56,1078.56
X$11494 17103 16927 16784 16956 16468 gf180mcu_fd_sc_mcu9t5v0__xnor2_1
* cell instance $11495 m0 *1 1405.6,1088.64
X$11495 12632 17260 17261 17123 17289 17418 gf180mcu_fd_sc_mcu9t5v0__oai21_1
* cell instance $11496 m0 *1 1415.12,1048.32
X$11496 13728 16030 13492 15898 16008 16029 gf180mcu_fd_sc_mcu9t5v0__mux2_1
* cell instance $11497 r0 *1 1391.6,1098.72
X$11497 14427 17546 16808 13180 17709 17521 gf180mcu_fd_sc_mcu9t5v0__dffrnq_2
* cell instance $11498 r0 *1 1437.52,1038.24
X$11498 15413 15756 13492 15898 15737 15713 gf180mcu_fd_sc_mcu9t5v0__mux2_1
* cell instance $11499 r0 *1 1418.48,1088.64
X$11499 14427 17302 14670 13180 17398 17289 gf180mcu_fd_sc_mcu9t5v0__dffrnq_2
* cell instance $11500 r0 *1 1419.04,1068.48
X$11500 14427 16680 14826 13180 16784 16653 gf180mcu_fd_sc_mcu9t5v0__dffrnq_2
* cell instance $11501 r0 *1 1448.72,1038.24
X$11501 15737 15898 gf180mcu_fd_sc_mcu9t5v0__filltie
* cell instance $11502 r0 *1 1398.32,1038.24
X$11502 15414 15882 13492 15898 15737 15907 gf180mcu_fd_sc_mcu9t5v0__mux2_1
* cell instance $11503 m0 *1 1422.4,1048.32
X$11503 3930 15898 16008 14427 gf180mcu_fd_sc_mcu9t5v0__clkbuf_8
* cell instance $11504 m0 *1 1426.32,1068.48
X$11504 14826 16681 13492 16506 16653 16680 gf180mcu_fd_sc_mcu9t5v0__mux2_1
* cell instance $11505 m0 *1 1425.2,1088.64
X$11505 14670 17419 13492 17123 17289 17302 gf180mcu_fd_sc_mcu9t5v0__mux2_1
* cell instance $11506 r0 *1 1382.64,1038.24
X$11506 16468 15898 15737 15590 14684 gf180mcu_fd_sc_mcu9t5v0__xor2_1
* cell instance $11507 m0 *1 1424.08,1058.4
X$11507 14427 16205 13897 13180 16194 16309 gf180mcu_fd_sc_mcu9t5v0__dffrnq_2
* cell instance $11508 m0 *1 1396.64,1098.72
X$11508 16808 18275 13492 17398 17521 17546 gf180mcu_fd_sc_mcu9t5v0__mux2_1
* cell instance $11509 r0 *1 1444.24,1058.4
X$11509 16539 16472 12632 16506 16309 16469 gf180mcu_fd_sc_mcu9t5v0__aoi21_1
* cell instance $11510 m0 *1 1405.04,1078.56
X$11510 4939 12632 16784 16956 16679 gf180mcu_fd_sc_mcu9t5v0__nand2_1
* cell instance $11511 r0 *1 1438.64,1058.4
X$11511 16471 12632 16470 16469 16506 16309 16205
+ gf180mcu_fd_sc_mcu9t5v0__aoi22_1
* cell instance $11512 r0 *1 1448.72,1048.32
X$11512 16008 16194 gf180mcu_fd_sc_mcu9t5v0__filltie
* cell instance $11513 r0 *1 1448.72,1088.64
X$11513 17289 17398 gf180mcu_fd_sc_mcu9t5v0__filltie
* cell instance $11514 r0 *1 1448.72,1098.72
X$11514 17521 17709 gf180mcu_fd_sc_mcu9t5v0__filltie
* cell instance $11515 r0 *1 1448.72,1078.56
X$11515 16956 17123 gf180mcu_fd_sc_mcu9t5v0__filltie
* cell instance $11516 r0 *1 1392.16,1058.4
X$11516 14427 16536 15543 13180 16506 16309 gf180mcu_fd_sc_mcu9t5v0__dffrnq_2
* cell instance $11517 m0 *1 1430.8,1018.08
X$11517 14672 15037 13492 14967 15138 14986 gf180mcu_fd_sc_mcu9t5v0__mux2_1
* cell instance $11518 r0 *1 1448.72,997.92
X$11518 14448 14708 gf180mcu_fd_sc_mcu9t5v0__filltie
* cell instance $11519 r0 *1 1383.76,997.92
X$11519 14685 14684 12632 14708 14448 14472 gf180mcu_fd_sc_mcu9t5v0__aoi21_1
* cell instance $11520 r0 *1 1396.64,987.84
X$11520 14427 14315 14420 13180 14406 14304 gf180mcu_fd_sc_mcu9t5v0__dffrnq_2
* cell instance $11521 m0 *1 1403.92,987.84
X$11521 14420 14428 13492 14126 14304 14315 gf180mcu_fd_sc_mcu9t5v0__mux2_1
* cell instance $11522 r0 *1 1448.72,1028.16
X$11522 15402 15576 gf180mcu_fd_sc_mcu9t5v0__filltie
* cell instance $11523 r0 *1 1448.72,977.76
X$11523 14009 14126 gf180mcu_fd_sc_mcu9t5v0__filltie
* cell instance $11524 r0 *1 1386.56,1018.08
X$11524 13175 13492 13489 15293 15271 15138 15034
+ gf180mcu_fd_sc_mcu9t5v0__oai22_1
* cell instance $11525 r0 *1 1444.24,987.84
X$11525 14473 14430 14429 14406 14304 14316 gf180mcu_fd_sc_mcu9t5v0__oai21_1
* cell instance $11526 r0 *1 1422.4,987.84
X$11526 14427 14316 4914 13180 14406 14304 gf180mcu_fd_sc_mcu9t5v0__dffrnq_2
* cell instance $11527 r0 *1 1417.36,1028.16
X$11527 14427 15548 13477 13180 15576 15402 gf180mcu_fd_sc_mcu9t5v0__dffrnq_2
* cell instance $11528 r0 *1 1424.64,977.76
X$11528 13909 14031 13492 14126 14009 14141 gf180mcu_fd_sc_mcu9t5v0__mux2_1
* cell instance $11529 m0 *1 1417.36,987.84
X$11529 14427 14141 13909 13180 14126 14304 gf180mcu_fd_sc_mcu9t5v0__dffrnq_2
* cell instance $11530 r0 *1 1425.2,1008
X$11530 14427 14986 14672 13180 14967 14857 gf180mcu_fd_sc_mcu9t5v0__dffrnq_2
* cell instance $11531 m0 *1 1411.2,1008
X$11531 14427 14834 14669 13180 14708 14857 gf180mcu_fd_sc_mcu9t5v0__dffrnq_2
* cell instance $11532 r0 *1 1448.72,987.84
X$11532 14304 14406 gf180mcu_fd_sc_mcu9t5v0__filltie
* cell instance $11533 m0 *1 1382.08,1018.08
X$11533 15033 15034 14967 15138 15035 gf180mcu_fd_sc_mcu9t5v0__nor2_1
* cell instance $11534 r0 *1 1448.72,967.68
X$11534 13719 13832 gf180mcu_fd_sc_mcu9t5v0__filltie
* cell instance $11535 r0 *1 1398.32,1028.16
X$11535 14427 15416 14668 13180 15576 15402 gf180mcu_fd_sc_mcu9t5v0__dffrnq_2
* cell instance $11536 r0 *1 1412.88,967.68
X$11536 12763 13846 13847 13832 13719 13732 gf180mcu_fd_sc_mcu9t5v0__oai21_1
* cell instance $11537 r0 *1 1397.2,977.76
X$11537 12763 14126 14009 14313 gf180mcu_fd_sc_mcu9t5v0__buf_8
* cell instance $11538 r0 *1 1394.4,1008
X$11538 14427 14985 14455 13180 14967 14857 gf180mcu_fd_sc_mcu9t5v0__dffrnq_2
* cell instance $11539 m0 *1 1404.48,1018.08
X$11539 14455 15036 13492 14967 15138 14985 gf180mcu_fd_sc_mcu9t5v0__mux2_1
* cell instance $11540 r0 *1 1441.44,987.84
X$11540 4914 12632 14406 14304 14429 gf180mcu_fd_sc_mcu9t5v0__nand2_1
* cell instance $11541 r0 *1 1448.72,1018.08
X$11541 15138 15271 gf180mcu_fd_sc_mcu9t5v0__filltie
* cell instance $11542 r0 *1 1417.36,967.68
X$11542 5899 12632 13832 13719 13847 gf180mcu_fd_sc_mcu9t5v0__nand2_1
* cell instance $11543 m0 *1 1385.44,1018.08
X$11543 14427 15035 13175 13180 14967 15138 gf180mcu_fd_sc_mcu9t5v0__dffrnq_2
* cell instance $11544 m0 *1 1405.6,997.92
X$11544 13492 14205 14406 14448 12763 gf180mcu_fd_sc_mcu9t5v0__nand2_1
* cell instance $11545 m0 *1 1386,977.76
X$11545 13595 13914 13492 13832 14009 13913 gf180mcu_fd_sc_mcu9t5v0__mux2_1
* cell instance $11546 r0 *1 1448.72,1008
X$11546 14857 14967 gf180mcu_fd_sc_mcu9t5v0__filltie
* cell instance $11547 m0 *1 1408.96,1028.16
X$11547 14668 15417 13492 15271 15402 15416 gf180mcu_fd_sc_mcu9t5v0__mux2_1
* cell instance $11548 r0 *1 1417.92,1008
X$11548 14669 14869 13492 14967 14857 14834 gf180mcu_fd_sc_mcu9t5v0__mux2_1
* cell instance $11549 r0 *1 1445.36,997.92
X$11549 12632 14685 14708 14448 13912 gf180mcu_fd_sc_mcu9t5v0__nor2_1
* cell instance $11550 m0 *1 1464.96,977.76
X$11550 13850 13849 13832 14009 13917 gf180mcu_fd_sc_mcu9t5v0__nand2_1
* cell instance $11551 m0 *1 1467.76,977.76
X$11551 13851 13733 13917 13832 14009 13853 gf180mcu_fd_sc_mcu9t5v0__oai21_1
* cell instance $11552 m0 *1 1504.16,977.76
X$11552 13706 13705 13832 14009 13919 gf180mcu_fd_sc_mcu9t5v0__nand2_1
* cell instance $11553 r0 *1 1480.08,1018.08
X$11553 13915 15162 15408 13180 15271 15138 gf180mcu_fd_sc_mcu9t5v0__dffrnq_2
* cell instance $11554 m0 *1 1486.8,1018.08
X$11554 15408 15039 13492 14967 15138 15162 gf180mcu_fd_sc_mcu9t5v0__mux2_1
* cell instance $11555 r0 *1 1487.36,987.84
X$11555 13915 14433 13227 13180 14406 14304 gf180mcu_fd_sc_mcu9t5v0__dffrnq_2
* cell instance $11556 r0 *1 1492.4,1028.16
X$11556 14473 15554 15555 15553 15576 15402 15591
+ gf180mcu_fd_sc_mcu9t5v0__oai31_1
* cell instance $11557 m0 *1 1511.44,987.84
X$11557 13183 14207 14205 14126 14304 14206 gf180mcu_fd_sc_mcu9t5v0__mux2_1
* cell instance $11558 m0 *1 1489.04,987.84
X$11558 13227 14126 14304 13036 gf180mcu_fd_sc_mcu9t5v0__clkinv_1
* cell instance $11559 r0 *1 1454.88,1028.16
X$11559 15550 15549 15576 15402 15418 gf180mcu_fd_sc_mcu9t5v0__nor2_1
* cell instance $11560 m0 *1 1468.88,1018.08
X$11560 8573 12632 14967 15138 15161 gf180mcu_fd_sc_mcu9t5v0__nand2_1
* cell instance $11561 m0 *1 1508.08,997.92
X$11561 13707 14206 14406 14448 14475 gf180mcu_fd_sc_mcu9t5v0__nand2_1
* cell instance $11562 r0 *1 1494.08,1008
X$11562 13915 14870 14671 13180 14967 14857 gf180mcu_fd_sc_mcu9t5v0__dffrnq_2
* cell instance $11563 m0 *1 1508.08,987.84
X$11563 13707 14206 14126 14304 14474 gf180mcu_fd_sc_mcu9t5v0__nor2_1
* cell instance $11564 r0 *1 1480.08,987.84
X$11564 13227 13705 14205 14406 14304 14204 gf180mcu_fd_sc_mcu9t5v0__mux2_1
* cell instance $11565 r0 *1 1458.8,1008
X$11565 4770 12632 14967 14857 14687 gf180mcu_fd_sc_mcu9t5v0__nand2_1
* cell instance $11566 m0 *1 1499.68,1008
X$11566 14671 14836 13492 14708 14857 14870 gf180mcu_fd_sc_mcu9t5v0__mux2_1
* cell instance $11567 m0 *1 1464.4,987.84
X$11567 13850 14318 14126 14304 14204 13848 gf180mcu_fd_sc_mcu9t5v0__xor3_1
* cell instance $11568 m0 *1 1469.44,997.92
X$11568 13850 14204 14406 14448 14432 gf180mcu_fd_sc_mcu9t5v0__or2_1
* cell instance $11569 r0 *1 1513.12,1008
X$11569 10061 12632 14967 14857 14987 gf180mcu_fd_sc_mcu9t5v0__nand2_1
* cell instance $11570 r0 *1 1461.6,967.68
X$11570 13850 13849 13832 13719 13851 gf180mcu_fd_sc_mcu9t5v0__nor2_1
* cell instance $11571 r0 *1 1504.16,967.68
X$11571 13707 13857 13832 13719 13041 13705 gf180mcu_fd_sc_mcu9t5v0__xnor3_1
* cell instance $11572 r0 *1 1467.2,987.84
X$11572 13850 14204 14406 14304 14317 gf180mcu_fd_sc_mcu9t5v0__and2_1
* cell instance $11573 r0 *1 1487.36,967.68
X$11573 13855 13704 13856 13832 13719 13734 gf180mcu_fd_sc_mcu9t5v0__oai21_1
* cell instance $11574 r0 *1 1499.68,967.68
X$11574 13857 13735 13919 13832 13719 13733 gf180mcu_fd_sc_mcu9t5v0__oai21_1
* cell instance $11575 r0 *1 1458.24,1028.16
X$11575 15550 15549 15576 15402 15419 gf180mcu_fd_sc_mcu9t5v0__and2_1
* cell instance $11576 r0 *1 1513.12,1018.08
X$11576 14473 15165 15164 14987 15271 15138 15040
+ gf180mcu_fd_sc_mcu9t5v0__oai31_1
* cell instance $11577 r0 *1 1471.68,987.84
X$11577 14432 14318 14317 14406 14304 14431 gf180mcu_fd_sc_mcu9t5v0__aoi21_1
* cell instance $11578 r0 *1 1464.96,967.68
X$11578 13852 13854 13832 13719 13853 12767 gf180mcu_fd_sc_mcu9t5v0__xor3_1
* cell instance $11579 r0 *1 1484,967.68
X$11579 13850 13036 13832 13719 13855 gf180mcu_fd_sc_mcu9t5v0__nor2_1
* cell instance $11580 m0 *1 1478.96,1008
X$11580 13918 14841 14685 14708 14857 14716 gf180mcu_fd_sc_mcu9t5v0__mux2_1
* cell instance $11581 m0 *1 1510.88,997.92
X$11581 14475 14476 14474 14406 14448 14318 gf180mcu_fd_sc_mcu9t5v0__aoi21_1
* cell instance $11582 r0 *1 1513.12,1028.16
X$11582 15557 15556 15576 15402 15164 gf180mcu_fd_sc_mcu9t5v0__nor2_1
* cell instance $11583 r0 *1 1470.56,997.92
X$11583 14688 14716 14708 14448 14031 14431 gf180mcu_fd_sc_mcu9t5v0__xnor3_1
* cell instance $11584 r0 *1 1457.12,997.92
X$11584 14473 14686 14687 14708 14448 14835 gf180mcu_fd_sc_mcu9t5v0__oai21_1
* cell instance $11585 r0 *1 1451.52,1018.08
X$11585 4946 12632 15271 15138 15294 gf180mcu_fd_sc_mcu9t5v0__nand2_1
* cell instance $11586 r0 *1 1506.96,997.92
X$11586 13915 14708 14448 gf180mcu_fd_sc_mcu9t5v0__inv_4
* cell instance $11587 r0 *1 1470,1028.16
X$11587 14473 15551 15552 15161 15576 15402 15160
+ gf180mcu_fd_sc_mcu9t5v0__oai31_1
* cell instance $11588 m0 *1 1453.76,1028.16
X$11588 14473 15418 15419 15294 15271 15402 15038
+ gf180mcu_fd_sc_mcu9t5v0__oai31_1
* cell instance $11589 r0 *1 1461.04,1018.08
X$11589 13915 15160 8573 13180 15271 15138 gf180mcu_fd_sc_mcu9t5v0__dffrnq_2
* cell instance $11590 r0 *1 1478.96,1008
X$11590 14688 14967 14857 14841 13854 gf180mcu_fd_sc_mcu9t5v0__xor2_1
* cell instance $11591 m0 *1 1491.28,997.92
X$11591 13036 14872 15163 14406 14448 14433 gf180mcu_fd_sc_mcu9t5v0__aoi21_1
* cell instance $11592 r0 *1 1491.84,967.68
X$11592 13850 13036 13832 13719 13856 gf180mcu_fd_sc_mcu9t5v0__nand2_1
* cell instance $11593 m0 *1 1472.24,977.76
X$11593 13918 13832 14009 13849 gf180mcu_fd_sc_mcu9t5v0__clkinv_1
* cell instance $11594 m0 *1 1439.2,907.2
X$11594 11587 9449 12037 10707 2987 3106 11971 12019 12035
+ gf180mcu_fd_sc_mcu9t5v0__mux4_1
* cell instance $11595 r0 *1 1431.36,897.12
X$11595 12037 10707 11587 9449 3120 3121 11971 11860 12036
+ gf180mcu_fd_sc_mcu9t5v0__mux4_1
* cell instance $11596 r0 *1 1449.84,846.72
X$11596 9107 9112 2777 10676 10570 10708 gf180mcu_fd_sc_mcu9t5v0__mux2_2
* cell instance $11597 r0 *1 1463.84,897.12
X$11597 8568 4048 11971 11860 9601 gf180mcu_fd_sc_mcu9t5v0__nand2_1
* cell instance $11598 m0 *1 1440.32,856.8
X$11598 10734 10706 10707 10676 10714 gf180mcu_fd_sc_mcu9t5v0__dffq_2
* cell instance $11599 r0 *1 1471.68,897.12
X$11599 12140 4769 11971 11860 11998 gf180mcu_fd_sc_mcu9t5v0__nand2_1
* cell instance $11600 r0 *1 1468.88,897.12
X$11600 9601 11998 11971 11860 11999 gf180mcu_fd_sc_mcu9t5v0__nand2_1
* cell instance $11601 r0 *1 1448.72,897.12
X$11601 11860 11971 gf180mcu_fd_sc_mcu9t5v0__filltie
* cell instance $11602 r0 *1 1474.48,897.12
X$11602 10734 11871 11995 11971 11860 gf180mcu_fd_sc_mcu9t5v0__dffq_2
* cell instance $11603 r0 *1 1449.84,917.28
X$11603 3930 12508 12253 gf180mcu_fd_sc_mcu9t5v0__clkinv_12
* cell instance $11604 m0 *1 1444.8,917.28
X$11604 12272 12253 12128 3930 gf180mcu_fd_sc_mcu9t5v0__clkbuf_16
* cell instance $11605 m0 *1 1441.44,957.6
X$11605 10734 13333 9820 13180 13318 13428 gf180mcu_fd_sc_mcu9t5v0__dffrnq_2
* cell instance $11606 r0 *1 1449.84,947.52
X$11606 10323 12632 13225 13487 13318 13160 13333
+ gf180mcu_fd_sc_mcu9t5v0__aoi22_1
* cell instance $11607 m0 *1 1442.56,927.36
X$11607 10734 12631 11192 13180 12508 12646 gf180mcu_fd_sc_mcu9t5v0__dffrnq_2
* cell instance $11608 m0 *1 1436.96,836.64
X$11608 9863 9600 9713 9590 3120 3121 10188 10308 10095
+ gf180mcu_fd_sc_mcu9t5v0__mux4_1
* cell instance $11609 r0 *1 1410.08,897.12
X$11609 10473 10990 10068 8864 3120 3121 11971 11860 11997
+ gf180mcu_fd_sc_mcu9t5v0__mux4_1
* cell instance $11610 r0 *1 1484,927.36
X$11610 12770 12769 12785 12646 12768 gf180mcu_fd_sc_mcu9t5v0__nor2_1
* cell instance $11611 r0 *1 1478.4,947.52
X$11611 13227 13037 13318 13160 13062 gf180mcu_fd_sc_mcu9t5v0__nand2_1
* cell instance $11612 m0 *1 1464.96,947.52
X$11612 13062 13061 12767 13054 13160 13181 gf180mcu_fd_sc_mcu9t5v0__aoi21_1
* cell instance $11613 m0 *1 1503.04,947.52
X$11613 13061 13182 12763 13054 13160 13063 gf180mcu_fd_sc_mcu9t5v0__aoi21_1
* cell instance $11614 m0 *1 1469.44,947.52
X$11614 13062 13061 12767 13054 13160 13226 gf180mcu_fd_sc_mcu9t5v0__and3_1
* cell instance $11615 r0 *1 1466.08,947.52
X$11615 14685 13181 13226 13318 13160 13225 gf180mcu_fd_sc_mcu9t5v0__or3_1
* cell instance $11616 r0 *1 1467.76,927.36
X$11616 12914 12768 12767 12785 12646 12766 gf180mcu_fd_sc_mcu9t5v0__nor3_1
* cell instance $11617 m0 *1 1509.2,947.52
X$11617 13183 13041 13054 13160 13040 gf180mcu_fd_sc_mcu9t5v0__and2_1
* cell instance $11618 m0 *1 1467.76,937.44
X$11618 12914 12768 12767 12785 12900 12795 gf180mcu_fd_sc_mcu9t5v0__oai21_1
* cell instance $11619 m0 *1 1507.52,927.36
X$11619 10699 12632 12508 12646 12290 gf180mcu_fd_sc_mcu9t5v0__nand2_1
* cell instance $11620 m0 *1 1507.52,917.28
X$11620 12290 12288 12128 12253 12289 gf180mcu_fd_sc_mcu9t5v0__nand2_1
* cell instance $11621 r0 *1 1493.52,937.44
X$11621 13063 13491 13054 12900 13038 gf180mcu_fd_sc_mcu9t5v0__nor2_1
* cell instance $11622 r0 *1 1514.8,947.52
X$11622 13183 13318 13160 13042 gf180mcu_fd_sc_mcu9t5v0__clkinv_1
* cell instance $11623 r0 *1 1515.36,957.6
X$11623 13707 13042 13586 13428 13598 gf180mcu_fd_sc_mcu9t5v0__nor2_1
* cell instance $11624 m0 *1 1458.8,937.44
X$11624 13912 12795 12785 12900 12765 gf180mcu_fd_sc_mcu9t5v0__nand2_1
* cell instance $11625 r0 *1 1456,927.36
X$11625 11192 12632 12785 12646 12764 gf180mcu_fd_sc_mcu9t5v0__nand2_1
* cell instance $11626 r0 *1 1497.44,937.44
X$11626 13040 13039 12770 13054 12900 13061 gf180mcu_fd_sc_mcu9t5v0__oai21_1
* cell instance $11627 r0 *1 1501.92,937.44
X$11627 13040 13039 12770 13054 12900 13182 gf180mcu_fd_sc_mcu9t5v0__or3_1
* cell instance $11628 r0 *1 1514.24,937.44
X$11628 13042 13041 13054 12900 12771 gf180mcu_fd_sc_mcu9t5v0__and2_1
* cell instance $11629 m0 *1 1481.2,927.36
X$11629 12140 12632 12508 12646 12633 gf180mcu_fd_sc_mcu9t5v0__nand2_1
* cell instance $11630 r0 *1 1453.76,957.6
X$11630 14685 13488 12632 13586 13428 13487 gf180mcu_fd_sc_mcu9t5v0__aoi21_1
* cell instance $11631 r0 *1 1458.8,927.36
X$11631 12766 12765 12764 12785 12646 12631 gf180mcu_fd_sc_mcu9t5v0__oai21_1
* cell instance $11632 m0 *1 1484,927.36
X$11632 12763 12634 12768 12633 12508 12646 12414
+ gf180mcu_fd_sc_mcu9t5v0__oai31_1
* cell instance $11633 r0 *1 1476.16,937.44
X$11633 13036 13037 13054 12900 12914 gf180mcu_fd_sc_mcu9t5v0__and2_1
* cell instance $11634 r0 *1 1481.2,937.44
X$11634 13036 13037 13054 12900 12770 gf180mcu_fd_sc_mcu9t5v0__xnor2_1
* cell instance $11635 r0 *1 1487.36,927.36
X$11635 12770 12769 12785 12646 12634 gf180mcu_fd_sc_mcu9t5v0__and2_1
* cell instance $11636 m0 *1 1466.64,907.2
X$11636 12143 12155 4493 11971 12019 12038 gf180mcu_fd_sc_mcu9t5v0__mux2_1
* cell instance $11637 r0 *1 1492.4,957.6
X$11637 13215 13492 13490 13489 13586 13428 13491
+ gf180mcu_fd_sc_mcu9t5v0__oai22_1
* cell instance $11638 m0 *1 1484,947.52
X$11638 10734 13038 13215 13180 13054 13160 gf180mcu_fd_sc_mcu9t5v0__dffrnq_2
* cell instance $11639 r0 *1 1481.76,917.28
X$11639 10734 12414 12140 13180 12508 12253 gf180mcu_fd_sc_mcu9t5v0__dffrnq_2
* cell instance $11640 r0 *1 1462.72,907.2
X$11640 10734 12038 12143 12128 12019 gf180mcu_fd_sc_mcu9t5v0__dffq_2
* cell instance $11641 r0 *1 1459.92,907.2
X$11641 12141 4769 12128 12019 12154 gf180mcu_fd_sc_mcu9t5v0__nand2_1
* cell instance $11642 r0 *1 1457.12,907.2
X$11642 11589 12154 12128 12019 12155 gf180mcu_fd_sc_mcu9t5v0__nand2_1
* cell instance $11643 m0 *1 1456.56,907.2
X$11643 9107 4048 11971 12019 11589 gf180mcu_fd_sc_mcu9t5v0__nand2_1
* cell instance $11644 r0 *1 1448.72,957.6
X$11644 13428 13586 gf180mcu_fd_sc_mcu9t5v0__filltie
* cell instance $11645 r0 *1 1448.72,937.44
X$11645 12900 13054 gf180mcu_fd_sc_mcu9t5v0__filltie
* cell instance $11646 r0 *1 1445.92,937.44
X$11646 9820 13054 12900 10323 gf180mcu_fd_sc_mcu9t5v0__clkinv_1
* cell instance $11647 r0 *1 1401.12,907.2
X$11647 3351 12035 12128 12019 12284 gf180mcu_fd_sc_mcu9t5v0__nand2_1
* cell instance $11648 m0 *1 1438.64,957.6
X$11648 5280 12632 13318 13428 13224 gf180mcu_fd_sc_mcu9t5v0__nand2_1
* cell instance $11649 r0 *1 1441.44,947.52
X$11649 13224 13223 13318 13160 13222 gf180mcu_fd_sc_mcu9t5v0__nand2_1
* cell instance $11650 r0 *1 1448.72,917.28
X$11650 12253 12508 gf180mcu_fd_sc_mcu9t5v0__filltie
* cell instance $11651 m0 *1 1429.68,947.52
X$11651 13028 13222 5280 13180 13054 13160 gf180mcu_fd_sc_mcu9t5v0__dffrnq_2
* cell instance $11652 r0 *1 1414,917.28
X$11652 9826 12152 1961 12508 12253 12520 gf180mcu_fd_sc_mcu9t5v0__mux2_1
* cell instance $11653 r0 *1 1400.56,937.44
X$11653 3351 12762 13054 12900 13035 gf180mcu_fd_sc_mcu9t5v0__nand2_1
* cell instance $11654 m0 *1 1410.64,947.52
X$11654 13028 13219 5164 13180 13054 13160 gf180mcu_fd_sc_mcu9t5v0__dffrnq_2
* cell instance $11655 r0 *1 1397.76,927.36
X$11655 11369 9827 12152 10703 2987 3106 12785 12646 12762
+ gf180mcu_fd_sc_mcu9t5v0__mux4_1
* cell instance $11656 m0 *1 1422.4,917.28
X$11656 12273 4769 12128 12253 12285 gf180mcu_fd_sc_mcu9t5v0__nand2_1
* cell instance $11657 m0 *1 1428,917.28
X$11657 10734 12287 12037 12128 12253 gf180mcu_fd_sc_mcu9t5v0__dffq_2
* cell instance $11658 r0 *1 1448.72,947.52
X$11658 13160 13318 gf180mcu_fd_sc_mcu9t5v0__filltie
* cell instance $11659 r0 *1 1429.12,957.6
X$11659 13693 13486 13492 13586 13428 13597 gf180mcu_fd_sc_mcu9t5v0__mux2_1
* cell instance $11660 m0 *1 1394.4,947.52
X$11660 3459 12794 13054 13160 13179 gf180mcu_fd_sc_mcu9t5v0__nand2_1
* cell instance $11661 r0 *1 1423.52,947.52
X$11661 5164 12632 13318 13160 13221 gf180mcu_fd_sc_mcu9t5v0__nand2_1
* cell instance $11662 m0 *1 1425.2,917.28
X$11662 11372 12285 12128 12253 12286 gf180mcu_fd_sc_mcu9t5v0__nand2_1
* cell instance $11663 r0 *1 1419.04,947.52
X$11663 12763 13220 13221 13318 13160 13219 gf180mcu_fd_sc_mcu9t5v0__oai21_1
* cell instance $11664 r0 *1 1421.84,927.36
X$11664 13028 12521 12411 12785 12646 gf180mcu_fd_sc_mcu9t5v0__dffq_2
* cell instance $11665 r0 *1 1398.32,907.2
X$11665 3459 12034 12128 12019 12153 gf180mcu_fd_sc_mcu9t5v0__nand2_1
* cell instance $11666 r0 *1 1425.76,917.28
X$11666 12411 12286 4493 12508 12253 12521 gf180mcu_fd_sc_mcu9t5v0__mux2_1
* cell instance $11667 m0 *1 1397.2,917.28
X$11667 3462 12284 12153 12128 12253 12413 gf180mcu_fd_sc_mcu9t5v0__nand3_1
* cell instance $11668 m0 *1 1397.2,947.52
X$11668 3462 13035 13179 13054 13160 13218 gf180mcu_fd_sc_mcu9t5v0__nand3_1
* cell instance $11669 m0 *1 1388.8,937.44
X$11669 10065 9830 10474 11315 2987 3106 12785 12900 12794
+ gf180mcu_fd_sc_mcu9t5v0__mux4_1
* cell instance $11670 r0 *1 1392.72,947.52
X$11670 3462 13217 13218 4952 13318 13160 13332
+ gf180mcu_fd_sc_mcu9t5v0__oai211_1
* cell instance $11671 m0 *1 1410.08,927.36
X$11671 13028 12520 12152 12508 12646 gf180mcu_fd_sc_mcu9t5v0__dffq_2
* cell instance $11672 r0 *1 1441.44,907.2
X$11672 9107 12037 1961 12128 12019 12287 gf180mcu_fd_sc_mcu9t5v0__mux2_1
* cell instance $11673 r0 *1 1393.28,917.28
X$11673 3462 12145 12413 4952 12508 12253 12913
+ gf180mcu_fd_sc_mcu9t5v0__oai211_1
* cell instance $11674 r0 *1 1448.72,907.2
X$11674 12019 12128 gf180mcu_fd_sc_mcu9t5v0__filltie
* cell instance $11675 r0 *1 1391.04,907.2
X$11675 12152 10703 2891 12128 12019 11858 gf180mcu_fd_sc_mcu9t5v0__mux2_1
* cell instance $11676 r0 *1 1394.4,957.6
X$11676 13028 13485 13481 13180 13586 13428 gf180mcu_fd_sc_mcu9t5v0__dffrnq_2
* cell instance $11677 m0 *1 1394.96,907.2
X$11677 10068 8864 10473 10990 2987 3106 11971 12019 12034
+ gf180mcu_fd_sc_mcu9t5v0__mux4_1
* cell instance $11678 m0 *1 1416.24,907.2
X$11678 12036 11997 3239 11971 12019 12029 gf180mcu_fd_sc_mcu9t5v0__mux2_1
* cell instance $11679 r0 *1 1448.72,927.36
X$11679 12646 12785 gf180mcu_fd_sc_mcu9t5v0__filltie
* cell instance $11680 m0 *1 1440.32,897.12
X$11680 12037 10707 2891 11720 11860 11737 gf180mcu_fd_sc_mcu9t5v0__mux2_1
* cell instance $11681 m0 *1 1422.4,887.04
X$11681 11587 9449 2891 11461 11600 11585 gf180mcu_fd_sc_mcu9t5v0__mux2_1
* cell instance $11682 r0 *1 1404.48,836.64
X$11682 3351 10069 10338 10308 10358 gf180mcu_fd_sc_mcu9t5v0__nand2_1
* cell instance $11683 r0 *1 1448.72,866.88
X$11683 11079 11181 gf180mcu_fd_sc_mcu9t5v0__filltie
* cell instance $11684 r0 *1 1448.72,856.8
X$11684 10714 10833 gf180mcu_fd_sc_mcu9t5v0__filltie
* cell instance $11685 r0 *1 1440.32,846.72
X$11685 10708 10707 2472 10676 10570 10706 gf180mcu_fd_sc_mcu9t5v0__mux2_2
* cell instance $11686 r0 *1 1425.2,876.96
X$11686 11373 3340 11372 8984 11586 11461 11294 11374
+ gf180mcu_fd_sc_mcu9t5v0__oai221_1
* cell instance $11687 r0 *1 1433.6,887.04
X$11687 3007 11737 11720 11600 11371 gf180mcu_fd_sc_mcu9t5v0__nand2_1
* cell instance $11688 r0 *1 1417.36,866.88
X$11688 10734 10989 10990 11181 11079 gf180mcu_fd_sc_mcu9t5v0__dffq_2
* cell instance $11689 r0 *1 1423.52,846.72
X$11689 10587 9831 2363 10676 10570 10705 gf180mcu_fd_sc_mcu9t5v0__mux2_1
* cell instance $11690 r0 *1 1403.92,876.96
X$11690 11371 11370 11468 11584 11461 11294 11366
+ gf180mcu_fd_sc_mcu9t5v0__aoi22_1
* cell instance $11691 m0 *1 1420.16,897.12
X$11691 9826 4048 11720 11860 11372 gf180mcu_fd_sc_mcu9t5v0__nand2_1
* cell instance $11692 r0 *1 1448.72,876.96
X$11692 11294 11461 gf180mcu_fd_sc_mcu9t5v0__filltie
* cell instance $11693 m0 *1 1417.92,887.04
X$11693 9709 4769 11461 11600 11586 gf180mcu_fd_sc_mcu9t5v0__nand2_1
* cell instance $11694 m0 *1 1422.4,866.88
X$11694 10991 10990 2373 10833 11079 10989 gf180mcu_fd_sc_mcu9t5v0__mux2_1
* cell instance $11695 r0 *1 1448.72,887.04
X$11695 11600 11720 gf180mcu_fd_sc_mcu9t5v0__filltie
* cell instance $11696 m0 *1 1406.72,887.04
X$11696 10068 4765 11585 3007 2992 11461 11600 11584
+ gf180mcu_fd_sc_mcu9t5v0__aoi221_1
* cell instance $11697 r0 *1 1445.92,866.88
X$11697 7670 4769 11181 11079 11090 gf180mcu_fd_sc_mcu9t5v0__nand2_1
* cell instance $11698 r0 *1 1430.8,846.72
X$11698 9571 9596 2141 10676 10570 10587 gf180mcu_fd_sc_mcu9t5v0__mux2_1
* cell instance $11699 m0 *1 1419.04,856.8
X$11699 10734 10705 9831 10676 10714 gf180mcu_fd_sc_mcu9t5v0__dffq_2
* cell instance $11700 r0 *1 1412.32,836.64
X$11700 9451 9216 10064 9831 2987 3106 10338 10308 10478
+ gf180mcu_fd_sc_mcu9t5v0__mux4_1
* cell instance $11701 m0 *1 1429.68,887.04
X$11701 10734 11374 11369 11461 11600 gf180mcu_fd_sc_mcu9t5v0__dffq_2
* cell instance $11702 m0 *1 1419.6,836.64
X$11702 10064 9831 9451 9216 3120 3121 10188 10308 10214
+ gf180mcu_fd_sc_mcu9t5v0__mux4_1
* cell instance $11703 m0 *1 1410.08,846.72
X$11703 3459 10478 10338 10570 10477 gf180mcu_fd_sc_mcu9t5v0__nand2_1
* cell instance $11704 m0 *1 1402.24,846.72
X$11704 3462 10358 10477 10338 10570 10476 gf180mcu_fd_sc_mcu9t5v0__nand3_1
* cell instance $11705 r0 *1 1448.72,836.64
X$11705 10308 10338 gf180mcu_fd_sc_mcu9t5v0__filltie
* cell instance $11706 r0 *1 1385.44,866.88
X$11706 3462 11088 6158 4952 11181 11079 11467 gf180mcu_fd_sc_mcu9t5v0__oai211_1
* cell instance $11707 m0 *1 1386.56,897.12
X$11707 11315 2997 11858 3007 2880 11720 11860 11857
+ gf180mcu_fd_sc_mcu9t5v0__aoi221_1
* cell instance $11708 m0 *1 1393.84,846.72
X$11708 3462 10472 10476 4952 10338 10570 12412
+ gf180mcu_fd_sc_mcu9t5v0__oai211_1
* cell instance $11709 r0 *1 1448.72,846.72
X$11709 10570 10676 gf180mcu_fd_sc_mcu9t5v0__filltie
* cell instance $11710 r0 *1 1434.16,866.88
X$11710 9107 9112 2141 11181 11079 10991 gf180mcu_fd_sc_mcu9t5v0__mux2_1
* cell instance $11711 r0 *1 1393.84,866.88
X$11711 10734 11089 11315 11181 11079 gf180mcu_fd_sc_mcu9t5v0__dffq_2
* cell instance $11712 r0 *1 1389.92,887.04
X$11712 3462 11734 8223 4952 11720 11600 11736 gf180mcu_fd_sc_mcu9t5v0__oai211_1
* cell instance $11713 m0 *1 1406.16,866.88
X$11713 9826 9709 2141 10833 11079 10988 gf180mcu_fd_sc_mcu9t5v0__mux2_1
* cell instance $11714 m0 *1 1399.44,876.96
X$11714 10988 11315 2363 11181 11294 11089 gf180mcu_fd_sc_mcu9t5v0__mux2_1
* cell instance $11715 m0 *1 1403.92,856.8
X$11715 9826 9709 2777 10676 10714 10704 gf180mcu_fd_sc_mcu9t5v0__mux2_2
* cell instance $11716 m0 *1 1387.12,856.8
X$11716 9591 10702 10703 10676 10714 gf180mcu_fd_sc_mcu9t5v0__dffq_2
* cell instance $11717 m0 *1 1400.56,887.04
X$11717 10473 4765 2997 10990 2880 11461 11600 11370
+ gf180mcu_fd_sc_mcu9t5v0__aoi221_1
* cell instance $11718 m0 *1 1397.76,887.04
X$11718 8864 2997 11461 11600 11468 gf180mcu_fd_sc_mcu9t5v0__nand2_1
* cell instance $11719 r0 *1 1391.6,846.72
X$11719 10704 10703 2472 10676 10570 10702 gf180mcu_fd_sc_mcu9t5v0__mux2_2
* cell instance $11720 r0 *1 1430.8,887.04
X$11720 11369 11720 11600 11373 gf180mcu_fd_sc_mcu9t5v0__clkinv_1
* cell instance $11721 m0 *1 1450.96,866.88
X$11721 10994 3340 10992 8984 11090 10833 11079 10993
+ gf180mcu_fd_sc_mcu9t5v0__oai221_1
* cell instance $11722 r0 *1 1472.24,856.8
X$11722 10734 10737 10861 10833 10714 gf180mcu_fd_sc_mcu9t5v0__dffq_2
* cell instance $11723 r0 *1 1474.48,836.64
X$11723 10699 4769 10338 10308 10332 gf180mcu_fd_sc_mcu9t5v0__nand2_1
* cell instance $11724 m0 *1 1471.68,836.64
X$11724 9833 10332 10188 10308 10215 gf180mcu_fd_sc_mcu9t5v0__nand2_1
* cell instance $11725 m0 *1 1451.52,887.04
X$11725 9112 4769 11461 11600 11588 gf180mcu_fd_sc_mcu9t5v0__nand2_1
* cell instance $11726 m0 *1 1472.8,876.96
X$11726 11611 4769 11181 11294 11316 gf180mcu_fd_sc_mcu9t5v0__nand2_1
* cell instance $11727 m0 *1 1470,876.96
X$11727 10992 11316 11181 11294 11317 gf180mcu_fd_sc_mcu9t5v0__nand2_1
* cell instance $11728 m0 *1 1477.28,876.96
X$11728 11198 11317 4493 11181 11294 11318 gf180mcu_fd_sc_mcu9t5v0__mux2_1
* cell instance $11729 r0 *1 1462.16,836.64
X$11729 10359 3340 10709 8984 10479 10338 10308 10360
+ gf180mcu_fd_sc_mcu9t5v0__oai221_1
* cell instance $11730 m0 *1 1474.48,836.64
X$11730 5293 10216 10213 10188 10308 gf180mcu_fd_sc_mcu9t5v0__dffq_2
* cell instance $11731 m0 *1 1467.2,897.12
X$11731 10734 11720 11860 gf180mcu_fd_sc_mcu9t5v0__clkbuf_2
* cell instance $11732 r0 *1 1469.44,856.8
X$11732 10979 4769 10833 10714 10735 gf180mcu_fd_sc_mcu9t5v0__nand2_1
* cell instance $11733 r0 *1 1474.48,876.96
X$11733 10734 11318 11198 11461 11294 gf180mcu_fd_sc_mcu9t5v0__dffq_2
* cell instance $11734 m0 *1 1463.84,846.72
X$11734 10734 10360 5789 10338 10570 gf180mcu_fd_sc_mcu9t5v0__dffq_2
* cell instance $11735 m0 *1 1472.24,856.8
X$11735 10709 10735 10676 10714 10736 gf180mcu_fd_sc_mcu9t5v0__nand2_1
* cell instance $11736 m0 *1 1475.04,856.8
X$11736 10861 10736 4493 10676 10714 10737 gf180mcu_fd_sc_mcu9t5v0__mux2_1
* cell instance $11737 m0 *1 1455.44,887.04
X$11737 11591 3340 11589 8984 11588 11461 11600 11590
+ gf180mcu_fd_sc_mcu9t5v0__oai221_1
* cell instance $11738 r0 *1 1455.44,887.04
X$11738 10734 11590 11587 11720 11600 gf180mcu_fd_sc_mcu9t5v0__dffq_2
* cell instance $11739 m0 *1 1467.2,887.04
X$11739 3930 11461 11600 10734 gf180mcu_fd_sc_mcu9t5v0__clkbuf_8
* cell instance $11740 m0 *1 1476.72,897.12
X$11740 11995 11999 4493 11720 11860 11871 gf180mcu_fd_sc_mcu9t5v0__mux2_1
* cell instance $11741 r0 *1 1461.6,846.72
X$11741 5064 4048 10676 10570 10709 gf180mcu_fd_sc_mcu9t5v0__nand2_1
* cell instance $11742 m0 *1 1457.68,846.72
X$11742 4967 4769 10338 10570 10479 gf180mcu_fd_sc_mcu9t5v0__nand2_1
* cell instance $11743 m0 *1 1459.36,876.96
X$11743 7349 4048 11181 11294 10992 gf180mcu_fd_sc_mcu9t5v0__nand2_1
* cell instance $11744 r0 *1 1468.32,846.72
X$11744 5789 10676 10570 10359 gf180mcu_fd_sc_mcu9t5v0__clkinv_1
* cell instance $11745 r0 *1 1450.4,866.88
X$11745 10734 10993 7986 11181 11079 gf180mcu_fd_sc_mcu9t5v0__dffq_2
* cell instance $11746 m0 *1 1456,876.96
X$11746 7986 11181 11294 10994 gf180mcu_fd_sc_mcu9t5v0__clkinv_1
* cell instance $11747 m0 *1 1460.48,897.12
X$11747 11587 11720 11860 11591 gf180mcu_fd_sc_mcu9t5v0__clkinv_1
* cell instance $11748 m0 *1 1568.56,917.28
X$11748 12253 12128 gf180mcu_fd_sc_mcu9t5v0__filltie
* cell instance $11749 m0 *1 1582,957.6
X$11749 13187 13335 13318 13428 13438 gf180mcu_fd_sc_mcu9t5v0__nor2_1
* cell instance $11750 r0 *1 1560.16,927.36
X$11750 12774 12773 12775 12785 12646 12641 gf180mcu_fd_sc_mcu9t5v0__oai21_1
* cell instance $11751 r0 *1 1580.32,957.6
X$11751 13915 13438 13484 14696 13586 13428 gf180mcu_fd_sc_mcu9t5v0__dffrnq_2
* cell instance $11752 m0 *1 1526.56,947.52
X$11752 13915 13044 13479 13180 13054 13160 gf180mcu_fd_sc_mcu9t5v0__dffrnq_2
* cell instance $11753 m0 *1 1568.56,947.52
X$11753 13160 13054 gf180mcu_fd_sc_mcu9t5v0__filltie
* cell instance $11754 m0 *1 1561.84,927.36
X$11754 12642 12641 12508 12646 12417 gf180mcu_fd_sc_mcu9t5v0__nand2_1
* cell instance $11755 r0 *1 1563.52,957.6
X$11755 13334 13496 13497 13586 13428 13184 gf180mcu_fd_sc_mcu9t5v0__aoi21_1
* cell instance $11756 m0 *1 1546.72,947.52
X$11756 13047 13048 13054 13160 12416 gf180mcu_fd_sc_mcu9t5v0__xnor2_1
* cell instance $11757 m0 *1 1553.44,947.52
X$11757 13185 13184 12416 13054 13160 12796 gf180mcu_fd_sc_mcu9t5v0__oai21_1
* cell instance $11758 m0 *1 1568.56,887.04
X$11758 11600 11461 gf180mcu_fd_sc_mcu9t5v0__filltie
* cell instance $11759 m0 *1 1560.72,957.6
X$11759 13334 13496 13318 13428 13495 gf180mcu_fd_sc_mcu9t5v0__nand2_1
* cell instance $11760 m0 *1 1528.8,937.44
X$11760 12797 12796 12636 12785 12900 13039 gf180mcu_fd_sc_mcu9t5v0__aoi21_1
* cell instance $11761 m0 *1 1568.56,957.6
X$11761 13428 13318 gf180mcu_fd_sc_mcu9t5v0__filltie
* cell instance $11762 m0 *1 1568.56,927.36
X$11762 12646 12508 gf180mcu_fd_sc_mcu9t5v0__filltie
* cell instance $11763 r0 *1 1556.8,957.6
X$11763 13495 12774 13586 13428 13599 gf180mcu_fd_sc_mcu9t5v0__xnor2_1
* cell instance $11764 m0 *1 1546.72,927.36
X$11764 12416 12415 12508 12646 12640 gf180mcu_fd_sc_mcu9t5v0__and2_1
* cell instance $11765 r0 *1 1546.16,927.36
X$11765 12416 12415 12772 12785 12646 12635 gf180mcu_fd_sc_mcu9t5v0__oai21_1
* cell instance $11766 r0 *1 1563.52,917.28
X$11766 5293 12417 12273 13180 12508 12253 gf180mcu_fd_sc_mcu9t5v0__dffrnq_2
* cell instance $11767 r0 *1 1543.36,937.44
X$11767 13048 13054 12900 13046 gf180mcu_fd_sc_mcu9t5v0__clkinv_1
* cell instance $11768 r0 *1 1539.44,937.44
X$11768 13047 13046 13054 12900 12797 gf180mcu_fd_sc_mcu9t5v0__nand2_1
* cell instance $11769 m0 *1 1526,917.28
X$11769 13915 12291 12141 13180 12128 12253 gf180mcu_fd_sc_mcu9t5v0__dffrnq_2
* cell instance $11770 m0 *1 1538.32,927.36
X$11770 12141 12632 12508 12646 12638 gf180mcu_fd_sc_mcu9t5v0__nand2_1
* cell instance $11771 m0 *1 1541.12,927.36
X$11771 12763 12639 12640 12638 12508 12646 12291
+ gf180mcu_fd_sc_mcu9t5v0__oai31_1
* cell instance $11772 m0 *1 1560.72,937.44
X$11772 12774 12773 13049 12785 12900 12415 gf180mcu_fd_sc_mcu9t5v0__aoi21_1
* cell instance $11773 r0 *1 1533.28,937.44
X$11773 12797 12796 12636 13054 12900 13045 gf180mcu_fd_sc_mcu9t5v0__and3_1
* cell instance $11774 m0 *1 1568.56,846.72
X$11774 10570 10338 gf180mcu_fd_sc_mcu9t5v0__filltie
* cell instance $11775 r0 *1 1546.16,917.28
X$11775 12416 12415 12508 12253 12639 gf180mcu_fd_sc_mcu9t5v0__nor2_1
* cell instance $11776 r0 *1 1546.16,937.44
X$11776 13047 13048 13054 12900 12772 gf180mcu_fd_sc_mcu9t5v0__or2_1
* cell instance $11777 m0 *1 1520.96,927.36
X$11777 12636 12635 12763 12508 12646 12637 gf180mcu_fd_sc_mcu9t5v0__aoi21_1
* cell instance $11778 m0 *1 1568.56,876.96
X$11778 11294 11181 gf180mcu_fd_sc_mcu9t5v0__filltie
* cell instance $11779 m0 *1 1568.56,907.2
X$11779 12019 11971 gf180mcu_fd_sc_mcu9t5v0__filltie
* cell instance $11780 m0 *1 1568.56,836.64
X$11780 10308 10188 gf180mcu_fd_sc_mcu9t5v0__filltie
* cell instance $11781 m0 *1 1568.56,897.12
X$11781 11860 11720 gf180mcu_fd_sc_mcu9t5v0__filltie
* cell instance $11782 r0 *1 1528.24,957.6
X$11782 13479 12632 13494 13493 13586 13428 13043
+ gf180mcu_fd_sc_mcu9t5v0__aoi22_1
* cell instance $11783 r0 *1 1527.68,937.44
X$11783 13039 12763 13045 13043 13054 12900 13044
+ gf180mcu_fd_sc_mcu9t5v0__oai31_1
* cell instance $11784 m0 *1 1568.56,937.44
X$11784 12900 12785 gf180mcu_fd_sc_mcu9t5v0__filltie
* cell instance $11785 m0 *1 1557.92,947.52
X$11785 13185 13184 12416 13054 13160 13186 gf180mcu_fd_sc_mcu9t5v0__or3_1
* cell instance $11786 m0 *1 1564.08,947.52
X$11786 12796 13186 12763 13054 13160 13187 gf180mcu_fd_sc_mcu9t5v0__aoi21_1
* cell instance $11787 m0 *1 1564.64,927.36
X$11787 12273 12632 12508 12646 12642 gf180mcu_fd_sc_mcu9t5v0__nand2_1
* cell instance $11788 r0 *1 1564.64,927.36
X$11788 12774 12773 12763 12785 12646 12775 gf180mcu_fd_sc_mcu9t5v0__aoi21_1
* cell instance $11789 r0 *1 1569.68,947.52
X$11789 13497 13318 13160 12774 gf180mcu_fd_sc_mcu9t5v0__buf_8
* cell instance $11790 m0 *1 1568.56,866.88
X$11790 11079 10833 gf180mcu_fd_sc_mcu9t5v0__filltie
* cell instance $11791 m0 *1 1568.56,856.8
X$11791 10714 10676 gf180mcu_fd_sc_mcu9t5v0__filltie
* cell instance $11792 m0 *1 1234.24,1078.56
X$11792 14677 16926 16804 13331 16784 16956 gf180mcu_fd_sc_mcu9t5v0__dffrnq_2
* cell instance $11793 r0 *1 1230.88,1008
X$11793 14677 14981 14675 13331 14967 14857 gf180mcu_fd_sc_mcu9t5v0__dffrnq_2
* cell instance $11794 m0 *1 1225.28,1098.72
X$11794 14677 17411 17254 13331 17398 17521 gf180mcu_fd_sc_mcu9t5v0__dffrnq_2
* cell instance $11795 m0 *1 1232,1038.24
X$11795 14677 15541 15542 13331 15576 15737 gf180mcu_fd_sc_mcu9t5v0__dffrnq_2
* cell instance $11796 r0 *1 1240.96,1068.48
X$11796 13489 18116 16809 16810 16784 16653 16926
+ gf180mcu_fd_sc_mcu9t5v0__oai211_1
* cell instance $11797 r0 *1 1239.84,1058.4
X$11797 14677 16506 16309 33557 gf180mcu_fd_sc_mcu9t5v0__inv_2
* cell instance $11798 m0 *1 1242.08,1058.4
X$11798 3816 16194 16309 14677 gf180mcu_fd_sc_mcu9t5v0__clkbuf_8
* cell instance $11799 r0 *1 1242.08,1078.56
X$11799 16804 12632 17123 16956 16809 gf180mcu_fd_sc_mcu9t5v0__nand2_1
* cell instance $11800 m0 *1 1238.16,987.84
X$11800 12268 14137 14025 13331 14126 14304 gf180mcu_fd_sc_mcu9t5v0__dffrnq_2
* cell instance $11801 r0 *1 1240.4,1028.16
X$11801 15542 15589 13214 15576 15402 15541 gf180mcu_fd_sc_mcu9t5v0__mux2_1
* cell instance $11802 r0 *1 1242.64,977.76
X$11802 14025 13909 13214 14126 14009 14137 gf180mcu_fd_sc_mcu9t5v0__mux2_1
* cell instance $11803 m0 *1 1239.84,997.92
X$11803 14677 14421 14463 13331 14406 14448 gf180mcu_fd_sc_mcu9t5v0__dffrnq_2
* cell instance $11804 m0 *1 1168.16,967.68
X$11804 13695 13586 13719 13210 gf180mcu_fd_sc_mcu9t5v0__clkinv_1
* cell instance $11805 m0 *1 1192.24,967.68
X$11805 13470 13696 13586 13719 13697 gf180mcu_fd_sc_mcu9t5v0__nand2_1
* cell instance $11806 m0 *1 1157.52,967.68
X$11806 13695 13729 13024 13586 13719 10043 gf180mcu_fd_sc_mcu9t5v0__mux2_1
* cell instance $11807 m0 *1 1294.72,967.68
X$11807 13484 13481 13024 13586 13719 9709 gf180mcu_fd_sc_mcu9t5v0__mux2_1
* cell instance $11808 r0 *1 1240.96,907.2
X$11808 12140 5766 12128 12019 12139 gf180mcu_fd_sc_mcu9t5v0__nand2_1
* cell instance $11809 m0 *1 1334.48,967.68
X$11809 6569 12632 13586 13719 13701 gf180mcu_fd_sc_mcu9t5v0__nand2_1
* cell instance $11810 m0 *1 1331.68,967.68
X$11810 13701 14196 13586 13719 13483 gf180mcu_fd_sc_mcu9t5v0__nand2_1
* cell instance $11811 m0 *1 1309.28,967.68
X$11811 13477 13700 13024 13586 13719 4967 gf180mcu_fd_sc_mcu9t5v0__mux2_1
* cell instance $11812 m0 *1 1344.56,967.68
X$11812 14464 13586 13719 5672 gf180mcu_fd_sc_mcu9t5v0__buf_8
* cell instance $11813 m0 *1 1328.88,967.68
X$11813 13719 13586 gf180mcu_fd_sc_mcu9t5v0__filltie
* cell instance $11814 m0 *1 1255.52,967.68
X$11814 13699 13596 14462 13331 13586 13719 gf180mcu_fd_sc_mcu9t5v0__dffrnq_2
* cell instance $11815 m0 *1 1287.44,967.68
X$11815 13479 13484 13024 13586 13719 9112 gf180mcu_fd_sc_mcu9t5v0__mux2_1
* cell instance $11816 m0 *1 1240.96,917.28
X$11816 5766 12277 12278 12139 12128 12253 11851
+ gf180mcu_fd_sc_mcu9t5v0__oai31_1
* cell instance $11817 m0 *1 1276.24,967.68
X$11817 13482 13728 13024 13586 13719 2370 gf180mcu_fd_sc_mcu9t5v0__mux2_1
* cell instance $11818 m0 *1 1247.68,967.68
X$11818 13693 13698 13024 13586 13719 3230 gf180mcu_fd_sc_mcu9t5v0__mux2_1
* cell instance $11819 r0 *1 1237.6,957.6
X$11819 13473 13595 13173 13586 13428 13467 gf180mcu_fd_sc_mcu9t5v0__mux2_1
* cell instance $11820 r0 *1 1242.08,897.12
X$11820 9591 11852 11991 11971 11860 gf180mcu_fd_sc_mcu9t5v0__dffq_2
* cell instance $11821 m0 *1 1240.4,876.96
X$11821 5667 9330 11308 11181 11294 11309 gf180mcu_fd_sc_mcu9t5v0__aoi21_1
* cell instance $11822 r0 *1 1239.28,876.96
X$11822 5766 11365 11309 11364 11461 11294 11310
+ gf180mcu_fd_sc_mcu9t5v0__oai31_1
* cell instance $11823 m0 *1 1238.72,856.8
X$11823 5667 9330 10728 10676 10714 10727 gf180mcu_fd_sc_mcu9t5v0__aoi21_1
* cell instance $11824 r0 *1 1242.08,846.72
X$11824 5766 10701 10727 10700 10676 10570 10353
+ gf180mcu_fd_sc_mcu9t5v0__oai31_1
* cell instance $11825 m0 *1 1239.84,866.88
X$11825 10976 8452 11084 10833 11079 10728 gf180mcu_fd_sc_mcu9t5v0__aoi21_1
* cell instance $11826 m0 *1 1214.64,836.64
X$11826 10850 10188 10308 5767 gf180mcu_fd_sc_mcu9t5v0__buf_20
* cell instance $11827 m0 *1 1242.08,846.72
X$11827 10578 10354 10355 10338 10570 gf180mcu_fd_sc_mcu9t5v0__dffq_2
* cell instance $11828 m0 *1 1232.56,967.68
X$11828 13474 14310 13024 13586 13719 13472 gf180mcu_fd_sc_mcu9t5v0__mux2_1
* cell instance $11829 m0 *1 1308.72,1048.32
X$11829 16026 15878 15898 16008 15877 15545 gf180mcu_fd_sc_mcu9t5v0__xnor3_1
* cell instance $11830 r0 *1 1307.6,1048.32
X$11830 13699 16194 16008 gf180mcu_fd_sc_mcu9t5v0__inv_4
* cell instance $11831 m0 *1 1303.12,1068.48
X$11831 13699 16531 13474 13180 16506 16653 gf180mcu_fd_sc_mcu9t5v0__dffrnq_2
* cell instance $11832 m0 *1 1289.12,1038.24
X$11832 13020 12632 15576 15737 15748 gf180mcu_fd_sc_mcu9t5v0__nand2_1
* cell instance $11833 m0 *1 1251.04,1038.24
X$11833 13477 13698 13475 15576 15737 15589 gf180mcu_fd_sc_mcu9t5v0__mux2_1
* cell instance $11834 m0 *1 1269.52,1038.24
X$11834 13700 15415 13475 15576 15737 15875 gf180mcu_fd_sc_mcu9t5v0__mux2_1
* cell instance $11835 m0 *1 1344.56,1038.24
X$11835 15708 15709 15576 15737 14829 15289 gf180mcu_fd_sc_mcu9t5v0__xnor3_1
* cell instance $11836 r0 *1 1310.4,1028.16
X$11836 15545 15544 15576 15402 15156 gf180mcu_fd_sc_mcu9t5v0__nor2_1
* cell instance $11837 m0 *1 1309.28,1038.24
X$11837 15545 15544 15576 15737 14468 gf180mcu_fd_sc_mcu9t5v0__xnor2_1
* cell instance $11838 m0 *1 1328.88,1038.24
X$11838 15737 15576 gf180mcu_fd_sc_mcu9t5v0__filltie
* cell instance $11839 m0 *1 1310.96,987.84
X$11839 3462 11993 14126 14304 14192 gf180mcu_fd_sc_mcu9t5v0__nor2_1
* cell instance $11840 r0 *1 1312.08,1018.08
X$11840 15156 15288 15022 15271 15138 15024 gf180mcu_fd_sc_mcu9t5v0__or3_1
* cell instance $11841 m0 *1 1330,1038.24
X$11841 15707 15706 15576 15737 15026 gf180mcu_fd_sc_mcu9t5v0__xnor2_1
* cell instance $11842 r0 *1 1309.28,997.92
X$11842 14468 14467 14679 14708 14448 14423 gf180mcu_fd_sc_mcu9t5v0__aoi21_1
* cell instance $11843 r0 *1 1311.52,1038.24
X$11843 14685 15877 15898 15737 16025 gf180mcu_fd_sc_mcu9t5v0__nand2_1
* cell instance $11844 r0 *1 1295.28,1008
X$11844 13699 14983 14454 13180 14967 14857 gf180mcu_fd_sc_mcu9t5v0__dffrnq_2
* cell instance $11845 m0 *1 1296.4,1038.24
X$11845 15905 15705 14468 15576 15737 15288 gf180mcu_fd_sc_mcu9t5v0__aoi21_1
* cell instance $11846 m0 *1 1307.6,1058.4
X$11846 3816 16194 16309 13699 gf180mcu_fd_sc_mcu9t5v0__clkbuf_8
* cell instance $11847 r0 *1 1311.52,1088.64
X$11847 16026 17415 17398 17289 17257 gf180mcu_fd_sc_mcu9t5v0__or2_1
* cell instance $11848 m0 *1 1373.12,1038.24
X$11848 15755 15292 15576 15737 15710 gf180mcu_fd_sc_mcu9t5v0__nand2_1
* cell instance $11849 m0 *1 1370.88,1038.24
X$11849 15754 15576 15737 15292 gf180mcu_fd_sc_mcu9t5v0__clkinv_1
* cell instance $11850 r0 *1 1310.96,1068.48
X$11850 13474 16811 13492 16784 16653 16531 gf180mcu_fd_sc_mcu9t5v0__mux2_1
* cell instance $11851 m0 *1 1309.84,1088.64
X$11851 17098 17257 17123 17289 17097 gf180mcu_fd_sc_mcu9t5v0__nand2_1
* cell instance $11852 r0 *1 1351.28,1078.56
X$11852 16812 17100 16978 17123 16956 17101 gf180mcu_fd_sc_mcu9t5v0__aoi21_1
* cell instance $11853 m0 *1 1328.88,1098.72
X$11853 17521 17398 gf180mcu_fd_sc_mcu9t5v0__filltie
* cell instance $11854 r0 *1 1349.04,1048.32
X$11854 16028 16194 16008 16168 gf180mcu_fd_sc_mcu9t5v0__clkinv_1
* cell instance $11855 m0 *1 1322.16,1058.4
X$11855 16026 16194 16309 16027 gf180mcu_fd_sc_mcu9t5v0__clkinv_1
* cell instance $11856 m0 *1 1330,1068.48
X$11856 16027 16200 16506 16653 16464 gf180mcu_fd_sc_mcu9t5v0__nor2_1
* cell instance $11857 m0 *1 1333.36,1048.32
X$11857 15027 16028 15898 16008 15707 gf180mcu_fd_sc_mcu9t5v0__xnor2_1
* cell instance $11858 m0 *1 1330,1058.4
X$11858 16027 16200 16194 16309 16327 gf180mcu_fd_sc_mcu9t5v0__nand2_1
* cell instance $11859 r0 *1 1338.96,1058.4
X$11859 16028 16532 16506 16309 16465 gf180mcu_fd_sc_mcu9t5v0__xnor2_1
* cell instance $11860 m0 *1 1332.8,1058.4
X$11860 16464 16462 16327 16465 16194 16309 16201
+ gf180mcu_fd_sc_mcu9t5v0__oai211_1
* cell instance $11861 m0 *1 1344.56,1058.4
X$11861 16168 16532 16201 16194 16309 16202 gf180mcu_fd_sc_mcu9t5v0__oai21_1
* cell instance $11862 m0 *1 1349.04,1058.4
X$11862 15708 16202 16194 16309 15290 16169 gf180mcu_fd_sc_mcu9t5v0__xnor3_1
* cell instance $11863 r0 *1 1327.76,1058.4
X$11863 16464 16462 16327 16506 16309 16463 gf180mcu_fd_sc_mcu9t5v0__oai21_1
* cell instance $11864 r0 *1 1332.24,1058.4
X$11864 16465 16506 16309 16463 15157 gf180mcu_fd_sc_mcu9t5v0__xor2_1
* cell instance $11865 r0 *1 1316,1078.56
X$11865 17098 17123 16956 17258 gf180mcu_fd_sc_mcu9t5v0__clkinv_1
* cell instance $11866 r0 *1 1360.24,1048.32
X$11866 15752 16169 16194 16008 16170 gf180mcu_fd_sc_mcu9t5v0__nor2_1
* cell instance $11867 m0 *1 1356.32,1048.32
X$11867 15708 15898 16008 15752 gf180mcu_fd_sc_mcu9t5v0__clkinv_1
* cell instance $11868 m0 *1 1328.88,1058.4
X$11868 16309 16194 gf180mcu_fd_sc_mcu9t5v0__filltie
* cell instance $11869 m0 *1 1330,1048.32
X$11869 16027 15546 15898 16008 15749 gf180mcu_fd_sc_mcu9t5v0__nor2_1
* cell instance $11870 m0 *1 1328.88,1048.32
X$11870 16008 15898 gf180mcu_fd_sc_mcu9t5v0__filltie
* cell instance $11871 m0 *1 1328.88,1068.48
X$11871 16653 16506 gf180mcu_fd_sc_mcu9t5v0__filltie
* cell instance $11872 m0 *1 1328.88,1078.56
X$11872 16956 16784 gf180mcu_fd_sc_mcu9t5v0__filltie
* cell instance $11873 m0 *1 1338.4,1098.72
X$11873 17966 15708 14872 17398 17521 17598 gf180mcu_fd_sc_mcu9t5v0__mux2_1
* cell instance $11874 r0 *1 1331.68,1078.56
X$11874 16028 17099 17123 16956 17134 gf180mcu_fd_sc_mcu9t5v0__xnor2_1
* cell instance $11875 r0 *1 1329.44,1088.64
X$11875 17134 17398 17289 17299 gf180mcu_fd_sc_mcu9t5v0__clkinv_1
* cell instance $11876 r0 *1 1314.32,1038.24
X$11876 15546 15898 15737 15545 gf180mcu_fd_sc_mcu9t5v0__clkinv_1
* cell instance $11877 r0 *1 1355.76,1038.24
X$11877 15752 15159 15898 15737 15751 gf180mcu_fd_sc_mcu9t5v0__nor2_1
* cell instance $11878 r0 *1 1330,1038.24
X$11878 15749 15878 15879 15707 15898 15737 15880
+ gf180mcu_fd_sc_mcu9t5v0__oai211_1
* cell instance $11879 r0 *1 1347.92,1038.24
X$11879 15027 16168 15880 15898 15737 15709 gf180mcu_fd_sc_mcu9t5v0__oai21_1
* cell instance $11880 m0 *1 1328.88,1088.64
X$11880 17289 17123 gf180mcu_fd_sc_mcu9t5v0__filltie
* cell instance $11881 m0 *1 1317.12,1088.64
X$11881 17258 17133 17257 17299 17123 17289 17259
+ gf180mcu_fd_sc_mcu9t5v0__oai211_1
* cell instance $11882 r0 *1 1351.84,1068.48
X$11882 16532 15159 14685 16784 16653 16676 gf180mcu_fd_sc_mcu9t5v0__mux2_1
* cell instance $11883 r0 *1 1359.12,1038.24
X$11883 15751 15709 15881 15898 15737 15753 gf180mcu_fd_sc_mcu9t5v0__oai21_1
* cell instance $11884 r0 *1 1335.6,1038.24
X$11884 16027 15546 15898 15737 15879 gf180mcu_fd_sc_mcu9t5v0__nand2_1
* cell instance $11885 r0 *1 1325.52,1038.24
X$11885 15749 15878 15879 15898 15737 15706 gf180mcu_fd_sc_mcu9t5v0__oai21_1
* cell instance $11886 m0 *1 1341.76,1078.56
X$11886 15708 17100 16784 16956 16811 16676 gf180mcu_fd_sc_mcu9t5v0__xnor3_1
* cell instance $11887 r0 *1 1313.76,1058.4
X$11887 16027 16462 16506 16309 15544 16200 gf180mcu_fd_sc_mcu9t5v0__xnor3_1
* cell instance $11888 r0 *1 1333.92,1098.72
X$11888 13699 17598 15708 13180 17709 17521 gf180mcu_fd_sc_mcu9t5v0__dffrnq_2
* cell instance $11889 m0 *1 1312.64,1088.64
X$11889 17258 17133 17257 17123 17289 17416 gf180mcu_fd_sc_mcu9t5v0__oai21_1
* cell instance $11890 r0 *1 1316,1088.64
X$11890 17299 17416 17398 17289 17417 gf180mcu_fd_sc_mcu9t5v0__xnor2_1
* cell instance $11891 m0 *1 1341.2,1088.64
X$11891 17300 17259 17123 17289 17100 gf180mcu_fd_sc_mcu9t5v0__and2_1
* cell instance $11892 r0 *1 1349.04,1068.48
X$11892 15708 16676 16784 16653 16812 gf180mcu_fd_sc_mcu9t5v0__nand2_1
* cell instance $11893 m0 *1 1354.64,1078.56
X$11893 15708 16676 16784 16956 16978 gf180mcu_fd_sc_mcu9t5v0__nor2_1
* cell instance $11894 m0 *1 1333.92,1088.64
X$11894 15027 16200 14205 17123 17289 17099 gf180mcu_fd_sc_mcu9t5v0__mux2_1
* cell instance $11895 r0 *1 1372,1058.4
X$11895 15755 16466 16506 16309 16533 gf180mcu_fd_sc_mcu9t5v0__nor2_1
* cell instance $11896 r0 *1 1370.88,1078.56
X$11896 15755 16979 17123 16956 16980 gf180mcu_fd_sc_mcu9t5v0__or2_1
* cell instance $11897 m0 *1 1367.52,1078.56
X$11897 16169 15754 14685 16784 16956 16979 gf180mcu_fd_sc_mcu9t5v0__mux2_1
* cell instance $11898 m0 *1 1374.8,1078.56
X$11898 15755 16979 16784 16956 16981 gf180mcu_fd_sc_mcu9t5v0__and2_1
* cell instance $11899 m0 *1 1364.16,1088.64
X$11899 15755 17101 17123 17289 16979 17301 gf180mcu_fd_sc_mcu9t5v0__xor3_1
* cell instance $11900 m0 *1 1366.4,1058.4
X$11900 15752 16169 16194 16309 16204 gf180mcu_fd_sc_mcu9t5v0__nand2_1
* cell instance $11901 r0 *1 1375.36,1078.56
X$11901 16980 17101 16981 17123 16956 17102 gf180mcu_fd_sc_mcu9t5v0__aoi21_1
* cell instance $11902 r0 *1 1336.16,1088.64
X$11902 16028 17099 17398 17289 17300 gf180mcu_fd_sc_mcu9t5v0__nand2_1
* cell instance $11903 m0 *1 1351.84,1098.72
X$11903 13699 17544 13473 13180 17398 17521 gf180mcu_fd_sc_mcu9t5v0__dffrnq_2
* cell instance $11904 r0 *1 1363.6,1038.24
X$11904 15752 15159 15898 15737 15881 gf180mcu_fd_sc_mcu9t5v0__nand2_1
* cell instance $11905 r0 *1 1359.12,1088.64
X$11905 13473 17301 13492 17398 17289 17544 gf180mcu_fd_sc_mcu9t5v0__mux2_1
* cell instance $11906 m0 *1 1361.92,1058.4
X$11906 16202 16170 16204 16194 16309 16203 gf180mcu_fd_sc_mcu9t5v0__oai21_1
* cell instance $11907 m0 *1 1312.64,1098.72
X$11907 15546 17597 14205 17398 17521 17415 gf180mcu_fd_sc_mcu9t5v0__mux2_1
* cell instance $11908 r0 *1 1285.2,1078.56
X$11908 17094 17123 16956 16976 gf180mcu_fd_sc_mcu9t5v0__clkinv_1
* cell instance $11909 r0 *1 1290.8,1088.64
X$11909 17256 17398 17289 17095 gf180mcu_fd_sc_mcu9t5v0__clkinv_1
* cell instance $11910 r0 *1 1243.2,1058.4
X$11910 14677 16460 16320 13331 16506 16309 gf180mcu_fd_sc_mcu9t5v0__dffrnq_2
* cell instance $11911 m0 *1 1282.96,1078.56
X$11911 16976 16977 15155 16784 16956 16529 gf180mcu_fd_sc_mcu9t5v0__or3_1
* cell instance $11912 r0 *1 1294.16,1078.56
X$11912 17095 17096 17123 16956 15287 gf180mcu_fd_sc_mcu9t5v0__nand2_1
* cell instance $11913 r0 *1 1287.44,1078.56
X$11913 17095 17096 17123 16956 15155 gf180mcu_fd_sc_mcu9t5v0__xnor2_1
* cell instance $11914 r0 *1 1293.04,1088.64
X$11914 17298 17540 17398 17289 17543 gf180mcu_fd_sc_mcu9t5v0__nor2_1
* cell instance $11915 m0 *1 1288.56,1068.48
X$11915 15705 16529 14313 16506 16653 16530 gf180mcu_fd_sc_mcu9t5v0__aoi21_1
* cell instance $11916 r0 *1 1262.8,1098.72
X$11916 13699 17596 15406 13331 17709 17521 gf180mcu_fd_sc_mcu9t5v0__dffrnq_2
* cell instance $11917 r0 *1 1294.16,1098.72
X$11917 17298 17540 17709 17521 17542 gf180mcu_fd_sc_mcu9t5v0__nand2_1
* cell instance $11918 r0 *1 1296.96,1098.72
X$11918 17597 17709 17521 17540 gf180mcu_fd_sc_mcu9t5v0__clkinv_1
* cell instance $11919 m0 *1 1296.96,1098.72
X$11919 17543 17541 17542 17398 17521 16462 gf180mcu_fd_sc_mcu9t5v0__oai21_1
* cell instance $11920 r0 *1 1282.4,1058.4
X$11920 13699 16461 13170 13180 16506 16309 gf180mcu_fd_sc_mcu9t5v0__dffrnq_2
* cell instance $11921 m0 *1 1289.12,1078.56
X$11921 16976 16977 15155 16784 16956 15705 gf180mcu_fd_sc_mcu9t5v0__oai21_1
* cell instance $11922 m0 *1 1294.72,1048.32
X$11922 15905 15705 15898 16008 15906 gf180mcu_fd_sc_mcu9t5v0__nand2_1
* cell instance $11923 m0 *1 1259.44,1068.48
X$11923 14677 16528 16525 13331 16506 16653 gf180mcu_fd_sc_mcu9t5v0__dffrnq_2
* cell instance $11924 r0 *1 1257.76,1078.56
X$11924 13699 17093 10046 13331 17123 16956 gf180mcu_fd_sc_mcu9t5v0__dffrnq_2
* cell instance $11925 r0 *1 1251.6,1098.72
X$11925 17538 14820 17709 17521 17414 gf180mcu_fd_sc_mcu9t5v0__nand2_1
* cell instance $11926 r0 *1 1250.48,1088.64
X$11926 14820 13910 17414 17398 17289 17413 gf180mcu_fd_sc_mcu9t5v0__oai21_1
* cell instance $11927 m0 *1 1270.08,1098.72
X$11927 15406 17539 13492 17398 17521 17596 gf180mcu_fd_sc_mcu9t5v0__mux2_1
* cell instance $11928 r0 *1 1255.52,1048.32
X$11928 13700 13475 15147 16194 16008 16166 gf180mcu_fd_sc_mcu9t5v0__aoi21_1
* cell instance $11929 m0 *1 1251.04,1068.48
X$11929 16320 14820 16506 16653 16167 gf180mcu_fd_sc_mcu9t5v0__nand2_1
* cell instance $11930 r0 *1 1249.92,1048.32
X$11930 14820 16166 16167 16194 16008 16460 gf180mcu_fd_sc_mcu9t5v0__oai21_1
* cell instance $11931 m0 *1 1299.76,1048.32
X$11931 14685 15876 16025 13492 15898 16008 16024
+ gf180mcu_fd_sc_mcu9t5v0__oai211_1
* cell instance $11932 r0 *1 1296.96,1078.56
X$11932 17132 17123 16956 15905 gf180mcu_fd_sc_mcu9t5v0__clkinv_1
* cell instance $11933 m0 *1 1263.92,1048.32
X$11933 15871 15875 13214 15898 16008 15874 gf180mcu_fd_sc_mcu9t5v0__mux2_1
* cell instance $11934 r0 *1 1270.64,1058.4
X$11934 13482 15543 13475 16506 16309 16675 gf180mcu_fd_sc_mcu9t5v0__mux2_1
* cell instance $11935 m0 *1 1284.08,1098.72
X$11935 17298 17541 17398 17521 17096 17540 gf180mcu_fd_sc_mcu9t5v0__xnor3_1
* cell instance $11936 r0 *1 1265.04,1068.48
X$11936 16525 16675 13214 16784 16653 16528 gf180mcu_fd_sc_mcu9t5v0__mux2_1
* cell instance $11937 m0 *1 1260.56,1078.56
X$11937 10046 12632 16784 16956 17092 gf180mcu_fd_sc_mcu9t5v0__nand2_1
* cell instance $11938 m0 *1 1289.68,1088.64
X$11938 17256 17096 17123 17289 17132 gf180mcu_fd_sc_mcu9t5v0__and2_1
* cell instance $11939 m0 *1 1244.88,1098.72
X$11939 14677 17413 17538 13331 17398 17521 gf180mcu_fd_sc_mcu9t5v0__dffrnq_2
* cell instance $11940 r0 *1 1258.88,1038.24
X$11940 14677 15874 15871 13331 15898 15737 gf180mcu_fd_sc_mcu9t5v0__dffrnq_2
* cell instance $11941 m0 *1 1286.88,1058.4
X$11941 16530 16326 16194 16309 16461 gf180mcu_fd_sc_mcu9t5v0__nor2_1
* cell instance $11942 r0 *1 1254.96,1078.56
X$11942 16810 17092 17123 16956 17093 gf180mcu_fd_sc_mcu9t5v0__nand2_1
* cell instance $11943 r0 *1 1280.16,1038.24
X$11943 13699 15904 13020 13180 15898 15737 gf180mcu_fd_sc_mcu9t5v0__dffrnq_2
* cell instance $11944 r0 *1 1299.2,1038.24
X$11944 15906 14468 15898 15737 15876 gf180mcu_fd_sc_mcu9t5v0__xnor2_1
* cell instance $11945 r0 *1 1305.36,1078.56
X$11945 17133 17097 17123 16956 14828 gf180mcu_fd_sc_mcu9t5v0__xnor2_1
* cell instance $11946 r0 *1 1308.72,1088.64
X$11946 16026 17415 17398 17289 17098 gf180mcu_fd_sc_mcu9t5v0__nand2_1
* cell instance $11947 m0 *1 1289.12,1048.32
X$11947 15748 16024 15898 16008 15904 gf180mcu_fd_sc_mcu9t5v0__nand2_1
* cell instance $11948 r0 *1 1252.16,1078.56
X$11948 13912 17091 17123 16956 16810 gf180mcu_fd_sc_mcu9t5v0__nand2_1
* cell instance $11949 m0 *1 1290.24,1058.4
X$11949 13170 13492 13489 16325 16194 16309 16326
+ gf180mcu_fd_sc_mcu9t5v0__oai22_1
* cell instance $11950 r0 *1 1288,967.68
X$11950 13480 13173 13832 13719 13478 gf180mcu_fd_sc_mcu9t5v0__and2_1
* cell instance $11951 r0 *1 1243.2,987.84
X$11951 14463 8823 13214 14406 14304 14421 gf180mcu_fd_sc_mcu9t5v0__mux2_1
* cell instance $11952 m0 *1 1270.64,1028.16
X$11952 13698 15415 13024 15271 15402 5275 gf180mcu_fd_sc_mcu9t5v0__mux2_1
* cell instance $11953 r0 *1 1254.96,967.68
X$11953 13215 13475 15147 13832 13719 13910 gf180mcu_fd_sc_mcu9t5v0__aoi21_1
* cell instance $11954 m0 *1 1291.92,987.84
X$11954 13028 14191 4961 13180 14126 14304 gf180mcu_fd_sc_mcu9t5v0__dffrnq_2
* cell instance $11955 r0 *1 1270.64,1028.16
X$11955 15415 15543 13024 15576 15402 4246 gf180mcu_fd_sc_mcu9t5v0__mux2_1
* cell instance $11956 m0 *1 1290.8,1028.16
X$11956 15155 15154 15287 15271 15402 14467 gf180mcu_fd_sc_mcu9t5v0__oai21_1
* cell instance $11957 m0 *1 1298.08,997.92
X$11957 14468 14467 14406 14448 14314 gf180mcu_fd_sc_mcu9t5v0__and2_1
* cell instance $11958 r0 *1 1249.36,1018.08
X$11958 15152 14820 15271 15138 15286 gf180mcu_fd_sc_mcu9t5v0__nand2_1
* cell instance $11959 m0 *1 1253.28,1028.16
X$11959 14820 15019 15286 15271 15402 15153 gf180mcu_fd_sc_mcu9t5v0__oai21_1
* cell instance $11960 m0 *1 1261.12,987.84
X$11960 13699 14138 14028 13331 14126 14304 gf180mcu_fd_sc_mcu9t5v0__dffrnq_2
* cell instance $11961 r0 *1 1257.2,997.92
X$11961 13699 14678 14674 13331 14708 14448 gf180mcu_fd_sc_mcu9t5v0__dffrnq_2
* cell instance $11962 m0 *1 1302.56,997.92
X$11962 14468 14467 14406 14448 14469 gf180mcu_fd_sc_mcu9t5v0__nor2_1
* cell instance $11963 m0 *1 1302,1008
X$11963 14454 14828 13492 14708 14857 14983 gf180mcu_fd_sc_mcu9t5v0__mux2_1
* cell instance $11964 m0 *1 1264.48,1008
X$11964 14027 14826 13475 14708 14857 14827 gf180mcu_fd_sc_mcu9t5v0__mux2_1
* cell instance $11965 m0 *1 1257.2,1008
X$11965 14674 14827 13214 14708 14857 14678 gf180mcu_fd_sc_mcu9t5v0__mux2_1
* cell instance $11966 r0 *1 1276.24,1008
X$11966 13699 14982 4956 13180 14967 14857 gf180mcu_fd_sc_mcu9t5v0__dffrnq_2
* cell instance $11967 r0 *1 1281.84,1018.08
X$11967 15155 15154 15271 15138 15020 gf180mcu_fd_sc_mcu9t5v0__nor2_1
* cell instance $11968 r0 *1 1296.4,977.76
X$11968 4961 12632 14126 14009 14139 gf180mcu_fd_sc_mcu9t5v0__nand2_1
* cell instance $11969 r0 *1 1296.4,987.84
X$11969 14313 14314 14469 14139 14406 14304 14191
+ gf180mcu_fd_sc_mcu9t5v0__oai31_1
* cell instance $11970 r0 *1 1264.48,977.76
X$11970 14028 13595 13214 14126 14009 14138 gf180mcu_fd_sc_mcu9t5v0__mux2_1
* cell instance $11971 r0 *1 1285.2,1018.08
X$11971 15155 15154 15271 15138 15021 gf180mcu_fd_sc_mcu9t5v0__and2_1
* cell instance $11972 m0 *1 1281.28,1008
X$11972 4956 12632 14708 14857 14868 gf180mcu_fd_sc_mcu9t5v0__nand2_1
* cell instance $11973 m0 *1 1282.4,1018.08
X$11973 14313 15020 15021 14868 14967 15138 14982
+ gf180mcu_fd_sc_mcu9t5v0__oai31_1
* cell instance $11974 r0 *1 1252.16,1018.08
X$11974 14677 15153 15152 13331 15271 15138 gf180mcu_fd_sc_mcu9t5v0__dffrnq_2
* cell instance $11975 m0 *1 1254.4,1018.08
X$11975 13477 13475 15147 14967 15138 15019 gf180mcu_fd_sc_mcu9t5v0__aoi21_1
* cell instance $11976 m0 *1 1281.84,987.84
X$11976 6406 12632 14126 14304 14190 gf180mcu_fd_sc_mcu9t5v0__nand2_1
* cell instance $11977 m0 *1 1279.04,997.92
X$11977 14313 14466 14190 14406 14448 14422 gf180mcu_fd_sc_mcu9t5v0__oai21_1
* cell instance $11978 r0 *1 1276.24,987.84
X$11978 13699 14422 6406 13180 14406 14304 gf180mcu_fd_sc_mcu9t5v0__dffrnq_2
* cell instance $11979 r0 *1 1344,1008
X$11979 15029 14967 14857 14197 14831 gf180mcu_fd_sc_mcu9t5v0__xor2_1
* cell instance $11980 r0 *1 1316,997.92
X$11980 13028 14680 13059 13180 14708 14448 gf180mcu_fd_sc_mcu9t5v0__dffrnq_2
* cell instance $11981 r0 *1 1350.72,1028.16
X$11981 15159 15576 15402 15289 gf180mcu_fd_sc_mcu9t5v0__clkinv_1
* cell instance $11982 r0 *1 1350.72,967.68
X$11982 5062 12632 13832 13719 13843 gf180mcu_fd_sc_mcu9t5v0__nand2_1
* cell instance $11983 m0 *1 1328.88,997.92
X$11983 14448 14406 gf180mcu_fd_sc_mcu9t5v0__filltie
* cell instance $11984 m0 *1 1353.52,1008
X$11984 13060 12632 14708 14857 14830 gf180mcu_fd_sc_mcu9t5v0__nand2_1
* cell instance $11985 r0 *1 1313.2,987.84
X$11985 15022 14423 14406 14304 14193 gf180mcu_fd_sc_mcu9t5v0__nor2_1
* cell instance $11986 r0 *1 1358.56,1018.08
X$11986 15159 15290 15271 15138 15031 gf180mcu_fd_sc_mcu9t5v0__and2_1
* cell instance $11987 m0 *1 1330,997.92
X$11987 15022 14423 14470 14406 14448 14424 gf180mcu_fd_sc_mcu9t5v0__oai21_1
* cell instance $11988 m0 *1 1328.88,987.84
X$11988 14304 14126 gf180mcu_fd_sc_mcu9t5v0__filltie
* cell instance $11989 m0 *1 1350.16,1028.16
X$11989 15289 15290 15271 15402 14425 gf180mcu_fd_sc_mcu9t5v0__and2_1
* cell instance $11990 r0 *1 1349.04,987.84
X$11990 14197 14424 14425 14406 14304 14199 gf180mcu_fd_sc_mcu9t5v0__aoi21_1
* cell instance $11991 r0 *1 1330,1018.08
X$11991 15027 15157 15271 15138 15022 gf180mcu_fd_sc_mcu9t5v0__xnor2_1
* cell instance $11992 m0 *1 1313.2,1018.08
X$11992 15156 15288 15022 14967 15138 15023 gf180mcu_fd_sc_mcu9t5v0__oai21_1
* cell instance $11993 r0 *1 1350.16,1018.08
X$11993 15159 15290 15271 15138 14197 gf180mcu_fd_sc_mcu9t5v0__xnor2_1
* cell instance $11994 m0 *1 1343.44,1018.08
X$11994 15028 15023 14197 14967 15138 15030 gf180mcu_fd_sc_mcu9t5v0__aoi21_1
* cell instance $11995 m0 *1 1357.44,987.84
X$11995 14201 14199 14126 14304 14200 gf180mcu_fd_sc_mcu9t5v0__and2_1
* cell instance $11996 r0 *1 1320.48,1008
X$11996 15025 14984 14967 14857 14680 gf180mcu_fd_sc_mcu9t5v0__nor2_1
* cell instance $11997 m0 *1 1328.88,1028.16
X$11997 15402 15271 gf180mcu_fd_sc_mcu9t5v0__filltie
* cell instance $11998 r0 *1 1337.28,1018.08
X$11998 15157 15271 15138 15158 gf180mcu_fd_sc_mcu9t5v0__clkinv_1
* cell instance $11999 r0 *1 1339.52,1018.08
X$11999 15027 15158 15271 15138 15028 gf180mcu_fd_sc_mcu9t5v0__nand2_1
* cell instance $12000 m0 *1 1328.88,1008
X$12000 14857 14708 gf180mcu_fd_sc_mcu9t5v0__filltie
* cell instance $12001 m0 *1 1323.28,1018.08
X$12001 13059 13492 13489 15026 14967 15138 14984
+ gf180mcu_fd_sc_mcu9t5v0__oai22_1
* cell instance $12002 r0 *1 1316.56,987.84
X$12002 15022 14423 14406 14304 14195 gf180mcu_fd_sc_mcu9t5v0__and2_1
* cell instance $12003 m0 *1 1365.28,1018.08
X$12003 15031 15030 14201 14967 15138 15032 gf180mcu_fd_sc_mcu9t5v0__or3_1
* cell instance $12004 m0 *1 1374.8,1018.08
X$12004 15032 14833 14313 14967 15138 15033 gf180mcu_fd_sc_mcu9t5v0__aoi21_1
* cell instance $12005 m0 *1 1375.92,1028.16
X$12005 15292 15291 15271 15402 14203 gf180mcu_fd_sc_mcu9t5v0__and2_1
* cell instance $12006 r0 *1 1373.12,1028.16
X$12006 15754 15291 15576 15402 14832 gf180mcu_fd_sc_mcu9t5v0__nand2_1
* cell instance $12007 m0 *1 1369.2,977.76
X$12007 13912 13911 13832 14009 13844 gf180mcu_fd_sc_mcu9t5v0__nand2_1
* cell instance $12008 r0 *1 1315.44,977.76
X$12008 5433 12632 14126 14009 14194 gf180mcu_fd_sc_mcu9t5v0__nand2_1
* cell instance $12009 m0 *1 1318.24,987.84
X$12009 14313 14193 14195 14194 14126 14304 14140
+ gf180mcu_fd_sc_mcu9t5v0__oai31_1
* cell instance $12010 r0 *1 1354.08,977.76
X$12010 14313 14200 14030 13843 14126 14009 14029
+ gf180mcu_fd_sc_mcu9t5v0__oai31_1
* cell instance $12011 m0 *1 1340.64,1018.08
X$12011 15028 15023 14967 15138 15029 gf180mcu_fd_sc_mcu9t5v0__nand2_1
* cell instance $12012 m0 *1 1337.28,977.76
X$12012 13028 14029 5062 13180 13832 14009 gf180mcu_fd_sc_mcu9t5v0__dffrnq_2
* cell instance $12013 r0 *1 1318.24,977.76
X$12013 13028 14140 5433 13180 14126 14009 gf180mcu_fd_sc_mcu9t5v0__dffrnq_2
* cell instance $12014 m0 *1 1372,1008
X$12014 14832 14833 14202 14708 14857 14682 gf180mcu_fd_sc_mcu9t5v0__and3_1
* cell instance $12015 r0 *1 1373.68,997.92
X$12015 14685 14682 14683 14708 14448 14471 gf180mcu_fd_sc_mcu9t5v0__or3_1
* cell instance $12016 r0 *1 1321.04,987.84
X$12016 12129 14406 14304 12272 gf180mcu_fd_sc_mcu9t5v0__clkbuf_8
* cell instance $12017 m0 *1 1365.28,987.84
X$12017 14203 14030 14202 14126 14304 13845 gf180mcu_fd_sc_mcu9t5v0__nor3_1
* cell instance $12018 r0 *1 1372.56,967.68
X$12018 9859 12632 13832 13719 13731 gf180mcu_fd_sc_mcu9t5v0__nand2_1
* cell instance $12019 m0 *1 1328.88,977.76
X$12019 14009 13832 gf180mcu_fd_sc_mcu9t5v0__filltie
* cell instance $12020 r0 *1 1368.08,967.68
X$12020 13845 13844 13731 13832 13719 13730 gf180mcu_fd_sc_mcu9t5v0__oai21_1
* cell instance $12021 r0 *1 1377.6,967.68
X$12021 8823 13832 13719 11363 gf180mcu_fd_sc_mcu9t5v0__clkinv_1
* cell instance $12022 m0 *1 1369.76,987.84
X$12022 14203 14030 14202 14126 14304 13911 gf180mcu_fd_sc_mcu9t5v0__oai21_1
* cell instance $12023 m0 *1 1318.24,1018.08
X$12023 15023 15024 14313 14967 15138 15025 gf180mcu_fd_sc_mcu9t5v0__aoi21_1
* cell instance $12024 m0 *1 1369.2,1028.16
X$12024 15292 15291 15271 15402 14201 gf180mcu_fd_sc_mcu9t5v0__xnor2_1
* cell instance $12025 m0 *1 1346.8,1008
X$12025 14313 14831 14829 13489 14830 14708 14857 14681
+ gf180mcu_fd_sc_mcu9t5v0__oai221_1
* cell instance $12026 m0 *1 1331.68,1018.08
X$12026 15027 15157 14967 15138 14470 gf180mcu_fd_sc_mcu9t5v0__or2_1
* cell instance $12027 r0 *1 1338.4,987.84
X$12027 14197 14424 14313 14406 14304 14198 gf180mcu_fd_sc_mcu9t5v0__aoi21_1
* cell instance $12028 m0 *1 1328.88,1018.08
X$12028 15138 14967 gf180mcu_fd_sc_mcu9t5v0__filltie
* cell instance $12029 m0 *1 1333.92,987.84
X$12029 14197 14424 14198 14126 14304 14196 gf180mcu_fd_sc_mcu9t5v0__oai21_1
* cell instance $12030 m0 *1 1361.92,987.84
X$12030 14201 14199 14126 14304 14030 gf180mcu_fd_sc_mcu9t5v0__nor2_1
* cell instance $12031 m0 *1 1360.8,1018.08
X$12031 15031 15030 14201 14967 15138 14833 gf180mcu_fd_sc_mcu9t5v0__oai21_1
* cell instance $12032 r0 *1 1346.24,997.92
X$12032 13028 14681 13060 13180 14708 14448 gf180mcu_fd_sc_mcu9t5v0__dffrnq_2
* cell instance $12033 r0 *1 1313.76,1028.16
X$12033 15546 15544 15576 15402 14679 gf180mcu_fd_sc_mcu9t5v0__nor2_1
* cell instance $12034 m0 *1 1160.88,1038.24
X$12034 15701 15587 15576 15737 15691 gf180mcu_fd_sc_mcu9t5v0__nand2_1
* cell instance $12035 m0 *1 1187.2,1038.24
X$12035 15703 15412 15538 15702 15903 15576 15737 15539
+ gf180mcu_fd_sc_mcu9t5v0__oai221_1
* cell instance $12036 m0 *1 1173.2,1008
X$12036 13904 14823 14708 14857 14864 gf180mcu_fd_sc_mcu9t5v0__nand2_1
* cell instance $12037 r0 *1 1172.08,1008
X$12037 4956 14014 13907 11611 14864 14967 14857 14979
+ gf180mcu_fd_sc_mcu9t5v0__aoi221_1
* cell instance $12038 m0 *1 1193.92,1038.24
X$12038 13895 15746 15576 15737 15703 gf180mcu_fd_sc_mcu9t5v0__nor2_1
* cell instance $12039 r0 *1 1170.96,1018.08
X$12039 13895 15152 13208 15151 15271 15138 15284
+ gf180mcu_fd_sc_mcu9t5v0__oai211_1
* cell instance $12040 m0 *1 1204,1038.24
X$12040 14677 15704 15746 13331 15576 15737 gf180mcu_fd_sc_mcu9t5v0__dffrnq_2
* cell instance $12041 r0 *1 1169.84,987.84
X$12041 13591 14457 14311 14189 14312 14406 14304 14185
+ gf180mcu_fd_sc_mcu9t5v0__aoi221_1
* cell instance $12042 m0 *1 1166.48,1078.56
X$12042 18153 16923 16672 13331 16784 16956 gf180mcu_fd_sc_mcu9t5v0__dffrnq_2
* cell instance $12043 m0 *1 1160.32,1058.4
X$12043 14182 16161 16162 13331 16194 16309 gf180mcu_fd_sc_mcu9t5v0__dffrnq_2
* cell instance $12044 r0 *1 1167.6,997.92
X$12044 14715 13841 13895 14708 14448 14457 gf180mcu_fd_sc_mcu9t5v0__mux2_1
* cell instance $12045 r0 *1 1173.2,1068.48
X$12045 13695 16804 13475 16784 16653 16805 gf180mcu_fd_sc_mcu9t5v0__mux2_1
* cell instance $12046 r0 *1 1170.96,1078.56
X$12046 16672 16805 13214 17123 16956 16923 gf180mcu_fd_sc_mcu9t5v0__mux2_1
* cell instance $12047 m0 *1 1226.96,1048.32
X$12047 15407 16021 13024 15898 16008 13838 gf180mcu_fd_sc_mcu9t5v0__mux2_1
* cell instance $12048 r0 *1 1209.04,1088.64
X$12048 17289 17398 gf180mcu_fd_sc_mcu9t5v0__filltie
* cell instance $12049 r0 *1 1188.88,1048.32
X$12049 16164 13838 13895 16194 16008 16020 gf180mcu_fd_sc_mcu9t5v0__mux2_1
* cell instance $12050 r0 *1 1179.92,1048.32
X$12050 16162 10677 13895 16194 16008 16163 gf180mcu_fd_sc_mcu9t5v0__mux2_1
* cell instance $12051 m0 *1 1183.84,1048.32
X$12051 13591 16020 16163 13465 15898 16008 15903
+ gf180mcu_fd_sc_mcu9t5v0__aoi22_1
* cell instance $12052 r0 *1 1188.88,1098.72
X$12052 17538 14865 16921 17254 17709 17521 17407
+ gf180mcu_fd_sc_mcu9t5v0__aoi22_1
* cell instance $12053 r0 *1 1209.04,1048.32
X$12053 16008 16194 gf180mcu_fd_sc_mcu9t5v0__filltie
* cell instance $12054 r0 *1 1186.08,1088.64
X$12054 17408 17407 17398 17289 17084 gf180mcu_fd_sc_mcu9t5v0__nand2_1
* cell instance $12055 r0 *1 1177.12,1098.72
X$12055 17538 13208 13465 17591 17716 17709 17521 17536
+ gf180mcu_fd_sc_mcu9t5v0__aoi221_1
* cell instance $12056 m0 *1 1209.04,1048.32
X$12056 15746 14820 15898 16008 15873 gf180mcu_fd_sc_mcu9t5v0__nand2_1
* cell instance $12057 m0 *1 1188.88,1098.72
X$12057 17297 16153 14825 17722 17398 17521 17408
+ gf180mcu_fd_sc_mcu9t5v0__aoi22_1
* cell instance $12058 r0 *1 1210.16,1058.4
X$12058 15414 13475 14822 16506 16309 16674 gf180mcu_fd_sc_mcu9t5v0__aoi21_1
* cell instance $12059 r0 *1 1200.64,1078.56
X$12059 16970 14820 17123 16956 16806 gf180mcu_fd_sc_mcu9t5v0__nand2_1
* cell instance $12060 r0 *1 1199.52,1068.48
X$12060 14820 16674 16806 16784 16653 16924 gf180mcu_fd_sc_mcu9t5v0__oai21_1
* cell instance $12061 r0 *1 1188.88,1068.48
X$12061 15413 15407 13475 16784 16653 16972 gf180mcu_fd_sc_mcu9t5v0__mux2_1
* cell instance $12062 r0 *1 1219.68,1068.48
X$12062 14826 16808 13475 16784 16653 16807 gf180mcu_fd_sc_mcu9t5v0__mux2_1
* cell instance $12063 r0 *1 1232.56,1088.64
X$12063 13060 13475 15534 17398 17289 17412 gf180mcu_fd_sc_mcu9t5v0__aoi21_1
* cell instance $12064 r0 *1 1221.36,1048.32
X$12064 14677 16165 16164 13331 16194 16008 gf180mcu_fd_sc_mcu9t5v0__dffrnq_2
* cell instance $12065 m0 *1 1234.24,1048.32
X$12065 15414 16021 13475 15898 16008 16023 gf180mcu_fd_sc_mcu9t5v0__mux2_1
* cell instance $12066 m0 *1 1228.64,1058.4
X$12066 16164 16023 13214 16194 16309 16165 gf180mcu_fd_sc_mcu9t5v0__mux2_1
* cell instance $12067 r0 *1 1216.88,1078.56
X$12067 16922 16807 13214 17123 16956 16925 gf180mcu_fd_sc_mcu9t5v0__mux2_1
* cell instance $12068 r0 *1 1199.52,1058.4
X$12068 13171 13024 16323 16506 16309 7454 gf180mcu_fd_sc_mcu9t5v0__aoi21_1
* cell instance $12069 m0 *1 1185.52,1058.4
X$12069 16164 16153 16921 16162 16194 16309 16322
+ gf180mcu_fd_sc_mcu9t5v0__aoi22_1
* cell instance $12070 r0 *1 1209.04,1038.24
X$12070 15737 15898 gf180mcu_fd_sc_mcu9t5v0__filltie
* cell instance $12071 r0 *1 1188.32,1038.24
X$12071 15871 15898 15737 15702 gf180mcu_fd_sc_mcu9t5v0__clkinv_1
* cell instance $12072 r0 *1 1204.56,1038.24
X$12072 15413 13475 14822 15898 15737 15872 gf180mcu_fd_sc_mcu9t5v0__aoi21_1
* cell instance $12073 r0 *1 1210.16,1038.24
X$12073 14820 15872 15873 15898 15737 15704 gf180mcu_fd_sc_mcu9t5v0__oai21_1
* cell instance $12074 m0 *1 1183.84,1068.48
X$12074 17589 14825 14865 15871 16506 16653 16458
+ gf180mcu_fd_sc_mcu9t5v0__aoi22_1
* cell instance $12075 m0 *1 1179.92,1098.72
X$12075 17537 17406 17536 17398 17521 14311 gf180mcu_fd_sc_mcu9t5v0__nand3_1
* cell instance $12076 r0 *1 1226.96,1068.48
X$12076 16021 16808 13024 16784 16653 14657 gf180mcu_fd_sc_mcu9t5v0__mux2_1
* cell instance $12077 r0 *1 1209.04,1058.4
X$12077 16309 16506 gf180mcu_fd_sc_mcu9t5v0__filltie
* cell instance $12078 r0 *1 1218,1098.72
X$12078 13473 13475 15744 17709 17521 17593 gf180mcu_fd_sc_mcu9t5v0__aoi21_1
* cell instance $12079 r0 *1 1209.04,1078.56
X$12079 16956 17123 gf180mcu_fd_sc_mcu9t5v0__filltie
* cell instance $12080 r0 *1 1215.2,1058.4
X$12080 16459 13173 16506 16309 16324 gf180mcu_fd_sc_mcu9t5v0__nor2_1
* cell instance $12081 m0 *1 1231.44,1088.64
X$12081 17254 14820 17123 17289 17255 gf180mcu_fd_sc_mcu9t5v0__nand2_1
* cell instance $12082 r0 *1 1228.08,1088.64
X$12082 14820 16022 17255 17398 17289 17411 gf180mcu_fd_sc_mcu9t5v0__oai21_1
* cell instance $12083 m0 *1 1212.96,1058.4
X$12083 13170 13173 16324 16194 16309 5910 gf180mcu_fd_sc_mcu9t5v0__aoi21_1
* cell instance $12084 r0 *1 1209.04,1098.72
X$12084 17521 17709 gf180mcu_fd_sc_mcu9t5v0__filltie
* cell instance $12085 m0 *1 1210.16,1078.56
X$12085 14677 16925 16922 13331 16784 16956 gf180mcu_fd_sc_mcu9t5v0__dffrnq_2
* cell instance $12086 r0 *1 1209.04,1068.48
X$12086 16653 16784 gf180mcu_fd_sc_mcu9t5v0__filltie
* cell instance $12087 m0 *1 1190.56,1078.56
X$12087 14677 16924 16970 13331 16784 16956 gf180mcu_fd_sc_mcu9t5v0__dffrnq_2
* cell instance $12088 r0 *1 1213.52,1098.72
X$12088 14820 17593 17594 17709 17521 17592 gf180mcu_fd_sc_mcu9t5v0__oai21_1
* cell instance $12089 m0 *1 1201.76,1098.72
X$12089 14677 17409 17297 13331 17398 17521 gf180mcu_fd_sc_mcu9t5v0__dffrnq_2
* cell instance $12090 r0 *1 1188.88,1088.64
X$12090 17254 13212 13464 17297 17398 17289 17406
+ gf180mcu_fd_sc_mcu9t5v0__aoi22_1
* cell instance $12091 r0 *1 1205.68,1058.4
X$12091 16459 13024 16506 16309 16323 gf180mcu_fd_sc_mcu9t5v0__nor2_1
* cell instance $12092 r0 *1 1210.16,1088.64
X$12092 17297 14820 17398 17289 17410 gf180mcu_fd_sc_mcu9t5v0__nand2_1
* cell instance $12093 r0 *1 1204.56,1088.64
X$12093 14820 15747 17410 17398 17289 17409 gf180mcu_fd_sc_mcu9t5v0__oai21_1
* cell instance $12094 r0 *1 1184.96,1058.4
X$12094 16322 16458 16506 16309 16305 gf180mcu_fd_sc_mcu9t5v0__nand2_1
* cell instance $12095 r0 *1 1136.8,1048.32
X$12095 13479 13728 13475 16194 16008 16160 gf180mcu_fd_sc_mcu9t5v0__mux2_1
* cell instance $12096 r0 *1 1132.32,1098.72
X$12096 17588 16160 13214 17709 17521 17721 gf180mcu_fd_sc_mcu9t5v0__mux2_1
* cell instance $12097 m0 *1 1111.04,1048.32
X$12097 14182 15866 16019 13331 15898 16008 gf180mcu_fd_sc_mcu9t5v0__dffrnq_2
* cell instance $12098 r0 *1 1145.2,1088.64
X$12098 14673 13475 15744 17398 17289 17252 gf180mcu_fd_sc_mcu9t5v0__aoi21_1
* cell instance $12099 r0 *1 1110.48,1098.72
X$12099 13172 13898 13475 17709 17521 17533 gf180mcu_fd_sc_mcu9t5v0__mux2_1
* cell instance $12100 r0 *1 1160.88,1058.4
X$12100 13171 16159 13475 16506 16309 16321 gf180mcu_fd_sc_mcu9t5v0__mux2_1
* cell instance $12101 m0 *1 1131.2,1068.48
X$12101 14189 14657 16506 16653 16673 gf180mcu_fd_sc_mcu9t5v0__or2_1
* cell instance $12102 r0 *1 1125.04,1068.48
X$12102 16800 16799 16784 16653 16782 gf180mcu_fd_sc_mcu9t5v0__nand2_1
* cell instance $12103 r0 *1 1149.12,1078.56
X$12103 16975 14820 17123 16956 17131 gf180mcu_fd_sc_mcu9t5v0__nand2_1
* cell instance $12104 r0 *1 1163.12,1048.32
X$12104 16162 16321 13214 16194 16008 16161 gf180mcu_fd_sc_mcu9t5v0__mux2_1
* cell instance $12105 r0 *1 1132.88,1068.48
X$12105 13895 16922 13591 16673 16784 16653 16801
+ gf180mcu_fd_sc_mcu9t5v0__oai211_1
* cell instance $12106 m0 *1 1142.96,1088.64
X$12106 14820 17252 17131 17123 17289 17253 gf180mcu_fd_sc_mcu9t5v0__oai21_1
* cell instance $12107 m0 *1 1149.12,1068.48
X$12107 16672 9845 13895 16506 16653 16527 gf180mcu_fd_sc_mcu9t5v0__mux2_1
* cell instance $12108 m0 *1 1147.44,1058.4
X$12108 16320 4967 13895 16194 16309 16319 gf180mcu_fd_sc_mcu9t5v0__mux2_1
* cell instance $12109 m0 *1 1144.08,1068.48
X$12109 13465 16527 16319 13208 16506 16653 16803
+ gf180mcu_fd_sc_mcu9t5v0__aoi22_1
* cell instance $12110 r0 *1 1138.48,1068.48
X$12110 16802 15868 16801 16803 16784 16653 16969
+ gf180mcu_fd_sc_mcu9t5v0__oai211_1
* cell instance $12111 m0 *1 1118.32,1098.72
X$12111 7790 17245 17993 14189 13902 17398 17521 17251
+ gf180mcu_fd_sc_mcu9t5v0__aoi221_1
* cell instance $12112 r0 *1 1165.92,1038.24
X$12112 15746 16153 14825 15870 15898 15737 15701
+ gf180mcu_fd_sc_mcu9t5v0__aoi22_1
* cell instance $12113 r0 *1 1158.64,1038.24
X$12113 15406 15869 13024 15898 15737 13906 gf180mcu_fd_sc_mcu9t5v0__mux2_1
* cell instance $12114 m0 *1 1167.6,1098.72
X$12114 14715 16153 16921 17591 17398 17521 17535
+ gf180mcu_fd_sc_mcu9t5v0__aoi22_1
* cell instance $12115 r0 *1 1137.92,1038.24
X$12115 14189 8340 13433 15898 15737 15868 gf180mcu_fd_sc_mcu9t5v0__oai21_1
* cell instance $12116 r0 *1 1114.96,1038.24
X$12116 14820 15865 15867 15898 15737 15866 gf180mcu_fd_sc_mcu9t5v0__oai21_1
* cell instance $12117 r0 *1 1109.36,1068.48
X$12117 13895 16970 16784 16653 16671 gf180mcu_fd_sc_mcu9t5v0__nor2_1
* cell instance $12118 r0 *1 1126.16,1048.32
X$12118 16019 13057 13895 16194 16008 16157 gf180mcu_fd_sc_mcu9t5v0__mux2_1
* cell instance $12119 r0 *1 1154.16,1098.72
X$12119 15870 13433 17718 17589 17709 17521 17527
+ gf180mcu_fd_sc_mcu9t5v0__aoi22_1
* cell instance $12120 r0 *1 1157.52,1068.48
X$12120 16159 16804 13024 16784 16653 9845 gf180mcu_fd_sc_mcu9t5v0__mux2_1
* cell instance $12121 m0 *1 1108.8,1068.48
X$12121 14189 13023 13464 16506 16653 16670 gf180mcu_fd_sc_mcu9t5v0__oai21_1
* cell instance $12122 m0 *1 1145.2,1078.56
X$12122 13895 16975 16784 16956 16802 gf180mcu_fd_sc_mcu9t5v0__nor2_1
* cell instance $12123 r0 *1 1118.88,1048.32
X$12123 13898 16159 13024 16194 16008 10677 gf180mcu_fd_sc_mcu9t5v0__mux2_1
* cell instance $12124 r0 *1 1159.2,1098.72
X$12124 17590 14825 14865 17588 17709 17521 17534
+ gf180mcu_fd_sc_mcu9t5v0__aoi22_1
* cell instance $12125 m0 *1 1162.56,1098.72
X$12125 17535 17534 17398 17521 17396 gf180mcu_fd_sc_mcu9t5v0__nand2_1
* cell instance $12126 m0 *1 1141.84,1048.32
X$12126 15869 14673 13024 15898 16008 8340 gf180mcu_fd_sc_mcu9t5v0__mux2_1
* cell instance $12127 m0 *1 1136.8,1048.32
X$12127 13479 13475 15147 15898 16008 15902 gf180mcu_fd_sc_mcu9t5v0__aoi21_1
* cell instance $12128 r0 *1 1127.84,1068.48
X$12128 16525 14865 16921 16672 16784 16653 16800
+ gf180mcu_fd_sc_mcu9t5v0__aoi22_1
* cell instance $12129 m0 *1 1117.2,1068.48
X$12129 14671 13475 14822 16506 16653 16451 gf180mcu_fd_sc_mcu9t5v0__aoi21_1
* cell instance $12130 m0 *1 1123.92,1078.56
X$12130 16922 16153 14825 16973 16784 16956 16799
+ gf180mcu_fd_sc_mcu9t5v0__aoi22_1
* cell instance $12131 r0 *1 1116.08,1048.32
X$12131 16019 14820 16194 16008 15867 gf180mcu_fd_sc_mcu9t5v0__nand2_1
* cell instance $12132 r0 *1 1126.72,1088.64
X$12132 17296 17398 17289 13436 gf180mcu_fd_sc_mcu9t5v0__buf_8
* cell instance $12133 r0 *1 1153.04,1078.56
X$12133 16975 14825 14865 16320 17123 16956 17130
+ gf180mcu_fd_sc_mcu9t5v0__aoi22_1
* cell instance $12134 m0 *1 1112.72,1078.56
X$12134 13895 16973 13434 16784 16956 16798 gf180mcu_fd_sc_mcu9t5v0__oai21_1
* cell instance $12135 m0 *1 1147.44,1088.64
X$12135 18153 17253 16975 13331 17123 17289 gf180mcu_fd_sc_mcu9t5v0__dffrnq_2
* cell instance $12136 r0 *1 1116.08,1088.64
X$12136 14671 14670 13475 17398 17289 17405 gf180mcu_fd_sc_mcu9t5v0__mux2_1
* cell instance $12137 m0 *1 1122.8,1088.64
X$12137 14019 18992 13900 17251 17123 17289 17296
+ gf180mcu_fd_sc_mcu9t5v0__aoi22_1
* cell instance $12138 r0 *1 1122.8,1028.16
X$12138 15408 13475 14822 15576 15402 15865 gf180mcu_fd_sc_mcu9t5v0__aoi21_1
* cell instance $12139 r0 *1 1147.44,967.68
X$12139 13729 14131 13024 13832 13719 7069 gf180mcu_fd_sc_mcu9t5v0__mux2_1
* cell instance $12140 r0 *1 1131.76,967.68
X$12140 13728 13897 13024 13832 13719 2257 gf180mcu_fd_sc_mcu9t5v0__mux2_1
* cell instance $12141 r0 *1 1135.12,1028.16
X$12141 14182 15410 15283 13331 15576 15402 gf180mcu_fd_sc_mcu9t5v0__dffrnq_2
* cell instance $12142 r0 *1 1116.64,997.92
X$12142 14455 14668 13024 14708 14448 14012 gf180mcu_fd_sc_mcu9t5v0__mux2_1
* cell instance $12143 m0 *1 1150.8,977.76
X$12143 11299 12632 13832 14009 13905 gf180mcu_fd_sc_mcu9t5v0__nand2_1
* cell instance $12144 m0 *1 1126.72,977.76
X$12144 13895 13593 13832 14009 13900 gf180mcu_fd_sc_mcu9t5v0__nand2_1
* cell instance $12145 m0 *1 1107.68,977.76
X$12145 13895 13592 13832 14009 13896 gf180mcu_fd_sc_mcu9t5v0__nand2_1
* cell instance $12146 m0 *1 1117.76,977.76
X$12146 5899 13891 13832 14009 13899 gf180mcu_fd_sc_mcu9t5v0__nand2_1
* cell instance $12147 m0 *1 1158.64,977.76
X$12147 11299 17245 14014 6406 10061 13907 13832 14009 14134
+ gf180mcu_fd_sc_mcu9t5v0__aoi222_1
* cell instance $12148 m0 *1 1133.44,977.76
X$12148 5280 13891 13832 14009 13903 gf180mcu_fd_sc_mcu9t5v0__nand2_1
* cell instance $12149 m0 *1 1129.52,977.76
X$12149 13904 13903 13901 13832 14009 13902 gf180mcu_fd_sc_mcu9t5v0__nand3_1
* cell instance $12150 m0 *1 1110.48,977.76
X$12150 14015 13898 13024 13832 14009 7951 gf180mcu_fd_sc_mcu9t5v0__mux2_1
* cell instance $12151 m0 *1 1147.44,997.92
X$12151 13904 14183 14406 14448 14445 gf180mcu_fd_sc_mcu9t5v0__nand2_1
* cell instance $12152 m0 *1 1167.04,987.84
X$12152 14186 14185 14126 14304 14183 gf180mcu_fd_sc_mcu9t5v0__nand2_1
* cell instance $12153 r0 *1 1135.12,997.92
X$12153 14672 14670 13024 14708 14448 12909 gf180mcu_fd_sc_mcu9t5v0__mux2_1
* cell instance $12154 m0 *1 1149.68,987.84
X$12154 14313 14456 13905 14126 14304 14184 gf180mcu_fd_sc_mcu9t5v0__oai21_1
* cell instance $12155 m0 *1 1168.72,1028.16
X$12155 13895 5910 15271 15402 15411 gf180mcu_fd_sc_mcu9t5v0__nand2_1
* cell instance $12156 r0 *1 1154.16,1028.16
X$12156 13433 13906 14307 13434 15576 15402 15535
+ gf180mcu_fd_sc_mcu9t5v0__aoi22_1
* cell instance $12157 r0 *1 1164.24,1028.16
X$12157 13895 15283 13212 15411 15576 15402 15588
+ gf180mcu_fd_sc_mcu9t5v0__oai211_1
* cell instance $12158 r0 *1 1154.16,987.84
X$12158 3816 14406 14304 12268 gf180mcu_fd_sc_mcu9t5v0__clkbuf_8
* cell instance $12159 m0 *1 1126.72,987.84
X$12159 14180 14179 13024 14126 14304 13200 gf180mcu_fd_sc_mcu9t5v0__mux2_1
* cell instance $12160 r0 *1 1145.2,977.76
X$12160 14182 14184 11299 13331 14126 14009 gf180mcu_fd_sc_mcu9t5v0__dffrnq_2
* cell instance $12161 r0 *1 1115.52,1028.16
X$12161 14668 15407 13024 15576 15402 13324 gf180mcu_fd_sc_mcu9t5v0__mux2_1
* cell instance $12162 r0 *1 1151.92,997.92
X$12162 14420 14672 13475 14708 14448 14714 gf180mcu_fd_sc_mcu9t5v0__mux2_1
* cell instance $12163 m0 *1 1151.92,1008
X$12163 14715 14714 13214 14708 14857 14863 gf180mcu_fd_sc_mcu9t5v0__mux2_1
* cell instance $12164 r0 *1 1126.72,997.92
X$12164 14671 14669 13024 14708 14448 14178 gf180mcu_fd_sc_mcu9t5v0__mux2_1
* cell instance $12165 r0 *1 1116.08,1018.08
X$12165 14669 14455 13475 15271 15138 15144 gf180mcu_fd_sc_mcu9t5v0__mux2_1
* cell instance $12166 m0 *1 1114.96,1028.16
X$12166 15408 14668 13475 15271 15402 15281 gf180mcu_fd_sc_mcu9t5v0__mux2_1
* cell instance $12167 r0 *1 1106,977.76
X$12167 14019 14443 13896 14453 14126 14009 13019
+ gf180mcu_fd_sc_mcu9t5v0__aoi22_1
* cell instance $12168 r0 *1 1108.8,987.84
X$12168 14310 14454 13024 14406 14304 8093 gf180mcu_fd_sc_mcu9t5v0__mux2_1
* cell instance $12169 r0 *1 1117.2,977.76
X$12169 13904 13899 14134 14126 14009 16154 gf180mcu_fd_sc_mcu9t5v0__nand3_1
* cell instance $12170 r0 *1 1146.88,1008
X$12170 14182 14863 14715 13331 14967 14857 gf180mcu_fd_sc_mcu9t5v0__dffrnq_2
* cell instance $12171 m0 *1 1136.24,997.92
X$12171 14454 15406 13024 14406 14448 8343 gf180mcu_fd_sc_mcu9t5v0__mux2_1
* cell instance $12172 m0 *1 1134,987.84
X$12172 14181 14180 13024 14126 14304 13449 gf180mcu_fd_sc_mcu9t5v0__mux2_1
* cell instance $12173 m0 *1 1134,1028.16
X$12173 13172 13475 15534 15271 15402 15409 gf180mcu_fd_sc_mcu9t5v0__aoi21_1
* cell instance $12174 m0 *1 1115.52,997.92
X$12174 14670 14455 13024 14406 14448 13727 gf180mcu_fd_sc_mcu9t5v0__mux2_1
* cell instance $12175 r0 *1 1159.2,1028.16
X$12175 15152 14865 16921 15283 15576 15402 15587
+ gf180mcu_fd_sc_mcu9t5v0__aoi22_1
* cell instance $12176 m0 *1 1144.64,1028.16
X$12176 15283 14820 15271 15402 15282 gf180mcu_fd_sc_mcu9t5v0__nand2_1
* cell instance $12177 r0 *1 1144.64,997.92
X$12177 14673 14181 13024 14708 14448 8342 gf180mcu_fd_sc_mcu9t5v0__mux2_1
* cell instance $12178 r0 *1 1132.32,1008
X$12178 14420 13475 14822 14967 14857 16974 gf180mcu_fd_sc_mcu9t5v0__aoi21_1
* cell instance $12179 m0 *1 1138.48,1028.16
X$12179 14820 15409 15282 15271 15402 15410 gf180mcu_fd_sc_mcu9t5v0__oai21_1
* cell instance $12180 r0 *1 1169.84,1028.16
X$12180 15284 15588 15740 15576 15402 15536 gf180mcu_fd_sc_mcu9t5v0__nand3_1
* cell instance $12181 m0 *1 1154.16,987.84
X$12181 12268 14126 14304 gf180mcu_fd_sc_mcu9t5v0__clkinv_8
* cell instance $12182 r0 *1 1130.64,1018.08
X$12182 14669 15408 13024 15271 15138 13057 gf180mcu_fd_sc_mcu9t5v0__mux2_1
* cell instance $12183 m0 *1 1170.4,1008
X$12183 4770 13891 14708 14857 14823 gf180mcu_fd_sc_mcu9t5v0__nand2_1
* cell instance $12184 m0 *1 1120.56,1008
X$12184 14669 13475 14822 14708 14857 14666 gf180mcu_fd_sc_mcu9t5v0__aoi21_1
* cell instance $12185 m0 *1 1169.84,987.84
X$12185 13895 13594 14126 14304 14186 gf180mcu_fd_sc_mcu9t5v0__nand2_1
* cell instance $12186 r0 *1 1111.6,1008
X$12186 14862 14820 14967 14857 14667 gf180mcu_fd_sc_mcu9t5v0__nand2_1
* cell instance $12187 r0 *1 1110.48,997.92
X$12187 14820 14666 14667 14708 14448 14665 gf180mcu_fd_sc_mcu9t5v0__oai21_1
* cell instance $12188 m0 *1 1191.68,1018.08
X$12188 14674 16153 14865 14462 14967 15138 15018
+ gf180mcu_fd_sc_mcu9t5v0__aoi22_1
* cell instance $12189 r0 *1 1209.04,1028.16
X$12189 15402 15576 gf180mcu_fd_sc_mcu9t5v0__filltie
* cell instance $12190 m0 *1 1186.64,1028.16
X$12190 14189 5275 13461 15271 15402 15538 gf180mcu_fd_sc_mcu9t5v0__oai21_1
* cell instance $12191 r0 *1 1189.44,997.92
X$12191 14462 13461 13465 14675 14708 14448 14460
+ gf180mcu_fd_sc_mcu9t5v0__aoi22_1
* cell instance $12192 r0 *1 1209.04,977.76
X$12192 14009 14126 gf180mcu_fd_sc_mcu9t5v0__filltie
* cell instance $12193 m0 *1 1177.12,1018.08
X$12193 13895 10352 14967 15138 15151 gf180mcu_fd_sc_mcu9t5v0__nand2_1
* cell instance $12194 m0 *1 1188.88,1018.08
X$12194 14980 15018 14967 15138 15007 gf180mcu_fd_sc_mcu9t5v0__nand2_1
* cell instance $12195 r0 *1 1187.76,977.76
X$12195 14187 14024 14022 14023 14126 14009 14135
+ gf180mcu_fd_sc_mcu9t5v0__and4_1
* cell instance $12196 r0 *1 1214.64,1018.08
X$12196 15285 15271 15138 11196 gf180mcu_fd_sc_mcu9t5v0__clkinv_1
* cell instance $12197 m0 *1 1219.68,1028.16
X$12197 15414 14826 13024 15271 15402 13437 gf180mcu_fd_sc_mcu9t5v0__mux2_1
* cell instance $12198 m0 *1 1211.84,1028.16
X$12198 15408 15413 13024 15271 15402 15285 gf180mcu_fd_sc_mcu9t5v0__mux2_1
* cell instance $12199 r0 *1 1209.04,987.84
X$12199 14304 14406 gf180mcu_fd_sc_mcu9t5v0__filltie
* cell instance $12200 m0 *1 1232,1028.16
X$12200 13175 13475 15534 15271 15402 16022 gf180mcu_fd_sc_mcu9t5v0__aoi21_1
* cell instance $12201 m0 *1 1182.16,977.76
X$12201 11192 13907 13469 13208 14019 13832 14009 14023
+ gf180mcu_fd_sc_mcu9t5v0__aoi221_1
* cell instance $12202 m0 *1 1212.4,977.76
X$12202 12758 13475 13832 14009 14822 gf180mcu_fd_sc_mcu9t5v0__nor2_1
* cell instance $12203 m0 *1 1233.68,1008
X$12203 13175 13695 13475 14708 14857 14867 gf180mcu_fd_sc_mcu9t5v0__mux2_1
* cell instance $12204 m0 *1 1233.68,1018.08
X$12204 14675 14867 13214 14967 15138 14981 gf180mcu_fd_sc_mcu9t5v0__mux2_1
* cell instance $12205 r0 *1 1227.52,987.84
X$12205 14420 14671 13024 14406 14304 13471 gf180mcu_fd_sc_mcu9t5v0__mux2_1
* cell instance $12206 m0 *1 1177.12,977.76
X$12206 10687 17245 13907 12140 13832 14009 14020
+ gf180mcu_fd_sc_mcu9t5v0__aoi22_1
* cell instance $12207 r0 *1 1209.04,997.92
X$12207 14448 14708 gf180mcu_fd_sc_mcu9t5v0__filltie
* cell instance $12208 m0 *1 1216.32,997.92
X$12208 13473 14181 13475 14406 14448 14465 gf180mcu_fd_sc_mcu9t5v0__mux2_1
* cell instance $12209 m0 *1 1209.04,997.92
X$12209 14459 14465 13214 14406 14448 14676 gf180mcu_fd_sc_mcu9t5v0__mux2_1
* cell instance $12210 r0 *1 1209.04,1008
X$12210 14857 14967 gf180mcu_fd_sc_mcu9t5v0__filltie
* cell instance $12211 r0 *1 1178.8,1028.16
X$12211 15538 15535 14189 15576 15402 15537 gf180mcu_fd_sc_mcu9t5v0__aoi21_1
* cell instance $12212 m0 *1 1210.16,987.84
X$12212 5433 14014 14126 14304 14136 gf180mcu_fd_sc_mcu9t5v0__nand2_1
* cell instance $12213 r0 *1 1197.28,977.76
X$12213 13904 14136 13908 14126 14009 14021 gf180mcu_fd_sc_mcu9t5v0__nand3_1
* cell instance $12214 r0 *1 1210.16,997.92
X$12214 14677 14676 14459 13331 14708 14448 gf180mcu_fd_sc_mcu9t5v0__dffrnq_2
* cell instance $12215 r0 *1 1184.4,997.92
X$12215 14459 13434 13591 14674 14708 14448 14458
+ gf180mcu_fd_sc_mcu9t5v0__aoi22_1
* cell instance $12216 m0 *1 1193.36,997.92
X$12216 14463 13212 13433 14028 14406 14448 14461
+ gf180mcu_fd_sc_mcu9t5v0__aoi22_1
* cell instance $12217 r0 *1 1225.28,977.76
X$12217 14420 14027 13173 14126 14009 13694 gf180mcu_fd_sc_mcu9t5v0__mux2_1
* cell instance $12218 m0 *1 1190,1008
X$12218 14028 14825 16921 14463 14708 14857 14824
+ gf180mcu_fd_sc_mcu9t5v0__aoi22_1
* cell instance $12219 m0 *1 1195.04,1008
X$12219 14025 16153 14865 13213 14708 14857 14866
+ gf180mcu_fd_sc_mcu9t5v0__aoi22_1
* cell instance $12220 r0 *1 1196.72,1008
X$12220 14824 14866 14967 14857 14859 gf180mcu_fd_sc_mcu9t5v0__nand2_1
* cell instance $12221 r0 *1 1187.76,1028.16
X$12221 15745 15540 15576 15402 14464 gf180mcu_fd_sc_mcu9t5v0__nor2_1
* cell instance $12222 m0 *1 1206.24,1028.16
X$12222 14189 15285 13464 15271 15402 15412 gf180mcu_fd_sc_mcu9t5v0__oai21_1
* cell instance $12223 r0 *1 1209.04,1018.08
X$12223 15138 15271 gf180mcu_fd_sc_mcu9t5v0__filltie
* cell instance $12224 m0 *1 1189.44,997.92
X$12224 14458 14461 14460 14406 14448 14188 gf180mcu_fd_sc_mcu9t5v0__nand3_1
* cell instance $12225 m0 *1 1189.44,987.84
X$12225 14189 14188 14126 14304 14187 gf180mcu_fd_sc_mcu9t5v0__nand2_1
* cell instance $12226 m0 *1 1214.08,1008
X$12226 14826 14672 13024 14708 14857 13841 gf180mcu_fd_sc_mcu9t5v0__mux2_1
* cell instance $12227 r0 *1 1210.16,977.76
X$12227 13909 14025 14189 14126 14009 14026 gf180mcu_fd_sc_mcu9t5v0__mux2_1
* cell instance $12228 r0 *1 1229.76,1018.08
X$12228 11363 13475 15271 15138 15534 gf180mcu_fd_sc_mcu9t5v0__nor2_1
* cell instance $12229 r0 *1 1226.96,1028.16
X$12229 15413 15414 13024 15576 15402 13023 gf180mcu_fd_sc_mcu9t5v0__mux2_1
* cell instance $12230 r0 *1 1217.44,977.76
X$12230 13909 14126 14009 12758 gf180mcu_fd_sc_mcu9t5v0__clkinv_1
* cell instance $12231 r0 *1 1201.2,977.76
X$12231 8573 13891 14026 13464 14014 9859 14126 14009 14024
+ gf180mcu_fd_sc_mcu9t5v0__aoi222_1
* cell instance $12232 r0 *1 1184.96,977.76
X$12232 5284 17245 14126 14009 14022 gf180mcu_fd_sc_mcu9t5v0__nand2_1
* cell instance $12233 r0 *1 1210.16,1018.08
X$12233 14027 13475 14822 15271 15138 15747 gf180mcu_fd_sc_mcu9t5v0__aoi21_1
* cell instance $12234 r0 *1 1191.68,1008
X$12234 14459 14825 16921 14675 14967 14857 14980
+ gf180mcu_fd_sc_mcu9t5v0__aoi22_1
* cell instance $12235 r0 *1 1183.28,1028.16
X$12235 15539 15537 15536 15576 15402 15540 gf180mcu_fd_sc_mcu9t5v0__nor3_1
* cell instance $12236 m0 *1 1233.12,977.76
X$12236 14027 13909 13173 13832 14009 13329 gf180mcu_fd_sc_mcu9t5v0__mux2_1
* cell instance $12237 r0 *1 1209.04,967.68
X$12237 13719 13832 gf180mcu_fd_sc_mcu9t5v0__filltie
* cell instance $12238 r0 *1 1228.64,967.68
X$12238 13595 13832 13719 8981 gf180mcu_fd_sc_mcu9t5v0__clkinv_1
* cell instance $12239 r0 *1 1202.32,967.68
X$12239 5164 13891 13907 12141 13832 13719 13908
+ gf180mcu_fd_sc_mcu9t5v0__aoi22_1
* cell instance $12240 r0 *1 1210.16,967.68
X$12240 6569 14014 13907 10699 13832 13719 13901
+ gf180mcu_fd_sc_mcu9t5v0__aoi22_1
* cell instance $12241 r0 *1 1177.12,967.68
X$12241 4946 13891 14014 5062 13832 13719 13842 gf180mcu_fd_sc_mcu9t5v0__aoi22_1
* cell instance $12242 r0 *1 1176.56,977.76
X$12242 13842 14020 14126 14009 14312 gf180mcu_fd_sc_mcu9t5v0__nand2_1
* cell instance $12243 r0 *1 1221.92,977.76
X$12243 8981 13475 14126 14009 15744 gf180mcu_fd_sc_mcu9t5v0__nor2_1
* cell instance $12244 r0 *1 1149.68,897.12
X$12244 11842 10349 11728 10581 2987 3106 11971 11860 11987
+ gf180mcu_fd_sc_mcu9t5v0__mux4_1
* cell instance $12245 r0 *1 1170.96,887.04
X$12245 11729 2786 4949 11730 11720 11600 11577 gf180mcu_fd_sc_mcu9t5v0__aoi22_1
* cell instance $12246 r0 *1 1172.08,876.96
X$12246 5902 11576 11362 11461 11294 11297 gf180mcu_fd_sc_mcu9t5v0__aoi21_1
* cell instance $12247 r0 *1 1170.4,856.8
X$12247 10853 4493 10971 4491 10852 10833 10714 10972
+ gf180mcu_fd_sc_mcu9t5v0__oai221_1
* cell instance $12248 m0 *1 1170.96,887.04
X$12248 10973 4254 4252 10462 11461 11600 11578 gf180mcu_fd_sc_mcu9t5v0__aoi22_1
* cell instance $12249 r0 *1 1173.76,897.12
X$12249 11578 11988 11971 11860 11989 gf180mcu_fd_sc_mcu9t5v0__nand2_1
* cell instance $12250 r0 *1 1211.84,897.12
X$12250 6973 11990 11731 11971 11860 11847 gf180mcu_fd_sc_mcu9t5v0__aoi21_1
* cell instance $12251 r0 *1 1209.04,897.12
X$12251 11860 11971 gf180mcu_fd_sc_mcu9t5v0__filltie
* cell instance $12252 r0 *1 1181.6,897.12
X$12252 12268 11864 11729 11971 11860 gf180mcu_fd_sc_mcu9t5v0__dffq_2
* cell instance $12253 r0 *1 1167.04,947.52
X$12253 13212 2688 13329 13464 8453 13208 13318 13160 13211
+ gf180mcu_fd_sc_mcu9t5v0__aoi222_1
* cell instance $12254 m0 *1 1165.92,927.36
X$12254 10973 12028 11729 11730 2987 3459 12508 12646 12790
+ gf180mcu_fd_sc_mcu9t5v0__mux4_1
* cell instance $12255 r0 *1 1165.92,917.28
X$12255 10973 12028 11729 11730 3120 3239 12508 12253 12400
+ gf180mcu_fd_sc_mcu9t5v0__mux4_1
* cell instance $12256 m0 *1 1169.28,866.88
X$12256 10578 10972 10973 10833 11079 gf180mcu_fd_sc_mcu9t5v0__dffq_2
* cell instance $12257 m0 *1 1163.68,876.96
X$12257 12135 11181 11294 10460 gf180mcu_fd_sc_mcu9t5v0__buf_8
* cell instance $12258 r0 *1 1167.6,897.12
X$12258 10349 4258 4275 11730 11971 11860 11988 gf180mcu_fd_sc_mcu9t5v0__aoi22_1
* cell instance $12259 r0 *1 1173.76,957.6
X$12259 13171 13695 13024 13586 13428 2148 gf180mcu_fd_sc_mcu9t5v0__mux2_1
* cell instance $12260 r0 *1 1225.28,897.12
X$12260 10578 11850 11615 11971 11860 gf180mcu_fd_sc_mcu9t5v0__dffq_2
* cell instance $12261 r0 *1 1173.2,937.44
X$12261 12268 13021 12028 13054 12900 gf180mcu_fd_sc_mcu9t5v0__dffq_2
* cell instance $12262 m0 *1 1236.48,957.6
X$12262 13467 13318 13428 7935 gf180mcu_fd_sc_mcu9t5v0__clkinv_1
* cell instance $12263 m0 *1 1237.04,937.44
X$12263 7800 12792 12793 12785 12900 12405 gf180mcu_fd_sc_mcu9t5v0__oai21_1
* cell instance $12264 r0 *1 1210.16,907.2
X$12264 5766 12136 12137 12404 12128 12019 11990
+ gf180mcu_fd_sc_mcu9t5v0__oai31_1
* cell instance $12265 r0 *1 1236.48,917.28
X$12265 5667 9330 12405 12508 12253 12275 gf180mcu_fd_sc_mcu9t5v0__aoi21_1
* cell instance $12266 m0 *1 1235.36,917.28
X$12266 8453 9856 11607 7685 12128 12253 12277 gf180mcu_fd_sc_mcu9t5v0__nor4_1
* cell instance $12267 r0 *1 1230.32,957.6
X$12267 13474 13473 13173 13586 13428 13328 gf180mcu_fd_sc_mcu9t5v0__mux2_1
* cell instance $12268 r0 *1 1219.68,907.2
X$12268 9112 5667 11195 12128 12019 12138 gf180mcu_fd_sc_mcu9t5v0__and3_1
* cell instance $12269 r0 *1 1203.44,907.2
X$12269 9709 5667 11195 12128 12019 12136 gf180mcu_fd_sc_mcu9t5v0__and3_1
* cell instance $12270 r0 *1 1212.96,957.6
X$12270 13433 13472 13471 13464 13586 13428 13590
+ gf180mcu_fd_sc_mcu9t5v0__aoi22_1
* cell instance $12271 r0 *1 1235.92,927.36
X$12271 12759 8452 11084 12785 12646 12276 gf180mcu_fd_sc_mcu9t5v0__aoi21_1
* cell instance $12272 m0 *1 1234.24,937.44
X$12272 12759 7800 12785 12900 12793 gf180mcu_fd_sc_mcu9t5v0__nand2_1
* cell instance $12273 m0 *1 1233.68,947.52
X$12273 12792 13329 8452 13054 13160 8568 gf180mcu_fd_sc_mcu9t5v0__mux2_1
* cell instance $12274 r0 *1 1211.84,917.28
X$12274 12651 7800 5667 11195 11084 12508 12253 12137
+ gf180mcu_fd_sc_mcu9t5v0__aoi221_1
* cell instance $12275 m0 *1 1191.12,917.28
X$12275 6919 9330 12135 12128 12253 12271 gf180mcu_fd_sc_mcu9t5v0__aoi21_1
* cell instance $12276 r0 *1 1209.04,937.44
X$12276 12900 13054 gf180mcu_fd_sc_mcu9t5v0__filltie
* cell instance $12277 m0 *1 1229.76,957.6
X$12277 13694 13318 13428 10976 gf180mcu_fd_sc_mcu9t5v0__clkinv_1
* cell instance $12278 m0 *1 1212.96,937.44
X$12278 8452 12792 12785 12900 11084 gf180mcu_fd_sc_mcu9t5v0__nor2_4
* cell instance $12279 m0 *1 1209.04,957.6
X$12279 12268 13330 13213 13331 13318 13428 gf180mcu_fd_sc_mcu9t5v0__dffrnq_2
* cell instance $12280 r0 *1 1194.48,917.28
X$12280 9820 6557 7685 12508 12253 12403 gf180mcu_fd_sc_mcu9t5v0__nor3_1
* cell instance $12281 r0 *1 1230.32,937.44
X$12281 13471 13054 12900 12759 gf180mcu_fd_sc_mcu9t5v0__clkinv_1
* cell instance $12282 r0 *1 1223.04,927.36
X$12282 12651 8452 11084 12785 12646 12653 gf180mcu_fd_sc_mcu9t5v0__aoi21_1
* cell instance $12283 r0 *1 1186.08,917.28
X$12283 11192 9333 12508 12253 12402 gf180mcu_fd_sc_mcu9t5v0__nand2_1
* cell instance $12284 m0 *1 1234.24,957.6
X$12284 13328 13318 13428 7804 gf180mcu_fd_sc_mcu9t5v0__clkinv_1
* cell instance $12285 r0 *1 1188.88,917.28
X$12285 9333 12271 12403 12402 12508 12253 12401
+ gf180mcu_fd_sc_mcu9t5v0__oai31_1
* cell instance $12286 m0 *1 1219.68,947.52
X$12286 13437 13054 13160 10975 gf180mcu_fd_sc_mcu9t5v0__clkinv_1
* cell instance $12287 m0 *1 1184.4,937.44
X$12287 12135 11192 10054 12785 12900 13022 gf180mcu_fd_sc_mcu9t5v0__mux2_1
* cell instance $12288 r0 *1 1209.04,957.6
X$12288 13428 13586 gf180mcu_fd_sc_mcu9t5v0__filltie
* cell instance $12289 m0 *1 1178.8,947.52
X$12289 12028 13022 10053 13054 13160 13021 gf180mcu_fd_sc_mcu9t5v0__mux2_1
* cell instance $12290 r0 *1 1189.44,957.6
X$12290 8823 13212 13465 2148 13433 13595 13586 13428 13470
+ gf180mcu_fd_sc_mcu9t5v0__aoi222_1
* cell instance $12291 r0 *1 1181.6,957.6
X$12291 13461 6281 13437 13591 8342 13434 13586 13428 13696
+ gf180mcu_fd_sc_mcu9t5v0__aoi222_1
* cell instance $12292 m0 *1 1203.44,947.52
X$12292 13020 13173 13054 13160 12910 gf180mcu_fd_sc_mcu9t5v0__and2_1
* cell instance $12293 r0 *1 1202.32,937.44
X$12293 13170 13024 12910 13054 12900 3926 gf180mcu_fd_sc_mcu9t5v0__aoi21_1
* cell instance $12294 r0 *1 1209.04,907.2
X$12294 12019 12128 gf180mcu_fd_sc_mcu9t5v0__filltie
* cell instance $12295 r0 *1 1204.56,917.28
X$12295 12273 8326 12508 12253 12404 gf180mcu_fd_sc_mcu9t5v0__or2_1
* cell instance $12296 r0 *1 1209.04,917.28
X$12296 12253 12508 gf180mcu_fd_sc_mcu9t5v0__filltie
* cell instance $12297 m0 *1 1190.56,957.6
X$12297 9820 13213 14189 13318 13428 13469 gf180mcu_fd_sc_mcu9t5v0__mux2_1
* cell instance $12298 r0 *1 1213.52,947.52
X$12298 13213 9820 13214 13318 13160 13330 gf180mcu_fd_sc_mcu9t5v0__mux2_1
* cell instance $12299 r0 *1 1209.04,947.52
X$12299 13160 13318 gf180mcu_fd_sc_mcu9t5v0__filltie
* cell instance $12300 r0 *1 1232.56,937.44
X$12300 12792 13023 8452 13054 12900 11308 gf180mcu_fd_sc_mcu9t5v0__mux2_1
* cell instance $12301 r0 *1 1218,917.28
X$12301 12141 8326 12508 12253 12274 gf180mcu_fd_sc_mcu9t5v0__or2_1
* cell instance $12302 m0 *1 1225.28,917.28
X$12302 5766 12138 12275 12274 12128 12253 11849
+ gf180mcu_fd_sc_mcu9t5v0__oai31_1
* cell instance $12303 r0 *1 1209.04,927.36
X$12303 12646 12785 gf180mcu_fd_sc_mcu9t5v0__filltie
* cell instance $12304 m0 *1 1232,957.6
X$12304 13472 13318 13428 7805 gf180mcu_fd_sc_mcu9t5v0__clkinv_1
* cell instance $12305 r0 *1 1210.16,927.36
X$12305 12758 8452 11084 12785 12646 12757 gf180mcu_fd_sc_mcu9t5v0__aoi21_1
* cell instance $12306 m0 *1 1196.16,917.28
X$12306 12272 12253 12128 3816 gf180mcu_fd_sc_mcu9t5v0__clkbuf_16
* cell instance $12307 m0 *1 1195.6,937.44
X$12307 12757 12785 12900 12135 gf180mcu_fd_sc_mcu9t5v0__buf_8
* cell instance $12308 m0 *1 1174.32,907.2
X$12308 10973 12028 2891 11971 12019 11576 gf180mcu_fd_sc_mcu9t5v0__mux2_1
* cell instance $12309 r0 *1 1165.36,957.6
X$12309 13211 13466 13468 13586 13428 13594 gf180mcu_fd_sc_mcu9t5v0__nand3_1
* cell instance $12310 m0 *1 1114.4,907.2
X$12310 12027 11971 12019 10053 gf180mcu_fd_sc_mcu9t5v0__buf_8
* cell instance $12311 m0 *1 1156.4,907.2
X$12311 3351 11987 11971 12019 11844 gf180mcu_fd_sc_mcu9t5v0__nand2_1
* cell instance $12312 r0 *1 1141.84,937.44
X$12312 13058 13054 12900 7349 gf180mcu_fd_sc_mcu9t5v0__buf_8
* cell instance $12313 r0 *1 1139.04,917.28
X$12313 12268 12269 11728 12508 12253 gf180mcu_fd_sc_mcu9t5v0__dffq_2
* cell instance $12314 m0 *1 1154.72,947.52
X$12314 13171 13173 13174 13054 13160 4047 gf180mcu_fd_sc_mcu9t5v0__aoi21_1
* cell instance $12315 r0 *1 1158.64,917.28
X$12315 11730 12401 7566 12508 12253 12270 gf180mcu_fd_sc_mcu9t5v0__mux2_1
* cell instance $12316 m0 *1 1131.2,957.6
X$12316 13433 13328 13200 13434 13318 13428 13435
+ gf180mcu_fd_sc_mcu9t5v0__aoi22_1
* cell instance $12317 r0 *1 1107.68,957.6
X$12317 13460 13432 13431 13586 13428 13592 gf180mcu_fd_sc_mcu9t5v0__nand3_1
* cell instance $12318 r0 *1 1155.28,957.6
X$12318 13461 2370 13465 10043 13586 13428 13466
+ gf180mcu_fd_sc_mcu9t5v0__aoi22_1
* cell instance $12319 r0 *1 1139.6,927.36
X$12319 8086 12755 12756 12785 12646 12652 gf180mcu_fd_sc_mcu9t5v0__oai21_1
* cell instance $12320 m0 *1 1162.56,947.52
X$12320 13906 13054 13160 7801 gf180mcu_fd_sc_mcu9t5v0__clkinv_1
* cell instance $12321 r0 *1 1118.32,907.2
X$12321 11982 12128 12019 10054 gf180mcu_fd_sc_mcu9t5v0__buf_8
* cell instance $12322 m0 *1 1164.8,937.44
X$12322 3462 12790 11845 4952 12785 12900 12791
+ gf180mcu_fd_sc_mcu9t5v0__oai211_1
* cell instance $12323 m0 *1 1154.72,917.28
X$12323 12268 12270 11730 12128 12253 gf180mcu_fd_sc_mcu9t5v0__dffq_2
* cell instance $12324 r0 *1 1111.04,927.36
X$12324 13019 12785 12646 7569 gf180mcu_fd_sc_mcu9t5v0__buf_8
* cell instance $12325 m0 *1 1145.76,917.28
X$12325 12135 11728 1961 12128 12253 12269 gf180mcu_fd_sc_mcu9t5v0__mux2_1
* cell instance $12326 r0 *1 1126.16,957.6
X$12326 13461 2257 12909 13591 13586 13428 13462
+ gf180mcu_fd_sc_mcu9t5v0__aoi22_1
* cell instance $12327 r0 *1 1120,917.28
X$12327 11837 12508 12253 9333 gf180mcu_fd_sc_mcu9t5v0__buf_8
* cell instance $12328 r0 *1 1160.32,957.6
X$12328 13467 13433 13449 13434 13586 13428 13468
+ gf180mcu_fd_sc_mcu9t5v0__aoi22_1
* cell instance $12329 r0 *1 1131.2,957.6
X$12329 13209 13462 13435 13463 13586 13428 13593
+ gf180mcu_fd_sc_mcu9t5v0__nand4_1
* cell instance $12330 m0 *1 1144.08,927.36
X$12330 4916 12400 12508 12646 12756 gf180mcu_fd_sc_mcu9t5v0__or2_1
* cell instance $12331 r0 *1 1111.6,957.6
X$12331 13461 3230 13324 13591 13586 13428 13460
+ gf180mcu_fd_sc_mcu9t5v0__aoi22_1
* cell instance $12332 m0 *1 1123.92,957.6
X$12332 13433 8343 7670 13208 13318 13428 13432 gf180mcu_fd_sc_mcu9t5v0__aoi22_1
* cell instance $12333 r0 *1 1130.08,927.36
X$12333 14178 12785 12646 12651 gf180mcu_fd_sc_mcu9t5v0__clkinv_1
* cell instance $12334 r0 *1 1142.96,957.6
X$12334 13465 7069 13694 13464 13586 13428 13463
+ gf180mcu_fd_sc_mcu9t5v0__aoi22_1
* cell instance $12335 m0 *1 1118.88,947.52
X$12335 13170 13172 13024 13054 13160 5529 gf180mcu_fd_sc_mcu9t5v0__mux2_1
* cell instance $12336 m0 *1 1111.6,947.52
X$12336 13172 13171 13024 13054 13160 6286 gf180mcu_fd_sc_mcu9t5v0__mux2_1
* cell instance $12337 r0 *1 1136.8,907.2
X$12337 11843 11840 3239 12128 12019 12755 gf180mcu_fd_sc_mcu9t5v0__mux2_1
* cell instance $12338 r0 *1 1134.56,947.52
X$12338 13212 5564 9596 13208 13318 13160 13209 gf180mcu_fd_sc_mcu9t5v0__aoi22_1
* cell instance $12339 m0 *1 1159.2,947.52
X$12339 13210 13173 13054 13160 13174 gf180mcu_fd_sc_mcu9t5v0__nor2_1
* cell instance $12340 m0 *1 1137.92,947.52
X$12340 12792 13057 8452 13054 13160 13058 gf180mcu_fd_sc_mcu9t5v0__mux2_1
* cell instance $12341 m0 *1 1107.68,957.6
X$12341 13465 7951 2262 13212 13318 13428 13431 gf180mcu_fd_sc_mcu9t5v0__aoi22_1
* cell instance $12342 m0 *1 1123.92,937.44
X$12342 12789 12785 12900 8339 gf180mcu_fd_sc_mcu9t5v0__buf_8
* cell instance $12343 r0 *1 1130.08,866.88
X$12343 10462 10969 10047 9819 3120 3121 11181 11079 11840
+ gf180mcu_fd_sc_mcu9t5v0__mux4_1
* cell instance $12344 m0 *1 1136.24,897.12
X$12344 3459 10970 11720 11860 11841 gf180mcu_fd_sc_mcu9t5v0__nand2_1
* cell instance $12345 m0 *1 1157.52,836.64
X$12345 10050 9703 2472 10188 10308 10086 gf180mcu_fd_sc_mcu9t5v0__mux2_2
* cell instance $12346 r0 *1 1147.44,866.88
X$12346 11081 3340 10971 8984 11082 11181 11079 11191
+ gf180mcu_fd_sc_mcu9t5v0__oai221_1
* cell instance $12347 r0 *1 1136.24,846.72
X$12347 10578 10579 10462 10676 10570 gf180mcu_fd_sc_mcu9t5v0__dffq_2
* cell instance $12348 m0 *1 1108.24,866.88
X$12348 9549 10833 11079 5781 gf180mcu_fd_sc_mcu9t5v0__clkbuf_8
* cell instance $12349 m0 *1 1147.44,866.88
X$12349 11842 10833 11079 11081 gf180mcu_fd_sc_mcu9t5v0__clkinv_1
* cell instance $12350 m0 *1 1157.52,856.8
X$12350 10580 10581 2472 10676 10714 10724 gf180mcu_fd_sc_mcu9t5v0__mux2_2
* cell instance $12351 m0 *1 1139.04,897.12
X$12351 11728 10581 11842 10349 3120 3121 11720 11860 11843
+ gf180mcu_fd_sc_mcu9t5v0__mux4_1
* cell instance $12352 r0 *1 1140.72,887.04
X$12352 2891 11728 11720 11600 11609 gf180mcu_fd_sc_mcu9t5v0__nor2_1
* cell instance $12353 r0 *1 1145.2,887.04
X$12353 4529 10581 11720 11600 11610 gf180mcu_fd_sc_mcu9t5v0__nor2_1
* cell instance $12354 m0 *1 1128.96,887.04
X$12354 10462 2786 4949 10969 2880 11461 11600 11608
+ gf180mcu_fd_sc_mcu9t5v0__aoi221_1
* cell instance $12355 r0 *1 1134.56,887.04
X$12355 4497 11609 11610 11608 11720 11600 11361
+ gf180mcu_fd_sc_mcu9t5v0__oai31_1
* cell instance $12356 r0 *1 1117.2,866.88
X$12356 11081 10320 2891 11181 11079 11190 gf180mcu_fd_sc_mcu9t5v0__mux2_1
* cell instance $12357 r0 *1 1124.48,866.88
X$12357 10047 2786 4949 9819 11181 11079 11305 gf180mcu_fd_sc_mcu9t5v0__aoi22_1
* cell instance $12358 r0 *1 1154.16,866.88
X$12358 9820 4769 11181 11079 11082 gf180mcu_fd_sc_mcu9t5v0__nand2_1
* cell instance $12359 m0 *1 1117.2,876.96
X$12359 4497 11190 11305 2880 11181 11294 11304
+ gf180mcu_fd_sc_mcu9t5v0__oai211_1
* cell instance $12360 r0 *1 1120,876.96
X$12360 11361 11304 3103 11461 11294 11335 gf180mcu_fd_sc_mcu9t5v0__aoi21_1
* cell instance $12361 m0 *1 1146.88,876.96
X$12361 10578 11191 11842 11181 11294 gf180mcu_fd_sc_mcu9t5v0__dffq_2
* cell instance $12362 r0 *1 1153.04,846.72
X$12362 10578 10724 10581 10676 10570 gf180mcu_fd_sc_mcu9t5v0__dffq_2
* cell instance $12363 r0 *1 1111.04,887.04
X$12363 12027 11720 11600 4911 gf180mcu_fd_sc_mcu9t5v0__buf_8
* cell instance $12364 m0 *1 1158.08,897.12
X$12364 3462 11844 11841 11720 11860 11845 gf180mcu_fd_sc_mcu9t5v0__nand3_1
* cell instance $12365 r0 *1 1119.44,846.72
X$12365 10578 10577 10969 10676 10570 gf180mcu_fd_sc_mcu9t5v0__dffq_2
* cell instance $12366 m0 *1 1128.4,866.88
X$12366 10047 9819 10462 10969 2987 3106 10833 11079 10970
+ gf180mcu_fd_sc_mcu9t5v0__mux4_1
* cell instance $12367 m0 *1 1162,846.72
X$12367 10460 9820 3677 10338 10570 10580 gf180mcu_fd_sc_mcu9t5v0__mux2_2
* cell instance $12368 m0 *1 1128.4,846.72
X$12368 10460 9820 2264 10338 10570 10461 gf180mcu_fd_sc_mcu9t5v0__mux2_1
* cell instance $12369 m0 *1 1145.76,846.72
X$12369 9820 10460 2250 10338 10570 10463 gf180mcu_fd_sc_mcu9t5v0__mux2_1
* cell instance $12370 m0 *1 1121.12,846.72
X$12370 10461 10969 2373 10338 10570 10577 gf180mcu_fd_sc_mcu9t5v0__mux2_1
* cell instance $12371 m0 *1 1114.4,846.72
X$12371 10349 10338 10570 10320 gf180mcu_fd_sc_mcu9t5v0__clkinv_1
* cell instance $12372 m0 *1 1138.48,846.72
X$12372 10463 10462 2134 10338 10570 10579 gf180mcu_fd_sc_mcu9t5v0__mux2_1
* cell instance $12373 m0 *1 1164.8,866.88
X$12373 4048 10460 10833 11079 10971 gf180mcu_fd_sc_mcu9t5v0__nand2_1
* cell instance $12374 m0 *1 1227.52,866.88
X$12374 8452 10975 11084 10833 11079 9336 gf180mcu_fd_sc_mcu9t5v0__aoi21_1
* cell instance $12375 r0 *1 1209.04,876.96
X$12375 11294 11461 gf180mcu_fd_sc_mcu9t5v0__filltie
* cell instance $12376 m0 *1 1209.6,897.12
X$12376 10578 11847 11848 11720 11860 gf180mcu_fd_sc_mcu9t5v0__dffq_2
* cell instance $12377 r0 *1 1236.48,876.96
X$12377 10979 5766 11461 11294 11364 gf180mcu_fd_sc_mcu9t5v0__nand2_1
* cell instance $12378 m0 *1 1201.76,897.12
X$12378 11727 11720 11860 11195 gf180mcu_fd_sc_mcu9t5v0__buf_4
* cell instance $12379 m0 *1 1198.96,856.8
X$12379 3816 10676 10714 10578 gf180mcu_fd_sc_mcu9t5v0__clkbuf_8
* cell instance $12380 m0 *1 1196.72,856.8
X$12380 10578 10676 10714 33558 gf180mcu_fd_sc_mcu9t5v0__inv_1
* cell instance $12381 r0 *1 1193.92,856.8
X$12381 10854 10833 10714 10697 gf180mcu_fd_sc_mcu9t5v0__buf_4
* cell instance $12382 r0 *1 1177.68,866.88
X$12382 11192 4769 11181 11079 10852 gf180mcu_fd_sc_mcu9t5v0__nand2_1
* cell instance $12383 r0 *1 1176,836.64
X$12383 10578 10324 9584 10338 10308 gf180mcu_fd_sc_mcu9t5v0__dffq_2
* cell instance $12384 r0 *1 1209.04,866.88
X$12384 11079 11181 gf180mcu_fd_sc_mcu9t5v0__filltie
* cell instance $12385 m0 *1 1186.64,836.64
X$12385 4048 8824 10188 10308 10325 gf180mcu_fd_sc_mcu9t5v0__nand2_1
* cell instance $12386 r0 *1 1192.24,866.88
X$12386 7349 10974 11193 5766 11181 11079 11083
+ gf180mcu_fd_sc_mcu9t5v0__aoi211_1
* cell instance $12387 r0 *1 1224.72,836.64
X$12387 10207 10338 10308 10350 gf180mcu_fd_sc_mcu9t5v0__clkinv_1
* cell instance $12388 m0 *1 1179.92,836.64
X$12388 10205 3340 10325 8984 10326 10188 10308 10324
+ gf180mcu_fd_sc_mcu9t5v0__oai221_1
* cell instance $12389 r0 *1 1219.12,836.64
X$12389 10350 6261 6042 10338 10308 10351 gf180mcu_fd_sc_mcu9t5v0__and3_1
* cell instance $12390 r0 *1 1209.04,836.64
X$12390 10308 10338 gf180mcu_fd_sc_mcu9t5v0__filltie
* cell instance $12391 r0 *1 1192.8,876.96
X$12391 8217 8216 8331 11461 11294 11306 gf180mcu_fd_sc_mcu9t5v0__aoi21_1
* cell instance $12392 m0 *1 1192.24,876.96
X$12392 11306 11194 11083 11188 11181 11294 11307
+ gf180mcu_fd_sc_mcu9t5v0__oai31_1
* cell instance $12393 r0 *1 1214.64,887.04
X$12393 8217 8216 8331 11848 11720 11600 11731 gf180mcu_fd_sc_mcu9t5v0__aoi211_1
* cell instance $12394 r0 *1 1226.96,876.96
X$12394 11363 5667 10850 11461 11294 9588 gf180mcu_fd_sc_mcu9t5v0__and3_1
* cell instance $12395 r0 *1 1209.04,856.8
X$12395 10714 10833 gf180mcu_fd_sc_mcu9t5v0__filltie
* cell instance $12396 r0 *1 1202.32,887.04
X$12396 5667 9330 12135 11720 11600 11613 gf180mcu_fd_sc_mcu9t5v0__aoi21_1
* cell instance $12397 m0 *1 1196.16,897.12
X$12397 10323 5667 10697 11720 11860 11614 gf180mcu_fd_sc_mcu9t5v0__and3_1
* cell instance $12398 m0 *1 1233.68,866.88
X$12398 10976 7800 6919 11195 11084 10833 11079 10977
+ gf180mcu_fd_sc_mcu9t5v0__aoi221_1
* cell instance $12399 r0 *1 1216.32,866.88
X$12399 7800 10975 5667 11195 11084 11181 11079 9329
+ gf180mcu_fd_sc_mcu9t5v0__aoi221_1
* cell instance $12400 r0 *1 1192.24,887.04
X$12400 11192 5766 11720 11600 11612 gf180mcu_fd_sc_mcu9t5v0__nand2_1
* cell instance $12401 m0 *1 1188.88,876.96
X$12401 11611 8326 11181 11294 11194 gf180mcu_fd_sc_mcu9t5v0__nor2_1
* cell instance $12402 r0 *1 1195.04,887.04
X$12402 5766 11613 11614 11612 11720 11600 11846
+ gf180mcu_fd_sc_mcu9t5v0__oai31_1
* cell instance $12403 m0 *1 1186.64,897.12
X$12403 11729 11846 6973 11720 11860 11864 gf180mcu_fd_sc_mcu9t5v0__mux2_2
* cell instance $12404 r0 *1 1210.16,866.88
X$12404 11196 7800 6919 11195 11084 11181 11079 10726
+ gf180mcu_fd_sc_mcu9t5v0__aoi221_1
* cell instance $12405 r0 *1 1210.16,846.72
X$12405 10352 6557 7685 6669 10676 10570 10725 gf180mcu_fd_sc_mcu9t5v0__oai31_1
* cell instance $12406 m0 *1 1228.08,876.96
X$12406 11727 11181 11294 9330 gf180mcu_fd_sc_mcu9t5v0__buf_4
* cell instance $12407 m0 *1 1213.52,856.8
X$12407 10061 6669 10726 10725 10676 10714 10698
+ gf180mcu_fd_sc_mcu9t5v0__oai22_1
* cell instance $12408 r0 *1 1218.56,846.72
X$12408 7566 10698 10351 10676 10570 10467 gf180mcu_fd_sc_mcu9t5v0__aoi21_1
* cell instance $12409 r0 *1 1209.04,887.04
X$12409 11600 11720 gf180mcu_fd_sc_mcu9t5v0__filltie
* cell instance $12410 m0 *1 1201.76,876.96
X$12410 10578 11307 11187 11181 11294 gf180mcu_fd_sc_mcu9t5v0__dffq_2
* cell instance $12411 r0 *1 1175.44,866.88
X$12411 10973 11181 11079 10853 gf180mcu_fd_sc_mcu9t5v0__clkinv_1
* cell instance $12412 r0 *1 1209.04,846.72
X$12412 10570 10676 gf180mcu_fd_sc_mcu9t5v0__filltie
* cell instance $12413 r0 *1 1220.24,887.04
X$12413 8217 8216 8331 11615 11720 11600 11732 gf180mcu_fd_sc_mcu9t5v0__aoi211_1
* cell instance $12414 r0 *1 1189.44,846.72
X$12414 10578 10465 9327 10676 10570 gf180mcu_fd_sc_mcu9t5v0__dffq_2
* cell instance $12415 r0 *1 1222.48,866.88
X$12415 11196 8452 11084 11181 11079 10055 gf180mcu_fd_sc_mcu9t5v0__aoi21_1
* cell instance $12416 m0 *1 1194.48,856.8
X$12416 9327 10676 10714 10466 gf180mcu_fd_sc_mcu9t5v0__clkinv_1
* cell instance $12417 m0 *1 1190.56,866.88
X$12417 5667 9330 10833 11079 10974 gf180mcu_fd_sc_mcu9t5v0__nand2_1
* cell instance $12418 m0 *1 1176,887.04
X$12418 3103 11577 11461 11600 11362 gf180mcu_fd_sc_mcu9t5v0__nand2_1
* cell instance $12419 m0 *1 1235.36,887.04
X$12419 4967 9856 11607 7685 11461 11600 11365 gf180mcu_fd_sc_mcu9t5v0__nor4_1
* cell instance $12420 r0 *1 1239.28,846.72
X$12420 10699 5766 10676 10570 10700 gf180mcu_fd_sc_mcu9t5v0__nand2_1
* cell instance $12421 r0 *1 1186.64,866.88
X$12421 7670 5667 10850 11181 11079 11193 gf180mcu_fd_sc_mcu9t5v0__and3_1
* cell instance $12422 m0 *1 1216.32,846.72
X$12422 10578 10467 10207 10338 10570 gf180mcu_fd_sc_mcu9t5v0__dffq_2
* cell instance $12423 m0 *1 1196.72,846.72
X$12423 9859 4769 10338 10570 10464 gf180mcu_fd_sc_mcu9t5v0__nand2_1
* cell instance $12424 m0 *1 1189.44,846.72
X$12424 10466 4493 10325 4491 10464 10338 10570 10465
+ gf180mcu_fd_sc_mcu9t5v0__oai221_1
* cell instance $12425 m0 *1 1181.04,846.72
X$12425 8823 4769 10338 10570 10326 gf180mcu_fd_sc_mcu9t5v0__nand2_1
* cell instance $12426 m0 *1 1226.96,897.12
X$12426 6973 11849 11732 11720 11860 11850 gf180mcu_fd_sc_mcu9t5v0__aoi21_1
* cell instance $12427 r0 *1 1267.84,897.12
X$12427 11866 9333 11865 11992 11971 11860 11867
+ gf180mcu_fd_sc_mcu9t5v0__oai31_1
* cell instance $12428 r0 *1 1263.36,897.12
X$12428 8453 6557 7685 11971 11860 11866 gf180mcu_fd_sc_mcu9t5v0__nor3_1
* cell instance $12429 m0 *1 1311.52,856.8
X$12429 2891 10861 10859 10676 10714 10733 gf180mcu_fd_sc_mcu9t5v0__oai21_1
* cell instance $12430 m0 *1 1309.28,866.88
X$12430 10984 4765 2997 11087 10833 11079 10860 gf180mcu_fd_sc_mcu9t5v0__aoi22_1
* cell instance $12431 r0 *1 1309.84,897.12
X$12431 11995 11994 11991 11869 2987 3459 11971 11860 11993
+ gf180mcu_fd_sc_mcu9t5v0__mux4_1
* cell instance $12432 r0 *1 1327.76,897.12
X$12432 2891 11995 11971 11860 11621 gf180mcu_fd_sc_mcu9t5v0__nor2_1
* cell instance $12433 r0 *1 1310.4,866.88
X$12433 3816 11181 11079 9591 gf180mcu_fd_sc_mcu9t5v0__clkbuf_8
* cell instance $12434 m0 *1 1311.52,876.96
X$12434 10861 10983 10984 11087 3120 3239 11181 11294 10985
+ gf180mcu_fd_sc_mcu9t5v0__mux4_1
* cell instance $12435 m0 *1 1300.32,836.64
X$12435 9570 10208 10060 10207 3120 3239 10188 10308 10328
+ gf180mcu_fd_sc_mcu9t5v0__mux4_1
* cell instance $12436 r0 *1 1370.32,897.12
X$12436 11848 4765 2997 12282 11971 11860 11996 gf180mcu_fd_sc_mcu9t5v0__aoi22_1
* cell instance $12437 r0 *1 1375.36,897.12
X$12437 3103 11996 11971 11860 11854 gf180mcu_fd_sc_mcu9t5v0__nand2_1
* cell instance $12438 m0 *1 1309.28,957.6
X$12438 13480 13477 13024 13318 13428 9809 gf180mcu_fd_sc_mcu9t5v0__mux2_1
* cell instance $12439 r0 *1 1310.4,957.6
X$12439 13700 13482 13024 13586 13428 6281 gf180mcu_fd_sc_mcu9t5v0__mux2_1
* cell instance $12440 m0 *1 1312.08,947.52
X$12440 13175 13024 13177 13054 13160 4055 gf180mcu_fd_sc_mcu9t5v0__aoi21_1
* cell instance $12441 r0 *1 1304.8,927.36
X$12441 12653 12785 12646 9826 gf180mcu_fd_sc_mcu9t5v0__buf_8
* cell instance $12442 r0 *1 1302,917.28
X$12442 12276 12508 12253 9107 gf180mcu_fd_sc_mcu9t5v0__buf_8
* cell instance $12443 r0 *1 1282.96,897.12
X$12443 9591 11868 11869 11971 11860 gf180mcu_fd_sc_mcu9t5v0__dffq_2
* cell instance $12444 r0 *1 1312.08,907.2
X$12444 2891 12143 12128 12019 12142 gf180mcu_fd_sc_mcu9t5v0__nor2_1
* cell instance $12445 m0 *1 1349.04,907.2
X$12445 8718 4258 4275 11869 11971 12019 12031 gf180mcu_fd_sc_mcu9t5v0__aoi22_1
* cell instance $12446 m0 *1 1356.32,907.2
X$12446 12033 12031 11971 12019 12032 gf180mcu_fd_sc_mcu9t5v0__nand2_1
* cell instance $12447 m0 *1 1331.12,917.28
X$12447 12030 8989 4916 12128 12253 12283 gf180mcu_fd_sc_mcu9t5v0__mux2_1
* cell instance $12448 m0 *1 1328.88,947.52
X$12448 13160 13054 gf180mcu_fd_sc_mcu9t5v0__filltie
* cell instance $12449 m0 *1 1330,927.36
X$12449 12629 12029 4916 12508 12646 12656 gf180mcu_fd_sc_mcu9t5v0__mux2_1
* cell instance $12450 m0 *1 1355.2,957.6
X$12450 4545 13216 13031 13318 13428 15750 gf180mcu_fd_sc_mcu9t5v0__oai21_1
* cell instance $12451 r0 *1 1319.36,917.28
X$12451 12143 12146 11615 12144 3120 3239 12508 12253 12629
+ gf180mcu_fd_sc_mcu9t5v0__mux4_1
* cell instance $12452 m0 *1 1328.88,927.36
X$12452 12646 12508 gf180mcu_fd_sc_mcu9t5v0__filltie
* cell instance $12453 m0 *1 1330,947.52
X$12453 11994 12911 10053 13054 13160 13029 gf180mcu_fd_sc_mcu9t5v0__mux2_1
* cell instance $12454 r0 *1 1318.8,907.2
X$12454 12143 12146 11615 12144 2987 3459 12128 12019 12145
+ gf180mcu_fd_sc_mcu9t5v0__mux4_1
* cell instance $12455 m0 *1 1328.88,937.44
X$12455 12900 12785 gf180mcu_fd_sc_mcu9t5v0__filltie
* cell instance $12456 m0 *1 1328.88,917.28
X$12456 12253 12128 gf180mcu_fd_sc_mcu9t5v0__filltie
* cell instance $12457 r0 *1 1352.4,917.28
X$12457 7349 11611 10054 12508 12253 12519 gf180mcu_fd_sc_mcu9t5v0__mux2_1
* cell instance $12458 m0 *1 1352.96,937.44
X$12458 9826 12273 10054 12785 12900 12912 gf180mcu_fd_sc_mcu9t5v0__mux2_1
* cell instance $12459 r0 *1 1350.72,937.44
X$12459 13178 12912 10053 13054 12900 13030 gf180mcu_fd_sc_mcu9t5v0__mux2_1
* cell instance $12460 m0 *1 1344.56,927.36
X$12460 13028 12630 11582 12508 12646 gf180mcu_fd_sc_mcu9t5v0__dffq_2
* cell instance $12461 m0 *1 1345.12,947.52
X$12461 13028 13030 13178 13054 13160 gf180mcu_fd_sc_mcu9t5v0__dffq_2
* cell instance $12462 r0 *1 1323.84,937.44
X$12462 13028 13029 11994 13054 12900 gf180mcu_fd_sc_mcu9t5v0__dffq_2
* cell instance $12463 m0 *1 1316.56,947.52
X$12463 11363 13024 13054 13160 13177 gf180mcu_fd_sc_mcu9t5v0__nor2_1
* cell instance $12464 m0 *1 1374.24,917.28
X$12464 2891 13178 12128 12253 12151 gf180mcu_fd_sc_mcu9t5v0__nand2_1
* cell instance $12465 m0 *1 1371.44,917.28
X$12465 4529 12411 12128 12253 12150 gf180mcu_fd_sc_mcu9t5v0__nand2_1
* cell instance $12466 m0 *1 1331.68,937.44
X$12466 8568 12140 10054 12785 12900 12911 gf180mcu_fd_sc_mcu9t5v0__mux2_1
* cell instance $12467 r0 *1 1370.88,937.44
X$12467 12411 4254 4252 10474 13054 12900 13031 gf180mcu_fd_sc_mcu9t5v0__aoi22_1
* cell instance $12468 r0 *1 1373.68,907.2
X$12468 12151 12150 4497 12128 12019 11855 gf180mcu_fd_sc_mcu9t5v0__aoi21_1
* cell instance $12469 r0 *1 1372.56,927.36
X$12469 12761 12657 3120 12785 12646 13033 gf180mcu_fd_sc_mcu9t5v0__mux2_1
* cell instance $12470 r0 *1 1349.6,907.2
X$12470 9449 4258 4275 12144 12128 12019 12147 gf180mcu_fd_sc_mcu9t5v0__aoi22_1
* cell instance $12471 r0 *1 1357.44,907.2
X$12471 12149 12147 12128 12019 12148 gf180mcu_fd_sc_mcu9t5v0__nand2_1
* cell instance $12472 m0 *1 1330,907.2
X$12472 11995 11994 11991 11869 3120 3239 11971 12019 12030
+ gf180mcu_fd_sc_mcu9t5v0__mux4_1
* cell instance $12473 r0 *1 1378.16,957.6
X$12473 13028 13586 13428 33568 gf180mcu_fd_sc_mcu9t5v0__clkinv_1
* cell instance $12474 m0 *1 1328.88,907.2
X$12474 12019 11971 gf180mcu_fd_sc_mcu9t5v0__filltie
* cell instance $12475 r0 *1 1349.6,927.36
X$12475 11582 12519 10053 12785 12646 12630 gf180mcu_fd_sc_mcu9t5v0__mux2_1
* cell instance $12476 r0 *1 1327.76,957.6
X$12476 13028 13483 6569 13180 13586 13428 gf180mcu_fd_sc_mcu9t5v0__dffrnq_2
* cell instance $12477 m0 *1 1316.56,957.6
X$12477 13060 13059 13024 13318 13428 3470 gf180mcu_fd_sc_mcu9t5v0__mux2_1
* cell instance $12478 m0 *1 1328.88,957.6
X$12478 13428 13318 gf180mcu_fd_sc_mcu9t5v0__filltie
* cell instance $12479 r0 *1 1349.6,947.52
X$12479 9827 4258 4275 12282 4545 13318 13160 13216
+ gf180mcu_fd_sc_mcu9t5v0__aoi221_1
* cell instance $12480 m0 *1 1363.6,907.2
X$12480 11995 4254 4252 8719 11971 12019 12033 gf180mcu_fd_sc_mcu9t5v0__aoi22_1
* cell instance $12481 r0 *1 1363.6,907.2
X$12481 12143 4254 4252 10473 12128 12019 12149 gf180mcu_fd_sc_mcu9t5v0__aoi22_1
* cell instance $12482 r0 *1 1363.6,937.44
X$12482 13034 13033 4916 13054 12900 13032 gf180mcu_fd_sc_mcu9t5v0__mux2_1
* cell instance $12483 m0 *1 1295.28,937.44
X$12483 9591 12655 12146 12785 12900 gf180mcu_fd_sc_mcu9t5v0__dffq_2
* cell instance $12484 m0 *1 1294.16,947.52
X$12484 13060 13024 13176 13054 13160 6976 gf180mcu_fd_sc_mcu9t5v0__aoi21_1
* cell instance $12485 m0 *1 1285.2,947.52
X$12485 13060 13173 13054 13160 13027 gf180mcu_fd_sc_mcu9t5v0__and2_1
* cell instance $12486 m0 *1 1265.04,947.52
X$12486 13059 13173 13054 13160 13025 gf180mcu_fd_sc_mcu9t5v0__and2_1
* cell instance $12487 r0 *1 1262.24,947.52
X$12487 13479 13215 13173 13318 13160 9596 gf180mcu_fd_sc_mcu9t5v0__mux2_1
* cell instance $12488 r0 *1 1264.48,937.44
X$12488 13020 13024 13025 13054 12900 4263 gf180mcu_fd_sc_mcu9t5v0__aoi21_1
* cell instance $12489 r0 *1 1288,957.6
X$12489 13477 13024 13478 13586 13428 10352 gf180mcu_fd_sc_mcu9t5v0__aoi21_1
* cell instance $12490 r0 *1 1268.96,937.44
X$12490 13479 13024 13026 13054 12900 10729 gf180mcu_fd_sc_mcu9t5v0__aoi21_1
* cell instance $12491 r0 *1 1276.24,917.28
X$12491 12282 12409 7566 12508 12253 12281 gf180mcu_fd_sc_mcu9t5v0__mux2_1
* cell instance $12492 r0 *1 1283.52,917.28
X$12492 9591 12410 12144 12508 12253 gf180mcu_fd_sc_mcu9t5v0__dffq_2
* cell instance $12493 r0 *1 1254.96,957.6
X$12493 10323 13475 13586 13428 15147 gf180mcu_fd_sc_mcu9t5v0__nor2_1
* cell instance $12494 r0 *1 1254.96,947.52
X$12494 13060 13175 13173 13318 13160 5564 gf180mcu_fd_sc_mcu9t5v0__mux2_1
* cell instance $12495 m0 *1 1260.56,917.28
X$12495 6919 9330 12276 12128 12253 12279 gf180mcu_fd_sc_mcu9t5v0__aoi21_1
* cell instance $12496 r0 *1 1288.56,947.52
X$12496 13215 9820 13173 13318 13160 8453 gf180mcu_fd_sc_mcu9t5v0__mux2_1
* cell instance $12497 m0 *1 1265.04,917.28
X$12497 9112 6557 7685 12128 12253 12280 gf180mcu_fd_sc_mcu9t5v0__nor3_1
* cell instance $12498 r0 *1 1252.72,927.36
X$12498 12141 10054 12785 12646 12760 gf180mcu_fd_sc_mcu9t5v0__nand2_1
* cell instance $12499 r0 *1 1246,927.36
X$12499 12405 8333 10053 12654 12760 12785 12646 12655
+ gf180mcu_fd_sc_mcu9t5v0__oai221_1
* cell instance $12500 r0 *1 1271.76,957.6
X$12500 13215 13482 13475 13586 13428 13476 gf180mcu_fd_sc_mcu9t5v0__mux2_1
* cell instance $12501 r0 *1 1263.36,957.6
X$12501 14462 13476 13214 13586 13428 13596 gf180mcu_fd_sc_mcu9t5v0__mux2_1
* cell instance $12502 r0 *1 1269.52,917.28
X$12502 9333 12279 12280 12628 12508 12253 12518
+ gf180mcu_fd_sc_mcu9t5v0__oai31_1
* cell instance $12503 m0 *1 1269.52,947.52
X$12503 13215 13173 13054 13160 13026 gf180mcu_fd_sc_mcu9t5v0__and2_1
* cell instance $12504 m0 *1 1279.04,917.28
X$12504 9591 12281 12282 12128 12253 gf180mcu_fd_sc_mcu9t5v0__dffq_2
* cell instance $12505 r0 *1 1289.12,937.44
X$12505 13059 13024 13027 13054 12900 4810 gf180mcu_fd_sc_mcu9t5v0__aoi21_1
* cell instance $12506 m0 *1 1260.56,927.36
X$12506 12141 9333 12508 12646 12628 gf180mcu_fd_sc_mcu9t5v0__nand2_1
* cell instance $12507 r0 *1 1259.44,917.28
X$12507 6919 9330 12653 12508 12253 12407 gf180mcu_fd_sc_mcu9t5v0__aoi21_1
* cell instance $12508 m0 *1 1248.8,947.52
X$12508 13059 13020 13024 13054 13160 2270 gf180mcu_fd_sc_mcu9t5v0__mux2_1
* cell instance $12509 m0 *1 1286.32,927.36
X$12509 12144 12518 7566 12508 12646 12410 gf180mcu_fd_sc_mcu9t5v0__mux2_1
* cell instance $12510 r0 *1 1281.28,947.52
X$12510 13175 8823 13173 13318 13160 2688 gf180mcu_fd_sc_mcu9t5v0__mux2_1
* cell instance $12511 r0 *1 1256.64,917.28
X$12511 12273 9333 12508 12253 12406 gf180mcu_fd_sc_mcu9t5v0__nand2_1
* cell instance $12512 r0 *1 1303.12,957.6
X$12512 13481 13480 13024 13586 13428 7670 gf180mcu_fd_sc_mcu9t5v0__mux2_1
* cell instance $12513 m0 *1 1267.28,907.2
X$12513 12140 9333 11971 12019 11992 gf180mcu_fd_sc_mcu9t5v0__nand2_1
* cell instance $12514 r0 *1 1263.92,917.28
X$12514 9333 12408 12407 12406 12508 12253 12409
+ gf180mcu_fd_sc_mcu9t5v0__oai31_1
* cell instance $12515 m0 *1 1307.6,927.36
X$12515 12146 12508 12646 12654 gf180mcu_fd_sc_mcu9t5v0__clkinv_1
* cell instance $12516 m0 *1 1246.56,917.28
X$12516 5667 9330 8568 12128 12253 12278 gf180mcu_fd_sc_mcu9t5v0__aoi21_1
* cell instance $12517 m0 *1 1289.68,947.52
X$12517 13175 13173 13054 13160 13176 gf180mcu_fd_sc_mcu9t5v0__and2_1
* cell instance $12518 r0 *1 1305.92,907.2
X$12518 2891 12654 12142 4497 12128 12019 11870
+ gf180mcu_fd_sc_mcu9t5v0__aoi211_1
* cell instance $12519 m0 *1 1263.36,927.36
X$12519 9709 6557 7685 12508 12646 12408 gf180mcu_fd_sc_mcu9t5v0__nor3_1
* cell instance $12520 m0 *1 1307.04,866.88
X$12520 10983 10833 11079 10857 gf180mcu_fd_sc_mcu9t5v0__clkinv_1
* cell instance $12521 m0 *1 1243.2,856.8
X$12521 10729 5667 10697 10676 10714 10701 gf180mcu_fd_sc_mcu9t5v0__and3_1
* cell instance $12522 m0 *1 1295.28,856.8
X$12522 5064 5434 10676 10714 10732 gf180mcu_fd_sc_mcu9t5v0__nand2_1
* cell instance $12523 r0 *1 1308.16,856.8
X$12523 2891 10857 10833 10714 10859 gf180mcu_fd_sc_mcu9t5v0__nand2_1
* cell instance $12524 m0 *1 1263.92,887.04
X$12524 6919 9330 7349 11461 11600 11617 gf180mcu_fd_sc_mcu9t5v0__aoi21_1
* cell instance $12525 m0 *1 1277.36,856.8
X$12525 10728 10676 10714 9571 gf180mcu_fd_sc_mcu9t5v0__buf_8
* cell instance $12526 r0 *1 1260,866.88
X$12526 6919 9330 11308 11181 11079 11085 gf180mcu_fd_sc_mcu9t5v0__aoi21_1
* cell instance $12527 m0 *1 1303.12,897.12
X$12527 11615 4765 2997 12144 11720 11860 11853 gf180mcu_fd_sc_mcu9t5v0__aoi22_1
* cell instance $12528 r0 *1 1264.48,866.88
X$12528 4967 6557 7685 11181 11079 11086 gf180mcu_fd_sc_mcu9t5v0__nor3_1
* cell instance $12529 m0 *1 1268.4,866.88
X$12529 10979 9333 10833 11079 10978 gf180mcu_fd_sc_mcu9t5v0__nand2_1
* cell instance $12530 r0 *1 1268.96,866.88
X$12530 9333 11085 11086 10978 11181 11079 10980
+ gf180mcu_fd_sc_mcu9t5v0__oai31_1
* cell instance $12531 m0 *1 1283.52,866.88
X$12531 11087 10980 7566 10833 11079 10981 gf180mcu_fd_sc_mcu9t5v0__mux2_1
* cell instance $12532 r0 *1 1245.44,876.96
X$12532 10578 11311 10984 11461 11294 gf180mcu_fd_sc_mcu9t5v0__dffq_2
* cell instance $12533 r0 *1 1259.44,856.8
X$12533 10729 6557 7685 6669 10833 10714 10855 gf180mcu_fd_sc_mcu9t5v0__oai31_1
* cell instance $12534 r0 *1 1265.04,856.8
X$12534 10699 6669 10977 10855 10833 10714 10730
+ gf180mcu_fd_sc_mcu9t5v0__oai22_1
* cell instance $12535 r0 *1 1272.88,887.04
X$12535 11611 9333 11720 11600 11618 gf180mcu_fd_sc_mcu9t5v0__nand2_1
* cell instance $12536 r0 *1 1279.6,866.88
X$12536 9591 10981 11087 11181 11079 gf180mcu_fd_sc_mcu9t5v0__dffq_2
* cell instance $12537 m0 *1 1285.2,887.04
X$12537 11580 11579 7566 11461 11600 11619 gf180mcu_fd_sc_mcu9t5v0__mux2_1
* cell instance $12538 r0 *1 1285.2,846.72
X$12538 11308 10676 10570 5064 gf180mcu_fd_sc_mcu9t5v0__buf_8
* cell instance $12539 r0 *1 1265.6,846.72
X$12539 10578 10731 10356 10676 10570 gf180mcu_fd_sc_mcu9t5v0__dffq_2
* cell instance $12540 r0 *1 1298.64,856.8
X$12540 10857 10053 10732 10858 10833 10714 10856
+ gf180mcu_fd_sc_mcu9t5v0__oai211_1
* cell instance $12541 m0 *1 1271.76,846.72
X$12541 10356 10338 10570 10468 gf180mcu_fd_sc_mcu9t5v0__clkinv_1
* cell instance $12542 r0 *1 1246,836.64
X$12542 10355 10353 5781 10338 10308 10354 gf180mcu_fd_sc_mcu9t5v0__mux2_2
* cell instance $12543 m0 *1 1292.48,836.64
X$12543 10208 10188 10308 10327 gf180mcu_fd_sc_mcu9t5v0__clkinv_1
* cell instance $12544 m0 *1 1284.64,836.64
X$12544 10327 10053 10062 10091 10188 10308 10090
+ gf180mcu_fd_sc_mcu9t5v0__oai211_1
* cell instance $12545 m0 *1 1303.68,846.72
X$12545 10328 9106 4916 10338 10570 10582 gf180mcu_fd_sc_mcu9t5v0__mux2_1
* cell instance $12546 m0 *1 1264.48,846.72
X$12546 10468 6261 6042 10338 10570 10469 gf180mcu_fd_sc_mcu9t5v0__and3_1
* cell instance $12547 m0 *1 1294.72,876.96
X$12547 9591 10856 10983 11181 11294 gf180mcu_fd_sc_mcu9t5v0__dffq_2
* cell instance $12548 m0 *1 1266.72,856.8
X$12548 7566 10730 10469 10676 10714 10731 gf180mcu_fd_sc_mcu9t5v0__aoi21_1
* cell instance $12549 r0 *1 1282.4,887.04
X$12549 9591 11619 11580 11720 11600 gf180mcu_fd_sc_mcu9t5v0__dffq_2
* cell instance $12550 m0 *1 1246,897.12
X$12550 11991 11851 5781 11720 11860 11852 gf180mcu_fd_sc_mcu9t5v0__mux2_2
* cell instance $12551 m0 *1 1264.48,897.12
X$12551 6919 11195 8568 11720 11860 11865 gf180mcu_fd_sc_mcu9t5v0__aoi21_1
* cell instance $12552 r0 *1 1262.8,887.04
X$12552 7670 6557 7685 11720 11600 11616 gf180mcu_fd_sc_mcu9t5v0__nor3_1
* cell instance $12553 m0 *1 1247.68,876.96
X$12553 10984 11310 5781 11181 11294 11311 gf180mcu_fd_sc_mcu9t5v0__mux2_2
* cell instance $12554 m0 *1 1301.44,866.88
X$12554 10979 10054 10833 11079 10858 gf180mcu_fd_sc_mcu9t5v0__nand2_1
* cell instance $12555 r0 *1 1304.8,866.88
X$12555 9591 11181 11079 gf180mcu_fd_sc_mcu9t5v0__inv_4
* cell instance $12556 r0 *1 1267.28,887.04
X$12556 9333 11616 11617 11618 11720 11600 11579
+ gf180mcu_fd_sc_mcu9t5v0__oai31_1
* cell instance $12557 m0 *1 1285.76,897.12
X$12557 11869 11867 7566 11720 11860 11868 gf180mcu_fd_sc_mcu9t5v0__mux2_1
* cell instance $12558 m0 *1 1308.16,897.12
X$12558 3103 11853 11720 11860 11733 gf180mcu_fd_sc_mcu9t5v0__nand2_1
* cell instance $12559 r0 *1 1305.92,887.04
X$12559 3103 11366 11870 11733 11720 11600 11180
+ gf180mcu_fd_sc_mcu9t5v0__oai22_1
* cell instance $12560 m0 *1 1353.52,876.96
X$12560 4497 11197 11313 11312 11181 11294 7979 gf180mcu_fd_sc_mcu9t5v0__oai31_1
* cell instance $12561 m0 *1 1328.88,876.96
X$12561 11294 11181 gf180mcu_fd_sc_mcu9t5v0__filltie
* cell instance $12562 m0 *1 1321.04,897.12
X$12562 11991 4765 2997 11869 5389 11720 11860 11620
+ gf180mcu_fd_sc_mcu9t5v0__aoi221_1
* cell instance $12563 m0 *1 1323.84,836.64
X$12563 10355 4765 2997 10356 10188 10308 10211 gf180mcu_fd_sc_mcu9t5v0__aoi22_1
* cell instance $12564 m0 *1 1369.76,846.72
X$12564 10475 10474 2134 10338 10570 10586 gf180mcu_fd_sc_mcu9t5v0__mux2_1
* cell instance $12565 m0 *1 1332.8,836.64
X$12565 4529 10471 10188 10308 10093 gf180mcu_fd_sc_mcu9t5v0__nor2_1
* cell instance $12566 r0 *1 1321.04,846.72
X$12566 9591 10583 10471 10676 10570 gf180mcu_fd_sc_mcu9t5v0__dffq_2
* cell instance $12567 r0 *1 1358,866.88
X$12567 2891 11198 11181 11079 11197 gf180mcu_fd_sc_mcu9t5v0__nor2_1
* cell instance $12568 m0 *1 1328.88,866.88
X$12568 11079 10833 gf180mcu_fd_sc_mcu9t5v0__filltie
* cell instance $12569 r0 *1 1326.64,887.04
X$12569 4497 11621 11622 11620 11720 11600 9706 gf180mcu_fd_sc_mcu9t5v0__oai31_1
* cell instance $12570 m0 *1 1314.32,866.88
X$12570 10985 5803 4916 10833 11079 10982 gf180mcu_fd_sc_mcu9t5v0__mux2_1
* cell instance $12571 m0 *1 1328.88,897.12
X$12571 11860 11720 gf180mcu_fd_sc_mcu9t5v0__filltie
* cell instance $12572 m0 *1 1321.6,846.72
X$12572 10471 10470 10053 10338 10570 10583 gf180mcu_fd_sc_mcu9t5v0__mux2_1
* cell instance $12573 m0 *1 1359.12,876.96
X$12573 8107 4258 4275 11580 11181 11294 11199 gf180mcu_fd_sc_mcu9t5v0__aoi22_1
* cell instance $12574 m0 *1 1328.88,856.8
X$12574 10714 10676 gf180mcu_fd_sc_mcu9t5v0__filltie
* cell instance $12575 m0 *1 1358,856.8
X$12575 9591 10584 10473 10676 10714 gf180mcu_fd_sc_mcu9t5v0__dffq_2
* cell instance $12576 r0 *1 1356.88,876.96
X$12576 4529 11582 11461 11294 11313 gf180mcu_fd_sc_mcu9t5v0__nor2_1
* cell instance $12577 m0 *1 1330,846.72
X$12577 9571 10699 10054 10338 10570 10470 gf180mcu_fd_sc_mcu9t5v0__mux2_1
* cell instance $12578 m0 *1 1316,856.8
X$12578 4497 10733 10860 10676 10714 8566 gf180mcu_fd_sc_mcu9t5v0__oai21_1
* cell instance $12579 m0 *1 1328.88,887.04
X$12579 11600 11461 gf180mcu_fd_sc_mcu9t5v0__filltie
* cell instance $12580 m0 *1 1350.16,866.88
X$12580 4545 10986 10987 10833 11079 11623 gf180mcu_fd_sc_mcu9t5v0__oai21_1
* cell instance $12581 m0 *1 1336.16,876.96
X$12581 11187 4765 2997 11580 5389 11181 11294 11312
+ gf180mcu_fd_sc_mcu9t5v0__aoi221_1
* cell instance $12582 r0 *1 1340.08,887.04
X$12582 11581 8105 4916 11720 11600 23386 gf180mcu_fd_sc_mcu9t5v0__mux2_1
* cell instance $12583 m0 *1 1344,866.88
X$12583 5574 4258 4275 11087 4545 10833 11079 10986
+ gf180mcu_fd_sc_mcu9t5v0__aoi221_1
* cell instance $12584 m0 *1 1344,887.04
X$12584 11198 11582 11187 11580 3120 3239 11461 11600 11581
+ gf180mcu_fd_sc_mcu9t5v0__mux4_1
* cell instance $12585 m0 *1 1330,897.12
X$12585 4529 11994 11720 11860 11622 gf180mcu_fd_sc_mcu9t5v0__nor2_1
* cell instance $12586 m0 *1 1362.48,846.72
X$12586 10585 10473 2134 10338 10570 10584 gf180mcu_fd_sc_mcu9t5v0__mux2_1
* cell instance $12587 m0 *1 1364.16,876.96
X$12587 11201 11199 11181 11294 11314 gf180mcu_fd_sc_mcu9t5v0__nand2_1
* cell instance $12588 m0 *1 1369.2,866.88
X$12588 10861 4254 4252 5405 10833 11079 10987 gf180mcu_fd_sc_mcu9t5v0__aoi22_1
* cell instance $12589 r0 *1 1374.8,876.96
X$12589 2891 9593 11368 4497 11461 11294 11367 gf180mcu_fd_sc_mcu9t5v0__aoi211_1
* cell instance $12590 m0 *1 1361.92,836.64
X$12590 10213 4254 4252 10064 10188 10308 10357 gf180mcu_fd_sc_mcu9t5v0__aoi22_1
* cell instance $12591 r0 *1 1364.72,846.72
X$12591 9112 9107 2255 10676 10570 10585 gf180mcu_fd_sc_mcu9t5v0__mux2_1
* cell instance $12592 m0 *1 1373.68,897.12
X$12592 3103 11856 11855 11854 11720 11860 11327
+ gf180mcu_fd_sc_mcu9t5v0__oai22_1
* cell instance $12593 m0 *1 1328.88,846.72
X$12593 10570 10338 gf180mcu_fd_sc_mcu9t5v0__filltie
* cell instance $12594 m0 *1 1369.76,876.96
X$12594 11198 4254 4252 7981 11181 11294 11201 gf180mcu_fd_sc_mcu9t5v0__aoi22_1
* cell instance $12595 r0 *1 1349.04,887.04
X$12595 11198 11582 11187 11580 2987 3459 11720 11600 11734
+ gf180mcu_fd_sc_mcu9t5v0__mux4_1
* cell instance $12596 r0 *1 1324.96,866.88
X$12596 10861 10983 10984 11087 2987 3459 11181 11079 11088
+ gf180mcu_fd_sc_mcu9t5v0__mux4_1
* cell instance $12597 m0 *1 1340.08,846.72
X$12597 10213 10471 10355 10356 2987 3459 10338 10570 10472
+ gf180mcu_fd_sc_mcu9t5v0__mux4_1
* cell instance $12598 m0 *1 1337.28,836.64
X$12598 10330 10212 4916 10188 10308 10329 gf180mcu_fd_sc_mcu9t5v0__mux2_1
* cell instance $12599 m0 *1 1328.88,836.64
X$12599 10308 10188 gf180mcu_fd_sc_mcu9t5v0__filltie
* cell instance $12600 r0 *1 1337.84,836.64
X$12600 10213 10471 10355 10356 3120 3239 10338 10308 10330
+ gf180mcu_fd_sc_mcu9t5v0__mux4_1
* cell instance $12601 m0 *1 1354.08,836.64
X$12601 9590 4258 4275 10356 10188 10308 10331 gf180mcu_fd_sc_mcu9t5v0__aoi22_1
* cell instance $12602 r0 *1 1359.68,836.64
X$12602 10357 10331 10338 10308 11200 gf180mcu_fd_sc_mcu9t5v0__nand2_1
* cell instance $12603 r0 *1 1242.08,816.48
X$12603 5667 9330 10055 9841 9810 9861 gf180mcu_fd_sc_mcu9t5v0__aoi21_1
* cell instance $12604 m0 *1 1241.52,826.56
X$12604 5766 10056 9861 10057 9841 10078 10058 gf180mcu_fd_sc_mcu9t5v0__oai31_1
* cell instance $12605 m0 *1 1240.4,796.32
X$12605 8823 6557 7685 9201 9315 9331 gf180mcu_fd_sc_mcu9t5v0__nor3_1
* cell instance $12606 r0 *1 1242.08,806.4
X$12606 9859 9333 9691 9575 9589 gf180mcu_fd_sc_mcu9t5v0__nand2_1
* cell instance $12607 m0 *1 1240.4,806.4
X$12607 9333 9331 9446 9589 9432 9575 9565 gf180mcu_fd_sc_mcu9t5v0__oai31_1
* cell instance $12608 r0 *1 1242.08,796.32
X$12608 7570 9332 9444 9432 9315 gf180mcu_fd_sc_mcu9t5v0__dffq_2
* cell instance $12609 m0 *1 1240.96,756
X$12609 6569 6669 8219 8098 8078 8204 8220 gf180mcu_fd_sc_mcu9t5v0__oai22_1
* cell instance $12610 m0 *1 1240.4,776.16
X$12610 5433 6669 8831 8713 8693 8818 8856 gf180mcu_fd_sc_mcu9t5v0__oai22_1
* cell instance $12611 r0 *1 1239.28,725.76
X$12611 4055 6557 7685 6669 7671 7558 7690 gf180mcu_fd_sc_mcu9t5v0__oai31_1
* cell instance $12612 m0 *1 1240.96,735.84
X$12612 5062 6669 7806 7690 7671 7814 7458 gf180mcu_fd_sc_mcu9t5v0__oai22_1
* cell instance $12613 r0 *1 1234.24,685.44
X$12613 5433 5766 6664 6425 6445 gf180mcu_fd_sc_mcu9t5v0__nand2_1
* cell instance $12614 m0 *1 1232,624.96
X$12614 4382 4957 4785 4903 5056 gf180mcu_fd_sc_mcu9t5v0__dffq_2
* cell instance $12615 m0 *1 1230.88,614.88
X$12615 4051 4785 4784 4384 3120 3239 4667 4794 4807
+ gf180mcu_fd_sc_mcu9t5v0__mux4_1
* cell instance $12616 r0 *1 1167.04,685.44
X$12616 6022 6664 6425 3677 gf180mcu_fd_sc_mcu9t5v0__clkbuf_20
* cell instance $12617 m0 *1 1163.68,695.52
X$12617 6437 6405 4911 6664 6805 6436 gf180mcu_fd_sc_mcu9t5v0__mux2_1
* cell instance $12618 m0 *1 1187.2,695.52
X$12618 6810 6027 4916 6664 6805 6784 gf180mcu_fd_sc_mcu9t5v0__mux2_1
* cell instance $12619 r0 *1 1209.04,685.44
X$12619 6425 6664 gf180mcu_fd_sc_mcu9t5v0__filltie
* cell instance $12620 r0 *1 1218,685.44
X$12620 6406 4769 6664 6425 6411 gf180mcu_fd_sc_mcu9t5v0__nand2_1
* cell instance $12621 r0 *1 1205.68,685.44
X$12621 4529 6437 6664 6425 6567 gf180mcu_fd_sc_mcu9t5v0__nor2_1
* cell instance $12622 m0 *1 1111.6,695.52
X$12622 7087 2786 6664 6805 6564 gf180mcu_fd_sc_mcu9t5v0__nand2_1
* cell instance $12623 r0 *1 1114.96,685.44
X$12623 6565 6435 6564 6274 3103 6664 6425 6563
+ gf180mcu_fd_sc_mcu9t5v0__aoi221_1
* cell instance $12624 m0 *1 1122.24,695.52
X$12624 6968 6922 5778 6275 2987 3106 6664 6805 6923
+ gf180mcu_fd_sc_mcu9t5v0__mux4_1
* cell instance $12625 r0 *1 1128.96,685.44
X$12625 2891 6968 6566 5902 6664 6425 6565 gf180mcu_fd_sc_mcu9t5v0__oai211_1
* cell instance $12626 m0 *1 1240.4,655.2
X$12626 5766 5912 5779 5801 5665 5794 5780 gf180mcu_fd_sc_mcu9t5v0__oai31_1
* cell instance $12627 r0 *1 1310.96,685.44
X$12627 6570 6811 6417 6278 2987 3106 6664 6425 6573
+ gf180mcu_fd_sc_mcu9t5v0__mux4_1
* cell instance $12628 m0 *1 1353.52,695.52
X$12628 6680 6813 6664 6805 6790 gf180mcu_fd_sc_mcu9t5v0__nand2_1
* cell instance $12629 m0 *1 1342.32,695.52
X$12629 6679 6664 6805 6789 gf180mcu_fd_sc_mcu9t5v0__clkinv_1
* cell instance $12630 m0 *1 1338.4,695.52
X$12630 6569 4769 6664 6805 6929 gf180mcu_fd_sc_mcu9t5v0__nand2_1
* cell instance $12631 m0 *1 1328.88,695.52
X$12631 6805 6664 gf180mcu_fd_sc_mcu9t5v0__filltie
* cell instance $12632 r0 *1 1303.68,685.44
X$12632 6573 6571 3459 6664 6425 6572 gf180mcu_fd_sc_mcu9t5v0__mux2_1
* cell instance $12633 m0 *1 1239.84,685.44
X$12633 7570 6413 6277 6392 6425 gf180mcu_fd_sc_mcu9t5v0__dffq_2
* cell instance $12634 m0 *1 1275.12,695.52
X$12634 6786 6677 6787 6664 6805 6450 gf180mcu_fd_sc_mcu9t5v0__oai21_1
* cell instance $12635 m0 *1 1293.6,695.52
X$12635 2891 6788 6664 6805 6678 gf180mcu_fd_sc_mcu9t5v0__nand2_1
* cell instance $12636 m0 *1 1253.84,695.52
X$12636 7570 6785 6676 6664 6805 gf180mcu_fd_sc_mcu9t5v0__dffq_2
* cell instance $12637 m0 *1 1237.6,695.52
X$12637 5667 6916 5432 6664 6805 6446 gf180mcu_fd_sc_mcu9t5v0__aoi21_1
* cell instance $12638 r0 *1 1237.04,685.44
X$12638 4810 5667 5767 6664 6425 6447 gf180mcu_fd_sc_mcu9t5v0__and3_1
* cell instance $12639 r0 *1 1289.68,685.44
X$12639 2891 6570 6678 5902 6664 6425 6415 gf180mcu_fd_sc_mcu9t5v0__oai211_1
* cell instance $12640 m0 *1 1279.6,695.52
X$12640 2891 6679 6664 6805 6786 gf180mcu_fd_sc_mcu9t5v0__nor2_1
* cell instance $12641 m0 *1 1270.64,695.52
X$12641 4529 6676 5902 6664 6805 6677 gf180mcu_fd_sc_mcu9t5v0__oai21_1
* cell instance $12642 r0 *1 1239.84,655.2
X$12642 5911 5920 5794 2373 gf180mcu_fd_sc_mcu9t5v0__buf_8
* cell instance $12643 r0 *1 1240.4,705.6
X$12643 7214 7071 6943 5565 gf180mcu_fd_sc_mcu9t5v0__buf_8
* cell instance $12644 r0 *1 1256.64,685.44
X$12644 5565 6569 5057 6664 6425 6568 gf180mcu_fd_sc_mcu9t5v0__mux2_1
* cell instance $12645 r0 *1 1242.08,614.88
X$12645 4051 4785 4784 4384 2987 3459 4903 4794 4958
+ gf180mcu_fd_sc_mcu9t5v0__mux4_1
* cell instance $12646 m0 *1 1238.72,594.72
X$12646 3103 3226 4261 4260 4150 4266 4147 gf180mcu_fd_sc_mcu9t5v0__oai22_1
* cell instance $12647 r0 *1 1242.08,635.04
X$12647 5401 5390 5297 2687 gf180mcu_fd_sc_mcu9t5v0__buf_8
* cell instance $12648 m0 *1 1237.6,635.04
X$12648 2156 4961 5057 5183 5297 5168 gf180mcu_fd_sc_mcu9t5v0__mux2_1
* cell instance $12649 r0 *1 1236.48,624.96
X$12649 4785 5168 4911 5183 5056 4957 gf180mcu_fd_sc_mcu9t5v0__mux2_1
* cell instance $12650 m0 *1 1365.28,695.52
X$12650 6791 4254 4252 6298 6664 6805 6680 gf180mcu_fd_sc_mcu9t5v0__aoi22_1
* cell instance $12651 m0 *1 1371.44,695.52
X$12651 2891 6792 6664 6805 6794 gf180mcu_fd_sc_mcu9t5v0__nand2_1
* cell instance $12652 m0 *1 1374.24,695.52
X$12652 4529 6791 6664 6805 6795 gf180mcu_fd_sc_mcu9t5v0__nand2_1
* cell instance $12653 r0 *1 1234.24,574.56
X$12653 2265 3792 3247 3796 3781 gf180mcu_fd_sc_mcu9t5v0__dffq_2
* cell instance $12654 m0 *1 1237.04,574.56
X$12654 3247 3690 3920 3558 3781 3792 gf180mcu_fd_sc_mcu9t5v0__mux2_1
* cell instance $12655 r0 *1 1285.2,756
X$12655 5902 8351 8445 8204 8352 gf180mcu_fd_sc_mcu9t5v0__nand2_1
* cell instance $12656 r0 *1 1288,756
X$12656 8221 8353 8352 8101 3103 8445 8204 8711
+ gf180mcu_fd_sc_mcu9t5v0__aoi221_1
* cell instance $12657 r0 *1 1275.68,756
X$12657 7463 9809 3677 8445 8204 8350 gf180mcu_fd_sc_mcu9t5v0__mux2_2
* cell instance $12658 r0 *1 1249.36,756
X$12658 7566 8220 8100 8445 8204 8349 gf180mcu_fd_sc_mcu9t5v0__aoi21_1
* cell instance $12659 m0 *1 1308.16,735.84
X$12659 7573 7572 2134 7671 7814 7571 gf180mcu_fd_sc_mcu9t5v0__mux2_1
* cell instance $12660 m0 *1 1302.56,766.08
X$12660 8563 8102 8715 7808 3239 3121 8445 8582 8565
+ gf180mcu_fd_sc_mcu9t5v0__mux4_1
* cell instance $12661 r0 *1 1309.84,745.92
X$12661 8103 7808 7572 8102 2987 3106 8078 7948 7974
+ gf180mcu_fd_sc_mcu9t5v0__mux4_1
* cell instance $12662 r0 *1 1303.68,725.76
X$12662 7570 7571 7572 7671 7558 gf180mcu_fd_sc_mcu9t5v0__dffq_2
* cell instance $12663 r0 *1 1310.4,806.4
X$12663 9591 9592 9570 9691 9575 gf180mcu_fd_sc_mcu9t5v0__dffq_2
* cell instance $12664 r0 *1 1299.76,705.6
X$12664 7570 6980 6811 7071 6943 gf180mcu_fd_sc_mcu9t5v0__dffq_2
* cell instance $12665 m0 *1 1312.08,816.48
X$12665 9570 4254 4252 7572 9691 9810 9822 gf180mcu_fd_sc_mcu9t5v0__aoi22_1
* cell instance $12666 r0 *1 1294.16,756
X$12666 7808 2997 8354 5902 2992 8445 8204 8353
+ gf180mcu_fd_sc_mcu9t5v0__aoi221_1
* cell instance $12667 m0 *1 1303.12,786.24
X$12667 8564 7572 8593 8103 3239 3121 8843 8961 8982
+ gf180mcu_fd_sc_mcu9t5v0__mux4_1
* cell instance $12668 m0 *1 1317.68,776.16
X$12668 3351 8716 8693 8818 8833 gf180mcu_fd_sc_mcu9t5v0__nand2_1
* cell instance $12669 r0 *1 1321.04,816.48
X$12669 10061 4769 9841 9810 9824 gf180mcu_fd_sc_mcu9t5v0__nand2_1
* cell instance $12670 m0 *1 1321.04,816.48
X$12670 8985 9824 9691 9810 9569 gf180mcu_fd_sc_mcu9t5v0__nand2_1
* cell instance $12671 m0 *1 1328.88,766.08
X$12671 8582 8445 gf180mcu_fd_sc_mcu9t5v0__filltie
* cell instance $12672 m0 *1 1322.16,766.08
X$12672 3103 8566 5566 4930 8445 8582 8687 gf180mcu_fd_sc_mcu9t5v0__aoi211_1
* cell instance $12673 r0 *1 1340.64,766.08
X$12673 8104 8594 8718 8693 8582 gf180mcu_fd_sc_mcu9t5v0__dffq_2
* cell instance $12674 m0 *1 1328.88,776.16
X$12674 8818 8693 gf180mcu_fd_sc_mcu9t5v0__filltie
* cell instance $12675 m0 *1 1360.24,796.32
X$12675 6280 8573 10054 9201 9315 9340 gf180mcu_fd_sc_mcu9t5v0__mux2_1
* cell instance $12676 r0 *1 1359.12,796.32
X$12676 6792 9340 10053 9432 9315 9339 gf180mcu_fd_sc_mcu9t5v0__mux2_1
* cell instance $12677 r0 *1 1314.88,766.08
X$12677 8593 8715 8564 8563 2987 3106 8693 8582 8716
+ gf180mcu_fd_sc_mcu9t5v0__mux4_1
* cell instance $12678 r0 *1 1354.08,816.48
X$12678 9591 9862 10064 9841 9810 gf180mcu_fd_sc_mcu9t5v0__dffq_2
* cell instance $12679 m0 *1 1328.88,826.56
X$12679 10078 9841 gf180mcu_fd_sc_mcu9t5v0__filltie
* cell instance $12680 m0 *1 1328.88,796.32
X$12680 9315 9201 gf180mcu_fd_sc_mcu9t5v0__filltie
* cell instance $12681 m0 *1 1323.28,796.32
X$12681 7463 4048 9201 9315 8985 gf180mcu_fd_sc_mcu9t5v0__nand2_1
* cell instance $12682 m0 *1 1346.24,766.08
X$12682 8453 8568 4255 8445 8582 8567 gf180mcu_fd_sc_mcu9t5v0__mux2_1
* cell instance $12683 m0 *1 1326.08,796.32
X$12683 9809 4769 9201 9315 8986 gf180mcu_fd_sc_mcu9t5v0__nand2_1
* cell instance $12684 m0 *1 1362.48,776.16
X$12684 8569 8719 2134 8693 8818 8595 gf180mcu_fd_sc_mcu9t5v0__mux2_1
* cell instance $12685 m0 *1 1362.48,816.48
X$12685 9596 9571 2255 9691 9810 9828 gf180mcu_fd_sc_mcu9t5v0__mux2_1
* cell instance $12686 m0 *1 1358.56,826.56
X$12686 9828 10064 2134 9841 10078 9862 gf180mcu_fd_sc_mcu9t5v0__mux2_1
* cell instance $12687 r0 *1 1358.56,766.08
X$12687 8104 8595 8719 8693 8582 gf180mcu_fd_sc_mcu9t5v0__dffq_2
* cell instance $12688 m0 *1 1358.56,786.24
X$12688 3930 8843 8961 8104 gf180mcu_fd_sc_mcu9t5v0__clkbuf_8
* cell instance $12689 r0 *1 1357.44,786.24
X$12689 8104 9339 6792 9201 8961 gf180mcu_fd_sc_mcu9t5v0__dffq_2
* cell instance $12690 m0 *1 1331.12,816.48
X$12690 3103 9825 9707 4930 9691 9810 9806 gf180mcu_fd_sc_mcu9t5v0__aoi211_1
* cell instance $12691 m0 *1 1330.56,776.16
X$12691 3103 8861 9706 8693 8818 8813 gf180mcu_fd_sc_mcu9t5v0__oai21_1
* cell instance $12692 m0 *1 1328.88,786.24
X$12692 8961 8843 gf180mcu_fd_sc_mcu9t5v0__filltie
* cell instance $12693 m0 *1 1330,786.24
X$12693 8593 8843 8961 8988 gf180mcu_fd_sc_mcu9t5v0__clkinv_1
* cell instance $12694 m0 *1 1367.52,766.08
X$12694 8453 8568 2255 8445 8582 8569 gf180mcu_fd_sc_mcu9t5v0__mux2_1
* cell instance $12695 m0 *1 1322.16,786.24
X$12695 8988 3340 8985 8984 8986 8843 8961 8987
+ gf180mcu_fd_sc_mcu9t5v0__oai221_1
* cell instance $12696 m0 *1 1320.48,776.16
X$12696 3462 8833 7975 8693 8818 8717 gf180mcu_fd_sc_mcu9t5v0__nand3_1
* cell instance $12697 m0 *1 1345.12,776.16
X$12697 8718 8567 7345 8693 8818 8594 gf180mcu_fd_sc_mcu9t5v0__mux2_1
* cell instance $12698 m0 *1 1328.88,806.4
X$12698 9575 9432 gf180mcu_fd_sc_mcu9t5v0__filltie
* cell instance $12699 m0 *1 1316,806.4
X$12699 9570 9569 4493 9432 9575 9592 gf180mcu_fd_sc_mcu9t5v0__mux2_1
* cell instance $12700 m0 *1 1360.24,816.48
X$12700 9827 9691 9810 9593 gf180mcu_fd_sc_mcu9t5v0__clkinv_1
* cell instance $12701 r0 *1 1354.08,786.24
X$12701 8104 9201 8961 33552 gf180mcu_fd_sc_mcu9t5v0__clkinv_2
* cell instance $12702 r0 *1 1349.6,796.32
X$12702 9449 9432 9315 9109 gf180mcu_fd_sc_mcu9t5v0__clkinv_1
* cell instance $12703 r0 *1 1340.64,786.24
X$12703 9107 4045 9201 8961 9108 gf180mcu_fd_sc_mcu9t5v0__nor2_1
* cell instance $12704 r0 *1 1349.6,786.24
X$12704 9112 4255 9201 8961 9111 gf180mcu_fd_sc_mcu9t5v0__nor2_1
* cell instance $12705 r0 *1 1344,786.24
X$12705 9109 3923 9108 9111 9201 8961 9110 gf180mcu_fd_sc_mcu9t5v0__aoi211_1
* cell instance $12706 r0 *1 1341.2,816.48
X$12706 9826 4045 9841 9810 9594 gf180mcu_fd_sc_mcu9t5v0__nor2_1
* cell instance $12707 r0 *1 1346.24,806.4
X$12707 9709 4255 9691 9575 9595 gf180mcu_fd_sc_mcu9t5v0__nor2_1
* cell instance $12708 r0 *1 1340.64,806.4
X$12708 9593 3923 9594 9595 9691 9575 9708 gf180mcu_fd_sc_mcu9t5v0__aoi211_1
* cell instance $12709 r0 *1 1322.72,786.24
X$12709 8104 8987 8593 9201 8961 gf180mcu_fd_sc_mcu9t5v0__dffq_2
* cell instance $12710 m0 *1 1317.12,816.48
X$12710 9822 9821 9691 9810 9823 gf180mcu_fd_sc_mcu9t5v0__nand2_1
* cell instance $12711 m0 *1 1339.52,816.48
X$12711 9591 9708 9827 9691 9810 gf180mcu_fd_sc_mcu9t5v0__dffq_2
* cell instance $12712 m0 *1 1328.88,816.48
X$12712 9810 9691 gf180mcu_fd_sc_mcu9t5v0__filltie
* cell instance $12713 m0 *1 1343.44,796.32
X$12713 8104 9110 9449 9201 9315 gf180mcu_fd_sc_mcu9t5v0__dffq_2
* cell instance $12714 m0 *1 1288.56,766.08
X$12714 8564 8563 2891 8445 8582 8351 gf180mcu_fd_sc_mcu9t5v0__mux2_1
* cell instance $12715 m0 *1 1289.12,826.56
X$12715 2891 10327 10063 4497 9841 10078 10089 gf180mcu_fd_sc_mcu9t5v0__aoi211_1
* cell instance $12716 m0 *1 1286.32,826.56
X$12716 10061 10054 9841 10078 10091 gf180mcu_fd_sc_mcu9t5v0__nand2_1
* cell instance $12717 r0 *1 1253.28,766.08
X$12717 8714 6261 6042 8693 8582 8857 gf180mcu_fd_sc_mcu9t5v0__and3_1
* cell instance $12718 m0 *1 1268.4,766.08
X$12718 7570 8562 8563 8445 8582 gf180mcu_fd_sc_mcu9t5v0__dffq_2
* cell instance $12719 m0 *1 1306.48,816.48
X$12719 8715 4258 4275 10207 9691 9810 9821 gf180mcu_fd_sc_mcu9t5v0__aoi22_1
* cell instance $12720 r0 *1 1304.8,786.24
X$12720 8982 8565 3120 9201 8961 9106 gf180mcu_fd_sc_mcu9t5v0__mux2_1
* cell instance $12721 r0 *1 1298.64,766.08
X$12721 8593 8715 2891 8693 8582 8354 gf180mcu_fd_sc_mcu9t5v0__mux2_1
* cell instance $12722 r0 *1 1270.64,776.16
X$12722 6930 8858 7566 8843 8818 8859 gf180mcu_fd_sc_mcu9t5v0__mux2_1
* cell instance $12723 m0 *1 1289.12,806.4
X$12723 8104 9448 8715 9432 9575 gf180mcu_fd_sc_mcu9t5v0__dffq_2
* cell instance $12724 m0 *1 1266.72,786.24
X$12724 7570 8859 6930 8843 8961 gf180mcu_fd_sc_mcu9t5v0__dffq_2
* cell instance $12725 r0 *1 1258.32,776.16
X$12725 5567 8843 8818 8714 gf180mcu_fd_sc_mcu9t5v0__clkinv_1
* cell instance $12726 r0 *1 1249.92,776.16
X$12726 7566 8856 8857 8843 8818 8832 gf180mcu_fd_sc_mcu9t5v0__aoi21_1
* cell instance $12727 r0 *1 1291.36,776.16
X$12727 7463 8564 1961 8843 8818 8860 gf180mcu_fd_sc_mcu9t5v0__mux2_1
* cell instance $12728 m0 *1 1286.32,786.24
X$12728 8104 8860 8564 8843 8961 gf180mcu_fd_sc_mcu9t5v0__dffq_2
* cell instance $12729 m0 *1 1249.36,776.16
X$12729 7570 8832 5567 8693 8818 gf180mcu_fd_sc_mcu9t5v0__dffq_2
* cell instance $12730 r0 *1 1272.88,766.08
X$12730 8350 8563 2472 8693 8582 8562 gf180mcu_fd_sc_mcu9t5v0__mux2_2
* cell instance $12731 r0 *1 1289.68,806.4
X$12731 7463 6925 4045 9691 9575 9337 gf180mcu_fd_sc_mcu9t5v0__nor3_1
* cell instance $12732 r0 *1 1289.12,796.32
X$12732 10352 6925 3923 9447 9337 9432 9315 9448
+ gf180mcu_fd_sc_mcu9t5v0__aoi221_1
* cell instance $12733 r0 *1 1267.28,806.4
X$12733 10578 9568 9590 9691 9575 gf180mcu_fd_sc_mcu9t5v0__dffq_2
* cell instance $12734 m0 *1 1244.88,796.32
X$12734 9444 9565 7566 9201 9315 9332 gf180mcu_fd_sc_mcu9t5v0__mux2_1
* cell instance $12735 m0 *1 1273.44,816.48
X$12735 9590 9691 9810 9566 gf180mcu_fd_sc_mcu9t5v0__clkinv_1
* cell instance $12736 m0 *1 1276.24,806.4
X$12736 9571 6925 4045 9432 9575 9567 gf180mcu_fd_sc_mcu9t5v0__nor3_1
* cell instance $12737 m0 *1 1268.4,806.4
X$12737 10729 6925 3923 9566 9567 9432 9575 9568
+ gf180mcu_fd_sc_mcu9t5v0__aoi221_1
* cell instance $12738 m0 *1 1259.44,796.32
X$12738 6281 6557 7685 9201 9315 9214 gf180mcu_fd_sc_mcu9t5v0__nor3_1
* cell instance $12739 r0 *1 1263.36,796.32
X$12739 6919 9330 9336 9432 9315 9335 gf180mcu_fd_sc_mcu9t5v0__aoi21_1
* cell instance $12740 r0 *1 1260.56,796.32
X$12740 8573 9333 9432 9315 9334 gf180mcu_fd_sc_mcu9t5v0__nand2_1
* cell instance $12741 m0 *1 1248.24,826.56
X$12741 10060 10058 5781 9841 10078 10059 gf180mcu_fd_sc_mcu9t5v0__mux2_2
* cell instance $12742 r0 *1 1279.04,786.24
X$12742 9336 9201 8961 6280 gf180mcu_fd_sc_mcu9t5v0__buf_8
* cell instance $12743 m0 *1 1263.92,796.32
X$12743 9333 9214 9335 9334 9201 9315 8858 gf180mcu_fd_sc_mcu9t5v0__oai31_1
* cell instance $12744 m0 *1 1262.24,826.56
X$12744 10055 9841 10078 7463 gf180mcu_fd_sc_mcu9t5v0__buf_8
* cell instance $12745 m0 *1 1308.16,796.32
X$12745 3806 8983 9201 9315 9338 gf180mcu_fd_sc_mcu9t5v0__nor2_1
* cell instance $12746 m0 *1 1283.52,826.56
X$12746 7463 5434 9841 10078 10062 gf180mcu_fd_sc_mcu9t5v0__nand2_1
* cell instance $12747 r0 *1 1294.72,806.4
X$12747 8715 9691 9575 9447 gf180mcu_fd_sc_mcu9t5v0__clkinv_1
* cell instance $12748 m0 *1 1300.32,756
X$12748 8103 2786 8078 8204 8221 gf180mcu_fd_sc_mcu9t5v0__nand2_1
* cell instance $12749 m0 *1 1276.8,735.84
X$12749 3816 7671 7814 7570 gf180mcu_fd_sc_mcu9t5v0__clkbuf_8
* cell instance $12750 r0 *1 1251.6,745.92
X$12750 8099 6261 6042 8078 7948 8100 gf180mcu_fd_sc_mcu9t5v0__and3_1
* cell instance $12751 m0 *1 1249.92,756
X$12751 7570 8349 6978 8078 8204 gf180mcu_fd_sc_mcu9t5v0__dffq_2
* cell instance $12752 r0 *1 1257.76,695.52
X$12752 6676 6568 4911 6909 6805 6785 gf180mcu_fd_sc_mcu9t5v0__mux2_1
* cell instance $12753 m0 *1 1271.2,705.6
X$12753 7093 2786 2997 6978 5389 6909 6943 6787
+ gf180mcu_fd_sc_mcu9t5v0__aoi221_1
* cell instance $12754 r0 *1 1262.8,735.84
X$12754 7936 6261 6042 7919 7814 7807 gf180mcu_fd_sc_mcu9t5v0__and3_1
* cell instance $12755 m0 *1 1293.04,715.68
X$12755 7098 7097 7071 7195 7216 gf180mcu_fd_sc_mcu9t5v0__nand2_1
* cell instance $12756 r0 *1 1291.92,705.6
X$12756 6679 4254 4252 6028 7071 6943 7098 gf180mcu_fd_sc_mcu9t5v0__aoi22_1
* cell instance $12757 m0 *1 1294.16,705.6
X$12757 4045 5565 6909 6943 6979 gf180mcu_fd_sc_mcu9t5v0__nor2_1
* cell instance $12758 m0 *1 1294.72,735.84
X$12758 7463 9809 2264 7671 7814 7827 gf180mcu_fd_sc_mcu9t5v0__mux2_1
* cell instance $12759 m0 *1 1291.92,745.92
X$12759 7827 8102 2373 7919 7948 7937 gf180mcu_fd_sc_mcu9t5v0__mux2_1
* cell instance $12760 r0 *1 1287.44,735.84
X$12760 7570 7937 8102 7919 7814 gf180mcu_fd_sc_mcu9t5v0__dffq_2
* cell instance $12761 r0 *1 1276.24,725.76
X$12761 8099 2987 7671 7558 7340 gf180mcu_fd_sc_mcu9t5v0__nand2_1
* cell instance $12762 r0 *1 1263.36,745.92
X$12762 4263 6557 7685 6669 8078 7948 7972 gf180mcu_fd_sc_mcu9t5v0__oai31_1
* cell instance $12763 r0 *1 1286.88,705.6
X$12763 6811 4258 4275 6978 7071 6943 7097 gf180mcu_fd_sc_mcu9t5v0__aoi22_1
* cell instance $12764 m0 *1 1268.4,735.84
X$12764 7566 7973 7807 7671 7814 7826 gf180mcu_fd_sc_mcu9t5v0__aoi21_1
* cell instance $12765 m0 *1 1297.52,705.6
X$12765 6976 6925 3923 6788 6979 6909 6943 6980
+ gf180mcu_fd_sc_mcu9t5v0__aoi221_1
* cell instance $12766 m0 *1 1262.24,745.92
X$12766 4961 6669 7971 7972 7919 7948 7973 gf180mcu_fd_sc_mcu9t5v0__oai22_1
* cell instance $12767 m0 *1 1262.8,715.68
X$12767 6679 6676 7093 6978 3120 3239 7071 7195 7096
+ gf180mcu_fd_sc_mcu9t5v0__mux4_1
* cell instance $12768 r0 *1 1261.12,705.6
X$12768 7096 6449 4916 7071 6943 7095 gf180mcu_fd_sc_mcu9t5v0__mux2_1
* cell instance $12769 r0 *1 1268.4,735.84
X$12769 7570 7826 4384 7919 7814 gf180mcu_fd_sc_mcu9t5v0__dffq_2
* cell instance $12770 r0 *1 1248.24,725.76
X$12770 7570 7459 4787 7671 7558 gf180mcu_fd_sc_mcu9t5v0__dffq_2
* cell instance $12771 r0 *1 1299.2,745.92
X$12771 7572 2786 2997 8102 2880 8078 7948 8101
+ gf180mcu_fd_sc_mcu9t5v0__aoi221_1
* cell instance $12772 r0 *1 1276.8,715.68
X$12772 7093 2987 7340 3459 7316 7195 7341 gf180mcu_fd_sc_mcu9t5v0__oai211_1
* cell instance $12773 m0 *1 1280.16,715.68
X$12773 6679 6676 2987 7071 7195 7215 gf180mcu_fd_sc_mcu9t5v0__mux2_1
* cell instance $12774 r0 *1 1296.4,695.52
X$12774 6811 6909 6805 6788 gf180mcu_fd_sc_mcu9t5v0__clkinv_1
* cell instance $12775 r0 *1 1283.52,715.68
X$12775 3806 7341 7462 7316 7195 7342 gf180mcu_fd_sc_mcu9t5v0__nand3_1
* cell instance $12776 r0 *1 1302.56,715.68
X$12776 3806 6572 7342 4952 7316 7195 7343 gf180mcu_fd_sc_mcu9t5v0__oai211_1
* cell instance $12777 m0 *1 1257.2,725.76
X$12777 4787 7316 7558 7461 gf180mcu_fd_sc_mcu9t5v0__clkinv_1
* cell instance $12778 m0 *1 1251.6,725.76
X$12778 7461 6261 6042 7316 7558 7460 gf180mcu_fd_sc_mcu9t5v0__and3_1
* cell instance $12779 m0 *1 1247.12,725.76
X$12779 7566 7458 7460 7316 7558 7459 gf180mcu_fd_sc_mcu9t5v0__aoi21_1
* cell instance $12780 r0 *1 1274.56,745.92
X$12780 6978 8078 7948 8099 gf180mcu_fd_sc_mcu9t5v0__clkinv_1
* cell instance $12781 m0 *1 1273.44,735.84
X$12781 7570 7671 7814 33551 gf180mcu_fd_sc_mcu9t5v0__clkinv_2
* cell instance $12782 r0 *1 1260.56,735.84
X$12782 4384 7919 7814 7936 gf180mcu_fd_sc_mcu9t5v0__clkinv_1
* cell instance $12783 m0 *1 1279.6,725.76
X$12783 3351 7215 7316 7558 7462 gf180mcu_fd_sc_mcu9t5v0__nand2_1
* cell instance $12784 m0 *1 1344.56,735.84
X$12784 7570 7575 5574 7671 7814 gf180mcu_fd_sc_mcu9t5v0__dffq_2
* cell instance $12785 m0 *1 1328.88,735.84
X$12785 7814 7671 gf180mcu_fd_sc_mcu9t5v0__filltie
* cell instance $12786 m0 *1 1330,745.92
X$12786 8222 8103 2573 7919 7948 7976 gf180mcu_fd_sc_mcu9t5v0__mux2_2
* cell instance $12787 m0 *1 1346.24,745.92
X$12787 7349 4045 7919 7948 7977 gf180mcu_fd_sc_mcu9t5v0__nor2_1
* cell instance $12788 r0 *1 1347.92,715.68
X$12788 6281 6280 4255 7316 7195 7344 gf180mcu_fd_sc_mcu9t5v0__mux2_1
* cell instance $12789 m0 *1 1365.84,705.6
X$12789 3103 6931 6909 6943 6932 gf180mcu_fd_sc_mcu9t5v0__nand2_1
* cell instance $12790 r0 *1 1340.64,715.68
X$12790 6814 7344 7345 7316 7195 7217 gf180mcu_fd_sc_mcu9t5v0__mux2_1
* cell instance $12791 r0 *1 1369.2,695.52
X$12791 3103 6793 6933 6932 6909 6805 6913 gf180mcu_fd_sc_mcu9t5v0__oai22_1
* cell instance $12792 m0 *1 1330,735.84
X$12792 7808 7574 5299 7671 7814 7691 gf180mcu_fd_sc_mcu9t5v0__mux2_1
* cell instance $12793 m0 *1 1350.16,745.92
X$12793 7670 4255 7919 7948 7978 gf180mcu_fd_sc_mcu9t5v0__nor2_1
* cell instance $12794 r0 *1 1346.24,745.92
X$12794 7982 3923 7977 7978 8078 7948 8106 gf180mcu_fd_sc_mcu9t5v0__aoi211_1
* cell instance $12795 m0 *1 1331.68,756
X$12795 9809 7463 2788 8078 8204 8222 gf180mcu_fd_sc_mcu9t5v0__mux2_1
* cell instance $12796 r0 *1 1321.6,725.76
X$12796 7570 7691 7808 7671 7558 gf180mcu_fd_sc_mcu9t5v0__dffq_2
* cell instance $12797 r0 *1 1348.48,725.76
X$12797 4967 5064 4255 7671 7558 7464 gf180mcu_fd_sc_mcu9t5v0__mux2_1
* cell instance $12798 m0 *1 1355.76,745.92
X$12798 3103 7938 7979 7919 7948 7920 gf180mcu_fd_sc_mcu9t5v0__oai21_1
* cell instance $12799 m0 *1 1346.8,725.76
X$12799 5574 7464 7345 7316 7558 7575 gf180mcu_fd_sc_mcu9t5v0__mux2_1
* cell instance $12800 r0 *1 1374.8,695.52
X$12800 6794 6795 4497 6909 6805 6933 gf180mcu_fd_sc_mcu9t5v0__aoi21_1
* cell instance $12801 r0 *1 1327.2,745.92
X$12801 8104 7976 8103 8078 7948 gf180mcu_fd_sc_mcu9t5v0__dffq_2
* cell instance $12802 m0 *1 1328.88,756
X$12802 8204 8078 gf180mcu_fd_sc_mcu9t5v0__filltie
* cell instance $12803 m0 *1 1330,725.76
X$12803 9809 7463 6030 7316 7558 7574 gf180mcu_fd_sc_mcu9t5v0__mux2_1
* cell instance $12804 m0 *1 1328.88,725.76
X$12804 7558 7316 gf180mcu_fd_sc_mcu9t5v0__filltie
* cell instance $12805 m0 *1 1328.88,705.6
X$12805 6943 6909 gf180mcu_fd_sc_mcu9t5v0__filltie
* cell instance $12806 m0 *1 1328.88,745.92
X$12806 7948 7919 gf180mcu_fd_sc_mcu9t5v0__filltie
* cell instance $12807 m0 *1 1328.88,715.68
X$12807 7195 7071 gf180mcu_fd_sc_mcu9t5v0__filltie
* cell instance $12808 m0 *1 1321.6,705.6
X$12808 6570 6927 3340 6909 6943 6981 gf180mcu_fd_sc_mcu9t5v0__mux2_1
* cell instance $12809 r0 *1 1354.64,695.52
X$12809 6814 4258 4275 6930 6909 6805 6813 gf180mcu_fd_sc_mcu9t5v0__aoi22_1
* cell instance $12810 r0 *1 1323.84,695.52
X$12810 6976 4048 6928 6909 6805 6927 gf180mcu_fd_sc_mcu9t5v0__oai21_1
* cell instance $12811 r0 *1 1351.84,745.92
X$12811 8104 8106 8107 8078 7948 gf180mcu_fd_sc_mcu9t5v0__dffq_2
* cell instance $12812 r0 *1 1331.12,695.52
X$12812 6789 4493 6928 4491 6929 6909 6805 6812
+ gf180mcu_fd_sc_mcu9t5v0__oai221_1
* cell instance $12813 m0 *1 1344,715.68
X$12813 7570 7217 6814 7071 7195 gf180mcu_fd_sc_mcu9t5v0__dffq_2
* cell instance $12814 r0 *1 1316.56,705.6
X$12814 7570 6981 6570 7071 6943 gf180mcu_fd_sc_mcu9t5v0__dffq_2
* cell instance $12815 r0 *1 1337.84,695.52
X$12815 5290 6812 6679 6909 6805 gf180mcu_fd_sc_mcu9t5v0__dffq_2
* cell instance $12816 r0 *1 1365.28,715.68
X$12816 7347 7218 4916 7316 7195 7346 gf180mcu_fd_sc_mcu9t5v0__mux2_1
* cell instance $12817 r0 *1 1361.92,695.52
X$12817 6815 4765 4906 6930 6909 6805 6931 gf180mcu_fd_sc_mcu9t5v0__aoi22_1
* cell instance $12818 m0 *1 1330.56,705.6
X$12818 4048 5565 6909 6943 6928 gf180mcu_fd_sc_mcu9t5v0__nand2_1
* cell instance $12819 m0 *1 1317.12,745.92
X$12819 3459 7974 7919 7948 7975 gf180mcu_fd_sc_mcu9t5v0__nand2_1
* cell instance $12820 m0 *1 1313.2,725.76
X$12820 9809 7463 2250 7316 7558 7573 gf180mcu_fd_sc_mcu9t5v0__mux2_1
* cell instance $12821 r0 *1 1371.44,745.92
X$12821 7939 7981 2134 8078 7948 7980 gf180mcu_fd_sc_mcu9t5v0__mux2_1
* cell instance $12822 r0 *1 1209.04,756
X$12822 8204 8445 gf180mcu_fd_sc_mcu9t5v0__filltie
* cell instance $12823 r0 *1 1174.88,756
X$12823 2262 5667 6916 8445 8204 8345 gf180mcu_fd_sc_mcu9t5v0__and3_1
* cell instance $12824 r0 *1 1180.48,756
X$12824 5766 8345 8214 8213 8445 8204 8346 gf180mcu_fd_sc_mcu9t5v0__oai31_1
* cell instance $12825 r0 *1 1188.88,756
X$12825 6272 8347 4782 8445 8204 gf180mcu_fd_sc_mcu9t5v0__dffq_2
* cell instance $12826 r0 *1 1214.64,756
X$12826 6272 8348 4784 8445 8204 gf180mcu_fd_sc_mcu9t5v0__dffq_2
* cell instance $12827 r0 *1 1173.76,705.6
X$12827 5910 5667 5767 7071 6943 7090 gf180mcu_fd_sc_mcu9t5v0__and3_1
* cell instance $12828 r0 *1 1169.84,776.16
X$12828 6272 8852 9103 8843 8818 gf180mcu_fd_sc_mcu9t5v0__dffq_2
* cell instance $12829 m0 *1 1173.76,786.24
X$12829 8826 9103 2134 8843 8961 8852 gf180mcu_fd_sc_mcu9t5v0__mux2_1
* cell instance $12830 r0 *1 1163.12,806.4
X$12830 9584 8853 8825 9703 2987 3106 9691 9575 9323
+ gf180mcu_fd_sc_mcu9t5v0__mux4_1
* cell instance $12831 r0 *1 1169.28,735.84
X$12831 6406 6669 7823 7824 7919 7814 7802 gf180mcu_fd_sc_mcu9t5v0__oai22_1
* cell instance $12832 m0 *1 1164.24,725.76
X$12832 7456 7316 7558 2263 gf180mcu_fd_sc_mcu9t5v0__buf_8
* cell instance $12833 r0 *1 1114.96,756
X$12833 5766 8336 8337 8211 8445 8204 8591 gf180mcu_fd_sc_mcu9t5v0__oai31_1
* cell instance $12834 r0 *1 1139.04,756
X$12834 8339 8342 8341 8445 8204 8338 gf180mcu_fd_sc_mcu9t5v0__oai21_1
* cell instance $12835 r0 *1 1153.6,756
X$12835 8093 8339 8341 8445 8204 7970 gf180mcu_fd_sc_mcu9t5v0__oai21_1
* cell instance $12836 r0 *1 1163.68,756
X$12836 8344 7800 7798 8445 8204 7456 gf180mcu_fd_sc_mcu9t5v0__aoi21_1
* cell instance $12837 r0 *1 1122.24,756
X$12837 5667 6916 8338 8445 8204 8337 gf180mcu_fd_sc_mcu9t5v0__aoi21_1
* cell instance $12838 r0 *1 1158.08,756
X$12838 8343 8339 8341 8445 8204 8212 gf180mcu_fd_sc_mcu9t5v0__oai21_1
* cell instance $12839 r0 *1 1109.36,756
X$12839 2148 5667 5767 8445 8204 8336 gf180mcu_fd_sc_mcu9t5v0__and3_1
* cell instance $12840 r0 *1 1235.92,766.08
X$12840 4810 6557 7685 6669 8693 8582 8713 gf180mcu_fd_sc_mcu9t5v0__oai31_1
* cell instance $12841 r0 *1 1209.04,776.16
X$12841 8818 8843 gf180mcu_fd_sc_mcu9t5v0__filltie
* cell instance $12842 m0 *1 1178.8,826.56
X$12842 10051 10049 4916 9841 10078 10087 gf180mcu_fd_sc_mcu9t5v0__mux2_1
* cell instance $12843 m0 *1 1194.48,816.48
X$12843 9549 9691 9810 6973 gf180mcu_fd_sc_mcu9t5v0__buf_4
* cell instance $12844 r0 *1 1235.36,796.32
X$12844 6919 9330 8980 9432 9315 9446 gf180mcu_fd_sc_mcu9t5v0__aoi21_1
* cell instance $12845 m0 *1 1190,806.4
X$12845 2891 9327 9432 9575 9562 gf180mcu_fd_sc_mcu9t5v0__nor2_1
* cell instance $12846 r0 *1 1190,806.4
X$12846 4529 9704 9691 9575 9563 gf180mcu_fd_sc_mcu9t5v0__nor2_1
* cell instance $12847 r0 *1 1181.6,806.4
X$12847 9585 2786 4949 9444 9691 9575 9561 gf180mcu_fd_sc_mcu9t5v0__aoi22_1
* cell instance $12848 m0 *1 1184.4,806.4
X$12848 4497 9562 9563 9561 9432 9575 9556 gf180mcu_fd_sc_mcu9t5v0__oai31_1
* cell instance $12849 m0 *1 1235.92,826.56
X$12849 10352 5667 10697 9841 10078 10056 gf180mcu_fd_sc_mcu9t5v0__and3_1
* cell instance $12850 r0 *1 1209.04,796.32
X$12850 9315 9432 gf180mcu_fd_sc_mcu9t5v0__filltie
* cell instance $12851 m0 *1 1202.88,806.4
X$12851 9585 9444 9327 9704 2987 3351 9432 9575 9445
+ gf180mcu_fd_sc_mcu9t5v0__mux4_1
* cell instance $12852 r0 *1 1210.16,796.32
X$12852 3462 9445 9325 4952 9432 9315 9586 gf180mcu_fd_sc_mcu9t5v0__oai211_1
* cell instance $12853 m0 *1 1226.96,806.4
X$12853 5667 9330 8980 9432 9575 9564 gf180mcu_fd_sc_mcu9t5v0__aoi21_1
* cell instance $12854 r0 *1 1186.64,796.32
X$12854 8853 4258 4275 9444 4545 9432 9315 9328
+ gf180mcu_fd_sc_mcu9t5v0__aoi221_1
* cell instance $12855 m0 *1 1226.96,786.24
X$12855 8981 7800 7798 8843 8961 8980 gf180mcu_fd_sc_mcu9t5v0__aoi21_2
* cell instance $12856 r0 *1 1222.48,816.48
X$12856 9859 5766 9841 9810 9860 gf180mcu_fd_sc_mcu9t5v0__nand2_1
* cell instance $12857 m0 *1 1187.2,796.32
X$12857 9327 4254 4252 9103 9201 9315 9326 gf180mcu_fd_sc_mcu9t5v0__aoi22_1
* cell instance $12858 r0 *1 1192.8,796.32
X$12858 4545 9328 9326 9432 9315 10206 gf180mcu_fd_sc_mcu9t5v0__oai21_1
* cell instance $12859 r0 *1 1221.36,806.4
X$12859 9585 9587 5781 9691 9575 9705 gf180mcu_fd_sc_mcu9t5v0__mux2_2
* cell instance $12860 m0 *1 1204,826.56
X$12860 8824 9859 10054 9841 10078 10052 gf180mcu_fd_sc_mcu9t5v0__mux2_1
* cell instance $12861 r0 *1 1215.76,796.32
X$12861 6281 5667 10697 9432 9315 9213 gf180mcu_fd_sc_mcu9t5v0__and3_1
* cell instance $12862 r0 *1 1209.04,806.4
X$12862 9575 9691 gf180mcu_fd_sc_mcu9t5v0__filltie
* cell instance $12863 r0 *1 1193.36,806.4
X$12863 9701 9691 9575 7800 gf180mcu_fd_sc_mcu9t5v0__buf_4
* cell instance $12864 m0 *1 1209.04,796.32
X$12864 8573 8326 9201 9315 9212 gf180mcu_fd_sc_mcu9t5v0__or2_1
* cell instance $12865 m0 *1 1196.72,826.56
X$12865 9704 10052 10053 9841 10078 10088 gf180mcu_fd_sc_mcu9t5v0__mux2_1
* cell instance $12866 r0 *1 1210.16,776.16
X$12866 6272 8855 6815 8843 8818 gf180mcu_fd_sc_mcu9t5v0__dffq_2
* cell instance $12867 m0 *1 1213.52,796.32
X$12867 5766 9213 9329 9212 9201 9315 8979 gf180mcu_fd_sc_mcu9t5v0__oai31_1
* cell instance $12868 r0 *1 1209.04,816.48
X$12868 9810 9841 gf180mcu_fd_sc_mcu9t5v0__filltie
* cell instance $12869 m0 *1 1213.52,786.24
X$12869 6973 8979 8830 8843 8961 8855 gf180mcu_fd_sc_mcu9t5v0__aoi21_1
* cell instance $12870 r0 *1 1187.76,776.16
X$12870 8853 8843 8818 8854 gf180mcu_fd_sc_mcu9t5v0__clkinv_1
* cell instance $12871 r0 *1 1183.84,816.48
X$12871 9327 9704 9585 9444 3120 3239 9841 9810 10051
+ gf180mcu_fd_sc_mcu9t5v0__mux4_1
* cell instance $12872 r0 *1 1209.04,786.24
X$12872 8961 9201 gf180mcu_fd_sc_mcu9t5v0__filltie
* cell instance $12873 m0 *1 1219.68,816.48
X$12873 10578 9705 9585 9691 9810 gf180mcu_fd_sc_mcu9t5v0__dffq_2
* cell instance $12874 r0 *1 1229.76,806.4
X$12874 5766 9564 9588 9860 9691 9575 9587 gf180mcu_fd_sc_mcu9t5v0__oai31_1
* cell instance $12875 r0 *1 1226.96,786.24
X$12875 8980 9201 8961 8824 gf180mcu_fd_sc_mcu9t5v0__buf_8
* cell instance $12876 m0 *1 1233.68,776.16
X$12876 7805 7800 6919 5767 7798 8693 8818 8831
+ gf180mcu_fd_sc_mcu9t5v0__aoi221_1
* cell instance $12877 m0 *1 1215.2,776.16
X$12877 8217 8216 8331 6815 8693 8818 8830 gf180mcu_fd_sc_mcu9t5v0__aoi211_1
* cell instance $12878 r0 *1 1209.04,766.08
X$12878 8582 8693 gf180mcu_fd_sc_mcu9t5v0__filltie
* cell instance $12879 m0 *1 1178.24,776.16
X$12879 8823 8824 2250 8693 8818 8826 gf180mcu_fd_sc_mcu9t5v0__mux2_1
* cell instance $12880 m0 *1 1192.24,776.16
X$12880 8854 3923 8828 8829 8693 8818 8827 gf180mcu_fd_sc_mcu9t5v0__aoi211_1
* cell instance $12881 m0 *1 1192.24,786.24
X$12881 4045 8824 8843 8961 8828 gf180mcu_fd_sc_mcu9t5v0__nor2_1
* cell instance $12882 m0 *1 1195.6,786.24
X$12882 8823 4255 8843 8961 8829 gf180mcu_fd_sc_mcu9t5v0__nor2_1
* cell instance $12883 r0 *1 1190,776.16
X$12883 6272 8827 8853 8843 8818 gf180mcu_fd_sc_mcu9t5v0__dffq_2
* cell instance $12884 r0 *1 1148.56,806.4
X$12884 9584 8853 2891 9691 9575 9702 gf180mcu_fd_sc_mcu9t5v0__mux2_1
* cell instance $12885 r0 *1 1145.2,806.4
X$12885 5902 9702 9691 9575 9559 gf180mcu_fd_sc_mcu9t5v0__nand2_1
* cell instance $12886 r0 *1 1129.52,776.16
X$12886 8823 8824 6030 8843 8818 8851 gf180mcu_fd_sc_mcu9t5v0__mux2_1
* cell instance $12887 m0 *1 1110.48,786.24
X$12887 8822 8976 2573 8843 8961 8975 gf180mcu_fd_sc_mcu9t5v0__mux2_1
* cell instance $12888 r0 *1 1154.16,816.48
X$12888 8825 9703 9584 8853 3120 3121 9841 9810 9858
+ gf180mcu_fd_sc_mcu9t5v0__mux4_1
* cell instance $12889 r0 *1 1137.36,786.24
X$12889 8976 2786 4949 8978 2992 9201 8961 9104
+ gf180mcu_fd_sc_mcu9t5v0__aoi221_1
* cell instance $12890 m0 *1 1163.12,826.56
X$12890 8824 8823 3677 9841 10078 10050 gf180mcu_fd_sc_mcu9t5v0__mux2_2
* cell instance $12891 m0 *1 1123.92,786.24
X$12891 6272 8977 8978 8843 8961 gf180mcu_fd_sc_mcu9t5v0__dffq_2
* cell instance $12892 m0 *1 1118.32,816.48
X$12892 9582 9691 9810 4045 gf180mcu_fd_sc_mcu9t5v0__buf_8
* cell instance $12893 m0 *1 1156.4,776.16
X$12893 6272 8712 8825 8693 8818 gf180mcu_fd_sc_mcu9t5v0__dffq_2
* cell instance $12894 r0 *1 1147.44,786.24
X$12894 9103 9321 8976 8978 3120 3121 9201 8961 9105
+ gf180mcu_fd_sc_mcu9t5v0__mux4_1
* cell instance $12895 m0 *1 1149.68,826.56
X$12895 9858 9105 3239 9841 10078 10049 gf180mcu_fd_sc_mcu9t5v0__mux2_1
* cell instance $12896 r0 *1 1155.84,806.4
X$12896 8825 9703 2891 9691 9575 9560 gf180mcu_fd_sc_mcu9t5v0__mux2_1
* cell instance $12897 m0 *1 1144.64,806.4
X$12897 5902 9560 9432 9575 9558 gf180mcu_fd_sc_mcu9t5v0__nand2_1
* cell instance $12898 r0 *1 1135.12,796.32
X$12898 9103 2786 4949 9321 2880 9432 9315 9443
+ gf180mcu_fd_sc_mcu9t5v0__aoi221_1
* cell instance $12899 m0 *1 1138.48,806.4
X$12899 9559 9104 9558 9443 3103 9432 9575 9557
+ gf180mcu_fd_sc_mcu9t5v0__aoi221_1
* cell instance $12900 r0 *1 1128.4,786.24
X$12900 8978 8851 5299 9201 8961 8977 gf180mcu_fd_sc_mcu9t5v0__mux2_1
* cell instance $12901 m0 *1 1135.12,826.56
X$12901 9820 10460 2788 9841 10078 10048 gf180mcu_fd_sc_mcu9t5v0__mux2_1
* cell instance $12902 r0 *1 1114.4,806.4
X$12902 9555 9691 9575 4255 gf180mcu_fd_sc_mcu9t5v0__buf_8
* cell instance $12903 m0 *1 1118.88,806.4
X$12903 9555 9582 9432 9575 3923 gf180mcu_fd_sc_mcu9t5v0__and2_4
* cell instance $12904 m0 *1 1135.12,766.08
X$12904 8452 8560 8445 8582 8341 gf180mcu_fd_sc_mcu9t5v0__or2_1
* cell instance $12905 r0 *1 1167.04,796.32
X$12905 3462 9324 9322 9432 9315 9325 gf180mcu_fd_sc_mcu9t5v0__nand3_1
* cell instance $12906 m0 *1 1130.64,766.08
X$12906 8340 8339 8341 8445 8582 8451 gf180mcu_fd_sc_mcu9t5v0__oai21_1
* cell instance $12907 m0 *1 1114.96,776.16
X$12907 8823 8824 2788 8693 8818 8822 gf180mcu_fd_sc_mcu9t5v0__mux2_1
* cell instance $12908 m0 *1 1145.2,786.24
X$12908 8976 8978 9103 9321 2987 3106 8843 8961 9211
+ gf180mcu_fd_sc_mcu9t5v0__mux4_1
* cell instance $12909 m0 *1 1127.84,826.56
X$12909 10048 10047 2573 9841 10078 10085 gf180mcu_fd_sc_mcu9t5v0__mux2_1
* cell instance $12910 r0 *1 1164.24,796.32
X$12910 3351 9323 9432 9315 9324 gf180mcu_fd_sc_mcu9t5v0__nand2_1
* cell instance $12911 m0 *1 1160.32,796.32
X$12911 3459 9211 9201 9315 9322 gf180mcu_fd_sc_mcu9t5v0__nand2_1
* cell instance $12912 r0 *1 1160.88,766.08
X$12912 8824 8825 1961 8693 8582 8712 gf180mcu_fd_sc_mcu9t5v0__mux2_1
* cell instance $12913 m0 *1 1114.4,796.32
X$12913 8824 8823 2141 9201 9315 9102 gf180mcu_fd_sc_mcu9t5v0__mux2_1
* cell instance $12914 m0 *1 1141.28,766.08
X$12914 8561 8445 8582 7798 gf180mcu_fd_sc_mcu9t5v0__buf_8
* cell instance $12915 r0 *1 1140.16,766.08
X$12915 8452 8560 8693 8582 8561 gf180mcu_fd_sc_mcu9t5v0__nor2_2
* cell instance $12916 m0 *1 1132.88,806.4
X$12916 3103 9556 9557 4930 9432 9575 9428 gf180mcu_fd_sc_mcu9t5v0__aoi211_1
* cell instance $12917 r0 *1 1114.4,725.76
X$12917 4048 6025 7671 7558 7683 gf180mcu_fd_sc_mcu9t5v0__nand2_1
* cell instance $12918 m0 *1 1167.04,735.84
X$12918 5910 6557 7685 6669 7671 7814 7824 gf180mcu_fd_sc_mcu9t5v0__oai31_1
* cell instance $12919 r0 *1 1170.96,705.6
X$12919 6406 5766 7071 6943 7212 gf180mcu_fd_sc_mcu9t5v0__nand2_1
* cell instance $12920 m0 *1 1156.96,756
X$12920 3816 8078 8204 6272 gf180mcu_fd_sc_mcu9t5v0__clkbuf_8
* cell instance $12921 r0 *1 1114.4,745.92
X$12921 7963 4769 8078 7948 7932 gf180mcu_fd_sc_mcu9t5v0__nand2_1
* cell instance $12922 r0 *1 1133.44,745.92
X$12922 6919 6916 8338 8078 7948 7966 gf180mcu_fd_sc_mcu9t5v0__aoi21_1
* cell instance $12923 m0 *1 1116.08,715.68
X$12923 6968 7209 3340 7071 7195 7210 gf180mcu_fd_sc_mcu9t5v0__mux2_1
* cell instance $12924 r0 *1 1132.88,695.52
X$12924 2891 6924 6909 6805 6566 gf180mcu_fd_sc_mcu9t5v0__nand2_1
* cell instance $12925 m0 *1 1151.92,705.6
X$12925 6970 6909 6943 2149 gf180mcu_fd_sc_mcu9t5v0__buf_8
* cell instance $12926 r0 *1 1144.64,695.52
X$12926 6925 6909 6805 3924 gf180mcu_fd_sc_mcu9t5v0__buf_8
* cell instance $12927 r0 *1 1133.44,705.6
X$12927 6272 6969 6922 7071 6943 gf180mcu_fd_sc_mcu9t5v0__dffq_2
* cell instance $12928 r0 *1 1122.8,695.52
X$12928 3351 6923 6909 6805 6967 gf180mcu_fd_sc_mcu9t5v0__nand2_1
* cell instance $12929 r0 *1 1134.56,725.76
X$12929 7566 7684 7567 7671 7558 7565 gf180mcu_fd_sc_mcu9t5v0__aoi21_1
* cell instance $12930 m0 *1 1117.76,735.84
X$12930 7795 7671 7814 6025 gf180mcu_fd_sc_mcu9t5v0__buf_8
* cell instance $12931 m0 *1 1114.4,725.76
X$12931 7454 4048 7683 7316 7558 7209 gf180mcu_fd_sc_mcu9t5v0__oai21_1
* cell instance $12932 r0 *1 1111.6,735.84
X$12932 7822 4493 7683 4491 7932 7919 7814 7933
+ gf180mcu_fd_sc_mcu9t5v0__oai221_1
* cell instance $12933 r0 *1 1137.92,745.92
X$12933 4047 6557 7685 6669 8078 7948 7967 gf180mcu_fd_sc_mcu9t5v0__oai31_1
* cell instance $12934 r0 *1 1128.96,705.6
X$12934 4045 6025 7071 6943 7089 gf180mcu_fd_sc_mcu9t5v0__nor2_1
* cell instance $12935 m0 *1 1138.48,745.92
X$12935 5284 6669 7966 7967 7919 7948 7684 gf180mcu_fd_sc_mcu9t5v0__oai22_1
* cell instance $12936 m0 *1 1111.04,745.92
X$12936 6272 7933 7337 7919 7948 gf180mcu_fd_sc_mcu9t5v0__dffq_2
* cell instance $12937 r0 *1 1156.96,745.92
X$12937 6272 8078 7948 gf180mcu_fd_sc_mcu9t5v0__clkinv_8
* cell instance $12938 r0 *1 1154.72,745.92
X$12938 8093 8078 7948 8094 gf180mcu_fd_sc_mcu9t5v0__clkinv_1
* cell instance $12939 m0 *1 1152.48,756
X$12939 8094 8452 7798 8078 8204 5398 gf180mcu_fd_sc_mcu9t5v0__aoi21_1
* cell instance $12940 r0 *1 1167.04,745.92
X$12940 8343 8078 7948 8344 gf180mcu_fd_sc_mcu9t5v0__clkinv_1
* cell instance $12941 m0 *1 1133.44,705.6
X$12941 7454 3924 3923 6924 7089 6909 6943 6969
+ gf180mcu_fd_sc_mcu9t5v0__aoi221_1
* cell instance $12942 m0 *1 1131.2,705.6
X$12942 6922 6909 6943 6924 gf180mcu_fd_sc_mcu9t5v0__clkinv_1
* cell instance $12943 m0 *1 1140.16,735.84
X$12943 4564 7671 7814 7455 gf180mcu_fd_sc_mcu9t5v0__clkinv_1
* cell instance $12944 m0 *1 1155.84,715.68
X$12944 7211 7071 7195 5286 gf180mcu_fd_sc_mcu9t5v0__buf_8
* cell instance $12945 m0 *1 1140.72,725.76
X$12945 7455 6261 6042 7316 7558 7567 gf180mcu_fd_sc_mcu9t5v0__and3_1
* cell instance $12946 r0 *1 1113.28,715.68
X$12946 6272 7210 6968 7316 7195 gf180mcu_fd_sc_mcu9t5v0__dffq_2
* cell instance $12947 r0 *1 1107.68,715.68
X$12947 4545 7335 7336 7316 7195 7338 gf180mcu_fd_sc_mcu9t5v0__oai21_1
* cell instance $12948 m0 *1 1142.4,735.84
X$12948 7799 7800 7798 7671 7814 7795 gf180mcu_fd_sc_mcu9t5v0__aoi21_2
* cell instance $12949 m0 *1 1150.8,745.92
X$12949 8342 7919 7948 7934 gf180mcu_fd_sc_mcu9t5v0__clkinv_1
* cell instance $12950 m0 *1 1118.32,756
X$12950 5284 8326 8078 8204 8211 gf180mcu_fd_sc_mcu9t5v0__or2_1
* cell instance $12951 m0 *1 1108.8,745.92
X$12951 7337 7919 7948 7822 gf180mcu_fd_sc_mcu9t5v0__clkinv_1
* cell instance $12952 m0 *1 1157.52,735.84
X$12952 7801 7800 7798 7671 7814 7211 gf180mcu_fd_sc_mcu9t5v0__aoi21_2
* cell instance $12953 r0 *1 1162.56,735.84
X$12953 7801 7800 6919 5767 7798 7919 7814 7823
+ gf180mcu_fd_sc_mcu9t5v0__aoi221_1
* cell instance $12954 m0 *1 1144.08,745.92
X$12954 8340 7919 7948 7799 gf180mcu_fd_sc_mcu9t5v0__clkinv_1
* cell instance $12955 r0 *1 1139.04,725.76
X$12955 6272 7565 4564 7671 7558 gf180mcu_fd_sc_mcu9t5v0__dffq_2
* cell instance $12956 r0 *1 1151.92,735.84
X$12956 7800 7934 7798 7919 7814 6970 gf180mcu_fd_sc_mcu9t5v0__aoi21_1
* cell instance $12957 m0 *1 1233.68,735.84
X$12957 7935 7800 6919 5767 7798 7671 7814 7806
+ gf180mcu_fd_sc_mcu9t5v0__aoi221_1
* cell instance $12958 r0 *1 1232.56,735.84
X$12958 7935 7800 7798 7919 7814 5401 gf180mcu_fd_sc_mcu9t5v0__aoi21_2
* cell instance $12959 r0 *1 1232,725.76
X$12959 7805 7800 7798 7671 7558 5432 gf180mcu_fd_sc_mcu9t5v0__aoi21_2
* cell instance $12960 m0 *1 1234.24,756
X$12960 7804 7800 6919 5767 7798 8078 8204 8219
+ gf180mcu_fd_sc_mcu9t5v0__aoi221_1
* cell instance $12961 r0 *1 1209.04,705.6
X$12961 6943 7071 gf180mcu_fd_sc_mcu9t5v0__filltie
* cell instance $12962 r0 *1 1209.04,725.76
X$12962 7558 7671 gf180mcu_fd_sc_mcu9t5v0__filltie
* cell instance $12963 m0 *1 1178.8,705.6
X$12963 6440 6972 6973 6909 6943 6971 gf180mcu_fd_sc_mcu9t5v0__mux2_2
* cell instance $12964 r0 *1 1181.6,725.76
X$12964 7686 6261 6042 7671 7558 7803 gf180mcu_fd_sc_mcu9t5v0__and3_1
* cell instance $12965 m0 *1 1178.8,735.84
X$12965 6272 7825 6439 7671 7814 gf180mcu_fd_sc_mcu9t5v0__dffq_2
* cell instance $12966 r0 *1 1210.16,725.76
X$12966 7570 7568 4781 7671 7558 gf180mcu_fd_sc_mcu9t5v0__dffq_2
* cell instance $12967 m0 *1 1189.44,756
X$12967 6973 8346 8215 8078 8204 8347 gf180mcu_fd_sc_mcu9t5v0__aoi21_1
* cell instance $12968 r0 *1 1179.36,705.6
X$12968 4382 6971 6440 7071 6943 gf180mcu_fd_sc_mcu9t5v0__dffq_2
* cell instance $12969 m0 *1 1210.72,745.92
X$12969 2270 5667 6916 7919 7948 7969 gf180mcu_fd_sc_mcu9t5v0__and3_1
* cell instance $12970 m0 *1 1177.12,715.68
X$12970 5667 6916 5286 7071 7195 7213 gf180mcu_fd_sc_mcu9t5v0__aoi21_1
* cell instance $12971 m0 *1 1181.6,715.68
X$12971 5766 7090 7213 7212 7071 7195 6972 gf180mcu_fd_sc_mcu9t5v0__oai31_1
* cell instance $12972 m0 *1 1196.16,705.6
X$12972 6442 6437 6440 6439 2987 3459 6909 6943 6974
+ gf180mcu_fd_sc_mcu9t5v0__mux4_1
* cell instance $12973 r0 *1 1191.68,695.52
X$12973 6442 6437 6440 6439 3120 3239 6909 6805 6810
+ gf180mcu_fd_sc_mcu9t5v0__mux4_1
* cell instance $12974 r0 *1 1204.56,745.92
X$12974 4961 8326 8078 7948 8095 gf180mcu_fd_sc_mcu9t5v0__or2_1
* cell instance $12975 r0 *1 1204.56,725.76
X$12975 7566 7688 7689 7671 7558 7568 gf180mcu_fd_sc_mcu9t5v0__aoi21_1
* cell instance $12976 r0 *1 1218,745.92
X$12976 5667 6916 7970 8078 7948 8097 gf180mcu_fd_sc_mcu9t5v0__aoi21_1
* cell instance $12977 m0 *1 1197.28,745.92
X$12977 6919 6916 8212 7919 7948 7968 gf180mcu_fd_sc_mcu9t5v0__aoi21_1
* cell instance $12978 r0 *1 1198.4,725.76
X$12978 3926 6557 7685 6669 7671 7558 7687 gf180mcu_fd_sc_mcu9t5v0__oai31_1
* cell instance $12979 r0 *1 1212.4,745.92
X$12979 5766 7969 8097 8095 8078 7948 8096 gf180mcu_fd_sc_mcu9t5v0__oai31_1
* cell instance $12980 m0 *1 1201.2,735.84
X$12980 4956 6669 7968 7687 7671 7814 7688 gf180mcu_fd_sc_mcu9t5v0__oai22_1
* cell instance $12981 m0 *1 1229.2,745.92
X$12981 6919 6916 7970 7919 7948 7971 gf180mcu_fd_sc_mcu9t5v0__aoi21_1
* cell instance $12982 m0 *1 1205.12,725.76
X$12982 4781 7316 7558 7457 gf180mcu_fd_sc_mcu9t5v0__clkinv_1
* cell instance $12983 m0 *1 1193.92,756
X$12983 8217 8216 8331 4782 8078 8204 8215 gf180mcu_fd_sc_mcu9t5v0__aoi211_1
* cell instance $12984 r0 *1 1209.04,735.84
X$12984 7814 7919 gf180mcu_fd_sc_mcu9t5v0__filltie
* cell instance $12985 m0 *1 1217.44,756
X$12985 8217 8216 8331 4784 8078 8204 8218 gf180mcu_fd_sc_mcu9t5v0__aoi211_1
* cell instance $12986 m0 *1 1212.96,756
X$12986 6973 8096 8218 8078 8204 8348 gf180mcu_fd_sc_mcu9t5v0__aoi21_1
* cell instance $12987 r0 *1 1209.04,745.92
X$12987 7948 8078 gf180mcu_fd_sc_mcu9t5v0__filltie
* cell instance $12988 m0 *1 1226.4,735.84
X$12988 7804 7800 7798 7671 7814 7214 gf180mcu_fd_sc_mcu9t5v0__aoi21_2
* cell instance $12989 m0 *1 1183.28,756
X$12989 5667 6916 8212 8078 8204 8214 gf180mcu_fd_sc_mcu9t5v0__aoi21_1
* cell instance $12990 m0 *1 1177.12,756
X$12990 4956 8326 8078 8204 8213 gf180mcu_fd_sc_mcu9t5v0__or2_1
* cell instance $12991 m0 *1 1174.32,735.84
X$12991 7566 7802 7803 7671 7814 7825 gf180mcu_fd_sc_mcu9t5v0__aoi21_1
* cell instance $12992 m0 *1 1207.36,725.76
X$12992 7457 6261 6042 7316 7558 7689 gf180mcu_fd_sc_mcu9t5v0__and3_1
* cell instance $12993 r0 *1 1184.4,735.84
X$12993 6439 7919 7814 7686 gf180mcu_fd_sc_mcu9t5v0__clkinv_1
* cell instance $12994 m0 *1 1224.16,705.6
X$12994 6569 5766 6909 6943 6975 gf180mcu_fd_sc_mcu9t5v0__nand2_1
* cell instance $12995 r0 *1 1236.48,745.92
X$12995 6976 6557 7685 6669 8078 7948 8098 gf180mcu_fd_sc_mcu9t5v0__oai31_1
* cell instance $12996 r0 *1 1209.04,695.52
X$12996 6805 6909 gf180mcu_fd_sc_mcu9t5v0__filltie
* cell instance $12997 m0 *1 1227.52,705.6
X$12997 6976 5667 5767 6909 6943 6977 gf180mcu_fd_sc_mcu9t5v0__and3_1
* cell instance $12998 r0 *1 1203.44,705.6
X$12998 3462 6974 6926 4952 7071 6943 7091 gf180mcu_fd_sc_mcu9t5v0__oai211_1
* cell instance $12999 r0 *1 1223.6,705.6
X$12999 7093 7339 5781 7071 6943 7092 gf180mcu_fd_sc_mcu9t5v0__mux2_2
* cell instance $13000 m0 *1 1219.68,715.68
X$13000 7570 7092 7093 7071 7195 gf180mcu_fd_sc_mcu9t5v0__dffq_2
* cell instance $13001 r0 *1 1232.56,705.6
X$13001 5667 6916 7214 7071 6943 7094 gf180mcu_fd_sc_mcu9t5v0__aoi21_1
* cell instance $13002 r0 *1 1209.04,715.68
X$13002 7195 7316 gf180mcu_fd_sc_mcu9t5v0__filltie
* cell instance $13003 r0 *1 1229.76,715.68
X$13003 5766 6977 7094 6975 7316 7195 7339 gf180mcu_fd_sc_mcu9t5v0__oai31_1
* cell instance $13004 r0 *1 1170.96,614.88
X$13004 4382 4805 4780 4903 4794 gf180mcu_fd_sc_mcu9t5v0__dffq_2
* cell instance $13005 m0 *1 1178.24,624.96
X$13005 2263 4956 5057 4903 5056 5061 gf180mcu_fd_sc_mcu9t5v0__mux2_1
* cell instance $13006 m0 *1 1158.64,685.44
X$13006 4382 6436 6437 6392 6425 gf180mcu_fd_sc_mcu9t5v0__dffq_2
* cell instance $13007 r0 *1 1162.56,594.72
X$13007 4382 4383 4256 4389 4266 gf180mcu_fd_sc_mcu9t5v0__dffq_2
* cell instance $13008 m0 *1 1172.64,655.2
X$13008 10722 5665 5794 2250 gf180mcu_fd_sc_mcu9t5v0__buf_8
* cell instance $13009 m0 *1 1163.12,665.28
X$13009 5928 5929 5428 4955 3120 3121 5920 6034 6026
+ gf180mcu_fd_sc_mcu9t5v0__mux4_1
* cell instance $13010 m0 *1 1154.16,624.96
X$13010 4955 4954 3920 4903 5056 4953 gf180mcu_fd_sc_mcu9t5v0__mux2_1
* cell instance $13011 m0 *1 1119.44,624.96
X$13011 3462 4951 3686 4952 4903 5056 4950 gf180mcu_fd_sc_mcu9t5v0__oai211_1
* cell instance $13012 r0 *1 1170.96,574.56
X$13012 2258 3817 3119 3796 3781 gf180mcu_fd_sc_mcu9t5v0__dffq_2
* cell instance $13013 r0 *1 1179.36,635.04
X$13013 4382 5287 5288 5390 5297 gf180mcu_fd_sc_mcu9t5v0__dffq_2
* cell instance $13014 m0 *1 1191.12,645.12
X$13014 5288 5427 5430 5671 3120 3121 5390 5411 5799
+ gf180mcu_fd_sc_mcu9t5v0__mux4_1
* cell instance $13015 r0 *1 1192.24,675.36
X$13015 5671 4258 4275 6439 4545 6392 6292 6410
+ gf180mcu_fd_sc_mcu9t5v0__aoi221_1
* cell instance $13016 r0 *1 1214.64,675.36
X$13016 6444 4493 6409 4491 6411 6392 6292 6412
+ gf180mcu_fd_sc_mcu9t5v0__oai221_1
* cell instance $13017 m0 *1 1235.92,655.2
X$13017 5667 6916 5401 5665 5794 5779 gf180mcu_fd_sc_mcu9t5v0__aoi21_1
* cell instance $13018 m0 *1 1196.16,685.44
X$13018 6442 4254 4252 5928 6392 6425 6441 gf180mcu_fd_sc_mcu9t5v0__aoi22_1
* cell instance $13019 m0 *1 1187.2,655.2
X$13019 3816 5665 5794 4382 gf180mcu_fd_sc_mcu9t5v0__clkbuf_8
* cell instance $13020 r0 *1 1209.04,655.2
X$13020 5794 5920 gf180mcu_fd_sc_mcu9t5v0__filltie
* cell instance $13021 m0 *1 1201.2,685.44
X$13021 4545 6410 6441 6392 6425 6443 gf180mcu_fd_sc_mcu9t5v0__oai21_1
* cell instance $13022 r0 *1 1209.04,675.36
X$13022 6292 6392 gf180mcu_fd_sc_mcu9t5v0__filltie
* cell instance $13023 r0 *1 1209.04,665.28
X$13023 6034 6144 gf180mcu_fd_sc_mcu9t5v0__filltie
* cell instance $13024 r0 *1 1188.88,655.2
X$13024 4045 5286 5920 5794 5907 gf180mcu_fd_sc_mcu9t5v0__nor2_1
* cell instance $13025 r0 *1 1189.44,675.36
X$13025 4048 5286 6392 6292 6409 gf180mcu_fd_sc_mcu9t5v0__nand2_1
* cell instance $13026 m0 *1 1183.84,645.12
X$13026 5288 5427 2891 5390 5411 5429 gf180mcu_fd_sc_mcu9t5v0__mux2_1
* cell instance $13027 r0 *1 1209.04,624.96
X$13027 5056 5183 gf180mcu_fd_sc_mcu9t5v0__filltie
* cell instance $13028 m0 *1 1208.48,665.28
X$13028 4382 5800 5671 5920 6034 gf180mcu_fd_sc_mcu9t5v0__dffq_2
* cell instance $13029 m0 *1 1201.2,635.04
X$13029 5430 5671 5288 5427 2987 3106 5183 5297 5289
+ gf180mcu_fd_sc_mcu9t5v0__mux4_1
* cell instance $13030 r0 *1 1231.44,655.2
X$13030 5062 5766 5920 5794 5801 gf180mcu_fd_sc_mcu9t5v0__nand2_1
* cell instance $13031 r0 *1 1214.64,665.28
X$13031 5910 4048 6409 6144 6034 5560 gf180mcu_fd_sc_mcu9t5v0__oai21_1
* cell instance $13032 r0 *1 1210.16,655.2
X$13032 5910 3924 3923 5909 5907 5920 5794 5800
+ gf180mcu_fd_sc_mcu9t5v0__aoi221_1
* cell instance $13033 m0 *1 1203.44,665.28
X$13033 3462 5559 5931 5920 6034 6926 gf180mcu_fd_sc_mcu9t5v0__nand3_1
* cell instance $13034 m0 *1 1187.2,665.28
X$13034 5799 6026 3239 5920 6034 6027 gf180mcu_fd_sc_mcu9t5v0__mux2_1
* cell instance $13035 m0 *1 1215.2,685.44
X$13035 4382 6412 6442 6392 6425 gf180mcu_fd_sc_mcu9t5v0__dffq_2
* cell instance $13036 r0 *1 1209.04,645.12
X$13036 5411 5665 gf180mcu_fd_sc_mcu9t5v0__filltie
* cell instance $13037 r0 *1 1184.96,655.2
X$13037 5902 5429 5920 5794 5905 gf180mcu_fd_sc_mcu9t5v0__nand2_1
* cell instance $13038 m0 *1 1180.48,665.28
X$13038 5928 2786 2997 5929 2880 5920 6034 5906
+ gf180mcu_fd_sc_mcu9t5v0__aoi221_1
* cell instance $13039 r0 *1 1205.12,655.2
X$13039 5671 5920 5794 5909 gf180mcu_fd_sc_mcu9t5v0__clkinv_1
* cell instance $13040 r0 *1 1200.64,655.2
X$13040 2891 5909 5920 5794 5908 gf180mcu_fd_sc_mcu9t5v0__nand2_1
* cell instance $13041 r0 *1 1192.24,655.2
X$13041 2891 5430 5908 5902 5920 5794 5930 gf180mcu_fd_sc_mcu9t5v0__oai211_1
* cell instance $13042 r0 *1 1179.92,655.2
X$13042 5905 5906 5930 6044 5920 5794 5904 gf180mcu_fd_sc_mcu9t5v0__aoi22_1
* cell instance $13043 m0 *1 1212.96,685.44
X$13043 6442 6392 6425 6444 gf180mcu_fd_sc_mcu9t5v0__clkinv_1
* cell instance $13044 m0 *1 1207.36,685.44
X$13044 4529 6444 6567 4497 6392 6425 6408 gf180mcu_fd_sc_mcu9t5v0__aoi211_1
* cell instance $13045 m0 *1 1181.6,685.44
X$13045 6440 2786 2997 6439 6392 6425 6438 gf180mcu_fd_sc_mcu9t5v0__aoi22_1
* cell instance $13046 m0 *1 1178.8,685.44
X$13046 3103 6438 6392 6425 6407 gf180mcu_fd_sc_mcu9t5v0__nand2_1
* cell instance $13047 r0 *1 1179.36,675.36
X$13047 3103 5904 6408 6407 6392 6292 6141 gf180mcu_fd_sc_mcu9t5v0__oai22_1
* cell instance $13048 m0 *1 1225.28,665.28
X$13048 4668 5920 6034 5902 gf180mcu_fd_sc_mcu9t5v0__buf_8
* cell instance $13049 r0 *1 1234.24,655.2
X$13049 4055 5667 5767 5920 5794 5912 gf180mcu_fd_sc_mcu9t5v0__and3_1
* cell instance $13050 r0 *1 1220.8,635.04
X$13050 5398 5390 5297 2156 gf180mcu_fd_sc_mcu9t5v0__buf_8
* cell instance $13051 m0 *1 1234.24,685.44
X$13051 5766 6446 6447 6445 6392 6425 6448 gf180mcu_fd_sc_mcu9t5v0__oai31_1
* cell instance $13052 m0 *1 1208.48,645.12
X$13052 3351 5289 5390 5411 5559 gf180mcu_fd_sc_mcu9t5v0__nand2_1
* cell instance $13053 m0 *1 1183.28,635.04
X$13053 5286 5288 1961 5183 5297 5287 gf180mcu_fd_sc_mcu9t5v0__mux2_1
* cell instance $13054 r0 *1 1218,645.12
X$13054 5430 5560 3340 5665 5411 5431 gf180mcu_fd_sc_mcu9t5v0__mux2_1
* cell instance $13055 r0 *1 1209.04,635.04
X$13055 5297 5390 gf180mcu_fd_sc_mcu9t5v0__filltie
* cell instance $13056 r0 *1 1187.2,645.12
X$13056 4382 5665 5411 33549 gf180mcu_fd_sc_mcu9t5v0__clkinv_4
* cell instance $13057 r0 *1 1176,624.96
X$13057 4780 5061 4911 5183 5056 4805 gf180mcu_fd_sc_mcu9t5v0__mux2_1
* cell instance $13058 m0 *1 1214.64,645.12
X$13058 4382 5431 5430 5390 5411 gf180mcu_fd_sc_mcu9t5v0__dffq_2
* cell instance $13059 r0 *1 1151.92,655.2
X$13059 5428 4955 5928 5929 2987 3106 5920 5794 5903
+ gf180mcu_fd_sc_mcu9t5v0__mux4_1
* cell instance $13060 r0 *1 1164.8,645.12
X$13060 5529 5286 2788 5665 5411 5400 gf180mcu_fd_sc_mcu9t5v0__mux2_1
* cell instance $13061 m0 *1 1134,665.28
X$13061 4382 6043 5929 5920 6034 gf180mcu_fd_sc_mcu9t5v0__dffq_2
* cell instance $13062 r0 *1 1144.64,655.2
X$13062 5286 5529 2264 5920 5794 5927 gf180mcu_fd_sc_mcu9t5v0__mux2_1
* cell instance $13063 r0 *1 1114.96,665.28
X$13063 6025 6286 2578 6144 6034 6156 gf180mcu_fd_sc_mcu9t5v0__mux2_2
* cell instance $13064 r0 *1 1109.92,675.36
X$13064 6156 6275 2472 6392 6292 6273 gf180mcu_fd_sc_mcu9t5v0__mux2_2
* cell instance $13065 r0 *1 1139.04,665.28
X$13065 5927 5929 2373 6144 6034 6043 gf180mcu_fd_sc_mcu9t5v0__mux2_1
* cell instance $13066 r0 *1 1117.76,655.2
X$13066 4382 5798 5778 5920 5794 gf180mcu_fd_sc_mcu9t5v0__dffq_2
* cell instance $13067 r0 *1 1164.24,665.28
X$13067 5428 2786 2997 4955 2992 6144 6034 6044
+ gf180mcu_fd_sc_mcu9t5v0__aoi221_1
* cell instance $13068 m0 *1 1144.64,635.04
X$13068 5286 5529 2564 5183 5297 5285 gf180mcu_fd_sc_mcu9t5v0__mux2_2
* cell instance $13069 m0 *1 1138.48,645.12
X$13069 5285 5427 2472 5390 5411 5397 gf180mcu_fd_sc_mcu9t5v0__mux2_2
* cell instance $13070 m0 *1 1139.6,685.44
X$13070 4382 6403 5928 6392 6425 gf180mcu_fd_sc_mcu9t5v0__dffq_2
* cell instance $13071 r0 *1 1125.6,675.36
X$13071 5778 6275 2891 6392 6292 6276 gf180mcu_fd_sc_mcu9t5v0__mux2_1
* cell instance $13072 m0 *1 1156.96,645.12
X$13072 2258 5399 5428 5390 5411 gf180mcu_fd_sc_mcu9t5v0__dffq_2
* cell instance $13073 m0 *1 1159.76,665.28
X$13073 3459 5903 5920 6034 5931 gf180mcu_fd_sc_mcu9t5v0__nand2_1
* cell instance $13074 r0 *1 1152.48,675.36
X$13074 5529 5286 2250 6392 6292 6404 gf180mcu_fd_sc_mcu9t5v0__mux2_1
* cell instance $13075 m0 *1 1106.56,635.04
X$13075 5926 4048 5283 5183 5297 3919 gf180mcu_fd_sc_mcu9t5v0__oai21_1
* cell instance $13076 m0 *1 1127.84,635.04
X$13076 2149 5284 5057 5183 5297 5426 gf180mcu_fd_sc_mcu9t5v0__mux2_1
* cell instance $13077 m0 *1 1122.8,645.12
X$13077 4565 5426 4911 5390 5411 5396 gf180mcu_fd_sc_mcu9t5v0__mux2_1
* cell instance $13078 m0 *1 1111.04,635.04
X$13078 5280 4769 5183 5297 5282 gf180mcu_fd_sc_mcu9t5v0__nand2_1
* cell instance $13079 r0 *1 1144.08,675.36
X$13079 6404 5928 2134 6392 6292 6403 gf180mcu_fd_sc_mcu9t5v0__mux2_2
* cell instance $13080 r0 *1 1149.12,624.96
X$13080 2258 4953 4955 5183 5056 gf180mcu_fd_sc_mcu9t5v0__dffq_2
* cell instance $13081 r0 *1 1160.32,635.04
X$13081 5400 5428 2573 5390 5297 5399 gf180mcu_fd_sc_mcu9t5v0__mux2_2
* cell instance $13082 m0 *1 1113.84,635.04
X$13082 2256 4048 5183 5297 5283 gf180mcu_fd_sc_mcu9t5v0__nand2_1
* cell instance $13083 r0 *1 1133.44,635.04
X$13083 2258 5397 5427 5390 5297 gf180mcu_fd_sc_mcu9t5v0__dffq_2
* cell instance $13084 r0 *1 1153.04,635.04
X$13084 5529 5286 3575 5390 5297 4954 gf180mcu_fd_sc_mcu9t5v0__mux2_1
* cell instance $13085 r0 *1 1116.64,635.04
X$13085 2258 5396 4565 5390 5297 gf180mcu_fd_sc_mcu9t5v0__dffq_2
* cell instance $13086 r0 *1 1106,655.2
X$13086 6286 6025 3575 5920 5794 5558 gf180mcu_fd_sc_mcu9t5v0__mux2_1
* cell instance $13087 r0 *1 1165.92,675.36
X$13087 5286 6406 5057 6392 6292 6405 gf180mcu_fd_sc_mcu9t5v0__mux2_1
* cell instance $13088 m0 *1 1105.44,675.36
X$13088 6272 6273 6275 6144 6292 gf180mcu_fd_sc_mcu9t5v0__dffq_2
* cell instance $13089 m0 *1 1121.68,655.2
X$13089 6025 5778 1961 5665 5794 5798 gf180mcu_fd_sc_mcu9t5v0__mux2_1
* cell instance $13090 m0 *1 1125.6,675.36
X$13090 6295 4949 6276 5902 2880 6144 6292 6274
+ gf180mcu_fd_sc_mcu9t5v0__aoi221_1
* cell instance $13091 m0 *1 1113.84,594.72
X$13091 2257 2256 4255 4150 4266 4380 gf180mcu_fd_sc_mcu9t5v0__mux2_1
* cell instance $13092 m0 *1 1154.16,594.72
X$13092 4256 4254 4252 2151 4150 4266 4276 gf180mcu_fd_sc_mcu9t5v0__aoi22_1
* cell instance $13093 r0 *1 1153.6,594.72
X$13093 3238 4258 4275 4564 4389 4266 4381 gf180mcu_fd_sc_mcu9t5v0__aoi22_1
* cell instance $13094 r0 *1 1120,604.8
X$13094 4256 4565 4527 4564 3120 3239 4667 4512 4563
+ gf180mcu_fd_sc_mcu9t5v0__mux4_1
* cell instance $13095 r0 *1 1121.12,614.88
X$13095 4256 4565 4527 4564 2987 3459 4903 4794 4951
+ gf180mcu_fd_sc_mcu9t5v0__mux4_1
* cell instance $13096 r0 *1 1142.96,604.8
X$13096 2891 4256 4667 4512 4566 gf180mcu_fd_sc_mcu9t5v0__nor2_1
* cell instance $13097 m0 *1 1136.24,614.88
X$13097 4529 4565 4667 4794 4671 gf180mcu_fd_sc_mcu9t5v0__nor2_1
* cell instance $13098 m0 *1 1126.72,604.8
X$13098 4527 2786 2997 4564 4389 4512 4528 gf180mcu_fd_sc_mcu9t5v0__aoi22_1
* cell instance $13099 r0 *1 1137.36,604.8
X$13099 4497 4566 4671 4528 4667 4512 4672 gf180mcu_fd_sc_mcu9t5v0__oai31_1
* cell instance $13100 m0 *1 1112.72,614.88
X$13100 4563 3347 4556 4667 4794 21889 gf180mcu_fd_sc_mcu9t5v0__mux2_1
* cell instance $13101 m0 *1 1136.24,594.72
X$13101 2258 4158 3238 4150 4266 gf180mcu_fd_sc_mcu9t5v0__dffq_2
* cell instance $13102 m0 *1 1140.72,614.88
X$13102 3103 4672 4673 4930 4667 4794 4793 gf180mcu_fd_sc_mcu9t5v0__aoi211_1
* cell instance $13103 m0 *1 1162,604.8
X$13103 4277 4493 4049 4491 4492 4389 4512 4383
+ gf180mcu_fd_sc_mcu9t5v0__oai221_1
* cell instance $13104 r0 *1 1111.6,594.72
X$13104 2370 2252 4255 4389 4266 4043 gf180mcu_fd_sc_mcu9t5v0__mux2_1
* cell instance $13105 r0 *1 1158.64,594.72
X$13105 4276 4381 4389 4266 4396 gf180mcu_fd_sc_mcu9t5v0__nand2_1
* cell instance $13106 m0 *1 1153.6,574.56
X$13106 2258 3576 3118 3558 3781 gf180mcu_fd_sc_mcu9t5v0__dffq_2
* cell instance $13107 m0 *1 1160.88,594.72
X$13107 4048 2149 4150 4266 4049 gf180mcu_fd_sc_mcu9t5v0__nand2_1
* cell instance $13108 m0 *1 1167.04,614.88
X$13108 5284 4769 4667 4794 4492 gf180mcu_fd_sc_mcu9t5v0__nand2_1
* cell instance $13109 r0 *1 1144.64,574.56
X$13109 2891 3921 3796 3781 3688 gf180mcu_fd_sc_mcu9t5v0__nand2_1
* cell instance $13110 r0 *1 1158.64,554.4
X$13110 3351 3240 3334 3227 3349 gf180mcu_fd_sc_mcu9t5v0__nand2_1
* cell instance $13111 r0 *1 1125.6,574.56
X$13111 2258 3796 3781 gf180mcu_fd_sc_mcu9t5v0__clkinv_3
* cell instance $13112 m0 *1 1141.28,584.64
X$13112 3238 3796 3907 3921 gf180mcu_fd_sc_mcu9t5v0__clkinv_1
* cell instance $13113 r0 *1 1131.2,564.48
X$13113 2148 2149 3575 3558 3444 3574 gf180mcu_fd_sc_mcu9t5v0__mux2_1
* cell instance $13114 r0 *1 1130.08,574.56
X$13114 3816 3796 3781 2258 gf180mcu_fd_sc_mcu9t5v0__clkbuf_8
* cell instance $13115 r0 *1 1139.04,554.4
X$13115 3117 3350 3120 3334 3227 3347 gf180mcu_fd_sc_mcu9t5v0__mux2_1
* cell instance $13116 m0 *1 1144.64,574.56
X$13116 2891 3118 3688 2983 3558 3781 3005 gf180mcu_fd_sc_mcu9t5v0__oai211_1
* cell instance $13117 m0 *1 1128.4,584.64
X$13117 3116 3574 3920 3796 3907 3687 gf180mcu_fd_sc_mcu9t5v0__mux2_1
* cell instance $13118 r0 *1 1125.04,554.4
X$13118 3459 3115 3334 3227 3348 gf180mcu_fd_sc_mcu9t5v0__nand2_1
* cell instance $13119 r0 *1 1157.52,564.48
X$13119 3118 3577 3340 3558 3444 3576 gf180mcu_fd_sc_mcu9t5v0__mux2_1
* cell instance $13120 m0 *1 1123.36,574.56
X$13120 2258 3687 3116 3558 3781 gf180mcu_fd_sc_mcu9t5v0__dffq_2
* cell instance $13121 m0 *1 1125.04,564.48
X$13121 3462 3349 3348 3334 3444 3686 gf180mcu_fd_sc_mcu9t5v0__nand3_1
* cell instance $13122 r0 *1 1106,584.64
X$13122 2258 4044 3237 4150 3907 gf180mcu_fd_sc_mcu9t5v0__dffq_2
* cell instance $13123 r0 *1 1107.68,564.48
X$13123 3346 3919 3340 3558 3444 3573 gf180mcu_fd_sc_mcu9t5v0__mux2_1
* cell instance $13124 r0 *1 1133.44,584.64
X$13124 4045 2149 4150 3907 4046 gf180mcu_fd_sc_mcu9t5v0__nor2_1
* cell instance $13125 r0 *1 1136.8,584.64
X$13125 4047 3924 3923 3921 4046 4150 3907 4158
+ gf180mcu_fd_sc_mcu9t5v0__aoi221_1
* cell instance $13126 r0 *1 1157.52,584.64
X$13126 4047 4048 4049 4150 3907 3577 gf180mcu_fd_sc_mcu9t5v0__oai21_1
* cell instance $13127 m0 *1 1152.48,614.88
X$13127 4668 4667 4794 2983 gf180mcu_fd_sc_mcu9t5v0__buf_8
* cell instance $13128 m0 *1 1167.6,594.72
X$13128 4256 4150 4266 4277 gf180mcu_fd_sc_mcu9t5v0__clkinv_1
* cell instance $13129 m0 *1 1223.04,584.64
X$13129 3122 3791 3920 3796 3907 3818 gf180mcu_fd_sc_mcu9t5v0__mux2_1
* cell instance $13130 m0 *1 1206.24,564.48
X$13130 3459 3241 3334 3444 3460 gf180mcu_fd_sc_mcu9t5v0__nand2_1
* cell instance $13131 m0 *1 1175.44,584.64
X$13131 3119 3790 3920 3796 3907 3817 gf180mcu_fd_sc_mcu9t5v0__mux2_1
* cell instance $13132 m0 *1 1214.08,564.48
X$13132 3462 3461 3460 3334 3444 3463 gf180mcu_fd_sc_mcu9t5v0__nand3_1
* cell instance $13133 r0 *1 1183.28,564.48
X$13133 2891 3578 3579 2983 3558 3444 3354 gf180mcu_fd_sc_mcu9t5v0__oai211_1
* cell instance $13134 r0 *1 1201.76,564.48
X$13134 3578 3581 3340 3558 3444 3580 gf180mcu_fd_sc_mcu9t5v0__mux2_1
* cell instance $13135 m0 *1 1177.12,604.8
X$13135 3103 3353 4495 4494 4389 4512 4509 gf180mcu_fd_sc_mcu9t5v0__oai22_1
* cell instance $13136 r0 *1 1179.92,554.4
X$13136 3354 3224 3352 2893 3334 3227 3353 gf180mcu_fd_sc_mcu9t5v0__aoi22_1
* cell instance $13137 r0 *1 1209.04,554.4
X$13137 3227 3334 gf180mcu_fd_sc_mcu9t5v0__filltie
* cell instance $13138 m0 *1 1211.28,564.48
X$13138 3351 3243 3334 3444 3461 gf180mcu_fd_sc_mcu9t5v0__nand2_1
* cell instance $13139 r0 *1 1209.04,594.72
X$13139 4266 4389 gf180mcu_fd_sc_mcu9t5v0__filltie
* cell instance $13140 m0 *1 1189.44,584.64
X$13140 3926 3924 3923 3689 3922 3796 3907 3925
+ gf180mcu_fd_sc_mcu9t5v0__aoi221_1
* cell instance $13141 r0 *1 1217.44,574.56
X$13141 2265 3818 3122 3796 3781 gf180mcu_fd_sc_mcu9t5v0__dffq_2
* cell instance $13142 r0 *1 1227.52,614.88
X$13142 4807 3244 4916 4903 4794 4917 gf180mcu_fd_sc_mcu9t5v0__mux2_1
* cell instance $13143 r0 *1 1204.56,614.88
X$13143 4956 4769 4903 4794 4498 gf180mcu_fd_sc_mcu9t5v0__nand2_1
* cell instance $13144 m0 *1 1177.68,574.56
X$13144 2262 2263 3575 3558 3781 3790 gf180mcu_fd_sc_mcu9t5v0__mux2_1
* cell instance $13145 m0 *1 1225.84,574.56
X$13145 2270 2156 3575 3558 3781 3791 gf180mcu_fd_sc_mcu9t5v0__mux2_1
* cell instance $13146 r0 *1 1209.04,564.48
X$13146 3444 3558 gf180mcu_fd_sc_mcu9t5v0__filltie
* cell instance $13147 r0 *1 1195.6,574.56
X$13147 3242 3796 3781 3689 gf180mcu_fd_sc_mcu9t5v0__clkinv_1
* cell instance $13148 r0 *1 1233.68,594.72
X$13148 4784 2786 2997 4384 4389 4266 4259 gf180mcu_fd_sc_mcu9t5v0__aoi22_1
* cell instance $13149 m0 *1 1202.32,594.72
X$13149 3926 4048 4257 4150 4266 3581 gf180mcu_fd_sc_mcu9t5v0__oai21_1
* cell instance $13150 m0 *1 1235.92,594.72
X$13150 3103 4259 4150 4266 4260 gf180mcu_fd_sc_mcu9t5v0__nand2_1
* cell instance $13151 m0 *1 1206.8,594.72
X$13151 4048 2263 4150 4266 4257 gf180mcu_fd_sc_mcu9t5v0__nand2_1
* cell instance $13152 m0 *1 1182.72,604.8
X$13152 4529 4499 4496 4497 4389 4512 4495 gf180mcu_fd_sc_mcu9t5v0__aoi211_1
* cell instance $13153 m0 *1 1216.88,614.88
X$13153 3462 4783 3463 4952 4667 4794 4674 gf180mcu_fd_sc_mcu9t5v0__oai211_1
* cell instance $13154 m0 *1 1221.36,604.8
X$13154 4278 4280 4389 4512 4530 gf180mcu_fd_sc_mcu9t5v0__nand2_1
* cell instance $13155 r0 *1 1209.04,604.8
X$13155 4512 4667 gf180mcu_fd_sc_mcu9t5v0__filltie
* cell instance $13156 r0 *1 1210.16,614.88
X$13156 4279 4780 4782 4781 2987 3459 4903 4794 4783
+ gf180mcu_fd_sc_mcu9t5v0__mux4_1
* cell instance $13157 m0 *1 1192.24,614.88
X$13157 4782 2786 2997 4781 4667 4794 4567 gf180mcu_fd_sc_mcu9t5v0__aoi22_1
* cell instance $13158 r0 *1 1185.52,604.8
X$13158 3103 4567 4667 4512 4494 gf180mcu_fd_sc_mcu9t5v0__nand2_1
* cell instance $13159 m0 *1 1197.28,614.88
X$13159 4279 4780 4782 4781 3120 3239 4667 4794 4806
+ gf180mcu_fd_sc_mcu9t5v0__mux4_1
* cell instance $13160 m0 *1 1219.12,594.72
X$13160 3242 4258 4275 4781 4150 4266 4280 gf180mcu_fd_sc_mcu9t5v0__aoi22_1
* cell instance $13161 m0 *1 1209.6,604.8
X$13161 4279 4389 4512 4499 gf180mcu_fd_sc_mcu9t5v0__clkinv_1
* cell instance $13162 r0 *1 1209.04,614.88
X$13162 4794 4903 gf180mcu_fd_sc_mcu9t5v0__filltie
* cell instance $13163 m0 *1 1188.88,574.56
X$13163 2891 3689 3558 3781 3579 gf180mcu_fd_sc_mcu9t5v0__nand2_1
* cell instance $13164 r0 *1 1196.72,554.4
X$13164 3357 3355 3239 3334 3227 3356 gf180mcu_fd_sc_mcu9t5v0__mux2_1
* cell instance $13165 r0 *1 1209.04,574.56
X$13165 3781 3796 gf180mcu_fd_sc_mcu9t5v0__filltie
* cell instance $13166 r0 *1 1197.28,614.88
X$13166 4806 3356 4916 4903 4794 4915 gf180mcu_fd_sc_mcu9t5v0__mux2_1
* cell instance $13167 m0 *1 1201.76,604.8
X$13167 4499 4493 4257 4491 4498 4389 4512 4397
+ gf180mcu_fd_sc_mcu9t5v0__oai221_1
* cell instance $13168 r0 *1 1185.52,584.64
X$13168 4045 2263 4150 3907 3922 gf180mcu_fd_sc_mcu9t5v0__nor2_1
* cell instance $13169 r0 *1 1209.04,584.64
X$13169 3907 4150 gf180mcu_fd_sc_mcu9t5v0__filltie
* cell instance $13170 r0 *1 1188.88,584.64
X$13170 4382 3925 3242 4150 3907 gf180mcu_fd_sc_mcu9t5v0__dffq_2
* cell instance $13171 r0 *1 1177.12,554.4
X$13171 2375 2786 3334 3227 3352 gf180mcu_fd_sc_mcu9t5v0__nand2_1
* cell instance $13172 m0 *1 1198.96,574.56
X$13172 2265 3580 3578 3558 3781 gf180mcu_fd_sc_mcu9t5v0__dffq_2
* cell instance $13173 m0 *1 1214.08,594.72
X$13173 4279 4254 4252 2375 4150 4266 4278 gf180mcu_fd_sc_mcu9t5v0__aoi22_1
* cell instance $13174 m0 *1 1183.84,614.88
X$13174 4529 4780 4667 4794 4496 gf180mcu_fd_sc_mcu9t5v0__nor2_1
* cell instance $13175 r0 *1 1210.16,594.72
X$13175 4382 4397 4279 4389 4266 gf180mcu_fd_sc_mcu9t5v0__dffq_2
* cell instance $13176 m0 *1 1328.88,624.96
X$13176 5056 4903 gf180mcu_fd_sc_mcu9t5v0__filltie
* cell instance $13177 m0 *1 1312.08,635.04
X$13177 5290 5173 4057 5183 5297 gf180mcu_fd_sc_mcu9t5v0__dffq_2
* cell instance $13178 m0 *1 1295.84,665.28
X$13178 5783 6029 6028 5914 2987 3106 5920 6034 6571
+ gf180mcu_fd_sc_mcu9t5v0__mux4_1
* cell instance $13179 m0 *1 1308.72,655.2
X$13179 5290 5437 5783 5665 5794 gf180mcu_fd_sc_mcu9t5v0__dffq_2
* cell instance $13180 m0 *1 1295.28,624.96
X$13180 4534 4962 4808 4787 2987 3459 4903 5056 4964
+ gf180mcu_fd_sc_mcu9t5v0__mux4_1
* cell instance $13181 r0 *1 1308.72,675.36
X$13181 6417 6278 2891 6392 6292 6416 gf180mcu_fd_sc_mcu9t5v0__mux2_1
* cell instance $13182 m0 *1 1299.76,685.44
X$13182 6417 6278 6570 6811 3120 3121 6392 6425 6451
+ gf180mcu_fd_sc_mcu9t5v0__mux4_1
* cell instance $13183 m0 *1 1267.84,624.96
X$13183 4961 4769 4903 5056 4501 gf180mcu_fd_sc_mcu9t5v0__nand2_1
* cell instance $13184 m0 *1 1256.08,624.96
X$13184 3462 4958 3584 4952 4903 5056 4959 gf180mcu_fd_sc_mcu9t5v0__oai211_1
* cell instance $13185 r0 *1 1305.92,554.4
X$13185 3359 2475 3694 4053 3120 3121 3334 3227 3358
+ gf180mcu_fd_sc_mcu9t5v0__mux4_1
* cell instance $13186 m0 *1 1311.52,564.48
X$13186 3694 4053 3359 2475 2987 3106 3334 3444 3467
+ gf180mcu_fd_sc_mcu9t5v0__mux4_1
* cell instance $13187 m0 *1 1284.08,624.96
X$13187 4962 4903 5056 4963 gf180mcu_fd_sc_mcu9t5v0__clkinv_1
* cell instance $13188 m0 *1 1265.04,624.96
X$13188 5062 5057 4903 5056 4960 gf180mcu_fd_sc_mcu9t5v0__nand2_1
* cell instance $13189 m0 *1 1314.88,624.96
X$13189 3462 4964 3589 4952 4903 5056 4965 gf180mcu_fd_sc_mcu9t5v0__oai211_1
* cell instance $13190 m0 *1 1309.28,604.8
X$13190 4570 4493 4056 4491 4504 4389 4512 4398
+ gf180mcu_fd_sc_mcu9t5v0__oai221_1
* cell instance $13191 r0 *1 1306.48,604.8
X$13191 2377 4398 4534 4667 4512 gf180mcu_fd_sc_mcu9t5v0__dffq_2
* cell instance $13192 r0 *1 1307.04,645.12
X$13192 6022 5411 5665 2578 gf180mcu_fd_sc_mcu9t5v0__clkbuf_16
* cell instance $13193 r0 *1 1297.52,584.64
X$13193 2377 4054 4053 4150 3907 gf180mcu_fd_sc_mcu9t5v0__dffq_2
* cell instance $13194 m0 *1 1366.96,675.36
X$13194 6281 6280 2255 6144 6292 6279 gf180mcu_fd_sc_mcu9t5v0__mux2_1
* cell instance $13195 r0 *1 1372.56,635.04
X$13195 5179 5405 2134 5390 5297 5292 gf180mcu_fd_sc_mcu9t5v0__mux2_1
* cell instance $13196 m0 *1 1344.56,675.36
X$13196 4765 6144 6292 2786 gf180mcu_fd_sc_mcu9t5v0__buf_8
* cell instance $13197 r0 *1 1314.88,665.28
X$13197 5290 6049 6278 6144 6034 gf180mcu_fd_sc_mcu9t5v0__dffq_2
* cell instance $13198 m0 *1 1328.88,665.28
X$13198 6034 5920 gf180mcu_fd_sc_mcu9t5v0__filltie
* cell instance $13199 m0 *1 1330,685.44
X$13199 5290 6418 6417 6392 6425 gf180mcu_fd_sc_mcu9t5v0__dffq_2
* cell instance $13200 m0 *1 1339.52,675.36
X$13200 6277 2786 4906 5567 6144 6292 6052 gf180mcu_fd_sc_mcu9t5v0__aoi22_1
* cell instance $13201 r0 *1 1342.88,665.28
X$13201 3103 6052 6144 6034 6051 gf180mcu_fd_sc_mcu9t5v0__nand2_1
* cell instance $13202 m0 *1 1340.64,655.2
X$13202 5439 5665 5794 5561 gf180mcu_fd_sc_mcu9t5v0__clkinv_1
* cell instance $13203 m0 *1 1320.48,665.28
X$13203 5565 5564 2777 5920 6034 6050 gf180mcu_fd_sc_mcu9t5v0__mux2_2
* cell instance $13204 r0 *1 1356.88,655.2
X$13204 5784 4918 4916 5920 5794 5913 gf180mcu_fd_sc_mcu9t5v0__mux2_1
* cell instance $13205 m0 *1 1335.04,635.04
X$13205 5433 4769 5183 5297 5174 gf180mcu_fd_sc_mcu9t5v0__nand2_1
* cell instance $13206 r0 *1 1358.56,675.36
X$13206 5290 6297 6298 6392 6292 gf180mcu_fd_sc_mcu9t5v0__dffq_2
* cell instance $13207 m0 *1 1328.88,655.2
X$13207 5794 5665 gf180mcu_fd_sc_mcu9t5v0__filltie
* cell instance $13208 r0 *1 1352.4,645.12
X$13208 5177 5439 6277 5567 2987 3459 5665 5411 5568
+ gf180mcu_fd_sc_mcu9t5v0__mux4_1
* cell instance $13209 m0 *1 1328.88,685.44
X$13209 6425 6392 gf180mcu_fd_sc_mcu9t5v0__filltie
* cell instance $13210 m0 *1 1319.36,675.36
X$13210 6050 6278 2472 6144 6292 6049 gf180mcu_fd_sc_mcu9t5v0__mux2_2
* cell instance $13211 m0 *1 1340.64,665.28
X$13211 3103 4059 5301 6051 5920 6034 6143 gf180mcu_fd_sc_mcu9t5v0__oai22_1
* cell instance $13212 m0 *1 1328.88,675.36
X$13212 6292 6144 gf180mcu_fd_sc_mcu9t5v0__filltie
* cell instance $13213 r0 *1 1336.16,624.96
X$13213 5175 4493 5063 4491 5174 5183 5056 5176
+ gf180mcu_fd_sc_mcu9t5v0__oai221_1
* cell instance $13214 m0 *1 1352.4,655.2
X$13214 5177 5439 6277 5567 3120 3239 5665 5794 5784
+ gf180mcu_fd_sc_mcu9t5v0__mux4_1
* cell instance $13215 m0 *1 1328.88,645.12
X$13215 5411 5390 gf180mcu_fd_sc_mcu9t5v0__filltie
* cell instance $13216 r0 *1 1345.68,645.12
X$13216 2891 5177 5665 5411 5404 gf180mcu_fd_sc_mcu9t5v0__nor2_1
* cell instance $13217 r0 *1 1318.8,655.2
X$13217 5564 5565 2788 5920 5794 5438 gf180mcu_fd_sc_mcu9t5v0__mux2_1
* cell instance $13218 m0 *1 1360.8,635.04
X$13218 5178 5291 5183 5297 5185 gf180mcu_fd_sc_mcu9t5v0__nand2_1
* cell instance $13219 r0 *1 1313.76,635.04
X$13219 3470 3469 3575 5390 5297 5300 gf180mcu_fd_sc_mcu9t5v0__mux2_1
* cell instance $13220 r0 *1 1317.12,624.96
X$13220 4057 5300 5299 5183 5056 5173 gf180mcu_fd_sc_mcu9t5v0__mux2_1
* cell instance $13221 m0 *1 1365.84,685.44
X$13221 5290 6392 6425 33550 gf180mcu_fd_sc_mcu9t5v0__clkinv_2
* cell instance $13222 m0 *1 1330,645.12
X$13222 5290 5562 5439 5390 5411 gf180mcu_fd_sc_mcu9t5v0__dffq_2
* cell instance $13223 r0 *1 1333.36,624.96
X$13223 4048 3469 5183 5056 5063 gf180mcu_fd_sc_mcu9t5v0__nand2_1
* cell instance $13224 r0 *1 1364.16,655.2
X$13224 3462 5568 4676 4952 5920 5794 5915 gf180mcu_fd_sc_mcu9t5v0__oai211_1
* cell instance $13225 m0 *1 1312.64,645.12
X$13225 5438 5783 2573 5390 5411 5437 gf180mcu_fd_sc_mcu9t5v0__mux2_2
* cell instance $13226 r0 *1 1338.96,635.04
X$13226 2891 5561 5404 4497 5390 5297 5301 gf180mcu_fd_sc_mcu9t5v0__aoi211_1
* cell instance $13227 r0 *1 1358.56,624.96
X$13227 5177 4254 4252 3696 5183 5056 5178 gf180mcu_fd_sc_mcu9t5v0__aoi22_1
* cell instance $13228 m0 *1 1355.76,635.04
X$13228 4572 4258 4275 5567 5183 5297 5291 gf180mcu_fd_sc_mcu9t5v0__aoi22_1
* cell instance $13229 m0 *1 1338.96,635.04
X$13229 5290 5176 5177 5183 5297 gf180mcu_fd_sc_mcu9t5v0__dffq_2
* cell instance $13230 r0 *1 1329.44,675.36
X$13230 5565 6417 1961 6392 6292 6418 gf180mcu_fd_sc_mcu9t5v0__mux2_1
* cell instance $13231 m0 *1 1359.68,675.36
X$13231 6279 6298 2134 6144 6292 6297 gf180mcu_fd_sc_mcu9t5v0__mux2_1
* cell instance $13232 m0 *1 1328.88,635.04
X$13232 5297 5183 gf180mcu_fd_sc_mcu9t5v0__filltie
* cell instance $13233 r0 *1 1342.88,624.96
X$13233 5177 5183 5056 5175 gf180mcu_fd_sc_mcu9t5v0__clkinv_1
* cell instance $13234 m0 *1 1263.36,645.12
X$13234 5433 5057 5390 5411 5436 gf180mcu_fd_sc_mcu9t5v0__nand2_1
* cell instance $13235 r0 *1 1244.88,675.36
X$13235 6277 6448 5781 6392 6292 6413 gf180mcu_fd_sc_mcu9t5v0__mux2_2
* cell instance $13236 r0 *1 1267.84,624.96
X$13236 2265 5170 4962 5183 5056 gf180mcu_fd_sc_mcu9t5v0__dffq_2
* cell instance $13237 r0 *1 1263.36,645.12
X$13237 5561 4911 5435 5436 5665 5411 5562 gf180mcu_fd_sc_mcu9t5v0__oai211_1
* cell instance $13238 m0 *1 1267.28,635.04
X$13238 5434 2687 5183 5297 5169 gf180mcu_fd_sc_mcu9t5v0__nand2_1
* cell instance $13239 r0 *1 1292.48,635.04
X$13239 6029 5403 5299 5390 5297 5402 gf180mcu_fd_sc_mcu9t5v0__mux2_1
* cell instance $13240 r0 *1 1292.48,675.36
X$13240 5902 6416 6392 6292 6296 gf180mcu_fd_sc_mcu9t5v0__nand2_1
* cell instance $13241 m0 *1 1287.44,685.44
X$13241 6451 6047 3239 6392 6425 6449 gf180mcu_fd_sc_mcu9t5v0__mux2_1
* cell instance $13242 m0 *1 1247.12,655.2
X$13242 4808 5780 5781 5665 5794 5802 gf180mcu_fd_sc_mcu9t5v0__mux2_2
* cell instance $13243 m0 *1 1288.56,645.12
X$13243 5290 5402 6029 5390 5411 gf180mcu_fd_sc_mcu9t5v0__dffq_2
* cell instance $13244 r0 *1 1281.84,665.28
X$13244 6028 2786 2997 5914 2880 6144 6034 6046
+ gf180mcu_fd_sc_mcu9t5v0__aoi221_1
* cell instance $13245 r0 *1 1288,655.2
X$13245 6028 5914 5783 6029 3120 3121 5920 5794 6047
+ gf180mcu_fd_sc_mcu9t5v0__mux4_1
* cell instance $13246 r0 *1 1287.44,675.36
X$13246 6415 6048 6296 6046 6392 6292 6414 gf180mcu_fd_sc_mcu9t5v0__aoi22_1
* cell instance $13247 m0 *1 1244.32,645.12
X$13247 5432 5390 5411 3469 gf180mcu_fd_sc_mcu9t5v0__buf_8
* cell instance $13248 m0 *1 1268.4,655.2
X$13248 4382 5782 5914 5665 5794 gf180mcu_fd_sc_mcu9t5v0__dffq_2
* cell instance $13249 r0 *1 1284.64,624.96
X$13249 5172 4809 4916 5183 5056 5171 gf180mcu_fd_sc_mcu9t5v0__mux2_1
* cell instance $13250 r0 *1 1272.88,655.2
X$13250 5563 5914 2373 5920 5794 5782 gf180mcu_fd_sc_mcu9t5v0__mux2_1
* cell instance $13251 m0 *1 1261.12,675.36
X$13251 7570 6157 6028 6144 6292 gf180mcu_fd_sc_mcu9t5v0__dffq_2
* cell instance $13252 r0 *1 1270.08,665.28
X$13252 5564 5565 2250 6144 6034 6045 gf180mcu_fd_sc_mcu9t5v0__mux2_1
* cell instance $13253 m0 *1 1244.88,665.28
X$13253 4382 5802 4808 5920 6034 gf180mcu_fd_sc_mcu9t5v0__dffq_2
* cell instance $13254 m0 *1 1289.68,665.28
X$13254 5783 2786 2997 6029 2992 5920 6034 6048
+ gf180mcu_fd_sc_mcu9t5v0__aoi221_1
* cell instance $13255 m0 *1 1273.44,685.44
X$13255 3103 6414 6450 6392 6425 6387 gf180mcu_fd_sc_mcu9t5v0__oai21_1
* cell instance $13256 m0 *1 1260.56,645.12
X$13256 5434 3469 5390 5411 5435 gf180mcu_fd_sc_mcu9t5v0__nand2_1
* cell instance $13257 r0 *1 1262.24,624.96
X$13257 4963 4911 5169 4960 5183 5056 5170 gf180mcu_fd_sc_mcu9t5v0__oai211_1
* cell instance $13258 r0 *1 1294.72,645.12
X$13258 5564 5565 3575 5665 5411 5403 gf180mcu_fd_sc_mcu9t5v0__mux2_1
* cell instance $13259 r0 *1 1262.8,665.28
X$13259 6045 6028 2134 6144 6034 6157 gf180mcu_fd_sc_mcu9t5v0__mux2_1
* cell instance $13260 r0 *1 1276.8,645.12
X$13260 5565 5564 2264 5665 5411 5563 gf180mcu_fd_sc_mcu9t5v0__mux2_1
* cell instance $13261 r0 *1 1267.84,564.48
X$13261 3464 3586 3340 3558 3444 3585 gf180mcu_fd_sc_mcu9t5v0__mux2_1
* cell instance $13262 m0 *1 1244.88,574.56
X$13262 2688 2687 3575 3558 3781 3690 gf180mcu_fd_sc_mcu9t5v0__mux2_1
* cell instance $13263 m0 *1 1250.48,594.72
X$13263 3127 4258 4275 4384 4545 4150 4266 4262
+ gf180mcu_fd_sc_mcu9t5v0__aoi221_1
* cell instance $13264 r0 *1 1281.28,604.8
X$13264 3103 4568 4159 4930 4667 4512 4786 gf180mcu_fd_sc_mcu9t5v0__aoi211_1
* cell instance $13265 r0 *1 1266.16,594.72
X$13265 4048 2156 4389 4266 4264 gf180mcu_fd_sc_mcu9t5v0__nand2_1
* cell instance $13266 m0 *1 1282.96,614.88
X$13266 4808 2786 2997 4787 4667 4794 4502 gf180mcu_fd_sc_mcu9t5v0__aoi22_1
* cell instance $13267 r0 *1 1261.68,604.8
X$13267 2377 4532 4051 4667 4512 gf180mcu_fd_sc_mcu9t5v0__dffq_2
* cell instance $13268 m0 *1 1283.52,604.8
X$13268 4497 4569 4502 4389 4512 4568 gf180mcu_fd_sc_mcu9t5v0__oai21_1
* cell instance $13269 m0 *1 1267.28,594.72
X$13269 4263 4048 4264 4150 4266 3586 gf180mcu_fd_sc_mcu9t5v0__oai21_1
* cell instance $13270 m0 *1 1295.28,584.64
X$13270 4045 2687 3796 3907 3928 gf180mcu_fd_sc_mcu9t5v0__nor2_1
* cell instance $13271 m0 *1 1266.16,584.64
X$13271 4045 2156 3796 3907 3927 gf180mcu_fd_sc_mcu9t5v0__nor2_1
* cell instance $13272 r0 *1 1267.84,584.64
X$13272 2377 4052 3127 4150 3907 gf180mcu_fd_sc_mcu9t5v0__dffq_2
* cell instance $13273 r0 *1 1256.08,564.48
X$13273 3462 3583 3582 3558 3444 3584 gf180mcu_fd_sc_mcu9t5v0__nand3_1
* cell instance $13274 m0 *1 1298.64,584.64
X$13274 4053 3796 3907 3820 gf180mcu_fd_sc_mcu9t5v0__clkinv_1
* cell instance $13275 m0 *1 1290.8,564.48
X$13275 3358 3248 3239 3334 3444 4809 gf180mcu_fd_sc_mcu9t5v0__mux2_1
* cell instance $13276 r0 *1 1295.84,574.56
X$13276 2891 3820 3796 3781 3695 gf180mcu_fd_sc_mcu9t5v0__nand2_1
* cell instance $13277 m0 *1 1296.4,604.8
X$13277 4534 4254 4252 2791 4389 4512 4503 gf180mcu_fd_sc_mcu9t5v0__aoi22_1
* cell instance $13278 m0 *1 1263.36,564.48
X$13278 3351 3466 3334 3444 3583 gf180mcu_fd_sc_mcu9t5v0__nand2_1
* cell instance $13279 m0 *1 1247.12,564.48
X$13279 3459 3246 3334 3444 3582 gf180mcu_fd_sc_mcu9t5v0__nand2_1
* cell instance $13280 r0 *1 1304.24,604.8
X$13280 4534 4667 4512 4570 gf180mcu_fd_sc_mcu9t5v0__clkinv_1
* cell instance $13281 m0 *1 1295.28,574.56
X$13281 2891 3694 3695 3007 3558 3781 3693 gf180mcu_fd_sc_mcu9t5v0__oai211_1
* cell instance $13282 r0 *1 1286.32,564.48
X$13282 3128 2786 2997 3247 2992 3558 3444 3587
+ gf180mcu_fd_sc_mcu9t5v0__aoi221_1
* cell instance $13283 r0 *1 1289.12,614.88
X$13283 4534 4962 4808 4787 3120 3239 4903 4794 5172
+ gf180mcu_fd_sc_mcu9t5v0__mux4_1
* cell instance $13284 m0 *1 1284.64,574.56
X$13284 2791 2786 3558 3781 3691 gf180mcu_fd_sc_mcu9t5v0__nand2_1
* cell instance $13285 m0 *1 1287.44,574.56
X$13285 3693 3587 3691 3692 3103 3558 3781 4159
+ gf180mcu_fd_sc_mcu9t5v0__aoi221_1
* cell instance $13286 m0 *1 1262.24,584.64
X$13286 3127 3796 3907 3819 gf180mcu_fd_sc_mcu9t5v0__clkinv_1
* cell instance $13287 r0 *1 1289.68,594.72
X$13287 4053 4258 4275 4787 4545 4389 4266 4385
+ gf180mcu_fd_sc_mcu9t5v0__aoi221_1
* cell instance $13288 m0 *1 1256.64,594.72
X$13288 4545 4262 4050 4150 4266 4281 gf180mcu_fd_sc_mcu9t5v0__oai21_1
* cell instance $13289 r0 *1 1260,574.56
X$13289 2891 3819 3796 3781 3465 gf180mcu_fd_sc_mcu9t5v0__nand2_1
* cell instance $13290 m0 *1 1291.92,604.8
X$13290 4545 4385 4503 4389 4512 4533 gf180mcu_fd_sc_mcu9t5v0__oai21_1
* cell instance $13291 r0 *1 1259.44,604.8
X$13291 4051 4667 4512 4500 gf180mcu_fd_sc_mcu9t5v0__clkinv_1
* cell instance $13292 r0 *1 1246.56,604.8
X$13292 4529 4785 4667 4512 4531 gf180mcu_fd_sc_mcu9t5v0__nor2_1
* cell instance $13293 m0 *1 1244.88,604.8
X$13293 4529 4500 4531 4497 4389 4512 4261 gf180mcu_fd_sc_mcu9t5v0__aoi211_1
* cell instance $13294 m0 *1 1263.36,604.8
X$13294 4500 4493 4264 4491 4501 4389 4512 4532
+ gf180mcu_fd_sc_mcu9t5v0__oai221_1
* cell instance $13295 r0 *1 1261.68,584.64
X$13295 4263 3924 3923 3819 3927 4150 3907 4052
+ gf180mcu_fd_sc_mcu9t5v0__aoi221_1
* cell instance $13296 r0 *1 1291.36,584.64
X$13296 4055 3924 3923 3820 3928 4150 3907 4054
+ gf180mcu_fd_sc_mcu9t5v0__aoi221_1
* cell instance $13297 m0 *1 1255.52,564.48
X$13297 2891 3464 3465 3007 3334 3444 3126 gf180mcu_fd_sc_mcu9t5v0__oai211_1
* cell instance $13298 m0 *1 1263.92,574.56
X$13298 2265 3585 3464 3558 3781 gf180mcu_fd_sc_mcu9t5v0__dffq_2
* cell instance $13299 r0 *1 1286.88,604.8
X$13299 4570 4963 2891 4667 4512 4569 gf180mcu_fd_sc_mcu9t5v0__mux2_1
* cell instance $13300 r0 *1 1251.6,584.64
X$13300 4051 4254 4252 3225 4150 3907 4050 gf180mcu_fd_sc_mcu9t5v0__aoi22_1
* cell instance $13301 m0 *1 1371.44,574.56
X$13301 3473 3932 2373 3558 3781 3592 gf180mcu_fd_sc_mcu9t5v0__mux2_1
* cell instance $13302 m0 *1 1313.2,594.72
X$13302 4048 2687 4150 4266 4056 gf180mcu_fd_sc_mcu9t5v0__nand2_1
* cell instance $13303 m0 *1 1334.48,584.64
X$13303 2377 3796 3907 33559 gf180mcu_fd_sc_mcu9t5v0__inv_1
* cell instance $13304 r0 *1 1347.36,574.56
X$13304 3932 2997 3796 3781 3931 gf180mcu_fd_sc_mcu9t5v0__nand2_1
* cell instance $13305 r0 *1 1345.68,584.64
X$13305 3472 2786 2997 4057 4061 4150 3907 4060
+ gf180mcu_fd_sc_mcu9t5v0__aoi221_1
* cell instance $13306 r0 *1 1314.32,574.56
X$13306 2377 3821 3694 3796 3781 gf180mcu_fd_sc_mcu9t5v0__dffq_2
* cell instance $13307 r0 *1 1352.4,564.48
X$13307 3591 3472 2573 3558 3444 3471 gf180mcu_fd_sc_mcu9t5v0__mux2_2
* cell instance $13308 r0 *1 1331.68,564.48
X$13308 2377 3590 3696 3558 3444 gf180mcu_fd_sc_mcu9t5v0__dffq_2
* cell instance $13309 m0 *1 1328.88,584.64
X$13309 3907 3796 gf180mcu_fd_sc_mcu9t5v0__filltie
* cell instance $13310 r0 *1 1324.4,584.64
X$13310 4668 4150 3907 3007 gf180mcu_fd_sc_mcu9t5v0__buf_8
* cell instance $13311 m0 *1 1340.08,564.48
X$13311 3470 3469 2255 3334 3444 3468 gf180mcu_fd_sc_mcu9t5v0__mux2_1
* cell instance $13312 m0 *1 1336.72,584.64
X$13312 3930 3796 3907 2377 gf180mcu_fd_sc_mcu9t5v0__clkbuf_8
* cell instance $13313 m0 *1 1336.16,574.56
X$13313 3468 3696 2134 3558 3781 3590 gf180mcu_fd_sc_mcu9t5v0__mux2_1
* cell instance $13314 r0 *1 1314.32,564.48
X$13314 3462 3588 3249 3558 3444 3589 gf180mcu_fd_sc_mcu9t5v0__nand3_1
* cell instance $13315 m0 *1 1328.88,564.48
X$13315 3444 3334 gf180mcu_fd_sc_mcu9t5v0__filltie
* cell instance $13316 m0 *1 1317.12,584.64
X$13316 3694 3929 3340 3796 3907 3821 gf180mcu_fd_sc_mcu9t5v0__mux2_1
* cell instance $13317 m0 *1 1328.88,574.56
X$13317 3781 3558 gf180mcu_fd_sc_mcu9t5v0__filltie
* cell instance $13318 m0 *1 1347.36,614.88
X$13318 2377 4675 4573 4667 4794 gf180mcu_fd_sc_mcu9t5v0__dffq_2
* cell instance $13319 r0 *1 1365.28,614.88
X$13319 4811 4160 3239 4903 4794 4918 gf180mcu_fd_sc_mcu9t5v0__mux2_1
* cell instance $13320 m0 *1 1328.88,614.88
X$13320 4794 4667 gf180mcu_fd_sc_mcu9t5v0__filltie
* cell instance $13321 r0 *1 1340.64,584.64
X$13321 2880 4060 3931 4058 4150 3907 4059 gf180mcu_fd_sc_mcu9t5v0__aoi22_1
* cell instance $13322 m0 *1 1369.76,604.8
X$13322 3351 4506 4389 4512 4574 gf180mcu_fd_sc_mcu9t5v0__nand2_1
* cell instance $13323 r0 *1 1363.6,604.8
X$13323 3462 4574 4283 4667 4512 4676 gf180mcu_fd_sc_mcu9t5v0__nand3_1
* cell instance $13324 r0 *1 1314.32,584.64
X$13324 4055 4048 4056 4150 3907 3929 gf180mcu_fd_sc_mcu9t5v0__oai21_1
* cell instance $13325 r0 *1 1338.4,614.88
X$13325 4810 4048 5063 4903 4794 4788 gf180mcu_fd_sc_mcu9t5v0__oai21_1
* cell instance $13326 r0 *1 1349.04,604.8
X$13326 4573 4788 3340 4667 4512 4675 gf180mcu_fd_sc_mcu9t5v0__mux2_1
* cell instance $13327 r0 *1 1356.32,604.8
X$13327 2891 4573 4667 4512 4536 gf180mcu_fd_sc_mcu9t5v0__nor2_1
* cell instance $13328 r0 *1 1324.4,604.8
X$13328 4045 3469 4667 4512 4571 gf180mcu_fd_sc_mcu9t5v0__nor2_1
* cell instance $13329 m0 *1 1328.88,594.72
X$13329 4266 4150 gf180mcu_fd_sc_mcu9t5v0__filltie
* cell instance $13330 m0 *1 1312.64,614.88
X$13330 5062 4769 4667 4794 4504 gf180mcu_fd_sc_mcu9t5v0__nand2_1
* cell instance $13331 m0 *1 1347.36,604.8
X$13331 2891 4505 4536 4497 4389 4512 4061 gf180mcu_fd_sc_mcu9t5v0__aoi211_1
* cell instance $13332 r0 *1 1358.56,584.64
X$13332 3696 3932 3472 4057 3120 3121 4150 3907 4160
+ gf180mcu_fd_sc_mcu9t5v0__mux4_1
* cell instance $13333 m0 *1 1330,604.8
X$13333 4810 3924 3923 4505 4571 4389 4512 4535
+ gf180mcu_fd_sc_mcu9t5v0__aoi221_1
* cell instance $13334 m0 *1 1361.36,594.72
X$13334 3459 4265 4150 4266 4283 gf180mcu_fd_sc_mcu9t5v0__nand2_1
* cell instance $13335 m0 *1 1352.4,584.64
X$13335 3472 4057 3696 3932 2987 3106 3796 3907 4265
+ gf180mcu_fd_sc_mcu9t5v0__mux4_1
* cell instance $13336 m0 *1 1349.04,564.48
X$13336 2377 3471 3472 3334 3444 gf180mcu_fd_sc_mcu9t5v0__dffq_2
* cell instance $13337 m0 *1 1341.2,594.72
X$13337 3696 2786 4282 3007 2880 4150 4266 4058
+ gf180mcu_fd_sc_mcu9t5v0__aoi221_1
* cell instance $13338 m0 *1 1358.56,574.56
X$13338 3470 3469 2788 3558 3781 3591 gf180mcu_fd_sc_mcu9t5v0__mux2_1
* cell instance $13339 r0 *1 1366.4,594.72
X$13339 4575 4576 2891 4389 4266 4282 gf180mcu_fd_sc_mcu9t5v0__mux2_1
* cell instance $13340 r0 *1 1344.56,604.8
X$13340 4572 4667 4512 4505 gf180mcu_fd_sc_mcu9t5v0__clkinv_1
* cell instance $13341 r0 *1 1327.76,604.8
X$13341 2377 4535 4572 4667 4512 gf180mcu_fd_sc_mcu9t5v0__dffq_2
* cell instance $13342 r0 *1 1318.24,564.48
X$13342 3351 3467 3558 3444 3588 gf180mcu_fd_sc_mcu9t5v0__nand2_1
* cell instance $13343 m0 *1 1328.88,604.8
X$13343 4512 4389 gf180mcu_fd_sc_mcu9t5v0__filltie
* cell instance $13344 m0 *1 1436.4,695.52
X$13344 6819 6814 6575 6285 2987 3106 6664 6805 6797
+ gf180mcu_fd_sc_mcu9t5v0__mux4_1
* cell instance $13345 m0 *1 1453.76,695.52
X$13345 6280 6575 1961 6664 6805 6801 gf180mcu_fd_sc_mcu9t5v0__mux2_1
* cell instance $13346 m0 *1 1383.76,695.52
X$13346 6160 6681 6298 6284 2987 3106 6664 6805 6796
+ gf180mcu_fd_sc_mcu9t5v0__mux4_1
* cell instance $13347 m0 *1 1401.12,695.52
X$13347 6298 6284 6160 6681 3120 3121 6664 6805 6798
+ gf180mcu_fd_sc_mcu9t5v0__mux4_1
* cell instance $13348 m0 *1 1568.56,695.52
X$13348 6805 6664 gf180mcu_fd_sc_mcu9t5v0__filltie
* cell instance $13349 r0 *1 1434.72,685.44
X$13349 6575 6285 2891 6664 6425 6682 gf180mcu_fd_sc_mcu9t5v0__mux2_1
* cell instance $13350 m0 *1 1427.44,695.52
X$13350 3007 6682 6664 6805 6799 gf180mcu_fd_sc_mcu9t5v0__nand2_1
* cell instance $13351 r0 *1 1410.64,685.44
X$13351 6298 4765 4906 6284 2880 6664 6425 6574
+ gf180mcu_fd_sc_mcu9t5v0__aoi221_1
* cell instance $13352 m0 *1 1418.48,695.52
X$13352 6936 6800 6799 6574 6664 6805 6793 gf180mcu_fd_sc_mcu9t5v0__aoi22_1
* cell instance $13353 r0 *1 1448.72,685.44
X$13353 6425 6664 gf180mcu_fd_sc_mcu9t5v0__filltie
* cell instance $13354 m0 *1 1568.56,796.32
X$13354 9315 9201 gf180mcu_fd_sc_mcu9t5v0__filltie
* cell instance $13355 m0 *1 1568.56,786.24
X$13355 8961 8843 gf180mcu_fd_sc_mcu9t5v0__filltie
* cell instance $13356 m0 *1 1568.56,776.16
X$13356 8818 8693 gf180mcu_fd_sc_mcu9t5v0__filltie
* cell instance $13357 m0 *1 1568.56,735.84
X$13357 7814 7671 gf180mcu_fd_sc_mcu9t5v0__filltie
* cell instance $13358 m0 *1 1568.56,816.48
X$13358 9810 9691 gf180mcu_fd_sc_mcu9t5v0__filltie
* cell instance $13359 m0 *1 1568.56,806.4
X$13359 9575 9432 gf180mcu_fd_sc_mcu9t5v0__filltie
* cell instance $13360 m0 *1 1568.56,725.76
X$13360 7558 7316 gf180mcu_fd_sc_mcu9t5v0__filltie
* cell instance $13361 m0 *1 1568.56,745.92
X$13361 7948 7919 gf180mcu_fd_sc_mcu9t5v0__filltie
* cell instance $13362 m0 *1 1568.56,715.68
X$13362 7195 7071 gf180mcu_fd_sc_mcu9t5v0__filltie
* cell instance $13363 m0 *1 1568.56,705.6
X$13363 6943 6909 gf180mcu_fd_sc_mcu9t5v0__filltie
* cell instance $13364 m0 *1 1568.56,826.56
X$13364 10078 9841 gf180mcu_fd_sc_mcu9t5v0__filltie
* cell instance $13365 m0 *1 1568.56,766.08
X$13365 8582 8445 gf180mcu_fd_sc_mcu9t5v0__filltie
* cell instance $13366 m0 *1 1568.56,756
X$13366 8204 8078 gf180mcu_fd_sc_mcu9t5v0__filltie
* cell instance $13367 r0 *1 1449.84,695.52
X$13367 5293 6801 6575 6909 6805 gf180mcu_fd_sc_mcu9t5v0__dffq_2
* cell instance $13368 r0 *1 1449.84,806.4
X$13368 9452 9600 2472 9691 9575 9572 gf180mcu_fd_sc_mcu9t5v0__mux2_1
* cell instance $13369 m0 *1 1438.64,826.56
X$13369 9713 9590 9863 9600 2987 3106 9841 10078 10069
+ gf180mcu_fd_sc_mcu9t5v0__mux4_1
* cell instance $13370 m0 *1 1442.56,806.4
X$13370 5293 9572 9600 9432 9575 gf180mcu_fd_sc_mcu9t5v0__dffq_2
* cell instance $13371 r0 *1 1403.92,756
X$13371 8453 8568 2788 8445 8204 8357 gf180mcu_fd_sc_mcu9t5v0__mux2_1
* cell instance $13372 r0 *1 1395.52,756
X$13372 8357 8356 2573 8445 8204 8355 gf180mcu_fd_sc_mcu9t5v0__mux2_2
* cell instance $13373 r0 *1 1449.84,715.68
X$13373 7349 7670 2777 7316 7195 7352 gf180mcu_fd_sc_mcu9t5v0__mux2_2
* cell instance $13374 r0 *1 1422.96,756
X$13374 8359 8720 2363 8445 8204 8358 gf180mcu_fd_sc_mcu9t5v0__mux2_1
* cell instance $13375 m0 *1 1442.56,766.08
X$13375 5293 8599 8572 8445 8582 gf180mcu_fd_sc_mcu9t5v0__dffq_2
* cell instance $13376 m0 *1 1436.4,735.84
X$13376 7578 7693 7986 8107 3120 3121 7671 7814 7942
+ gf180mcu_fd_sc_mcu9t5v0__mux4_1
* cell instance $13377 m0 *1 1439.76,725.76
X$13377 5290 7351 7693 7316 7558 gf180mcu_fd_sc_mcu9t5v0__dffq_2
* cell instance $13378 m0 *1 1438.64,745.92
X$13378 7986 8107 7578 7693 2987 3106 7919 7948 7984
+ gf180mcu_fd_sc_mcu9t5v0__mux4_1
* cell instance $13379 r0 *1 1468.88,756
X$13379 6819 8445 8204 8110 gf180mcu_fd_sc_mcu9t5v0__clkinv_1
* cell instance $13380 r0 *1 1430.24,756
X$13380 8568 8453 2141 8445 8204 8359 gf180mcu_fd_sc_mcu9t5v0__mux2_1
* cell instance $13381 r0 *1 1448.72,756
X$13381 8204 8445 gf180mcu_fd_sc_mcu9t5v0__filltie
* cell instance $13382 r0 *1 1492.4,766.08
X$13382 5293 8693 8582 gf180mcu_fd_sc_mcu9t5v0__inv_4
* cell instance $13383 m0 *1 1492.4,776.16
X$13383 3930 8693 8818 5293 gf180mcu_fd_sc_mcu9t5v0__clkbuf_8
* cell instance $13384 r0 *1 1464.4,786.24
X$13384 9114 3340 9601 8984 9217 9201 8961 9218
+ gf180mcu_fd_sc_mcu9t5v0__oai221_1
* cell instance $13385 r0 *1 1473.36,806.4
X$13385 9713 9691 9575 9715 gf180mcu_fd_sc_mcu9t5v0__clkinv_1
* cell instance $13386 r0 *1 1457.68,816.48
X$13386 9571 9863 1961 9841 9810 9864 gf180mcu_fd_sc_mcu9t5v0__mux2_1
* cell instance $13387 r0 *1 1471.12,786.24
X$13387 8993 9201 8961 9114 gf180mcu_fd_sc_mcu9t5v0__clkinv_1
* cell instance $13388 m0 *1 1459.92,776.16
X$13388 8568 8836 1961 8693 8818 8837 gf180mcu_fd_sc_mcu9t5v0__mux2_1
* cell instance $13389 r0 *1 1453.2,796.32
X$13389 9571 9596 2578 9432 9315 9452 gf180mcu_fd_sc_mcu9t5v0__mux2_2
* cell instance $13390 m0 *1 1456,826.56
X$13390 10734 9864 9863 9841 10078 gf180mcu_fd_sc_mcu9t5v0__dffq_2
* cell instance $13391 r0 *1 1464.96,806.4
X$13391 9596 4769 9691 9575 9714 gf180mcu_fd_sc_mcu9t5v0__nand2_1
* cell instance $13392 m0 *1 1466.64,766.08
X$13392 8573 4769 8445 8582 8225 gf180mcu_fd_sc_mcu9t5v0__nand2_1
* cell instance $13393 m0 *1 1462.72,816.48
X$13393 9715 3340 9833 8984 9714 9691 9810 9834
+ gf180mcu_fd_sc_mcu9t5v0__oai221_1
* cell instance $13394 r0 *1 1453.76,766.08
X$13394 8568 8453 2578 8693 8582 8600 gf180mcu_fd_sc_mcu9t5v0__mux2_2
* cell instance $13395 r0 *1 1457.12,776.16
X$13395 5293 8837 8836 8843 8818 gf180mcu_fd_sc_mcu9t5v0__dffq_2
* cell instance $13396 m0 *1 1469.44,816.48
X$13396 5293 9834 9713 9691 9810 gf180mcu_fd_sc_mcu9t5v0__dffq_2
* cell instance $13397 m0 *1 1465.52,796.32
X$13397 5293 9218 8993 9201 9315 gf180mcu_fd_sc_mcu9t5v0__dffq_2
* cell instance $13398 m0 *1 1462.72,796.32
X$13398 8453 4769 9201 9315 9217 gf180mcu_fd_sc_mcu9t5v0__nand2_1
* cell instance $13399 m0 *1 1418.48,786.24
X$13399 8991 8992 3106 8843 8961 8983 gf180mcu_fd_sc_mcu9t5v0__mux2_1
* cell instance $13400 r0 *1 1415.68,806.4
X$13400 9451 4765 9597 3007 2992 9691 9575 9598
+ gf180mcu_fd_sc_mcu9t5v0__aoi221_1
* cell instance $13401 r0 *1 1421.84,806.4
X$13401 9712 9711 9599 9598 3103 9691 9575 9707
+ gf180mcu_fd_sc_mcu9t5v0__aoi221_1
* cell instance $13402 r0 *1 1406.72,806.4
X$13402 9596 9571 2788 9691 9575 9342 gf180mcu_fd_sc_mcu9t5v0__mux2_1
* cell instance $13403 r0 *1 1448.72,776.16
X$13403 8818 8843 gf180mcu_fd_sc_mcu9t5v0__filltie
* cell instance $13404 m0 *1 1399.44,786.24
X$13404 8719 8720 8356 8571 3120 3121 8843 8961 8990
+ gf180mcu_fd_sc_mcu9t5v0__mux4_1
* cell instance $13405 r0 *1 1381.52,776.16
X$13405 8864 8863 5299 8843 8818 8862 gf180mcu_fd_sc_mcu9t5v0__mux2_1
* cell instance $13406 r0 *1 1402.8,796.32
X$13406 9342 9451 2573 9432 9315 9450 gf180mcu_fd_sc_mcu9t5v0__mux2_2
* cell instance $13407 m0 *1 1392.72,826.56
X$13407 9709 9826 2788 9841 10078 10066 gf180mcu_fd_sc_mcu9t5v0__mux2_1
* cell instance $13408 m0 *1 1429.12,816.48
X$13408 3007 9832 9691 9810 9712 gf180mcu_fd_sc_mcu9t5v0__nand2_1
* cell instance $13409 m0 *1 1381.52,766.08
X$13409 8571 8570 5299 8445 8582 8596 gf180mcu_fd_sc_mcu9t5v0__mux2_1
* cell instance $13410 m0 *1 1431.92,816.48
X$13410 9713 9590 2891 9691 9810 9597 gf180mcu_fd_sc_mcu9t5v0__mux2_1
* cell instance $13411 r0 *1 1410.08,766.08
X$13411 8356 4765 8693 8582 8597 gf180mcu_fd_sc_mcu9t5v0__nand2_1
* cell instance $13412 m0 *1 1415.68,776.16
X$13412 8571 4906 8834 3007 2992 8693 8818 8722
+ gf180mcu_fd_sc_mcu9t5v0__aoi221_1
* cell instance $13413 r0 *1 1448.72,786.24
X$13413 8961 9201 gf180mcu_fd_sc_mcu9t5v0__filltie
* cell instance $13414 r0 *1 1431.36,786.24
X$13414 8836 8572 8993 8718 3120 3121 9201 8961 9113
+ gf180mcu_fd_sc_mcu9t5v0__mux4_1
* cell instance $13415 m0 *1 1382.64,776.16
X$13415 8453 8568 6030 8693 8818 8570 gf180mcu_fd_sc_mcu9t5v0__mux2_1
* cell instance $13416 r0 *1 1448.72,806.4
X$13416 9575 9691 gf180mcu_fd_sc_mcu9t5v0__filltie
* cell instance $13417 m0 *1 1409.52,776.16
X$13417 8719 4765 4906 8720 2880 8693 8818 8721
+ gf180mcu_fd_sc_mcu9t5v0__aoi221_1
* cell instance $13418 r0 *1 1412.88,766.08
X$13418 8597 8722 8598 8721 8693 8582 8861 gf180mcu_fd_sc_mcu9t5v0__aoi22_1
* cell instance $13419 m0 *1 1439.2,816.48
X$13419 9863 9600 2891 9691 9810 9832 gf180mcu_fd_sc_mcu9t5v0__mux2_1
* cell instance $13420 m0 *1 1391.6,766.08
X$13420 8104 8355 8356 8445 8582 gf180mcu_fd_sc_mcu9t5v0__dffq_2
* cell instance $13421 r0 *1 1448.72,796.32
X$13421 9315 9432 gf180mcu_fd_sc_mcu9t5v0__filltie
* cell instance $13422 r0 *1 1448.72,816.48
X$13422 9810 9841 gf180mcu_fd_sc_mcu9t5v0__filltie
* cell instance $13423 r0 *1 1448.72,766.08
X$13423 8582 8693 gf180mcu_fd_sc_mcu9t5v0__filltie
* cell instance $13424 m0 *1 1419.04,766.08
X$13424 5290 8358 8720 8445 8582 gf180mcu_fd_sc_mcu9t5v0__dffq_2
* cell instance $13425 m0 *1 1385.44,806.4
X$13425 9596 9571 6030 9432 9575 9215 gf180mcu_fd_sc_mcu9t5v0__mux2_1
* cell instance $13426 m0 *1 1420.72,816.48
X$13426 10064 4765 4906 9831 2880 9691 9810 9711
+ gf180mcu_fd_sc_mcu9t5v0__aoi221_1
* cell instance $13427 m0 *1 1421.28,806.4
X$13427 9216 4906 9432 9575 9599 gf180mcu_fd_sc_mcu9t5v0__nand2_1
* cell instance $13428 m0 *1 1410.64,826.56
X$13428 9112 9107 2788 9841 10078 10070 gf180mcu_fd_sc_mcu9t5v0__mux2_1
* cell instance $13429 m0 *1 1384.32,796.32
X$13429 9216 9215 5299 9201 9315 9341 gf180mcu_fd_sc_mcu9t5v0__mux2_1
* cell instance $13430 r0 *1 1440.32,766.08
X$13430 8600 8572 2472 8693 8582 8599 gf180mcu_fd_sc_mcu9t5v0__mux2_2
* cell instance $13431 m0 *1 1439.2,776.16
X$13431 8836 8572 2891 8693 8818 8835 gf180mcu_fd_sc_mcu9t5v0__mux2_1
* cell instance $13432 r0 *1 1382.64,786.24
X$13432 9112 9107 6030 9201 8961 8863 gf180mcu_fd_sc_mcu9t5v0__mux2_1
* cell instance $13433 m0 *1 1426.88,786.24
X$13433 8836 8572 8719 8720 2987 3459 8843 8961 8992
+ gf180mcu_fd_sc_mcu9t5v0__mux4_1
* cell instance $13434 m0 *1 1433.04,776.16
X$13434 3007 8835 8693 8818 8598 gf180mcu_fd_sc_mcu9t5v0__nand2_1
* cell instance $13435 m0 *1 1384.32,826.56
X$13435 10066 10065 2573 9841 10078 10094 gf180mcu_fd_sc_mcu9t5v0__mux2_2
* cell instance $13436 r0 *1 1429.68,776.16
X$13436 8993 8718 2891 8843 8818 8834 gf180mcu_fd_sc_mcu9t5v0__mux2_1
* cell instance $13437 r0 *1 1414,786.24
X$13437 8993 8718 8356 8571 2987 3459 9201 8961 8991
+ gf180mcu_fd_sc_mcu9t5v0__mux4_1
* cell instance $13438 r0 *1 1402.24,786.24
X$13438 9113 8990 3239 9201 8961 8989 gf180mcu_fd_sc_mcu9t5v0__mux2_1
* cell instance $13439 m0 *1 1399.44,806.4
X$13439 8104 9450 9451 9432 9575 gf180mcu_fd_sc_mcu9t5v0__dffq_2
* cell instance $13440 m0 *1 1402.24,826.56
X$13440 10070 10068 2573 9841 10078 10067 gf180mcu_fd_sc_mcu9t5v0__mux2_2
* cell instance $13441 r0 *1 1440.32,715.68
X$13441 7352 7693 2472 7316 7195 7351 gf180mcu_fd_sc_mcu9t5v0__mux2_2
* cell instance $13442 r0 *1 1392.72,745.92
X$13442 3462 7983 8108 8078 7948 8223 gf180mcu_fd_sc_mcu9t5v0__nand3_1
* cell instance $13443 r0 *1 1382.64,745.92
X$13443 8107 8078 7948 7982 gf180mcu_fd_sc_mcu9t5v0__clkinv_1
* cell instance $13444 r0 *1 1385.44,715.68
X$13444 7670 7349 6030 7316 7195 7348 gf180mcu_fd_sc_mcu9t5v0__mux2_1
* cell instance $13445 m0 *1 1407.84,735.84
X$13445 7220 4765 4906 7577 2992 7671 7814 7809
+ gf180mcu_fd_sc_mcu9t5v0__aoi221_1
* cell instance $13446 m0 *1 1418.48,745.92
X$13446 7981 4765 7919 7948 7829 gf180mcu_fd_sc_mcu9t5v0__nand2_1
* cell instance $13447 m0 *1 1392.72,745.92
X$13447 3459 7940 7919 7948 8108 gf180mcu_fd_sc_mcu9t5v0__nand2_1
* cell instance $13448 r0 *1 1422.4,735.84
X$13448 7828 4906 7692 3007 2880 7919 7814 7810
+ gf180mcu_fd_sc_mcu9t5v0__aoi221_1
* cell instance $13449 r0 *1 1386.56,705.6
X$13449 3462 7099 6934 4952 7071 6943 7100 gf180mcu_fd_sc_mcu9t5v0__oai211_1
* cell instance $13450 m0 *1 1424.08,725.76
X$13450 7222 7828 2363 7316 7558 7350 gf180mcu_fd_sc_mcu9t5v0__mux2_1
* cell instance $13451 r0 *1 1448.72,725.76
X$13451 7558 7671 gf180mcu_fd_sc_mcu9t5v0__filltie
* cell instance $13452 r0 *1 1416.8,695.52
X$13452 6160 4765 6818 3007 2992 6909 6805 6800
+ gf180mcu_fd_sc_mcu9t5v0__aoi221_1
* cell instance $13453 r0 *1 1430.8,695.52
X$13453 6575 6285 6819 6814 3120 3121 6909 6805 6817
+ gf180mcu_fd_sc_mcu9t5v0__mux4_1
* cell instance $13454 r0 *1 1448.72,745.92
X$13454 7948 8078 gf180mcu_fd_sc_mcu9t5v0__filltie
* cell instance $13455 r0 *1 1393.84,695.52
X$13455 3351 6797 6909 6805 6816 gf180mcu_fd_sc_mcu9t5v0__nand2_1
* cell instance $13456 r0 *1 1423.52,695.52
X$13456 6819 6814 2891 6909 6805 6818 gf180mcu_fd_sc_mcu9t5v0__mux2_1
* cell instance $13457 m0 *1 1425.76,745.92
X$13457 2891 7982 7919 7948 7985 gf180mcu_fd_sc_mcu9t5v0__nand2_1
* cell instance $13458 r0 *1 1399.44,715.68
X$13458 5290 7219 7220 7316 7195 gf180mcu_fd_sc_mcu9t5v0__dffq_2
* cell instance $13459 m0 *1 1382.08,725.76
X$13459 5290 7576 7577 7316 7558 gf180mcu_fd_sc_mcu9t5v0__dffq_2
* cell instance $13460 m0 *1 1420.16,735.84
X$13460 7830 7809 7829 7810 7671 7814 7938 gf180mcu_fd_sc_mcu9t5v0__aoi22_1
* cell instance $13461 m0 *1 1428.56,745.92
X$13461 2891 7986 7985 3007 7919 7948 7830 gf180mcu_fd_sc_mcu9t5v0__oai211_1
* cell instance $13462 r0 *1 1403.92,695.52
X$13462 6817 6798 3239 6909 6805 7218 gf180mcu_fd_sc_mcu9t5v0__mux2_1
* cell instance $13463 r0 *1 1387.12,695.52
X$13463 3459 6796 6909 6805 6935 gf180mcu_fd_sc_mcu9t5v0__nand2_1
* cell instance $13464 m0 *1 1430.24,715.68
X$13464 7349 7670 2141 7071 7195 7222 gf180mcu_fd_sc_mcu9t5v0__mux2_1
* cell instance $13465 r0 *1 1438.08,725.76
X$13465 7578 7693 2891 7671 7558 7692 gf180mcu_fd_sc_mcu9t5v0__mux2_1
* cell instance $13466 r0 *1 1448.72,735.84
X$13466 7814 7919 gf180mcu_fd_sc_mcu9t5v0__filltie
* cell instance $13467 m0 *1 1396.64,745.92
X$13467 3351 7984 7919 7948 7983 gf180mcu_fd_sc_mcu9t5v0__nand2_1
* cell instance $13468 r0 *1 1448.72,715.68
X$13468 7195 7316 gf180mcu_fd_sc_mcu9t5v0__filltie
* cell instance $13469 m0 *1 1406.72,725.76
X$13469 7670 7349 2788 7316 7558 7221 gf180mcu_fd_sc_mcu9t5v0__mux2_1
* cell instance $13470 r0 *1 1387.68,735.84
X$13470 7220 7577 7981 7828 2987 3106 7919 7814 7940
+ gf180mcu_fd_sc_mcu9t5v0__mux4_1
* cell instance $13471 r0 *1 1420.16,715.68
X$13471 5290 7350 7828 7316 7195 gf180mcu_fd_sc_mcu9t5v0__dffq_2
* cell instance $13472 r0 *1 1384.88,725.76
X$13472 7577 7348 5299 7671 7558 7576 gf180mcu_fd_sc_mcu9t5v0__mux2_1
* cell instance $13473 r0 *1 1405.04,735.84
X$13473 7981 7828 7220 7577 3120 3121 7919 7814 7941
+ gf180mcu_fd_sc_mcu9t5v0__mux4_1
* cell instance $13474 r0 *1 1448.72,695.52
X$13474 6805 6909 gf180mcu_fd_sc_mcu9t5v0__filltie
* cell instance $13475 r0 *1 1411.2,695.52
X$13475 6681 4906 6909 6805 6936 gf180mcu_fd_sc_mcu9t5v0__nand2_1
* cell instance $13476 r0 *1 1410.08,745.92
X$13476 7942 7941 3239 8078 7948 8105 gf180mcu_fd_sc_mcu9t5v0__mux2_1
* cell instance $13477 r0 *1 1448.72,705.6
X$13477 6943 7071 gf180mcu_fd_sc_mcu9t5v0__filltie
* cell instance $13478 m0 *1 1402.24,715.68
X$13478 7221 7220 2573 7071 7195 7219 gf180mcu_fd_sc_mcu9t5v0__mux2_2
* cell instance $13479 r0 *1 1389.92,695.52
X$13479 3462 6816 6935 6909 6805 6934 gf180mcu_fd_sc_mcu9t5v0__nand3_1
* cell instance $13480 m0 *1 1458.24,756
X$13480 6281 4769 8078 8204 8109 gf180mcu_fd_sc_mcu9t5v0__nand2_1
* cell instance $13481 r0 *1 1462.72,745.92
X$13481 8110 3340 8224 8984 8109 8078 7948 8111
+ gf180mcu_fd_sc_mcu9t5v0__oai221_1
* cell instance $13482 m0 *1 1457.12,735.84
X$13482 5293 7694 7578 7671 7814 gf180mcu_fd_sc_mcu9t5v0__dffq_2
* cell instance $13483 m0 *1 1461.04,725.76
X$13483 5293 7354 6791 7316 7558 gf180mcu_fd_sc_mcu9t5v0__dffq_2
* cell instance $13484 m0 *1 1461.04,756
X$13484 8224 8225 8078 8204 7353 gf180mcu_fd_sc_mcu9t5v0__nand2_1
* cell instance $13485 r0 *1 1465.52,715.68
X$13485 6791 7353 4493 7316 7195 7354 gf180mcu_fd_sc_mcu9t5v0__mux2_1
* cell instance $13486 m0 *1 1463.84,756
X$13486 5293 8111 6819 8078 8204 gf180mcu_fd_sc_mcu9t5v0__dffq_2
* cell instance $13487 m0 *1 1455.44,756
X$13487 6280 4048 8078 8204 8224 gf180mcu_fd_sc_mcu9t5v0__nand2_1
* cell instance $13488 r0 *1 1459.92,725.76
X$13488 7349 7578 1961 7671 7558 7694 gf180mcu_fd_sc_mcu9t5v0__mux2_1
* cell instance $13489 r0 *1 1448.72,614.88
X$13489 4794 4903 gf180mcu_fd_sc_mcu9t5v0__filltie
* cell instance $13490 m0 *1 1450.96,655.2
X$13490 5293 5577 5576 5665 5794 gf180mcu_fd_sc_mcu9t5v0__dffq_2
* cell instance $13491 m0 *1 1382.64,665.28
X$13491 4967 5064 6030 5920 6034 5785 gf180mcu_fd_sc_mcu9t5v0__mux2_1
* cell instance $13492 r0 *1 1450.96,635.04
X$13492 5064 4967 2578 5390 5297 5302 gf180mcu_fd_sc_mcu9t5v0__mux2_1
* cell instance $13493 m0 *1 1383.76,675.36
X$13493 6281 6280 6030 6144 6292 6282 gf180mcu_fd_sc_mcu9t5v0__mux2_1
* cell instance $13494 r0 *1 1448.72,574.56
X$13494 3781 3796 gf180mcu_fd_sc_mcu9t5v0__filltie
* cell instance $13495 m0 *1 1383.76,685.44
X$13495 6681 6282 5299 6392 6425 6299 gf180mcu_fd_sc_mcu9t5v0__mux2_1
* cell instance $13496 r0 *1 1448.72,554.4
X$13496 3227 3334 gf180mcu_fd_sc_mcu9t5v0__filltie
* cell instance $13497 r0 *1 1448.72,564.48
X$13497 3444 3558 gf180mcu_fd_sc_mcu9t5v0__filltie
* cell instance $13498 r0 *1 1441.44,635.04
X$13498 5302 5295 2472 5390 5297 5294 gf180mcu_fd_sc_mcu9t5v0__mux2_1
* cell instance $13499 m0 *1 1382.08,584.64
X$13499 3469 4575 1961 3796 3907 3933 gf180mcu_fd_sc_mcu9t5v0__mux2_1
* cell instance $13500 m0 *1 1438.64,635.04
X$13500 5293 5294 5295 5183 5297 gf180mcu_fd_sc_mcu9t5v0__dffq_2
* cell instance $13501 m0 *1 1386,604.8
X$13501 2377 4399 4576 4389 4512 gf180mcu_fd_sc_mcu9t5v0__dffq_2
* cell instance $13502 r0 *1 1449.84,665.28
X$13502 6280 6281 2578 6144 6034 6054 gf180mcu_fd_sc_mcu9t5v0__mux2_1
* cell instance $13503 r0 *1 1441.44,665.28
X$13503 6054 6285 2472 6144 6034 6162 gf180mcu_fd_sc_mcu9t5v0__mux2_1
* cell instance $13504 r0 *1 1388.8,645.12
X$13504 3459 5569 5665 5411 5570 gf180mcu_fd_sc_mcu9t5v0__nand2_1
* cell instance $13505 r0 *1 1455.44,645.12
X$13505 5064 5576 1961 5665 5411 5577 gf180mcu_fd_sc_mcu9t5v0__mux2_1
* cell instance $13506 r0 *1 1448.72,635.04
X$13506 5297 5390 gf180mcu_fd_sc_mcu9t5v0__filltie
* cell instance $13507 r0 *1 1403.92,645.12
X$13507 5405 4765 4906 5440 2880 5665 5411 5571
+ gf180mcu_fd_sc_mcu9t5v0__aoi221_1
* cell instance $13508 m0 *1 1400.56,675.36
X$13508 5290 6159 6160 6144 6292 gf180mcu_fd_sc_mcu9t5v0__dffq_2
* cell instance $13509 r0 *1 1448.72,675.36
X$13509 6292 6392 gf180mcu_fd_sc_mcu9t5v0__filltie
* cell instance $13510 m0 *1 1391.04,624.96
X$13510 2377 4966 5180 4903 5056 gf180mcu_fd_sc_mcu9t5v0__dffq_2
* cell instance $13511 m0 *1 1400.56,614.88
X$13511 4789 4667 4794 4765 gf180mcu_fd_sc_mcu9t5v0__buf_8
* cell instance $13512 r0 *1 1448.72,584.64
X$13512 3907 4150 gf180mcu_fd_sc_mcu9t5v0__filltie
* cell instance $13513 r0 *1 1448.72,594.72
X$13513 4266 4389 gf180mcu_fd_sc_mcu9t5v0__filltie
* cell instance $13514 r0 *1 1410.08,645.12
X$13514 5406 5573 5572 5571 3103 5665 5411 5566
+ gf180mcu_fd_sc_mcu9t5v0__aoi221_1
* cell instance $13515 m0 *1 1423.52,624.96
X$13515 5064 4967 2141 4903 5056 5065 gf180mcu_fd_sc_mcu9t5v0__mux2_1
* cell instance $13516 m0 *1 1419.04,635.04
X$13516 5065 5440 2373 5183 5297 5182 gf180mcu_fd_sc_mcu9t5v0__mux2_1
* cell instance $13517 m0 *1 1432.48,655.2
X$13517 5789 5574 5576 5295 2987 3106 5665 5794 5787
+ gf180mcu_fd_sc_mcu9t5v0__mux4_1
* cell instance $13518 r0 *1 1430.24,665.28
X$13518 6280 6281 2141 6144 6034 6161 gf180mcu_fd_sc_mcu9t5v0__mux2_1
* cell instance $13519 m0 *1 1394.4,655.2
X$13519 3351 5787 5665 5794 5786 gf180mcu_fd_sc_mcu9t5v0__nand2_1
* cell instance $13520 m0 *1 1386,645.12
X$13520 5180 5441 5405 5440 2987 3106 5390 5411 5569
+ gf180mcu_fd_sc_mcu9t5v0__mux4_1
* cell instance $13521 m0 *1 1389.92,655.2
X$13521 3462 5786 5570 5665 5794 6158 gf180mcu_fd_sc_mcu9t5v0__nand3_1
* cell instance $13522 r0 *1 1448.72,655.2
X$13522 5794 5920 gf180mcu_fd_sc_mcu9t5v0__filltie
* cell instance $13523 m0 *1 1394.96,614.88
X$13523 2891 4668 4667 4794 4789 gf180mcu_fd_sc_mcu9t5v0__nor2_1
* cell instance $13524 r0 *1 1448.72,645.12
X$13524 5411 5665 gf180mcu_fd_sc_mcu9t5v0__filltie
* cell instance $13525 r0 *1 1403.36,624.96
X$13525 4967 5064 2788 5183 5056 5181 gf180mcu_fd_sc_mcu9t5v0__mux2_1
* cell instance $13526 m0 *1 1420.16,675.36
X$13526 5290 6283 6284 6144 6292 gf180mcu_fd_sc_mcu9t5v0__dffq_2
* cell instance $13527 r0 *1 1387.68,594.72
X$13527 4386 4576 2472 4389 4266 4399 gf180mcu_fd_sc_mcu9t5v0__mux2_2
* cell instance $13528 r0 *1 1409.52,635.04
X$13528 5180 4765 5390 5297 5406 gf180mcu_fd_sc_mcu9t5v0__nand2_1
* cell instance $13529 m0 *1 1419.6,655.2
X$13529 5789 5574 2891 5665 5794 5788 gf180mcu_fd_sc_mcu9t5v0__mux2_1
* cell instance $13530 m0 *1 1411.2,655.2
X$13530 5441 4906 5788 3007 2992 5665 5794 5573
+ gf180mcu_fd_sc_mcu9t5v0__aoi221_1
* cell instance $13531 r0 *1 1414.56,624.96
X$13531 2377 5182 5440 5183 5056 gf180mcu_fd_sc_mcu9t5v0__dffq_2
* cell instance $13532 r0 *1 1448.72,624.96
X$13532 5056 5183 gf180mcu_fd_sc_mcu9t5v0__filltie
* cell instance $13533 m0 *1 1431.36,645.12
X$13533 5576 5295 2891 5390 5411 5575 gf180mcu_fd_sc_mcu9t5v0__mux2_1
* cell instance $13534 r0 *1 1423.52,645.12
X$13534 3007 5575 5665 5411 5572 gf180mcu_fd_sc_mcu9t5v0__nand2_1
* cell instance $13535 r0 *1 1426.32,645.12
X$13535 5576 5295 5789 5574 3120 3121 5665 5411 5805
+ gf180mcu_fd_sc_mcu9t5v0__mux4_1
* cell instance $13536 m0 *1 1403.36,645.12
X$13536 5405 5440 5180 5441 3120 3121 5390 5411 5442
+ gf180mcu_fd_sc_mcu9t5v0__mux4_1
* cell instance $13537 r0 *1 1406.16,655.2
X$13537 5805 5442 3239 5920 5794 5803 gf180mcu_fd_sc_mcu9t5v0__mux2_1
* cell instance $13538 r0 *1 1394.96,624.96
X$13538 5181 5180 2573 5183 5056 4966 gf180mcu_fd_sc_mcu9t5v0__mux2_2
* cell instance $13539 r0 *1 1424.08,675.36
X$13539 6161 6284 2363 6392 6292 6283 gf180mcu_fd_sc_mcu9t5v0__mux2_1
* cell instance $13540 r0 *1 1406.72,675.36
X$13540 6281 6280 2788 6392 6292 6053 gf180mcu_fd_sc_mcu9t5v0__mux2_1
* cell instance $13541 r0 *1 1402.24,665.28
X$13541 6053 6160 2573 6144 6034 6159 gf180mcu_fd_sc_mcu9t5v0__mux2_2
* cell instance $13542 r0 *1 1448.72,604.8
X$13542 4512 4667 gf180mcu_fd_sc_mcu9t5v0__filltie
* cell instance $13543 m0 *1 1438.08,675.36
X$13543 5293 6162 6285 6144 6292 gf180mcu_fd_sc_mcu9t5v0__dffq_2
* cell instance $13544 r0 *1 1448.72,665.28
X$13544 6034 6144 gf180mcu_fd_sc_mcu9t5v0__filltie
* cell instance $13545 m0 *1 1568.56,574.56
X$13545 3781 3558 gf180mcu_fd_sc_mcu9t5v0__filltie
* cell instance $13546 m0 *1 1568.56,564.48
X$13546 3444 3334 gf180mcu_fd_sc_mcu9t5v0__filltie
* cell instance $13547 m0 *1 1568.56,584.64
X$13547 3907 3796 gf180mcu_fd_sc_mcu9t5v0__filltie
* cell instance $13548 m0 *1 1568.56,655.2
X$13548 5794 5665 gf180mcu_fd_sc_mcu9t5v0__filltie
* cell instance $13549 m0 *1 1568.56,685.44
X$13549 6425 6392 gf180mcu_fd_sc_mcu9t5v0__filltie
* cell instance $13550 m0 *1 1568.56,675.36
X$13550 6292 6144 gf180mcu_fd_sc_mcu9t5v0__filltie
* cell instance $13551 m0 *1 1568.56,665.28
X$13551 6034 5920 gf180mcu_fd_sc_mcu9t5v0__filltie
* cell instance $13552 m0 *1 1568.56,624.96
X$13552 5056 4903 gf180mcu_fd_sc_mcu9t5v0__filltie
* cell instance $13553 m0 *1 1568.56,594.72
X$13553 4266 4150 gf180mcu_fd_sc_mcu9t5v0__filltie
* cell instance $13554 m0 *1 1568.56,604.8
X$13554 4512 4389 gf180mcu_fd_sc_mcu9t5v0__filltie
* cell instance $13555 m0 *1 1568.56,614.88
X$13555 4794 4667 gf180mcu_fd_sc_mcu9t5v0__filltie
* cell instance $13556 m0 *1 1568.56,645.12
X$13556 5411 5390 gf180mcu_fd_sc_mcu9t5v0__filltie
* cell instance $13557 m0 *1 1568.56,635.04
X$13557 5297 5183 gf180mcu_fd_sc_mcu9t5v0__filltie
* cell instance $13558 r0 *1 1448.72,383.04
X$13558 90 89 gf180mcu_fd_sc_mcu9t5v0__filltie
* cell instance $13559 r0 *1 1448.72,504
X$13559 2138 2243 gf180mcu_fd_sc_mcu9t5v0__filltie
* cell instance $13560 m0 *1 1568.56,493.92
X$13560 1959 1789 gf180mcu_fd_sc_mcu9t5v0__filltie
* cell instance $13561 r0 *1 1448.72,403.2
X$13561 430 429 gf180mcu_fd_sc_mcu9t5v0__filltie
* cell instance $13562 r0 *1 1448.72,524.16
X$13562 2561 2668 gf180mcu_fd_sc_mcu9t5v0__filltie
* cell instance $13563 m0 *1 1568.56,524.16
X$13563 2561 2464 gf180mcu_fd_sc_mcu9t5v0__filltie
* cell instance $13564 m0 *1 1568.56,514.08
X$13564 2361 2243 gf180mcu_fd_sc_mcu9t5v0__filltie
* cell instance $13565 r0 *1 1448.72,423.36
X$13565 770 769 gf180mcu_fd_sc_mcu9t5v0__filltie
* cell instance $13566 m0 *1 1568.56,453.6
X$13566 1280 1109 gf180mcu_fd_sc_mcu9t5v0__filltie
* cell instance $13567 m0 *1 1568.56,463.68
X$13567 1450 1279 gf180mcu_fd_sc_mcu9t5v0__filltie
* cell instance $13568 r0 *1 1448.72,393.12
X$13568 260 259 gf180mcu_fd_sc_mcu9t5v0__filltie
* cell instance $13569 m0 *1 1568.56,534.24
X$13569 2775 2668 gf180mcu_fd_sc_mcu9t5v0__filltie
* cell instance $13570 r0 *1 1448.72,473.76
X$13570 1620 1619 gf180mcu_fd_sc_mcu9t5v0__filltie
* cell instance $13571 m0 *1 1568.56,504
X$13571 2138 2130 gf180mcu_fd_sc_mcu9t5v0__filltie
* cell instance $13572 r0 *1 1448.72,534.24
X$13572 2775 2876 gf180mcu_fd_sc_mcu9t5v0__filltie
* cell instance $13573 m0 *1 1568.56,473.76
X$13573 1620 1449 gf180mcu_fd_sc_mcu9t5v0__filltie
* cell instance $13574 m0 *1 1568.56,403.2
X$13574 430 259 gf180mcu_fd_sc_mcu9t5v0__filltie
* cell instance $13575 m0 *1 1568.56,544.32
X$13575 3093 2876 gf180mcu_fd_sc_mcu9t5v0__filltie
* cell instance $13576 r0 *1 1448.72,544.32
X$13576 3093 3215 gf180mcu_fd_sc_mcu9t5v0__filltie
* cell instance $13577 r0 *1 1448.72,483.84
X$13577 1790 1789 gf180mcu_fd_sc_mcu9t5v0__filltie
* cell instance $13578 m0 *1 1568.56,423.36
X$13578 770 599 gf180mcu_fd_sc_mcu9t5v0__filltie
* cell instance $13579 m0 *1 1568.56,413.28
X$13579 600 429 gf180mcu_fd_sc_mcu9t5v0__filltie
* cell instance $13580 m0 *1 1568.56,443.52
X$13580 1110 939 gf180mcu_fd_sc_mcu9t5v0__filltie
* cell instance $13581 r0 *1 1448.72,433.44
X$13581 940 939 gf180mcu_fd_sc_mcu9t5v0__filltie
* cell instance $13582 r0 *1 1448.72,493.92
X$13582 1959 2130 gf180mcu_fd_sc_mcu9t5v0__filltie
* cell instance $13583 m0 *1 1568.56,433.44
X$13583 940 769 gf180mcu_fd_sc_mcu9t5v0__filltie
* cell instance $13584 r0 *1 1448.72,514.08
X$13584 2361 2464 gf180mcu_fd_sc_mcu9t5v0__filltie
* cell instance $13585 r0 *1 1448.72,453.6
X$13585 1280 1279 gf180mcu_fd_sc_mcu9t5v0__filltie
* cell instance $13586 m0 *1 1568.56,483.84
X$13586 1790 1619 gf180mcu_fd_sc_mcu9t5v0__filltie
* cell instance $13587 r0 *1 1448.72,443.52
X$13587 1110 1109 gf180mcu_fd_sc_mcu9t5v0__filltie
* cell instance $13588 r0 *1 1448.72,372.96
X$13588 2 4 gf180mcu_fd_sc_mcu9t5v0__filltie
* cell instance $13589 r0 *1 1568.56,372.96
X$13589 2 4 gf180mcu_fd_sc_mcu9t5v0__filltie
* cell instance $13590 r0 *1 1448.72,413.28
X$13590 600 599 gf180mcu_fd_sc_mcu9t5v0__filltie
* cell instance $13591 r0 *1 1448.72,463.68
X$13591 1450 1449 gf180mcu_fd_sc_mcu9t5v0__filltie
* cell instance $13592 m0 *1 1568.56,393.12
X$13592 260 89 gf180mcu_fd_sc_mcu9t5v0__filltie
* cell instance $13593 m0 *1 1568.56,383.04
X$13593 90 4 gf180mcu_fd_sc_mcu9t5v0__filltie
* cell instance $13594 r0 *1 1241.52,544.32
X$13594 2684 2786 2997 3122 2992 3215 3093 3124
+ gf180mcu_fd_sc_mcu9t5v0__aoi221_1
* cell instance $13595 m0 *1 1240.4,544.32
X$13595 2469 2997 2876 3093 3098 gf180mcu_fd_sc_mcu9t5v0__nand2_1
* cell instance $13596 r0 *1 1238.72,504
X$13596 2265 2271 3225 2243 2138 gf180mcu_fd_sc_mcu9t5v0__dffq_2
* cell instance $13597 m0 *1 1242.08,514.08
X$13597 2157 3225 2134 2243 2361 2271 gf180mcu_fd_sc_mcu9t5v0__mux2_1
* cell instance $13598 r0 *1 1209.04,413.28
X$13598 600 599 gf180mcu_fd_sc_mcu9t5v0__filltie
* cell instance $13599 m0 *1 1246,504
X$13599 2270 2156 2250 2130 2138 2157 gf180mcu_fd_sc_mcu9t5v0__mux2_1
* cell instance $13600 m0 *1 1328.88,463.68
X$13600 1450 1279 gf180mcu_fd_sc_mcu9t5v0__filltie
* cell instance $13601 r0 *1 1243.2,524.16
X$13601 2265 2470 2471 2668 2561 gf180mcu_fd_sc_mcu9t5v0__dffq_2
* cell instance $13602 r0 *1 1312.08,514.08
X$13602 2473 2475 2472 2464 2361 2474 gf180mcu_fd_sc_mcu9t5v0__mux2_2
* cell instance $13603 m0 *1 1328.88,534.24
X$13603 2775 2668 gf180mcu_fd_sc_mcu9t5v0__filltie
* cell instance $13604 r0 *1 1262.8,504
X$13604 2156 2273 1961 2243 2138 2272 gf180mcu_fd_sc_mcu9t5v0__mux2_1
* cell instance $13605 m0 *1 1328.88,524.16
X$13605 2561 2464 gf180mcu_fd_sc_mcu9t5v0__filltie
* cell instance $13606 m0 *1 1308.16,524.16
X$13606 2377 2474 2475 2464 2561 gf180mcu_fd_sc_mcu9t5v0__dffq_2
* cell instance $13607 m0 *1 1282.96,514.08
X$13607 2377 2274 2275 2243 2361 gf180mcu_fd_sc_mcu9t5v0__dffq_2
* cell instance $13608 m0 *1 1328.88,493.92
X$13608 1959 1789 gf180mcu_fd_sc_mcu9t5v0__filltie
* cell instance $13609 m0 *1 1308.16,544.32
X$13609 2377 2895 3359 2876 3093 gf180mcu_fd_sc_mcu9t5v0__dffq_2
* cell instance $13610 r0 *1 1313.76,544.32
X$13610 3359 2475 2891 3215 3093 3129 gf180mcu_fd_sc_mcu9t5v0__mux2_1
* cell instance $13611 m0 *1 1285.2,534.24
X$13611 2377 2689 3128 2668 2775 gf180mcu_fd_sc_mcu9t5v0__dffq_2
* cell instance $13612 m0 *1 1288,544.32
X$13612 2275 2997 3129 3007 2880 2876 3093 3692
+ gf180mcu_fd_sc_mcu9t5v0__aoi221_1
* cell instance $13613 m0 *1 1328.88,514.08
X$13613 2361 2243 gf180mcu_fd_sc_mcu9t5v0__filltie
* cell instance $13614 m0 *1 1249.36,524.16
X$13614 2156 2270 2578 2464 2561 2583 gf180mcu_fd_sc_mcu9t5v0__mux2_2
* cell instance $13615 m0 *1 1328.88,504
X$13615 2138 2130 gf180mcu_fd_sc_mcu9t5v0__filltie
* cell instance $13616 m0 *1 1258.88,514.08
X$13616 2265 2272 2273 2243 2361 gf180mcu_fd_sc_mcu9t5v0__dffq_2
* cell instance $13617 m0 *1 1266.16,534.24
X$13617 2265 2790 2791 2668 2775 gf180mcu_fd_sc_mcu9t5v0__dffq_2
* cell instance $13618 m0 *1 1328.88,423.36
X$13618 770 599 gf180mcu_fd_sc_mcu9t5v0__filltie
* cell instance $13619 m0 *1 1328.88,453.6
X$13619 1280 1109 gf180mcu_fd_sc_mcu9t5v0__filltie
* cell instance $13620 m0 *1 1328.88,443.52
X$13620 1110 939 gf180mcu_fd_sc_mcu9t5v0__filltie
* cell instance $13621 m0 *1 1328.88,433.44
X$13621 940 769 gf180mcu_fd_sc_mcu9t5v0__filltie
* cell instance $13622 r0 *1 1295.84,534.24
X$13622 2688 2687 2788 2876 2775 2690 gf180mcu_fd_sc_mcu9t5v0__mux2_1
* cell instance $13623 r0 *1 1289.12,524.16
X$13623 2690 3128 2573 2668 2561 2689 gf180mcu_fd_sc_mcu9t5v0__mux2_2
* cell instance $13624 r0 *1 1285.2,544.32
X$13624 3128 3247 2791 2275 2987 3106 3215 3093 3130
+ gf180mcu_fd_sc_mcu9t5v0__mux4_1
* cell instance $13625 r0 *1 1275.12,524.16
X$13625 2688 2687 2250 2668 2561 2686 gf180mcu_fd_sc_mcu9t5v0__mux2_1
* cell instance $13626 r0 *1 1256.64,544.32
X$13626 2273 2471 3464 3127 3120 3121 3215 3093 3245
+ gf180mcu_fd_sc_mcu9t5v0__mux4_1
* cell instance $13627 m0 *1 1328.88,544.32
X$13627 3093 2876 gf180mcu_fd_sc_mcu9t5v0__filltie
* cell instance $13628 m0 *1 1328.88,473.76
X$13628 1620 1449 gf180mcu_fd_sc_mcu9t5v0__filltie
* cell instance $13629 r0 *1 1309.84,524.16
X$13629 2687 2688 2564 2668 2561 2473 gf180mcu_fd_sc_mcu9t5v0__mux2_2
* cell instance $13630 r0 *1 1267.84,524.16
X$13630 2686 2791 2134 2668 2561 2790 gf180mcu_fd_sc_mcu9t5v0__mux2_1
* cell instance $13631 r0 *1 1258.88,534.24
X$13631 2273 2471 2891 2876 2775 2894 gf180mcu_fd_sc_mcu9t5v0__mux2_1
* cell instance $13632 m0 *1 1252.72,544.32
X$13632 3225 2786 2894 3007 2880 2876 3093 3125
+ gf180mcu_fd_sc_mcu9t5v0__aoi221_1
* cell instance $13633 r0 *1 1247.68,544.32
X$13633 3126 3124 3098 3125 3215 3093 3226 gf180mcu_fd_sc_mcu9t5v0__aoi22_1
* cell instance $13634 m0 *1 1328.88,483.84
X$13634 1790 1619 gf180mcu_fd_sc_mcu9t5v0__filltie
* cell instance $13635 r0 *1 1293.04,514.08
X$13635 2687 2688 2264 2464 2361 2276 gf180mcu_fd_sc_mcu9t5v0__mux2_1
* cell instance $13636 r0 *1 1287.44,504
X$13636 2276 2275 2373 2243 2138 2274 gf180mcu_fd_sc_mcu9t5v0__mux2_1
* cell instance $13637 r0 *1 1247.68,514.08
X$13637 2583 2471 2472 2464 2361 2470 gf180mcu_fd_sc_mcu9t5v0__mux2_2
* cell instance $13638 r0 *1 1312.08,534.24
X$13638 2687 3359 1961 2876 2775 2895 gf180mcu_fd_sc_mcu9t5v0__mux2_1
* cell instance $13639 r0 *1 1200.64,524.16
X$13639 2682 2681 2472 2668 2561 2582 gf180mcu_fd_sc_mcu9t5v0__mux2_2
* cell instance $13640 m0 *1 1108.8,544.32
X$13640 3003 3113 2573 2876 3093 3002 gf180mcu_fd_sc_mcu9t5v0__mux2_2
* cell instance $13641 r0 *1 1122.8,544.32
X$13641 2575 3116 2151 2260 2987 3106 3215 3093 3115
+ gf180mcu_fd_sc_mcu9t5v0__mux4_1
* cell instance $13642 r0 *1 1127.28,524.16
X$13642 2258 2574 2575 2668 2561 gf180mcu_fd_sc_mcu9t5v0__dffq_2
* cell instance $13643 r0 *1 1144.08,544.32
X$13643 2154 2151 3118 2575 3239 3109 3215 3093 3117
+ gf180mcu_fd_sc_mcu9t5v0__mux4_1
* cell instance $13644 r0 *1 1106.56,524.16
X$13644 2258 2571 2677 2668 2561 gf180mcu_fd_sc_mcu9t5v0__dffq_2
* cell instance $13645 m0 *1 1136.24,534.24
X$13645 2148 2149 2788 2668 2775 2576 gf180mcu_fd_sc_mcu9t5v0__mux2_1
* cell instance $13646 r0 *1 1223.6,544.32
X$13646 3225 2469 2684 3122 3120 3121 3215 3093 3123
+ gf180mcu_fd_sc_mcu9t5v0__mux4_1
* cell instance $13647 r0 *1 1224.72,524.16
X$13647 2685 2684 2573 2668 2561 2683 gf180mcu_fd_sc_mcu9t5v0__mux2_2
* cell instance $13648 m0 *1 1144.08,544.32
X$13648 3006 2889 3005 3004 3103 2876 3093 4673
+ gf180mcu_fd_sc_mcu9t5v0__aoi221_1
* cell instance $13649 m0 *1 1114.4,534.24
X$13649 2370 2252 2788 2668 2775 2572 gf180mcu_fd_sc_mcu9t5v0__mux2_1
* cell instance $13650 m0 *1 1184.96,534.24
X$13650 2262 2263 2788 2668 2775 2581 gf180mcu_fd_sc_mcu9t5v0__mux2_1
* cell instance $13651 r0 *1 1159.2,534.24
X$13651 2154 2789 2891 2876 2775 2890 gf180mcu_fd_sc_mcu9t5v0__mux2_1
* cell instance $13652 r0 *1 1156.4,534.24
X$13652 2983 2890 2876 2775 3006 gf180mcu_fd_sc_mcu9t5v0__nand2_1
* cell instance $13653 r0 *1 1143.52,534.24
X$13653 2151 2786 2997 2260 2880 2876 2775 2889
+ gf180mcu_fd_sc_mcu9t5v0__aoi221_1
* cell instance $13654 m0 *1 1134.56,544.32
X$13654 2575 2786 2997 3116 2992 2876 3093 3004
+ gf180mcu_fd_sc_mcu9t5v0__aoi221_1
* cell instance $13655 r0 *1 1178.8,544.32
X$13655 2580 2786 2997 3119 2992 3215 3093 3224
+ gf180mcu_fd_sc_mcu9t5v0__aoi221_1
* cell instance $13656 r0 *1 1233.12,524.16
X$13656 2270 2156 2788 2668 2561 2685 gf180mcu_fd_sc_mcu9t5v0__mux2_1
* cell instance $13657 m0 *1 1147.44,514.08
X$13657 2148 2149 2250 2243 2361 2152 gf180mcu_fd_sc_mcu9t5v0__mux2_1
* cell instance $13658 m0 *1 1141.28,504
X$13658 2152 2151 2134 2130 2138 2150 gf180mcu_fd_sc_mcu9t5v0__mux2_2
* cell instance $13659 m0 *1 1108.8,514.08
X$13659 2146 2371 2373 2243 2361 2372 gf180mcu_fd_sc_mcu9t5v0__mux2_1
* cell instance $13660 m0 *1 1112.72,504
X$13660 2256 2257 2141 2130 2138 2146 gf180mcu_fd_sc_mcu9t5v0__mux2_1
* cell instance $13661 m0 *1 1126.72,514.08
X$13661 2147 2260 2363 2243 2361 2259 gf180mcu_fd_sc_mcu9t5v0__mux2_1
* cell instance $13662 m0 *1 1157.52,504
X$13662 2149 2154 1961 2130 2138 2153 gf180mcu_fd_sc_mcu9t5v0__mux2_1
* cell instance $13663 m0 *1 1131.2,504
X$13663 2149 2148 2141 2130 2138 2147 gf180mcu_fd_sc_mcu9t5v0__mux2_1
* cell instance $13664 r0 *1 1136.24,504
X$13664 2258 2150 2151 2243 2138 gf180mcu_fd_sc_mcu9t5v0__dffq_2
* cell instance $13665 r0 *1 1119.44,504
X$13665 2258 2259 2260 2243 2138 gf180mcu_fd_sc_mcu9t5v0__dffq_2
* cell instance $13666 m0 *1 1170.4,514.08
X$13666 2265 2374 2468 2243 2361 gf180mcu_fd_sc_mcu9t5v0__dffq_2
* cell instance $13667 r0 *1 1210.16,504
X$13667 2263 2268 1961 2243 2138 2267 gf180mcu_fd_sc_mcu9t5v0__mux2_1
* cell instance $13668 r0 *1 1225.84,514.08
X$13668 2269 2469 2373 2464 2361 2376 gf180mcu_fd_sc_mcu9t5v0__mux2_1
* cell instance $13669 m0 *1 1193.36,514.08
X$13669 2155 2375 2134 2243 2361 2266 gf180mcu_fd_sc_mcu9t5v0__mux2_1
* cell instance $13670 r0 *1 1209.04,514.08
X$13670 2361 2464 gf180mcu_fd_sc_mcu9t5v0__filltie
* cell instance $13671 m0 *1 1204,514.08
X$13671 2265 2267 2268 2243 2361 gf180mcu_fd_sc_mcu9t5v0__dffq_2
* cell instance $13672 r0 *1 1209.04,493.92
X$13672 1959 2130 gf180mcu_fd_sc_mcu9t5v0__filltie
* cell instance $13673 m0 *1 1197.84,504
X$13673 2262 2263 2250 2130 2138 2155 gf180mcu_fd_sc_mcu9t5v0__mux2_1
* cell instance $13674 r0 *1 1178.24,504
X$13674 2263 2262 2264 2243 2138 2261 gf180mcu_fd_sc_mcu9t5v0__mux2_1
* cell instance $13675 r0 *1 1209.04,463.68
X$13675 1450 1449 gf180mcu_fd_sc_mcu9t5v0__filltie
* cell instance $13676 r0 *1 1189.44,504
X$13676 2265 2266 2375 2243 2138 gf180mcu_fd_sc_mcu9t5v0__dffq_2
* cell instance $13677 r0 *1 1209.04,483.84
X$13677 1790 1789 gf180mcu_fd_sc_mcu9t5v0__filltie
* cell instance $13678 r0 *1 1174.88,514.08
X$13678 2261 2468 2373 2464 2361 2374 gf180mcu_fd_sc_mcu9t5v0__mux2_1
* cell instance $13679 r0 *1 1209.04,504
X$13679 2138 2243 gf180mcu_fd_sc_mcu9t5v0__filltie
* cell instance $13680 r0 *1 1209.04,473.76
X$13680 1620 1619 gf180mcu_fd_sc_mcu9t5v0__filltie
* cell instance $13681 r0 *1 1209.04,423.36
X$13681 770 769 gf180mcu_fd_sc_mcu9t5v0__filltie
* cell instance $13682 r0 *1 1209.04,433.44
X$13682 940 939 gf180mcu_fd_sc_mcu9t5v0__filltie
* cell instance $13683 r0 *1 1209.04,443.52
X$13683 1110 1109 gf180mcu_fd_sc_mcu9t5v0__filltie
* cell instance $13684 r0 *1 1201.76,534.24
X$13684 2268 2681 2891 2876 2775 2892 gf180mcu_fd_sc_mcu9t5v0__mux2_1
* cell instance $13685 r0 *1 1177.68,534.24
X$13685 2468 2997 2892 2983 2880 2876 2775 2893
+ gf180mcu_fd_sc_mcu9t5v0__aoi221_1
* cell instance $13686 r0 *1 1184.96,544.32
X$13686 2375 2468 2580 3119 3120 3121 3215 3093 3355
+ gf180mcu_fd_sc_mcu9t5v0__mux4_1
* cell instance $13687 m0 *1 1221.36,534.24
X$13687 2265 2683 2684 2668 2775 gf180mcu_fd_sc_mcu9t5v0__dffq_2
* cell instance $13688 r0 *1 1209.04,453.6
X$13688 1280 1279 gf180mcu_fd_sc_mcu9t5v0__filltie
* cell instance $13689 m0 *1 1159.2,524.16
X$13689 2149 2148 2578 2464 2561 2577 gf180mcu_fd_sc_mcu9t5v0__mux2_2
* cell instance $13690 r0 *1 1212.4,534.24
X$13690 2265 2876 2775 gf180mcu_fd_sc_mcu9t5v0__clkinv_3
* cell instance $13691 m0 *1 1198.4,524.16
X$13691 2265 2582 2681 2464 2561 gf180mcu_fd_sc_mcu9t5v0__dffq_2
* cell instance $13692 m0 *1 1179.36,524.16
X$13692 2581 2580 2573 2464 2561 2579 gf180mcu_fd_sc_mcu9t5v0__mux2_2
* cell instance $13693 r0 *1 1209.04,534.24
X$13693 2775 2876 gf180mcu_fd_sc_mcu9t5v0__filltie
* cell instance $13694 r0 *1 1151.36,524.16
X$13694 2265 2680 2789 2668 2561 gf180mcu_fd_sc_mcu9t5v0__dffq_2
* cell instance $13695 m0 *1 1131.2,524.16
X$13695 2576 2575 2573 2464 2561 2574 gf180mcu_fd_sc_mcu9t5v0__mux2_2
* cell instance $13696 r0 *1 1153.04,504
X$13696 2265 2153 2154 2243 2138 gf180mcu_fd_sc_mcu9t5v0__dffq_2
* cell instance $13697 m0 *1 1109.92,524.16
X$13697 2572 2677 2573 2464 2561 2571 gf180mcu_fd_sc_mcu9t5v0__mux2_2
* cell instance $13698 r0 *1 1216.88,534.24
X$13698 3816 2876 2775 2265 gf180mcu_fd_sc_mcu9t5v0__clkbuf_8
* cell instance $13699 r0 *1 1209.04,544.32
X$13699 3093 3215 gf180mcu_fd_sc_mcu9t5v0__filltie
* cell instance $13700 r0 *1 1209.04,524.16
X$13700 2561 2668 gf180mcu_fd_sc_mcu9t5v0__filltie
* cell instance $13701 m0 *1 1155.28,534.24
X$13701 2577 2789 2472 2668 2775 2680 gf180mcu_fd_sc_mcu9t5v0__mux2_2
* cell instance $13702 r0 *1 1229.76,504
X$13702 2156 2270 2264 2243 2138 2269 gf180mcu_fd_sc_mcu9t5v0__mux2_1
* cell instance $13703 m0 *1 1220.8,514.08
X$13703 2265 2376 2469 2243 2361 gf180mcu_fd_sc_mcu9t5v0__dffq_2
* cell instance $13704 m0 *1 1204,534.24
X$13704 2263 2262 2578 2668 2775 2682 gf180mcu_fd_sc_mcu9t5v0__mux2_2
* cell instance $13705 r0 *1 1175.44,524.16
X$13705 2265 2579 2580 2668 2561 gf180mcu_fd_sc_mcu9t5v0__dffq_2
* cell instance $13706 r0 *1 1209.04,403.2
X$13706 430 429 gf180mcu_fd_sc_mcu9t5v0__filltie
* cell instance $13707 r0 *1 1209.04,383.04
X$13707 90 89 gf180mcu_fd_sc_mcu9t5v0__filltie
* cell instance $13708 r0 *1 1209.04,372.96
X$13708 2 4 gf180mcu_fd_sc_mcu9t5v0__filltie
* cell instance $13709 r0 *1 1209.04,393.12
X$13709 260 259 gf180mcu_fd_sc_mcu9t5v0__filltie
* cell instance $13710 m0 *1 1328.88,403.2
X$13710 430 259 gf180mcu_fd_sc_mcu9t5v0__filltie
* cell instance $13711 m0 *1 1328.88,413.28
X$13711 600 429 gf180mcu_fd_sc_mcu9t5v0__filltie
* cell instance $13712 m0 *1 1328.88,393.12
X$13712 260 89 gf180mcu_fd_sc_mcu9t5v0__filltie
* cell instance $13713 m0 *1 1328.88,383.04
X$13713 90 4 gf180mcu_fd_sc_mcu9t5v0__filltie
* cell instance $13714 r0 *1 1328.88,372.96
X$13714 2 4 gf180mcu_fd_sc_mcu9t5v0__filltie
* cell instance $13715 m0 *1 1808.24,514.08
X$13715 2361 2243 gf180mcu_fd_sc_mcu9t5v0__filltie
* cell instance $13716 r0 *1 1688.4,524.16
X$13716 2561 2668 gf180mcu_fd_sc_mcu9t5v0__filltie
* cell instance $13717 m0 *1 1808.24,403.2
X$13717 430 259 gf180mcu_fd_sc_mcu9t5v0__filltie
* cell instance $13718 r0 *1 1688.4,473.76
X$13718 1620 1619 gf180mcu_fd_sc_mcu9t5v0__filltie
* cell instance $13719 m90 *1 1864.8,413.28
X$13719 600 599 gf180mcu_fd_sc_mcu9t5v0__endcap
* cell instance $13720 r180 *1 1864.8,524.16
X$13720 33928 33856 gf180mcu_fd_sc_mcu9t5v0__endcap
* cell instance $13721 m0 *1 1808.24,423.36
X$13721 770 599 gf180mcu_fd_sc_mcu9t5v0__filltie
* cell instance $13722 m90 *1 1864.8,544.32
X$13722 33926 33830 gf180mcu_fd_sc_mcu9t5v0__endcap
* cell instance $13723 r0 *1 1688.4,514.08
X$13723 2361 2464 gf180mcu_fd_sc_mcu9t5v0__filltie
* cell instance $13724 m0 *1 1808.24,534.24
X$13724 2775 2668 gf180mcu_fd_sc_mcu9t5v0__filltie
* cell instance $13725 r180 *1 1864.8,443.52
X$13725 1110 939 gf180mcu_fd_sc_mcu9t5v0__endcap
* cell instance $13726 m90 *1 1864.8,524.16
X$13726 33928 33855 gf180mcu_fd_sc_mcu9t5v0__endcap
* cell instance $13727 m90 *1 1864.8,463.68
X$13727 1450 1449 gf180mcu_fd_sc_mcu9t5v0__endcap
* cell instance $13728 r0 *1 1688.4,423.36
X$13728 770 769 gf180mcu_fd_sc_mcu9t5v0__filltie
* cell instance $13729 m90 *1 1864.8,483.84
X$13729 1790 1789 gf180mcu_fd_sc_mcu9t5v0__endcap
* cell instance $13730 m90 *1 1864.8,473.76
X$13730 1620 1619 gf180mcu_fd_sc_mcu9t5v0__endcap
* cell instance $13731 r180 *1 1864.8,463.68
X$13731 1450 1279 gf180mcu_fd_sc_mcu9t5v0__endcap
* cell instance $13732 m0 *1 1808.24,493.92
X$13732 1959 1789 gf180mcu_fd_sc_mcu9t5v0__filltie
* cell instance $13733 r0 *1 1688.4,443.52
X$13733 1110 1109 gf180mcu_fd_sc_mcu9t5v0__filltie
* cell instance $13734 m90 *1 1864.8,423.36
X$13734 770 769 gf180mcu_fd_sc_mcu9t5v0__endcap
* cell instance $13735 m90 *1 2210,0
X$13735 gf180mcu_fd_io__cor
* cell instance $13736 m0 *1 1808.24,473.76
X$13736 1620 1449 gf180mcu_fd_sc_mcu9t5v0__filltie
* cell instance $13737 m0 *1 1808.24,433.44
X$13737 940 769 gf180mcu_fd_sc_mcu9t5v0__filltie
* cell instance $13738 m90 *1 1864.8,372.96
X$13738 2 4 gf180mcu_fd_sc_mcu9t5v0__endcap
* cell instance $13739 r0 *1 1688.4,534.24
X$13739 2775 2876 gf180mcu_fd_sc_mcu9t5v0__filltie
* cell instance $13740 r0 *1 1688.4,493.92
X$13740 1959 2130 gf180mcu_fd_sc_mcu9t5v0__filltie
* cell instance $13741 m0 *1 1808.24,443.52
X$13741 1110 939 gf180mcu_fd_sc_mcu9t5v0__filltie
* cell instance $13742 r180 *1 1864.8,383.04
X$13742 90 4 gf180mcu_fd_sc_mcu9t5v0__endcap
* cell instance $13743 m90 *1 1864.8,403.2
X$13743 430 429 gf180mcu_fd_sc_mcu9t5v0__endcap
* cell instance $13744 m90 *1 1864.8,393.12
X$13744 260 259 gf180mcu_fd_sc_mcu9t5v0__endcap
* cell instance $13745 m90 *1 1864.8,534.24
X$13745 33927 33854 gf180mcu_fd_sc_mcu9t5v0__endcap
* cell instance $13746 r180 *1 1864.8,413.28
X$13746 600 429 gf180mcu_fd_sc_mcu9t5v0__endcap
* cell instance $13747 r0 *1 1688.4,372.96
X$13747 2 4 gf180mcu_fd_sc_mcu9t5v0__filltie
* cell instance $13748 r0 *1 1688.4,483.84
X$13748 1790 1789 gf180mcu_fd_sc_mcu9t5v0__filltie
* cell instance $13749 r180 *1 1864.8,483.84
X$13749 1790 1619 gf180mcu_fd_sc_mcu9t5v0__endcap
* cell instance $13750 m0 *1 1789.76,504
X$13750 2130 2138 20066 gf180mcu_fd_sc_mcu9t5v0__tieh
* cell instance $13751 m0 *1 1780.24,504
X$13751 2130 2138 20018 gf180mcu_fd_sc_mcu9t5v0__tiel
* cell instance $13752 m0 *1 1808.24,483.84
X$13752 1790 1619 gf180mcu_fd_sc_mcu9t5v0__filltie
* cell instance $13753 r0 *1 1808.24,372.96
X$13753 2 4 gf180mcu_fd_sc_mcu9t5v0__filltie
* cell instance $13754 m0 *1 1808.24,504
X$13754 2138 2130 gf180mcu_fd_sc_mcu9t5v0__filltie
* cell instance $13755 r180 *1 1864.8,534.24
X$13755 33927 33855 gf180mcu_fd_sc_mcu9t5v0__endcap
* cell instance $13756 r180 *1 1864.8,453.6
X$13756 1280 1109 gf180mcu_fd_sc_mcu9t5v0__endcap
* cell instance $13757 r180 *1 1864.8,393.12
X$13757 260 89 gf180mcu_fd_sc_mcu9t5v0__endcap
* cell instance $13758 r0 *1 1688.4,413.28
X$13758 600 599 gf180mcu_fd_sc_mcu9t5v0__filltie
* cell instance $13759 r180 *1 1864.8,493.92
X$13759 1959 1789 gf180mcu_fd_sc_mcu9t5v0__endcap
* cell instance $13760 m90 *1 1864.8,443.52
X$13760 1110 1109 gf180mcu_fd_sc_mcu9t5v0__endcap
* cell instance $13761 m0 *1 1808.24,413.28
X$13761 600 429 gf180mcu_fd_sc_mcu9t5v0__filltie
* cell instance $13762 r180 *1 1864.8,504
X$13762 2138 2130 gf180mcu_fd_sc_mcu9t5v0__endcap
* cell instance $13763 m0 *1 1808.24,383.04
X$13763 90 4 gf180mcu_fd_sc_mcu9t5v0__filltie
* cell instance $13764 m0 *1 1808.24,463.68
X$13764 1450 1279 gf180mcu_fd_sc_mcu9t5v0__filltie
* cell instance $13765 m90 *1 1864.8,493.92
X$13765 1959 2130 gf180mcu_fd_sc_mcu9t5v0__endcap
* cell instance $13766 r180 *1 1864.8,544.32
X$13766 33926 33854 gf180mcu_fd_sc_mcu9t5v0__endcap
* cell instance $13767 r0 *1 1688.4,383.04
X$13767 90 89 gf180mcu_fd_sc_mcu9t5v0__filltie
* cell instance $13768 r0 *1 1688.4,433.44
X$13768 940 939 gf180mcu_fd_sc_mcu9t5v0__filltie
* cell instance $13769 m90 *1 1864.8,383.04
X$13769 90 89 gf180mcu_fd_sc_mcu9t5v0__endcap
* cell instance $13770 m90 *1 1864.8,453.6
X$13770 1280 1279 gf180mcu_fd_sc_mcu9t5v0__endcap
* cell instance $13771 r180 *1 1864.8,433.44
X$13771 940 769 gf180mcu_fd_sc_mcu9t5v0__endcap
* cell instance $13772 m0 *1 1808.24,544.32
X$13772 3093 2876 gf180mcu_fd_sc_mcu9t5v0__filltie
* cell instance $13773 r180 *1 1864.8,403.2
X$13773 430 259 gf180mcu_fd_sc_mcu9t5v0__endcap
* cell instance $13774 r0 *1 1688.4,403.2
X$13774 430 429 gf180mcu_fd_sc_mcu9t5v0__filltie
* cell instance $13775 r180 *1 1864.8,423.36
X$13775 770 599 gf180mcu_fd_sc_mcu9t5v0__endcap
* cell instance $13776 r0 *1 1688.4,504
X$13776 2138 2243 gf180mcu_fd_sc_mcu9t5v0__filltie
* cell instance $13777 r0 *1 1688.4,463.68
X$13777 1450 1449 gf180mcu_fd_sc_mcu9t5v0__filltie
* cell instance $13778 r0 *1 1688.4,544.32
X$13778 3093 3215 gf180mcu_fd_sc_mcu9t5v0__filltie
* cell instance $13779 m0 *1 1808.24,453.6
X$13779 1280 1109 gf180mcu_fd_sc_mcu9t5v0__filltie
* cell instance $13780 r0 *1 1688.4,393.12
X$13780 260 259 gf180mcu_fd_sc_mcu9t5v0__filltie
* cell instance $13781 r180 *1 1864.8,473.76
X$13781 1620 1449 gf180mcu_fd_sc_mcu9t5v0__endcap
* cell instance $13782 m90 *1 1864.8,514.08
X$13782 33902 33856 gf180mcu_fd_sc_mcu9t5v0__endcap
* cell instance $13783 m90 *1 1864.8,433.44
X$13783 940 939 gf180mcu_fd_sc_mcu9t5v0__endcap
* cell instance $13784 m90 *1 1864.8,504
X$13784 2138 33835 gf180mcu_fd_sc_mcu9t5v0__endcap
* cell instance $13785 m0 *1 1808.24,393.12
X$13785 260 89 gf180mcu_fd_sc_mcu9t5v0__filltie
* cell instance $13786 r180 *1 1864.8,514.08
X$13786 33902 33835 gf180mcu_fd_sc_mcu9t5v0__endcap
* cell instance $13787 m0 *1 1808.24,524.16
X$13787 2561 2464 gf180mcu_fd_sc_mcu9t5v0__filltie
* cell instance $13788 r0 *1 1688.4,453.6
X$13788 1280 1279 gf180mcu_fd_sc_mcu9t5v0__filltie
.ENDS butterfold_padframe_top

* cell gf180mcu_fd_sc_mcu9t5v0__endcap
* pin VSS
* pin VDD
.SUBCKT gf180mcu_fd_sc_mcu9t5v0__endcap 1 2
* net 1 VSS
* net 2 VDD
.ENDS gf180mcu_fd_sc_mcu9t5v0__endcap

* cell gf180mcu_fd_sc_mcu9t5v0__filltie
* pin VSS
* pin VDD
.SUBCKT gf180mcu_fd_sc_mcu9t5v0__filltie 1 2
* net 1 VSS
* net 2 VDD
.ENDS gf180mcu_fd_sc_mcu9t5v0__filltie

* cell gf180mcu_fd_sc_mcu9t5v0__clkbuf_16
* pin I
* pin VSS
* pin VDD
* pin Z
.SUBCKT gf180mcu_fd_sc_mcu9t5v0__clkbuf_16 1 2 4 5
* net 1 I
* net 2 VSS
* net 4 VDD
* net 5 Z
.ENDS gf180mcu_fd_sc_mcu9t5v0__clkbuf_16

* cell gf180mcu_fd_sc_mcu9t5v0__buf_8
* pin I
* pin VDD
* pin VSS
* pin Z
.SUBCKT gf180mcu_fd_sc_mcu9t5v0__buf_8 1 2 3 5
* net 1 I
* net 2 VDD
* net 3 VSS
* net 5 Z
.ENDS gf180mcu_fd_sc_mcu9t5v0__buf_8

* cell gf180mcu_fd_sc_mcu9t5v0__nor3_1
* pin A1
* pin A2
* pin A3
* pin VDD
* pin VSS
* pin ZN
.SUBCKT gf180mcu_fd_sc_mcu9t5v0__nor3_1 1 2 3 4 5 6
* net 1 A1
* net 2 A2
* net 3 A3
* net 4 VDD
* net 5 VSS
* net 6 ZN
.ENDS gf180mcu_fd_sc_mcu9t5v0__nor3_1

* cell gf180mcu_fd_sc_mcu9t5v0__clkbuf_1
* pin I
* pin VDD
* pin VSS
* pin Z
.SUBCKT gf180mcu_fd_sc_mcu9t5v0__clkbuf_1 1 2 3 4
* net 1 I
* net 2 VDD
* net 3 VSS
* net 4 Z
.ENDS gf180mcu_fd_sc_mcu9t5v0__clkbuf_1

* cell gf180mcu_fd_sc_mcu9t5v0__clkinv_1
* pin I
* pin VDD
* pin VSS
* pin ZN
.SUBCKT gf180mcu_fd_sc_mcu9t5v0__clkinv_1 1 2 3 4
* net 1 I
* net 2 VDD
* net 3 VSS
* net 4 ZN
.ENDS gf180mcu_fd_sc_mcu9t5v0__clkinv_1

* cell gf180mcu_fd_sc_mcu9t5v0__nand2_1
* pin A1
* pin A2
* pin VDD
* pin VSS
* pin ZN
.SUBCKT gf180mcu_fd_sc_mcu9t5v0__nand2_1 1 2 3 4 5
* net 1 A1
* net 2 A2
* net 3 VDD
* net 4 VSS
* net 5 ZN
.ENDS gf180mcu_fd_sc_mcu9t5v0__nand2_1

* cell gf180mcu_fd_sc_mcu9t5v0__nor2_1
* pin A1
* pin A2
* pin VDD
* pin VSS
* pin ZN
.SUBCKT gf180mcu_fd_sc_mcu9t5v0__nor2_1 1 2 3 4 5
* net 1 A1
* net 2 A2
* net 3 VDD
* net 4 VSS
* net 5 ZN
.ENDS gf180mcu_fd_sc_mcu9t5v0__nor2_1

* cell gf180mcu_fd_sc_mcu9t5v0__oai31_2
* pin A1
* pin A2
* pin A3
* pin B
* pin VDD
* pin VSS
* pin ZN
.SUBCKT gf180mcu_fd_sc_mcu9t5v0__oai31_2 1 2 3 4 5 6 7
* net 1 A1
* net 2 A2
* net 3 A3
* net 4 B
* net 5 VDD
* net 6 VSS
* net 7 ZN
.ENDS gf180mcu_fd_sc_mcu9t5v0__oai31_2

* cell gf180mcu_fd_sc_mcu9t5v0__aoi22_1
* pin A1
* pin A2
* pin B1
* pin B2
* pin VDD
* pin VSS
* pin ZN
.SUBCKT gf180mcu_fd_sc_mcu9t5v0__aoi22_1 1 2 3 4 5 6 7
* net 1 A1
* net 2 A2
* net 3 B1
* net 4 B2
* net 5 VDD
* net 6 VSS
* net 7 ZN
.ENDS gf180mcu_fd_sc_mcu9t5v0__aoi22_1

* cell gf180mcu_fd_sc_mcu9t5v0__mux2_1
* pin I0
* pin I1
* pin S
* pin VDD
* pin VSS
* pin Z
.SUBCKT gf180mcu_fd_sc_mcu9t5v0__mux2_1 1 2 3 4 5 6
* net 1 I0
* net 2 I1
* net 3 S
* net 4 VDD
* net 5 VSS
* net 6 Z
.ENDS gf180mcu_fd_sc_mcu9t5v0__mux2_1

* cell gf180mcu_fd_sc_mcu9t5v0__oai211_1
* pin A1
* pin A2
* pin B
* pin C
* pin VDD
* pin VSS
* pin ZN
.SUBCKT gf180mcu_fd_sc_mcu9t5v0__oai211_1 1 2 3 4 5 6 7
* net 1 A1
* net 2 A2
* net 3 B
* net 4 C
* net 5 VDD
* net 6 VSS
* net 7 ZN
.ENDS gf180mcu_fd_sc_mcu9t5v0__oai211_1

* cell gf180mcu_fd_sc_mcu9t5v0__oai221_1
* pin A1
* pin A2
* pin B1
* pin B2
* pin C
* pin VDD
* pin VSS
* pin ZN
.SUBCKT gf180mcu_fd_sc_mcu9t5v0__oai221_1 1 2 3 4 5 6 7 8
* net 1 A1
* net 2 A2
* net 3 B1
* net 4 B2
* net 5 C
* net 6 VDD
* net 7 VSS
* net 8 ZN
.ENDS gf180mcu_fd_sc_mcu9t5v0__oai221_1

* cell gf180mcu_fd_sc_mcu9t5v0__mux4_1
* pin I0
* pin I1
* pin I2
* pin I3
* pin S0
* pin S1
* pin VDD
* pin VSS
* pin Z
.SUBCKT gf180mcu_fd_sc_mcu9t5v0__mux4_1 1 2 3 4 5 6 7 8 9
* net 1 I0
* net 2 I1
* net 3 I2
* net 4 I3
* net 5 S0
* net 6 S1
* net 7 VDD
* net 8 VSS
* net 9 Z
.ENDS gf180mcu_fd_sc_mcu9t5v0__mux4_1

* cell gf180mcu_fd_sc_mcu9t5v0__aoi211_1
* pin A1
* pin A2
* pin B
* pin C
* pin VDD
* pin VSS
* pin ZN
.SUBCKT gf180mcu_fd_sc_mcu9t5v0__aoi211_1 1 2 3 4 5 6 7
* net 1 A1
* net 2 A2
* net 3 B
* net 4 C
* net 5 VDD
* net 6 VSS
* net 7 ZN
.ENDS gf180mcu_fd_sc_mcu9t5v0__aoi211_1

* cell gf180mcu_fd_sc_mcu9t5v0__aoi21_1
* pin A1
* pin A2
* pin B
* pin VDD
* pin VSS
* pin ZN
.SUBCKT gf180mcu_fd_sc_mcu9t5v0__aoi21_1 1 2 3 4 5 6
* net 1 A1
* net 2 A2
* net 3 B
* net 4 VDD
* net 5 VSS
* net 6 ZN
.ENDS gf180mcu_fd_sc_mcu9t5v0__aoi21_1

* cell gf180mcu_fd_sc_mcu9t5v0__xor2_1
* pin A1
* pin VDD
* pin VSS
* pin A2
* pin Z
.SUBCKT gf180mcu_fd_sc_mcu9t5v0__xor2_1 1 2 3 5 6
* net 1 A1
* net 2 VDD
* net 3 VSS
* net 5 A2
* net 6 Z
.ENDS gf180mcu_fd_sc_mcu9t5v0__xor2_1

* cell gf180mcu_fd_sc_mcu9t5v0__oai21_1
* pin A1
* pin A2
* pin B
* pin VDD
* pin VSS
* pin ZN
.SUBCKT gf180mcu_fd_sc_mcu9t5v0__oai21_1 1 2 3 4 5 6
* net 1 A1
* net 2 A2
* net 3 B
* net 4 VDD
* net 5 VSS
* net 6 ZN
.ENDS gf180mcu_fd_sc_mcu9t5v0__oai21_1

* cell gf180mcu_fd_sc_mcu9t5v0__oai31_1
* pin A1
* pin A2
* pin A3
* pin B
* pin VDD
* pin VSS
* pin ZN
.SUBCKT gf180mcu_fd_sc_mcu9t5v0__oai31_1 1 2 3 4 5 6 7
* net 1 A1
* net 2 A2
* net 3 A3
* net 4 B
* net 5 VDD
* net 6 VSS
* net 7 ZN
.ENDS gf180mcu_fd_sc_mcu9t5v0__oai31_1

* cell gf180mcu_fd_sc_mcu9t5v0__and2_1
* pin A1
* pin A2
* pin VDD
* pin VSS
* pin Z
.SUBCKT gf180mcu_fd_sc_mcu9t5v0__and2_1 1 2 3 4 5
* net 1 A1
* net 2 A2
* net 3 VDD
* net 4 VSS
* net 5 Z
.ENDS gf180mcu_fd_sc_mcu9t5v0__and2_1

* cell gf180mcu_fd_sc_mcu9t5v0__xnor2_1
* pin A1
* pin A2
* pin VDD
* pin VSS
* pin ZN
.SUBCKT gf180mcu_fd_sc_mcu9t5v0__xnor2_1 1 2 3 4 5
* net 1 A1
* net 2 A2
* net 3 VDD
* net 4 VSS
* net 5 ZN
.ENDS gf180mcu_fd_sc_mcu9t5v0__xnor2_1

* cell gf180mcu_fd_sc_mcu9t5v0__xnor3_1
* pin A1
* pin A3
* pin VDD
* pin VSS
* pin ZN
* pin A2
.SUBCKT gf180mcu_fd_sc_mcu9t5v0__xnor3_1 1 2 3 4 5 7
* net 1 A1
* net 2 A3
* net 3 VDD
* net 4 VSS
* net 5 ZN
* net 7 A2
.ENDS gf180mcu_fd_sc_mcu9t5v0__xnor3_1

* cell gf180mcu_fd_sc_mcu9t5v0__aoi221_1
* pin A1
* pin A2
* pin B1
* pin B2
* pin C
* pin VDD
* pin VSS
* pin ZN
.SUBCKT gf180mcu_fd_sc_mcu9t5v0__aoi221_1 1 2 3 4 5 6 7 8
* net 1 A1
* net 2 A2
* net 3 B1
* net 4 B2
* net 5 C
* net 6 VDD
* net 7 VSS
* net 8 ZN
.ENDS gf180mcu_fd_sc_mcu9t5v0__aoi221_1

* cell gf180mcu_fd_sc_mcu9t5v0__or2_4
* pin A1
* pin A2
* pin VDD
* pin VSS
* pin Z
.SUBCKT gf180mcu_fd_sc_mcu9t5v0__or2_4 1 2 3 4 5
* net 1 A1
* net 2 A2
* net 3 VDD
* net 4 VSS
* net 5 Z
.ENDS gf180mcu_fd_sc_mcu9t5v0__or2_4

* cell gf180mcu_fd_sc_mcu9t5v0__dffq_2
* pin CLK
* pin D
* pin Q
* pin VDD
* pin VSS
.SUBCKT gf180mcu_fd_sc_mcu9t5v0__dffq_2 1 2 3 4 5
* net 1 CLK
* net 2 D
* net 3 Q
* net 4 VDD
* net 5 VSS
.ENDS gf180mcu_fd_sc_mcu9t5v0__dffq_2

* cell gf180mcu_fd_sc_mcu9t5v0__dffrnq_2
* pin CLK
* pin D
* pin Q
* pin RN
* pin VDD
* pin VSS
.SUBCKT gf180mcu_fd_sc_mcu9t5v0__dffrnq_2 1 2 3 4 5 6
* net 1 CLK
* net 2 D
* net 3 Q
* net 4 RN
* net 5 VDD
* net 6 VSS
.ENDS gf180mcu_fd_sc_mcu9t5v0__dffrnq_2

* cell gf180mcu_fd_sc_mcu9t5v0__buf_20
* pin I
* pin VDD
* pin VSS
* pin Z
.SUBCKT gf180mcu_fd_sc_mcu9t5v0__buf_20 1 3 4 5
* net 1 I
* net 3 VDD
* net 4 VSS
* net 5 Z
.ENDS gf180mcu_fd_sc_mcu9t5v0__buf_20

* cell gf180mcu_fd_sc_mcu9t5v0__buf_1
* pin I
* pin VDD
* pin VSS
* pin Z
.SUBCKT gf180mcu_fd_sc_mcu9t5v0__buf_1 1 2 3 4
* net 1 I
* net 2 VDD
* net 3 VSS
* net 4 Z
.ENDS gf180mcu_fd_sc_mcu9t5v0__buf_1

* cell gf180mcu_fd_sc_mcu9t5v0__and3_1
* pin A1
* pin A2
* pin A3
* pin VDD
* pin VSS
* pin Z
.SUBCKT gf180mcu_fd_sc_mcu9t5v0__and3_1 1 2 3 4 5 6
* net 1 A1
* net 2 A2
* net 3 A3
* net 4 VDD
* net 5 VSS
* net 6 Z
.ENDS gf180mcu_fd_sc_mcu9t5v0__and3_1

* cell gf180mcu_fd_sc_mcu9t5v0__xor3_1
* pin A1
* pin A3
* pin VDD
* pin VSS
* pin A2
* pin Z
.SUBCKT gf180mcu_fd_sc_mcu9t5v0__xor3_1 1 2 3 4 6 9
* net 1 A1
* net 2 A3
* net 3 VDD
* net 4 VSS
* net 6 A2
* net 9 Z
.ENDS gf180mcu_fd_sc_mcu9t5v0__xor3_1

* cell gf180mcu_fd_ip_sram__sram256x8m8wm1
* pin VDD
* pin D[0]
* pin WEN[0]
* pin Q[0]
* pin Q[1]
* pin D[1]
* pin WEN[1]
* pin WEN[2]
* pin D[2]
* pin Q[2]
* pin Q[3]
* pin WEN[3]
* pin D[3]
* pin CLK
* pin A[7]
* pin A[2]
* pin A[1]
* pin VSS
* pin A[0]
* pin GWEN
* pin CEN
* pin A[6]
* pin A[5]
* pin A[4]
* pin A[3]
* pin D[4]
* pin WEN[4]
* pin Q[4]
* pin VSS
* pin Q[5]
* pin D[5]
* pin WEN[5]
* pin WEN[6]
* pin D[6]
* pin Q[6]
* pin VSS
* pin Q[7]
* pin WEN[7]
* pin D[7]
* pin VSS
* pin VSS
* pin VSS
* pin VSS
* pin VSS
* pin VSS
* pin VSS
* pin VSS
* pin VSS
* pin VSS
* pin VSS
* pin VSS
* pin VSS
* pin VSS
* pin VSS
* pin VSS
* pin VSS
* pin VSS
* pin VSS
* pin VSS
* pin VSS
* pin VSS
* pin VSS
* pin VSS
* pin VDD
* pin VSS
* pin VSS
* pin VSS
* pin VSS
.SUBCKT gf180mcu_fd_ip_sram__sram256x8m8wm1 1 2 3 4 7 8 9 10 11 12 15 16 17 18
+ 19 20 22 23 24 27 31 34 35 36 37 38 39 40 41 43 44 45 46 47 48 50 51 52 53 55
+ 56 58 61 63 64 66 68 69 90 94 98 102 106 110 114 118 122 126 130 134 138 142
+ 146 148 154 160 171 177
* net 1 VDD
* net 2 D[0]
* net 3 WEN[0]
* net 4 Q[0]
* net 5 VSS
* net 6 VSS
* net 7 Q[1]
* net 8 D[1]
* net 9 WEN[1]
* net 10 WEN[2]
* net 11 D[2]
* net 12 Q[2]
* net 13 VSS
* net 14 VSS
* net 15 Q[3]
* net 16 WEN[3]
* net 17 D[3]
* net 18 CLK
* net 19 A[7]
* net 20 A[2]
* net 21 VSS
* net 22 A[1]
* net 23 VSS
* net 24 A[0]
* net 25 VSS
* net 26 VSS
* net 27 GWEN
* net 28 VSS
* net 29 VSS
* net 30 VSS
* net 31 CEN
* net 32 VSS
* net 33 VSS
* net 34 A[6]
* net 35 A[5]
* net 36 A[4]
* net 37 A[3]
* net 38 D[4]
* net 39 WEN[4]
* net 40 Q[4]
* net 41 VSS
* net 42 VSS
* net 43 Q[5]
* net 44 D[5]
* net 45 WEN[5]
* net 46 WEN[6]
* net 47 D[6]
* net 48 Q[6]
* net 49 VSS
* net 50 VSS
* net 51 Q[7]
* net 52 WEN[7]
* net 53 D[7]
* net 54 VDD
* net 55 VSS
* net 56 VSS
* net 57 VDD
* net 58 VSS
* net 59 VDD
* net 60 VDD
* net 61 VSS
* net 62 VDD
* net 63 VSS
* net 64 VSS
* net 65 VDD
* net 66 VSS
* net 67 VDD
* net 68 VSS
* net 69 VSS
* net 70 VDD
* net 71 VSS
* net 72 VSS
* net 73 VDD
* net 74 VDD
* net 75 VSS
* net 76 VDD
* net 77 VDD
* net 78 VSS
* net 79 VDD
* net 80 VSS
* net 81 VDD
* net 82 VSS
* net 83 VDD
* net 84 VSS
* net 85 VSS
* net 86 VDD
* net 87 VSS
* net 88 VDD
* net 89 VDD
* net 90 VSS
* net 91 VSS
* net 92 VDD
* net 93 VDD
* net 94 VSS
* net 95 VSS
* net 96 VDD
* net 97 VDD
* net 98 VSS
* net 99 VSS
* net 100 VDD
* net 101 VDD
* net 102 VSS
* net 103 VSS
* net 104 VDD
* net 105 VDD
* net 106 VSS
* net 107 VSS
* net 108 VDD
* net 109 VDD
* net 110 VSS
* net 111 VSS
* net 112 VDD
* net 113 VDD
* net 114 VSS
* net 115 VSS
* net 116 VDD
* net 117 VDD
* net 118 VSS
* net 119 VSS
* net 120 VDD
* net 121 VDD
* net 122 VSS
* net 123 VSS
* net 124 VDD
* net 125 VDD
* net 126 VSS
* net 127 VSS
* net 128 VDD
* net 129 VDD
* net 130 VSS
* net 131 VSS
* net 132 VDD
* net 133 VDD
* net 134 VSS
* net 135 VSS
* net 136 VDD
* net 137 VDD
* net 138 VSS
* net 139 VSS
* net 140 VDD
* net 141 VDD
* net 142 VSS
* net 143 VSS
* net 144 VDD
* net 145 VDD
* net 146 VSS
* net 147 VSS
* net 148 VDD
* net 149 VSS
* net 150 VSS
* net 151 VSS
* net 152 VSS
* net 153 VSS
* net 154 VSS
* net 155 VSS
* net 156 VSS
* net 157 VSS
* net 158 VSS
* net 159 VSS
* net 160 VSS
* net 161 VSS
* net 162 VSS
* net 163 VSS
* net 164 VSS
* net 165 VSS
* net 166 VSS
* net 167 VSS
* net 168 VSS
* net 169 VSS
* net 170 VSS
* net 171 VSS
* net 172 VSS
* net 173 VSS
* net 174 VSS
* net 175 VSS
* net 176 VSS
* net 177 VSS
.ENDS gf180mcu_fd_ip_sram__sram256x8m8wm1

* cell gf180mcu_fd_io__cor
.SUBCKT gf180mcu_fd_io__cor
* net 1 DVSS
* net 2 DVSS
* net 3 DVSS
* net 4 DVSS
* net 5 DVSS
* net 6 DVSS
* net 7 DVSS
* net 8 DVSS
* net 9 DVSS
* net 10 DVDD
* net 11 DVDD
* net 12 DVDD
* net 13 DVSS
* net 14 DVSS
* net 15 DVSS
* net 16 DVDD
* net 17 DVDD
* net 18 DVDD
* net 19 DVDD
* net 20 DVDD
* net 21 DVDD
* net 22 DVDD
* net 23 DVDD
* net 24 DVDD
* net 25 DVDD
* net 26 DVDD
* net 27 DVDD
* net 28 DVSS
* net 29 DVSS
* net 30 DVSS
* net 31 DVDD
* net 32 DVDD
* net 33 DVDD
* net 34 DVDD
* net 35 DVDD
* net 36 DVDD
* net 37 DVSS
* net 38 DVSS
* net 39 DVSS
* net 40 VSS
* net 41 VSS
* net 42 VSS
* net 43 VDD
* net 44 VDD
* net 45 VDD
* net 46 DVDD
* net 47 DVDD
* net 48 DVDD
* net 49 DVDD
* net 50 DVDD
* net 51 DVDD
* net 52 DVDD
* net 53 DVDD
* net 54 DVDD
* net 55 DVSS
* net 56 DVSS
* net 57 DVSS
* net 58 DVDD
* net 59 DVDD
* net 60 DVDD
* net 61 DVSS
* net 62 DVSS
* net 63 DVSS
* net 64 VDD
* net 65 VDD
* net 66 VDD
* net 67 VSS
* net 68 VSS
* net 69 VSS
* net 70 DVSS
* net 71 DVSS
* net 72 DVSS
* net 73 DVDD
* net 74 DVDD
* net 75 DVDD
* net 76 DVSS
* net 77 DVSS
* net 78 DVSS
.ENDS gf180mcu_fd_io__cor

* cell gf180mcu_fd_sc_mcu9t5v0__or2_1
* pin A1
* pin A2
* pin VDD
* pin VSS
* pin Z
.SUBCKT gf180mcu_fd_sc_mcu9t5v0__or2_1 1 2 3 4 5
* net 1 A1
* net 2 A2
* net 3 VDD
* net 4 VSS
* net 5 Z
.ENDS gf180mcu_fd_sc_mcu9t5v0__or2_1

* cell gf180mcu_fd_sc_mcu9t5v0__oai21_2
* pin A1
* pin A2
* pin B
* pin VDD
* pin VSS
* pin ZN
.SUBCKT gf180mcu_fd_sc_mcu9t5v0__oai21_2 1 2 3 4 5 6
* net 1 A1
* net 2 A2
* net 3 B
* net 4 VDD
* net 5 VSS
* net 6 ZN
.ENDS gf180mcu_fd_sc_mcu9t5v0__oai21_2

* cell gf180mcu_fd_sc_mcu9t5v0__aoi21_2
* pin A1
* pin A2
* pin B
* pin VDD
* pin VSS
* pin ZN
.SUBCKT gf180mcu_fd_sc_mcu9t5v0__aoi21_2 1 2 3 4 5 6
* net 1 A1
* net 2 A2
* net 3 B
* net 4 VDD
* net 5 VSS
* net 6 ZN
.ENDS gf180mcu_fd_sc_mcu9t5v0__aoi21_2

* cell gf180mcu_fd_sc_mcu9t5v0__clkbuf_8
* pin I
* pin VDD
* pin VSS
* pin Z
.SUBCKT gf180mcu_fd_sc_mcu9t5v0__clkbuf_8 1 2 3 5
* net 1 I
* net 2 VDD
* net 3 VSS
* net 5 Z
.ENDS gf180mcu_fd_sc_mcu9t5v0__clkbuf_8

* cell gf180mcu_fd_sc_mcu9t5v0__inv_3
* pin I
* pin VDD
* pin VSS
.SUBCKT gf180mcu_fd_sc_mcu9t5v0__inv_3 1 2 3
* net 1 I
* net 2 VDD
* net 3 VSS
* net 4 ZN
.ENDS gf180mcu_fd_sc_mcu9t5v0__inv_3

* cell gf180mcu_fd_sc_mcu9t5v0__aoi222_1
* pin A1
* pin A2
* pin B1
* pin B2
* pin C1
* pin C2
* pin VDD
* pin VSS
* pin ZN
.SUBCKT gf180mcu_fd_sc_mcu9t5v0__aoi222_1 1 2 3 4 5 6 7 8 9
* net 1 A1
* net 2 A2
* net 3 B1
* net 4 B2
* net 5 C1
* net 6 C2
* net 7 VDD
* net 8 VSS
* net 9 ZN
.ENDS gf180mcu_fd_sc_mcu9t5v0__aoi222_1

* cell gf180mcu_fd_sc_mcu9t5v0__nand3_1
* pin A1
* pin A2
* pin A3
* pin VDD
* pin VSS
* pin ZN
.SUBCKT gf180mcu_fd_sc_mcu9t5v0__nand3_1 1 2 3 4 5 6
* net 1 A1
* net 2 A2
* net 3 A3
* net 4 VDD
* net 5 VSS
* net 6 ZN
.ENDS gf180mcu_fd_sc_mcu9t5v0__nand3_1

* cell gf180mcu_fd_sc_mcu9t5v0__nand4_1
* pin A1
* pin A2
* pin A3
* pin A4
* pin VDD
* pin VSS
* pin ZN
.SUBCKT gf180mcu_fd_sc_mcu9t5v0__nand4_1 1 2 3 4 5 6 7
* net 1 A1
* net 2 A2
* net 3 A3
* net 4 A4
* net 5 VDD
* net 6 VSS
* net 7 ZN
.ENDS gf180mcu_fd_sc_mcu9t5v0__nand4_1

* cell gf180mcu_fd_sc_mcu9t5v0__oai22_1
* pin A1
* pin A2
* pin B1
* pin B2
* pin VDD
* pin VSS
* pin ZN
.SUBCKT gf180mcu_fd_sc_mcu9t5v0__oai22_1 1 2 3 4 5 6 7
* net 1 A1
* net 2 A2
* net 3 B1
* net 4 B2
* net 5 VDD
* net 6 VSS
* net 7 ZN
.ENDS gf180mcu_fd_sc_mcu9t5v0__oai22_1

* cell gf180mcu_fd_sc_mcu9t5v0__inv_1
* pin I
* pin VDD
* pin VSS
* pin ZN
.SUBCKT gf180mcu_fd_sc_mcu9t5v0__inv_1 1 2 3 4
* net 1 I
* net 2 VDD
* net 3 VSS
* net 4 ZN
.ENDS gf180mcu_fd_sc_mcu9t5v0__inv_1

* cell gf180mcu_fd_sc_mcu9t5v0__nand2_2
* pin A1
* pin A2
* pin VDD
* pin VSS
* pin ZN
.SUBCKT gf180mcu_fd_sc_mcu9t5v0__nand2_2 1 2 3 4 5
* net 1 A1
* net 2 A2
* net 3 VDD
* net 4 VSS
* net 5 ZN
.ENDS gf180mcu_fd_sc_mcu9t5v0__nand2_2

* cell gf180mcu_fd_sc_mcu9t5v0__and4_1
* pin A1
* pin A2
* pin A3
* pin A4
* pin VDD
* pin VSS
* pin Z
.SUBCKT gf180mcu_fd_sc_mcu9t5v0__and4_1 1 2 3 4 5 6 7
* net 1 A1
* net 2 A2
* net 3 A3
* net 4 A4
* net 5 VDD
* net 6 VSS
* net 7 Z
.ENDS gf180mcu_fd_sc_mcu9t5v0__and4_1

* cell gf180mcu_fd_sc_mcu9t5v0__or3_1
* pin A1
* pin A2
* pin A3
* pin VDD
* pin VSS
* pin Z
.SUBCKT gf180mcu_fd_sc_mcu9t5v0__or3_1 1 2 3 4 5 6
* net 1 A1
* net 2 A2
* net 3 A3
* net 4 VDD
* net 5 VSS
* net 6 Z
.ENDS gf180mcu_fd_sc_mcu9t5v0__or3_1

* cell gf180mcu_fd_sc_mcu9t5v0__nor2_4
* pin A1
* pin A2
* pin VDD
* pin VSS
* pin ZN
.SUBCKT gf180mcu_fd_sc_mcu9t5v0__nor2_4 1 2 3 4 5
* net 1 A1
* net 2 A2
* net 3 VDD
* net 4 VSS
* net 5 ZN
.ENDS gf180mcu_fd_sc_mcu9t5v0__nor2_4

* cell gf180mcu_fd_sc_mcu9t5v0__or2_2
* pin A1
* pin A2
* pin VDD
* pin VSS
* pin Z
.SUBCKT gf180mcu_fd_sc_mcu9t5v0__or2_2 1 2 3 4 5
* net 1 A1
* net 2 A2
* net 3 VDD
* net 4 VSS
* net 5 Z
.ENDS gf180mcu_fd_sc_mcu9t5v0__or2_2

* cell gf180mcu_fd_sc_mcu9t5v0__and3_2
* pin A1
* pin A2
* pin A3
* pin VDD
* pin VSS
* pin Z
.SUBCKT gf180mcu_fd_sc_mcu9t5v0__and3_2 1 2 3 4 5 6
* net 1 A1
* net 2 A2
* net 3 A3
* net 4 VDD
* net 5 VSS
* net 6 Z
.ENDS gf180mcu_fd_sc_mcu9t5v0__and3_2

* cell gf180mcu_fd_sc_mcu9t5v0__clkinv_12
* pin I
* pin VDD
* pin VSS
.SUBCKT gf180mcu_fd_sc_mcu9t5v0__clkinv_12 1 2 3
* net 1 I
* net 2 VDD
* net 3 VSS
* net 4 ZN
.ENDS gf180mcu_fd_sc_mcu9t5v0__clkinv_12

* cell gf180mcu_fd_sc_mcu9t5v0__clkinv_8
* pin I
* pin VDD
* pin VSS
.SUBCKT gf180mcu_fd_sc_mcu9t5v0__clkinv_8 1 2 3
* net 1 I
* net 2 VDD
* net 3 VSS
* net 4 ZN
.ENDS gf180mcu_fd_sc_mcu9t5v0__clkinv_8

* cell gf180mcu_fd_sc_mcu9t5v0__xor3_2
* pin A1
* pin A3
* pin VDD
* pin VSS
* pin A2
* pin Z
.SUBCKT gf180mcu_fd_sc_mcu9t5v0__xor3_2 1 2 3 4 6 10
* net 1 A1
* net 2 A3
* net 3 VDD
* net 4 VSS
* net 6 A2
* net 10 Z
.ENDS gf180mcu_fd_sc_mcu9t5v0__xor3_2

* cell gf180mcu_fd_sc_mcu9t5v0__xor2_2
* pin A1
* pin VDD
* pin VSS
* pin Z
* pin A2
.SUBCKT gf180mcu_fd_sc_mcu9t5v0__xor2_2 1 2 3 4 7
* net 1 A1
* net 2 VDD
* net 3 VSS
* net 4 Z
* net 7 A2
.ENDS gf180mcu_fd_sc_mcu9t5v0__xor2_2

* cell gf180mcu_fd_sc_mcu9t5v0__oai32_4
* pin A1
* pin A2
* pin A3
* pin B1
* pin VDD
* pin VSS
* pin ZN
* pin B2
.SUBCKT gf180mcu_fd_sc_mcu9t5v0__oai32_4 1 2 3 4 5 6 7 8
* net 1 A1
* net 2 A2
* net 3 A3
* net 4 B1
* net 5 VDD
* net 6 VSS
* net 7 ZN
* net 8 B2
.ENDS gf180mcu_fd_sc_mcu9t5v0__oai32_4

* cell gf180mcu_fd_sc_mcu9t5v0__inv_2
* pin I
* pin VDD
* pin VSS
* pin ZN
.SUBCKT gf180mcu_fd_sc_mcu9t5v0__inv_2 1 2 3 4
* net 1 I
* net 2 VDD
* net 3 VSS
* net 4 ZN
.ENDS gf180mcu_fd_sc_mcu9t5v0__inv_2

* cell gf180mcu_fd_sc_mcu9t5v0__oai22_2
* pin A1
* pin A2
* pin B1
* pin B2
* pin VDD
* pin VSS
* pin ZN
.SUBCKT gf180mcu_fd_sc_mcu9t5v0__oai22_2 1 2 3 4 5 6 7
* net 1 A1
* net 2 A2
* net 3 B1
* net 4 B2
* net 5 VDD
* net 6 VSS
* net 7 ZN
.ENDS gf180mcu_fd_sc_mcu9t5v0__oai22_2

* cell gf180mcu_fd_sc_mcu9t5v0__dffrnq_4
* pin CLK
* pin D
* pin RN
* pin VSS
* pin Q
* pin VDD
.SUBCKT gf180mcu_fd_sc_mcu9t5v0__dffrnq_4 1 2 3 4 8 10
* net 1 CLK
* net 2 D
* net 3 RN
* net 4 VSS
* net 8 Q
* net 10 VDD
.ENDS gf180mcu_fd_sc_mcu9t5v0__dffrnq_4

* cell gf180mcu_fd_sc_mcu9t5v0__clkbuf_4
* pin I
* pin VDD
* pin VSS
.SUBCKT gf180mcu_fd_sc_mcu9t5v0__clkbuf_4 1 2 3
* net 1 I
* net 2 VDD
* net 3 VSS
* net 4 Z
.ENDS gf180mcu_fd_sc_mcu9t5v0__clkbuf_4

* cell gf180mcu_fd_sc_mcu9t5v0__nor4_1
* pin A1
* pin A2
* pin A3
* pin A4
* pin VDD
* pin VSS
* pin ZN
.SUBCKT gf180mcu_fd_sc_mcu9t5v0__nor4_1 1 2 3 4 5 6 7
* net 1 A1
* net 2 A2
* net 3 A3
* net 4 A4
* net 5 VDD
* net 6 VSS
* net 7 ZN
.ENDS gf180mcu_fd_sc_mcu9t5v0__nor4_1

* cell gf180mcu_fd_sc_mcu9t5v0__clkinv_3
* pin I
* pin VDD
* pin VSS
.SUBCKT gf180mcu_fd_sc_mcu9t5v0__clkinv_3 1 2 3
* net 1 I
* net 2 VDD
* net 3 VSS
* net 4 ZN
.ENDS gf180mcu_fd_sc_mcu9t5v0__clkinv_3

* cell gf180mcu_fd_sc_mcu9t5v0__inv_4
* pin I
* pin VDD
* pin VSS
.SUBCKT gf180mcu_fd_sc_mcu9t5v0__inv_4 1 2 3
* net 1 I
* net 2 VDD
* net 3 VSS
* net 4 ZN
.ENDS gf180mcu_fd_sc_mcu9t5v0__inv_4

* cell gf180mcu_fd_sc_mcu9t5v0__aoi211_2
* pin A1
* pin A2
* pin B
* pin C
* pin VDD
* pin VSS
* pin ZN
.SUBCKT gf180mcu_fd_sc_mcu9t5v0__aoi211_2 1 2 3 4 5 6 7
* net 1 A1
* net 2 A2
* net 3 B
* net 4 C
* net 5 VDD
* net 6 VSS
* net 7 ZN
.ENDS gf180mcu_fd_sc_mcu9t5v0__aoi211_2

* cell gf180mcu_fd_sc_mcu9t5v0__oai32_1
* pin A1
* pin A2
* pin A3
* pin B1
* pin B2
* pin VDD
* pin VSS
* pin ZN
.SUBCKT gf180mcu_fd_sc_mcu9t5v0__oai32_1 1 2 3 4 5 6 7 8
* net 1 A1
* net 2 A2
* net 3 A3
* net 4 B1
* net 5 B2
* net 6 VDD
* net 7 VSS
* net 8 ZN
.ENDS gf180mcu_fd_sc_mcu9t5v0__oai32_1

* cell gf180mcu_fd_io__bi_t
* pin PAD
* pin DVSS
* pin DVSS
* pin DVSS
* pin DVSS
* pin DVSS
* pin DVSS
* pin DVSS
* pin DVSS
* pin DVSS
* pin DVDD
* pin DVDD
* pin DVDD
* pin DVSS
* pin DVSS
* pin DVSS
* pin DVDD
* pin DVDD
* pin DVDD
* pin DVDD
* pin DVDD
* pin DVDD
* pin DVDD
* pin DVDD
* pin DVDD
* pin DVDD
* pin DVDD
* pin DVDD
* pin DVSS
* pin DVSS
* pin DVSS
* pin DVDD
* pin DVDD
* pin DVDD
* pin DVDD
* pin DVDD
* pin DVDD
* pin DVSS
* pin DVSS
* pin DVSS
* pin VSS
* pin VSS
* pin VSS
* pin VDD
* pin VDD
* pin VDD
* pin DVDD
* pin PDRV0
* pin DVDD
* pin DVDD
* pin DVDD
* pin DVDD
* pin DVDD
* pin DVDD
* pin DVDD
* pin DVDD
* pin DVSS
* pin DVSS
* pin DVSS
* pin DVSS
* pin DVDD
* pin DVDD
* pin DVSS
* pin DVSS
* pin DVDD
* pin VDD
* pin VDD
* pin VDD
* pin VSS
* pin VSS
* pin VSS
* pin DVDD
* pin DVSS
* pin DVSS
* pin DVSS
* pin DVDD
* pin DVDD
* pin PD
* pin DVSS
* pin DVSS
* pin DVSS
* pin PDRV1
* pin CS
* pin PU
* pin IE
* pin SL
* pin A
* pin OE
.SUBCKT gf180mcu_fd_io__bi_t 1 2 3 4 5 6 7 8 9 10 11 12 13 14 15 16 17 18 19 20
+ 21 22 23 24 25 26 27 28 29 30 31 32 33 34 35 36 37 38 39 40 41 42 43 44 45 46
+ 47 48 49 50 51 52 53 54 55 56 57 58 59 60 61 62 63 64 65 66 67 68 69 70 71 72
+ 73 74 75 76 77 78 79 80 81 82 83 84 85 86 87 88
* net 1 PAD
* net 2 DVSS
* net 3 DVSS
* net 4 DVSS
* net 5 DVSS
* net 6 DVSS
* net 7 DVSS
* net 8 DVSS
* net 9 DVSS
* net 10 DVSS
* net 11 DVDD
* net 12 DVDD
* net 13 DVDD
* net 14 DVSS
* net 15 DVSS
* net 16 DVSS
* net 17 DVDD
* net 18 DVDD
* net 19 DVDD
* net 20 DVDD
* net 21 DVDD
* net 22 DVDD
* net 23 DVDD
* net 24 DVDD
* net 25 DVDD
* net 26 DVDD
* net 27 DVDD
* net 28 DVDD
* net 29 DVSS
* net 30 DVSS
* net 31 DVSS
* net 32 DVDD
* net 33 DVDD
* net 34 DVDD
* net 35 DVDD
* net 36 DVDD
* net 37 DVDD
* net 38 DVSS
* net 39 DVSS
* net 40 DVSS
* net 41 VSS
* net 42 VSS
* net 43 VSS
* net 44 VDD
* net 45 VDD
* net 46 VDD
* net 47 DVDD
* net 48 PDRV0
* net 49 DVDD
* net 50 DVDD
* net 51 DVDD
* net 52 DVDD
* net 53 DVDD
* net 54 DVDD
* net 55 DVDD
* net 56 DVDD
* net 57 DVSS
* net 58 DVSS
* net 59 DVSS
* net 60 DVSS
* net 61 DVDD
* net 62 DVDD
* net 63 DVSS
* net 64 DVSS
* net 65 DVDD
* net 66 VDD
* net 67 VDD
* net 68 VDD
* net 69 VSS
* net 70 VSS
* net 71 VSS
* net 72 DVDD
* net 73 DVSS
* net 74 DVSS
* net 75 DVSS
* net 76 DVDD
* net 77 DVDD
* net 78 PD
* net 79 DVSS
* net 80 DVSS
* net 81 DVSS
* net 82 PDRV1
* net 83 CS
* net 84 PU
* net 85 IE
* net 86 SL
* net 87 A
* net 88 OE
* net 89 Y
.ENDS gf180mcu_fd_io__bi_t

* cell gf180mcu_fd_sc_mcu9t5v0__tieh
* pin VDD
* pin VSS
* pin Z
.SUBCKT gf180mcu_fd_sc_mcu9t5v0__tieh 1 2 3
* net 1 VDD
* net 2 VSS
* net 3 Z
.ENDS gf180mcu_fd_sc_mcu9t5v0__tieh

* cell gf180mcu_fd_sc_mcu9t5v0__tiel
* pin VDD
* pin VSS
* pin ZN
.SUBCKT gf180mcu_fd_sc_mcu9t5v0__tiel 1 2 3
* net 1 VDD
* net 2 VSS
* net 3 ZN
.ENDS gf180mcu_fd_sc_mcu9t5v0__tiel

* cell gf180mcu_fd_sc_mcu9t5v0__or4_1
* pin A1
* pin A2
* pin A3
* pin A4
* pin VDD
* pin VSS
* pin Z
.SUBCKT gf180mcu_fd_sc_mcu9t5v0__or4_1 1 2 3 4 5 6 7
* net 1 A1
* net 2 A2
* net 3 A3
* net 4 A4
* net 5 VDD
* net 6 VSS
* net 7 Z
.ENDS gf180mcu_fd_sc_mcu9t5v0__or4_1

* cell gf180mcu_fd_io__dvdd
* pin DVSS
* pin DVSS
* pin DVSS
* pin DVSS
* pin DVSS
* pin DVSS
* pin DVSS
* pin DVSS
* pin DVSS
* pin DVDD
* pin DVDD
* pin DVDD
* pin DVSS
* pin DVSS
* pin DVSS
* pin DVDD
* pin DVDD
* pin DVDD
* pin DVDD
* pin DVDD
* pin DVDD
* pin DVDD
* pin DVDD
* pin DVDD
* pin DVDD
* pin DVDD
* pin DVDD
* pin DVSS
* pin DVSS
* pin DVSS
* pin DVDD
* pin DVDD
* pin DVDD
* pin DVDD
* pin DVDD
* pin DVDD
* pin DVSS
* pin DVSS
* pin DVSS
* pin VSS
* pin VSS
* pin VSS
* pin DVDD
* pin DVDD
* pin DVDD
* pin DVDD
* pin DVDD
* pin DVDD
* pin DVDD
* pin DVDD
* pin DVDD
* pin DVDD
* pin DVDD
* pin DVDD
* pin DVSS
* pin DVSS
* pin DVSS
* pin DVDD
* pin DVDD
* pin DVDD
* pin DVSS
* pin DVSS
* pin DVSS
* pin DVDD
* pin DVDD
* pin DVDD
* pin VSS
* pin VSS
* pin VSS
* pin DVDD
* pin DVSS
* pin DVSS
* pin DVDD
* pin DVDD
* pin DVSS
* pin DVSS
* pin DVSS
* pin DVSS
.SUBCKT gf180mcu_fd_io__dvdd 2 3 4 5 6 7 8 9 10 11 12 13 14 15 16 17 18 19 20
+ 21 22 23 24 25 26 27 28 29 30 31 32 33 34 35 36 37 38 39 40 41 42 43 44 45 46
+ 47 48 49 50 51 52 53 54 55 56 57 58 59 60 61 62 63 64 65 66 67 68 69 70 71 72
+ 73 74 75 76 77 78 79
* net 1 DVDD
* net 2 DVSS
* net 3 DVSS
* net 4 DVSS
* net 5 DVSS
* net 6 DVSS
* net 7 DVSS
* net 8 DVSS
* net 9 DVSS
* net 10 DVSS
* net 11 DVDD
* net 12 DVDD
* net 13 DVDD
* net 14 DVSS
* net 15 DVSS
* net 16 DVSS
* net 17 DVDD
* net 18 DVDD
* net 19 DVDD
* net 20 DVDD
* net 21 DVDD
* net 22 DVDD
* net 23 DVDD
* net 24 DVDD
* net 25 DVDD
* net 26 DVDD
* net 27 DVDD
* net 28 DVDD
* net 29 DVSS
* net 30 DVSS
* net 31 DVSS
* net 32 DVDD
* net 33 DVDD
* net 34 DVDD
* net 35 DVDD
* net 36 DVDD
* net 37 DVDD
* net 38 DVSS
* net 39 DVSS
* net 40 DVSS
* net 41 VSS
* net 42 VSS
* net 43 VSS
* net 44 DVDD
* net 45 DVDD
* net 46 DVDD
* net 47 DVDD
* net 48 DVDD
* net 49 DVDD
* net 50 DVDD
* net 51 DVDD
* net 52 DVDD
* net 53 DVDD
* net 54 DVDD
* net 55 DVDD
* net 56 DVSS
* net 57 DVSS
* net 58 DVSS
* net 59 DVDD
* net 60 DVDD
* net 61 DVDD
* net 62 DVSS
* net 63 DVSS
* net 64 DVSS
* net 65 DVDD
* net 66 DVDD
* net 67 DVDD
* net 68 VSS
* net 69 VSS
* net 70 VSS
* net 71 DVDD
* net 72 DVSS
* net 73 DVSS
* net 74 DVDD
* net 75 DVDD
* net 76 DVSS
* net 77 DVSS
* net 78 DVSS
* net 79 DVSS
* net 80 DVDD
* net 81 DVDD
* net 82 DVDD
* net 83 DVDD
* net 84 DVDD
* net 85 DVDD
.ENDS gf180mcu_fd_io__dvdd

* cell gf180mcu_fd_io__in_c
* pin PAD
* pin DVSS
* pin DVSS
* pin DVSS
* pin DVSS
* pin DVSS
* pin DVSS
* pin DVSS
* pin DVSS
* pin DVSS
* pin DVDD
* pin DVDD
* pin DVDD
* pin DVSS
* pin DVSS
* pin DVSS
* pin DVDD
* pin DVDD
* pin DVDD
* pin DVDD
* pin DVDD
* pin DVDD
* pin DVDD
* pin DVDD
* pin DVDD
* pin DVDD
* pin DVDD
* pin DVDD
* pin DVSS
* pin DVSS
* pin DVSS
* pin DVDD
* pin DVDD
* pin DVDD
* pin DVDD
* pin DVDD
* pin DVDD
* pin DVSS
* pin DVSS
* pin DVSS
* pin VSS
* pin VSS
* pin VSS
* pin VDD
* pin VDD
* pin VDD
* pin DVDD
* pin DVDD
* pin DVDD
* pin DVDD
* pin DVDD
* pin DVDD
* pin DVDD
* pin DVDD
* pin DVDD
* pin DVSS
* pin DVSS
* pin DVSS
* pin DVDD
* pin DVDD
* pin DVDD
* pin DVSS
* pin DVSS
* pin DVSS
* pin VDD
* pin VDD
* pin VDD
* pin VSS
* pin VSS
* pin VSS
* pin DVSS
* pin DVSS
* pin DVSS
* pin PD
* pin DVDD
* pin DVDD
* pin DVDD
* pin DVSS
* pin DVSS
* pin DVSS
* pin PU
* pin Y
.SUBCKT gf180mcu_fd_io__in_c 1 2 3 4 5 6 7 8 9 10 11 12 13 14 15 16 17 18 19 20
+ 21 22 23 24 25 26 27 28 29 30 31 32 33 34 35 36 37 38 39 40 41 42 43 44 45 46
+ 47 48 49 50 51 52 53 54 55 56 57 58 59 60 61 62 63 64 65 66 67 68 69 70 71 72
+ 73 74 75 76 77 78 79 80 81 82
* net 1 PAD
* net 2 DVSS
* net 3 DVSS
* net 4 DVSS
* net 5 DVSS
* net 6 DVSS
* net 7 DVSS
* net 8 DVSS
* net 9 DVSS
* net 10 DVSS
* net 11 DVDD
* net 12 DVDD
* net 13 DVDD
* net 14 DVSS
* net 15 DVSS
* net 16 DVSS
* net 17 DVDD
* net 18 DVDD
* net 19 DVDD
* net 20 DVDD
* net 21 DVDD
* net 22 DVDD
* net 23 DVDD
* net 24 DVDD
* net 25 DVDD
* net 26 DVDD
* net 27 DVDD
* net 28 DVDD
* net 29 DVSS
* net 30 DVSS
* net 31 DVSS
* net 32 DVDD
* net 33 DVDD
* net 34 DVDD
* net 35 DVDD
* net 36 DVDD
* net 37 DVDD
* net 38 DVSS
* net 39 DVSS
* net 40 DVSS
* net 41 VSS
* net 42 VSS
* net 43 VSS
* net 44 VDD
* net 45 VDD
* net 46 VDD
* net 47 DVDD
* net 48 DVDD
* net 49 DVDD
* net 50 DVDD
* net 51 DVDD
* net 52 DVDD
* net 53 DVDD
* net 54 DVDD
* net 55 DVDD
* net 56 DVSS
* net 57 DVSS
* net 58 DVSS
* net 59 DVDD
* net 60 DVDD
* net 61 DVDD
* net 62 DVSS
* net 63 DVSS
* net 64 DVSS
* net 65 VDD
* net 66 VDD
* net 67 VDD
* net 68 VSS
* net 69 VSS
* net 70 VSS
* net 71 DVSS
* net 72 DVSS
* net 73 DVSS
* net 74 PD
* net 75 DVDD
* net 76 DVDD
* net 77 DVDD
* net 78 DVSS
* net 79 DVSS
* net 80 DVSS
* net 81 PU
* net 82 Y
.ENDS gf180mcu_fd_io__in_c

* cell gf180mcu_fd_sc_mcu9t5v0__dffsnq_2
* pin CLK
* pin D
* pin Q
* pin SETN
* pin VSS
* pin VDD
.SUBCKT gf180mcu_fd_sc_mcu9t5v0__dffsnq_2 1 2 3 4 5 9
* net 1 CLK
* net 2 D
* net 3 Q
* net 4 SETN
* net 5 VSS
* net 9 VDD
.ENDS gf180mcu_fd_sc_mcu9t5v0__dffsnq_2

* cell gf180mcu_fd_sc_mcu9t5v0__dlyc_1
* pin I
* pin VDD
* pin VSS
* pin Z
.SUBCKT gf180mcu_fd_sc_mcu9t5v0__dlyc_1 1 2 3 4
* net 1 I
* net 2 VDD
* net 3 VSS
* net 4 Z
.ENDS gf180mcu_fd_sc_mcu9t5v0__dlyc_1

* cell gf180mcu_fd_sc_mcu9t5v0__aoi221_2
* pin A1
* pin A2
* pin B1
* pin B2
* pin C
* pin VDD
* pin VSS
* pin ZN
.SUBCKT gf180mcu_fd_sc_mcu9t5v0__aoi221_2 1 2 3 4 5 6 7 8
* net 1 A1
* net 2 A2
* net 3 B1
* net 4 B2
* net 5 C
* net 6 VDD
* net 7 VSS
* net 8 ZN
.ENDS gf180mcu_fd_sc_mcu9t5v0__aoi221_2

* cell gf180mcu_fd_sc_mcu9t5v0__oai21_4
* pin A1
* pin A2
* pin B
* pin VDD
* pin VSS
* pin ZN
.SUBCKT gf180mcu_fd_sc_mcu9t5v0__oai21_4 1 2 3 4 5 6
* net 1 A1
* net 2 A2
* net 3 B
* net 4 VDD
* net 5 VSS
* net 6 ZN
.ENDS gf180mcu_fd_sc_mcu9t5v0__oai21_4

* cell gf180mcu_fd_sc_mcu9t5v0__and2_2
* pin A1
* pin A2
* pin VDD
* pin VSS
* pin Z
.SUBCKT gf180mcu_fd_sc_mcu9t5v0__and2_2 1 2 3 4 5
* net 1 A1
* net 2 A2
* net 3 VDD
* net 4 VSS
* net 5 Z
.ENDS gf180mcu_fd_sc_mcu9t5v0__and2_2

* cell gf180mcu_fd_sc_mcu9t5v0__nor3_2
* pin A1
* pin A2
* pin A3
* pin VDD
* pin VSS
* pin ZN
.SUBCKT gf180mcu_fd_sc_mcu9t5v0__nor3_2 1 2 3 4 5 6
* net 1 A1
* net 2 A2
* net 3 A3
* net 4 VDD
* net 5 VSS
* net 6 ZN
.ENDS gf180mcu_fd_sc_mcu9t5v0__nor3_2

* cell gf180mcu_fd_sc_mcu9t5v0__oai31_4
* pin A1
* pin A2
* pin A3
* pin B
* pin VDD
* pin VSS
* pin ZN
.SUBCKT gf180mcu_fd_sc_mcu9t5v0__oai31_4 1 2 3 4 5 6 7
* net 1 A1
* net 2 A2
* net 3 A3
* net 4 B
* net 5 VDD
* net 6 VSS
* net 7 ZN
.ENDS gf180mcu_fd_sc_mcu9t5v0__oai31_4

* cell gf180mcu_fd_sc_mcu9t5v0__nor4_2
* pin A1
* pin A3
* pin A4
* pin VDD
* pin VSS
* pin ZN
* pin A2
.SUBCKT gf180mcu_fd_sc_mcu9t5v0__nor4_2 1 2 3 4 5 6 7
* net 1 A1
* net 2 A3
* net 3 A4
* net 4 VDD
* net 5 VSS
* net 6 ZN
* net 7 A2
.ENDS gf180mcu_fd_sc_mcu9t5v0__nor4_2

* cell gf180mcu_fd_sc_mcu9t5v0__aoi21_4
* pin A1
* pin A2
* pin B
* pin VDD
* pin VSS
* pin ZN
.SUBCKT gf180mcu_fd_sc_mcu9t5v0__aoi21_4 1 2 3 4 5 6
* net 1 A1
* net 2 A2
* net 3 B
* net 4 VDD
* net 5 VSS
* net 6 ZN
.ENDS gf180mcu_fd_sc_mcu9t5v0__aoi21_4

* cell gf180mcu_fd_sc_mcu9t5v0__oai222_1
* pin A1
* pin A2
* pin B1
* pin B2
* pin C1
* pin C2
* pin VDD
* pin VSS
* pin ZN
.SUBCKT gf180mcu_fd_sc_mcu9t5v0__oai222_1 1 2 3 4 5 6 7 8 9
* net 1 A1
* net 2 A2
* net 3 B1
* net 4 B2
* net 5 C1
* net 6 C2
* net 7 VDD
* net 8 VSS
* net 9 ZN
.ENDS gf180mcu_fd_sc_mcu9t5v0__oai222_1

* cell gf180mcu_fd_sc_mcu9t5v0__nand3_2
* pin A1
* pin A2
* pin A3
* pin VDD
* pin VSS
* pin ZN
.SUBCKT gf180mcu_fd_sc_mcu9t5v0__nand3_2 1 2 3 4 5 6
* net 1 A1
* net 2 A2
* net 3 A3
* net 4 VDD
* net 5 VSS
* net 6 ZN
.ENDS gf180mcu_fd_sc_mcu9t5v0__nand3_2

* cell gf180mcu_fd_sc_mcu9t5v0__nor2_2
* pin A1
* pin A2
* pin VDD
* pin VSS
* pin ZN
.SUBCKT gf180mcu_fd_sc_mcu9t5v0__nor2_2 1 2 3 4 5
* net 1 A1
* net 2 A2
* net 3 VDD
* net 4 VSS
* net 5 ZN
.ENDS gf180mcu_fd_sc_mcu9t5v0__nor2_2

* cell gf180mcu_fd_sc_mcu9t5v0__nand4_2
* pin A1
* pin A2
* pin A3
* pin VDD
* pin VSS
* pin A4
* pin ZN
.SUBCKT gf180mcu_fd_sc_mcu9t5v0__nand4_2 1 2 3 4 5 6 7
* net 1 A1
* net 2 A2
* net 3 A3
* net 4 VDD
* net 5 VSS
* net 6 A4
* net 7 ZN
.ENDS gf180mcu_fd_sc_mcu9t5v0__nand4_2

* cell gf180mcu_fd_sc_mcu9t5v0__inv_8
* pin I
* pin VDD
* pin VSS
.SUBCKT gf180mcu_fd_sc_mcu9t5v0__inv_8 1 2 3
* net 1 I
* net 2 VDD
* net 3 VSS
* net 4 ZN
.ENDS gf180mcu_fd_sc_mcu9t5v0__inv_8

* cell gf180mcu_fd_sc_mcu9t5v0__nor3_4
* pin A1
* pin A2
* pin A3
* pin VDD
* pin VSS
* pin ZN
.SUBCKT gf180mcu_fd_sc_mcu9t5v0__nor3_4 1 2 3 4 5 6
* net 1 A1
* net 2 A2
* net 3 A3
* net 4 VDD
* net 5 VSS
* net 6 ZN
.ENDS gf180mcu_fd_sc_mcu9t5v0__nor3_4

* cell gf180mcu_fd_sc_mcu9t5v0__aoi211_4
* pin A1
* pin A2
* pin B
* pin C
* pin VDD
* pin VSS
* pin ZN
.SUBCKT gf180mcu_fd_sc_mcu9t5v0__aoi211_4 1 2 3 4 5 6 7
* net 1 A1
* net 2 A2
* net 3 B
* net 4 C
* net 5 VDD
* net 6 VSS
* net 7 ZN
.ENDS gf180mcu_fd_sc_mcu9t5v0__aoi211_4

* cell gf180mcu_fd_sc_mcu9t5v0__and3_4
* pin A1
* pin A2
* pin A3
* pin VDD
* pin VSS
* pin Z
.SUBCKT gf180mcu_fd_sc_mcu9t5v0__and3_4 1 2 3 4 5 6
* net 1 A1
* net 2 A2
* net 3 A3
* net 4 VDD
* net 5 VSS
* net 6 Z
.ENDS gf180mcu_fd_sc_mcu9t5v0__and3_4

* cell gf180mcu_fd_sc_mcu9t5v0__clkinv_4
* pin I
* pin VDD
* pin VSS
* pin ZN
.SUBCKT gf180mcu_fd_sc_mcu9t5v0__clkinv_4 1 2 3 4
* net 1 I
* net 2 VDD
* net 3 VSS
* net 4 ZN
.ENDS gf180mcu_fd_sc_mcu9t5v0__clkinv_4

* cell gf180mcu_fd_sc_mcu9t5v0__clkinv_2
* pin I
* pin VDD
* pin VSS
* pin ZN
.SUBCKT gf180mcu_fd_sc_mcu9t5v0__clkinv_2 1 2 3 4
* net 1 I
* net 2 VDD
* net 3 VSS
* net 4 ZN
.ENDS gf180mcu_fd_sc_mcu9t5v0__clkinv_2

* cell gf180mcu_fd_sc_mcu9t5v0__nand2_4
* pin A1
* pin A2
* pin VDD
* pin VSS
* pin ZN
.SUBCKT gf180mcu_fd_sc_mcu9t5v0__nand2_4 1 2 3 4 5
* net 1 A1
* net 2 A2
* net 3 VDD
* net 4 VSS
* net 5 ZN
.ENDS gf180mcu_fd_sc_mcu9t5v0__nand2_4

* cell gf180mcu_fd_sc_mcu9t5v0__or3_2
* pin A1
* pin A2
* pin A3
* pin VDD
* pin VSS
* pin Z
.SUBCKT gf180mcu_fd_sc_mcu9t5v0__or3_2 1 2 3 4 5 6
* net 1 A1
* net 2 A2
* net 3 A3
* net 4 VDD
* net 5 VSS
* net 6 Z
.ENDS gf180mcu_fd_sc_mcu9t5v0__or3_2

* cell gf180mcu_fd_sc_mcu9t5v0__mux2_2
* pin I0
* pin I1
* pin S
* pin VDD
* pin VSS
* pin Z
.SUBCKT gf180mcu_fd_sc_mcu9t5v0__mux2_2 1 2 3 4 5 6
* net 1 I0
* net 2 I1
* net 3 S
* net 4 VDD
* net 5 VSS
* net 6 Z
.ENDS gf180mcu_fd_sc_mcu9t5v0__mux2_2

* cell gf180mcu_fd_sc_mcu9t5v0__aoi22_4
* pin A1
* pin B1
* pin B2
* pin VDD
* pin VSS
* pin ZN
* pin A2
.SUBCKT gf180mcu_fd_sc_mcu9t5v0__aoi22_4 1 2 3 4 5 6 7
* net 1 A1
* net 2 B1
* net 3 B2
* net 4 VDD
* net 5 VSS
* net 6 ZN
* net 7 A2
.ENDS gf180mcu_fd_sc_mcu9t5v0__aoi22_4

* cell gf180mcu_fd_sc_mcu9t5v0__nor4_4
* pin A1
* pin A2
* pin A4
* pin VDD
* pin VSS
* pin ZN
* pin A3
.SUBCKT gf180mcu_fd_sc_mcu9t5v0__nor4_4 1 2 3 4 5 6 7
* net 1 A1
* net 2 A2
* net 3 A4
* net 4 VDD
* net 5 VSS
* net 6 ZN
* net 7 A3
.ENDS gf180mcu_fd_sc_mcu9t5v0__nor4_4

* cell gf180mcu_fd_sc_mcu9t5v0__buf_12
* pin I
* pin VDD
* pin VSS
* pin Z
.SUBCKT gf180mcu_fd_sc_mcu9t5v0__buf_12 1 3 4 5
* net 1 I
* net 3 VDD
* net 4 VSS
* net 5 Z
.ENDS gf180mcu_fd_sc_mcu9t5v0__buf_12

* cell gf180mcu_fd_sc_mcu9t5v0__aoi221_4
* pin A2
* pin B2
* pin C
* pin VSS
* pin A1
* pin ZN
* pin B1
* pin VDD
.SUBCKT gf180mcu_fd_sc_mcu9t5v0__aoi221_4 1 2 3 4 5 6 7 8
* net 1 A2
* net 2 B2
* net 3 C
* net 4 VSS
* net 5 A1
* net 6 ZN
* net 7 B1
* net 8 VDD
.ENDS gf180mcu_fd_sc_mcu9t5v0__aoi221_4

* cell gf180mcu_fd_sc_mcu9t5v0__and4_4
* pin A1
* pin A2
* pin A3
* pin A4
* pin VDD
* pin VSS
* pin Z
.SUBCKT gf180mcu_fd_sc_mcu9t5v0__and4_4 1 2 3 4 5 6 7
* net 1 A1
* net 2 A2
* net 3 A3
* net 4 A4
* net 5 VDD
* net 6 VSS
* net 7 Z
.ENDS gf180mcu_fd_sc_mcu9t5v0__and4_4

* cell gf180mcu_fd_sc_mcu9t5v0__oai211_2
* pin A1
* pin A2
* pin B
* pin C
* pin VDD
* pin VSS
* pin ZN
.SUBCKT gf180mcu_fd_sc_mcu9t5v0__oai211_2 1 2 3 4 5 6 7
* net 1 A1
* net 2 A2
* net 3 B
* net 4 C
* net 5 VDD
* net 6 VSS
* net 7 ZN
.ENDS gf180mcu_fd_sc_mcu9t5v0__oai211_2

* cell gf180mcu_fd_sc_mcu9t5v0__or3_4
* pin A1
* pin A2
* pin A3
* pin VDD
* pin VSS
* pin Z
.SUBCKT gf180mcu_fd_sc_mcu9t5v0__or3_4 1 2 3 4 5 6
* net 1 A1
* net 2 A2
* net 3 A3
* net 4 VDD
* net 5 VSS
* net 6 Z
.ENDS gf180mcu_fd_sc_mcu9t5v0__or3_4

* cell gf180mcu_fd_sc_mcu9t5v0__or4_4
* pin A1
* pin A2
* pin A3
* pin VDD
* pin VSS
* pin Z
* pin A4
.SUBCKT gf180mcu_fd_sc_mcu9t5v0__or4_4 1 2 3 4 5 6 7
* net 1 A1
* net 2 A2
* net 3 A3
* net 4 VDD
* net 5 VSS
* net 6 Z
* net 7 A4
.ENDS gf180mcu_fd_sc_mcu9t5v0__or4_4

* cell gf180mcu_fd_sc_mcu9t5v0__nand3_4
* pin A1
* pin A2
* pin A3
* pin VDD
* pin VSS
* pin ZN
.SUBCKT gf180mcu_fd_sc_mcu9t5v0__nand3_4 1 2 3 4 5 6
* net 1 A1
* net 2 A2
* net 3 A3
* net 4 VDD
* net 5 VSS
* net 6 ZN
.ENDS gf180mcu_fd_sc_mcu9t5v0__nand3_4

* cell gf180mcu_fd_sc_mcu9t5v0__oai211_4
* pin A1
* pin A2
* pin B
* pin C
* pin VSS
* pin ZN
* pin VDD
.SUBCKT gf180mcu_fd_sc_mcu9t5v0__oai211_4 1 2 3 4 5 6 7
* net 1 A1
* net 2 A2
* net 3 B
* net 4 C
* net 5 VSS
* net 6 ZN
* net 7 VDD
.ENDS gf180mcu_fd_sc_mcu9t5v0__oai211_4

* cell gf180mcu_fd_sc_mcu9t5v0__and4_2
* pin A1
* pin A2
* pin A3
* pin A4
* pin VDD
* pin VSS
* pin Z
.SUBCKT gf180mcu_fd_sc_mcu9t5v0__and4_2 1 2 3 4 5 6 7
* net 1 A1
* net 2 A2
* net 3 A3
* net 4 A4
* net 5 VDD
* net 6 VSS
* net 7 Z
.ENDS gf180mcu_fd_sc_mcu9t5v0__and4_2

* cell gf180mcu_fd_sc_mcu9t5v0__oai221_4
* pin A1
* pin A2
* pin B1
* pin B2
* pin C
* pin VDD
* pin VSS
* pin ZN
.SUBCKT gf180mcu_fd_sc_mcu9t5v0__oai221_4 1 2 3 4 5 6 7 8
* net 1 A1
* net 2 A2
* net 3 B1
* net 4 B2
* net 5 C
* net 6 VDD
* net 7 VSS
* net 8 ZN
.ENDS gf180mcu_fd_sc_mcu9t5v0__oai221_4

* cell gf180mcu_fd_sc_mcu9t5v0__aoi22_2
* pin A1
* pin A2
* pin B1
* pin B2
* pin VDD
* pin VSS
* pin ZN
.SUBCKT gf180mcu_fd_sc_mcu9t5v0__aoi22_2 1 2 3 4 5 6 7
* net 1 A1
* net 2 A2
* net 3 B1
* net 4 B2
* net 5 VDD
* net 6 VSS
* net 7 ZN
.ENDS gf180mcu_fd_sc_mcu9t5v0__aoi22_2

* cell gf180mcu_fd_sc_mcu9t5v0__clkbuf_20
* pin I
* pin VDD
* pin VSS
* pin Z
.SUBCKT gf180mcu_fd_sc_mcu9t5v0__clkbuf_20 1 3 4 5
* net 1 I
* net 3 VDD
* net 4 VSS
* net 5 Z
.ENDS gf180mcu_fd_sc_mcu9t5v0__clkbuf_20

* cell gf180mcu_fd_sc_mcu9t5v0__nand4_4
* pin A1
* pin A2
* pin A3
* pin A4
* pin VDD
* pin VSS
* pin ZN
.SUBCKT gf180mcu_fd_sc_mcu9t5v0__nand4_4 1 2 3 4 5 6 7
* net 1 A1
* net 2 A2
* net 3 A3
* net 4 A4
* net 5 VDD
* net 6 VSS
* net 7 ZN
.ENDS gf180mcu_fd_sc_mcu9t5v0__nand4_4

* cell gf180mcu_fd_sc_mcu9t5v0__buf_4
* pin I
* pin VDD
* pin VSS
* pin Z
.SUBCKT gf180mcu_fd_sc_mcu9t5v0__buf_4 1 2 3 4
* net 1 I
* net 2 VDD
* net 3 VSS
* net 4 Z
.ENDS gf180mcu_fd_sc_mcu9t5v0__buf_4

* cell gf180mcu_fd_io__dvss
.SUBCKT gf180mcu_fd_io__dvss
* net 1 DVSS
* net 2 DVSS
* net 3 DVSS
* net 4 DVSS
* net 5 DVSS
* net 6 DVSS
* net 7 DVSS
* net 8 DVSS
* net 9 DVSS
* net 10 DVSS
* net 11 DVDD
* net 12 DVDD
* net 13 DVDD
* net 14 DVSS
* net 15 DVSS
* net 16 DVSS
* net 17 DVDD
* net 18 DVDD
* net 19 DVDD
* net 20 DVDD
* net 21 DVDD
* net 22 DVDD
* net 23 DVDD
* net 24 DVDD
* net 25 DVDD
* net 26 DVDD
* net 27 DVDD
* net 28 DVDD
* net 29 DVSS
* net 30 DVSS
* net 31 DVSS
* net 32 DVDD
* net 33 DVDD
* net 34 DVDD
* net 35 DVDD
* net 36 DVDD
* net 37 DVDD
* net 38 DVSS
* net 39 DVSS
* net 40 DVSS
* net 41 DVSS
* net 42 DVSS
* net 43 DVSS
* net 44 VDD
* net 45 VDD
* net 46 VDD
* net 47 DVDD
* net 48 DVDD
* net 49 DVDD
* net 50 DVDD
* net 51 DVDD
* net 52 DVDD
* net 53 DVDD
* net 54 DVDD
* net 55 DVDD
* net 56 DVSS
* net 57 DVSS
* net 58 DVSS
* net 59 DVDD
* net 60 DVDD
* net 61 DVDD
* net 62 DVSS
* net 63 DVSS
* net 64 DVSS
* net 65 DVSS
* net 66 VDD
* net 67 DVSS
* net 68 DVSS
* net 69 VDD
* net 70 VDD
* net 71 DVSS
* net 72 DVSS
* net 73 DVSS
* net 74 DVDD
* net 75 DVSS
* net 76 DVDD
* net 77 DVDD
* net 78 DVSS
* net 79 DVSS
* net 80 DVSS
* net 81 DVSS
* net 82 DVSS
* net 83 DVSS
* net 84 DVSS
* net 85 DVSS
.ENDS gf180mcu_fd_io__dvss

* cell gf180mcu_fd_sc_mcu9t5v0__clkbuf_2
* pin I
* pin VDD
* pin VSS
.SUBCKT gf180mcu_fd_sc_mcu9t5v0__clkbuf_2 1 2 3
* net 1 I
* net 2 VDD
* net 3 VSS
* net 4 Z
.ENDS gf180mcu_fd_sc_mcu9t5v0__clkbuf_2

* cell gf180mcu_fd_sc_mcu9t5v0__and2_4
* pin A1
* pin A2
* pin VDD
* pin VSS
* pin Z
.SUBCKT gf180mcu_fd_sc_mcu9t5v0__and2_4 1 2 3 4 5
* net 1 A1
* net 2 A2
* net 3 VDD
* net 4 VSS
* net 5 Z
.ENDS gf180mcu_fd_sc_mcu9t5v0__and2_4
