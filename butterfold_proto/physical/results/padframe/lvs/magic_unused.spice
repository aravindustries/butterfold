* NGSPICE file created from butterfold_padframe_top.ext - technology: gf180mcuD

.subckt butterfold_padframe_top VDD VSS pad_clk pad_din[0] pad_din[1] pad_din[2] pad_din[3]
+ pad_din[4] pad_din[5] pad_din[6] pad_din[7] pad_din_ready_o pad_din_valid_i pad_dout[0]
+ pad_dout[1] pad_dout[2] pad_dout[3] pad_dout[4] pad_dout[5] pad_dout[6] pad_dout[7]
+ pad_dout_valid_o pad_rst_n
.ends
