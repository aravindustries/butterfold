* NGSPICE file created from gf180mcu_fd_sc_mcu9t5v0__clkbuf_1.ext - technology: gf180mcuD

.subckt gf180mcu_fd_sc_mcu9t5v0__clkbuf_1 I Z VDD VNW VPW VSS
X0 VSS I a_36_140# VPW nfet_05v0 ad=0.21475p pd=1.5u as=0.1606p ps=1.61u w=0.365u l=0.6u
X1 Z a_36_140# VDD VNW pfet_05v0 ad=0.8052p pd=4.54u as=0.50325p ps=2.53u w=1.83u l=0.5u
X2 VDD I a_36_140# VNW pfet_05v0 ad=0.50325p pd=2.53u as=0.4026p ps=2.71u w=0.915u l=0.5u
X3 Z a_36_140# VSS VPW nfet_05v0 ad=0.352p pd=2.48u as=0.21475p ps=1.5u w=0.8u l=0.6u
.ends
