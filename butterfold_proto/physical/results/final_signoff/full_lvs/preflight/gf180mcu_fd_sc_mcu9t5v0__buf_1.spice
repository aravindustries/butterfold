* NGSPICE file created from gf180mcu_fd_sc_mcu9t5v0__buf_1.ext - technology: gf180mcuD

.subckt gf180mcu_fd_sc_mcu9t5v0__buf_1 I Z VDD VNW VPW VSS
X0 VSS I a_36_146# VPW nfet_05v0 ad=0.363p pd=2.02u as=0.2904p ps=2.2u w=0.66u l=0.6u
X1 Z a_36_146# VDD VNW pfet_05v0 ad=0.8052p pd=4.54u as=0.50325p ps=2.53u w=1.83u l=0.5u
X2 Z a_36_146# VSS VPW nfet_05v0 ad=0.5808p pd=3.52u as=0.363p ps=2.02u w=1.32u l=0.6u
X3 VDD I a_36_146# VNW pfet_05v0 ad=0.50325p pd=2.53u as=0.4026p ps=2.71u w=0.915u l=0.5u
.ends
