* NGSPICE file created from gf180mcu_fd_sc_mcu9t5v0__aoi21_1.ext - technology: gf180mcuD

.subckt gf180mcu_fd_sc_mcu9t5v0__aoi21_1 A1 A2 B ZN VDD VNW VPW VSS
X0 a_36_573# A1 ZN VNW pfet_05v0 ad=0.6405p pd=2.53u as=0.4758p ps=2.35u w=1.83u l=0.5u
X1 VDD B a_36_573# VNW pfet_05v0 ad=0.8052p pd=4.54u as=0.6405p ps=2.53u w=1.83u l=0.5u
X2 ZN A1 a_244_69# VPW nfet_05v0 ad=0.402p pd=2.02u as=0.2112p ps=1.64u w=1.32u l=0.6u
X3 a_244_69# A2 VSS VPW nfet_05v0 ad=0.2112p pd=1.64u as=0.5808p ps=3.52u w=1.32u l=0.6u
X4 VSS B ZN VPW nfet_05v0 ad=0.4048p pd=2.72u as=0.402p ps=2.02u w=0.92u l=0.6u
X5 ZN A2 a_36_573# VNW pfet_05v0 ad=0.4758p pd=2.35u as=0.8052p ps=4.54u w=1.83u l=0.5u
.ends
