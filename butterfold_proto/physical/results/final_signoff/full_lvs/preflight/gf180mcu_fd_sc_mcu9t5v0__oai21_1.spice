* NGSPICE file created from gf180mcu_fd_sc_mcu9t5v0__oai21_1.ext - technology: gf180mcuD

.subckt gf180mcu_fd_sc_mcu9t5v0__oai21_1 A1 A2 B ZN VDD VNW VPW VSS
X0 a_36_69# A1 ZN VPW nfet_05v0 ad=0.3432p pd=1.84u as=0.3432p ps=1.84u w=1.32u l=0.6u
X1 VDD B ZN VNW pfet_05v0 ad=0.7238p pd=4.17u as=0.61275p ps=2.53u w=1.645u l=0.5u
X2 VSS B a_36_69# VPW nfet_05v0 ad=0.5808p pd=3.52u as=0.3432p ps=1.84u w=1.32u l=0.6u
X3 ZN A1 a_234_573# VNW pfet_05v0 ad=0.61275p pd=2.53u as=0.52155p ps=2.4u w=1.83u l=0.5u
X4 ZN A2 a_36_69# VPW nfet_05v0 ad=0.3432p pd=1.84u as=0.5808p ps=3.52u w=1.32u l=0.6u
X5 a_234_573# A2 VDD VNW pfet_05v0 ad=0.52155p pd=2.4u as=0.8052p ps=4.54u w=1.83u l=0.5u
.ends
