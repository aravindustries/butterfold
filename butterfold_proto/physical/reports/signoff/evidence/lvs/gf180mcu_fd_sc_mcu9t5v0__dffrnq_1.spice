* NGSPICE file created from gf180mcu_fd_sc_mcu9t5v0__dffrnq_1.ext - technology: gf180mcuD

.subckt gf180mcu_fd_sc_mcu9t5v0__dffrnq_1 D RN CLK Q VDD VNW VPW VSS
X0 a_2160_170# a_432_573# a_1336_126# VPW nfet_05v0 ad=0.182p pd=1.22u as=0.182p ps=1.22u w=0.7u l=0.6u
X1 a_2832_170# RN VSS VPW nfet_05v0 ad=0.263p pd=1.49u as=0.182p ps=1.22u w=0.7u l=0.6u
X2 a_432_573# a_40_175# VSS VPW nfet_05v0 ad=0.3476p pd=2.46u as=0.2054p ps=1.31u w=0.79u l=0.6u
X3 a_1028_593# a_40_175# a_824_593# VPW nfet_05v0 ad=0.182p pd=1.22u as=0.182p ps=1.22u w=0.7u l=0.6u
X4 VSS a_2488_126# a_2384_170# VPW nfet_05v0 ad=0.182p pd=1.22u as=0.182p ps=1.22u w=0.7u l=0.6u
X5 VDD a_2488_126# a_2384_170# VNW pfet_05v0 ad=0.5472p pd=2.35u as=0.26p ps=1.52u w=1u l=0.5u
X6 VSS a_2488_126# Q VPW nfet_05v0 ad=0.5808p pd=3.52u as=0.5808p ps=3.52u w=1.32u l=0.6u
X7 VDD a_2488_126# Q VNW pfet_05v0 ad=0.8052p pd=4.54u as=0.8052p ps=4.54u w=1.83u l=0.5u
X8 a_824_593# D VDD VNW pfet_05v0 ad=0.26p pd=1.52u as=0.44p ps=2.88u w=1u l=0.5u
X9 VSS CLK a_40_175# VPW nfet_05v0 ad=0.2054p pd=1.31u as=0.3476p ps=2.46u w=0.79u l=0.6u
X10 a_1028_593# a_432_573# a_824_593# VNW pfet_05v0 ad=0.26p pd=1.52u as=0.26p ps=1.52u w=1u l=0.5u
X11 a_824_593# D VSS VPW nfet_05v0 ad=0.182p pd=1.22u as=0.308p ps=2.28u w=0.7u l=0.6u
X12 VDD CLK a_40_175# VNW pfet_05v0 ad=0.3588p pd=1.9u as=0.6072p ps=3.64u w=1.38u l=0.5u
X13 a_2384_170# a_40_175# a_2160_170# VPW nfet_05v0 ad=0.182p pd=1.22u as=0.182p ps=1.22u w=0.7u l=0.6u
X14 a_432_573# a_40_175# VDD VNW pfet_05v0 ad=0.6072p pd=3.64u as=0.3588p ps=1.9u w=1.38u l=0.5u
X15 a_1456_170# a_1336_126# a_1288_170# VPW nfet_05v0 ad=0.238p pd=1.38u as=83.99999f ps=0.94u w=0.7u l=0.6u
X16 a_1336_126# a_1028_593# VSS VPW nfet_05v0 ad=0.182p pd=1.22u as=0.182p ps=1.22u w=0.7u l=0.6u
X17 a_2488_126# RN VDD VNW pfet_05v0 ad=0.2548p pd=1.5u as=0.5472p ps=2.35u w=0.98u l=0.5u
X18 a_1232_593# a_40_175# a_1028_593# VNW pfet_05v0 ad=0.26p pd=1.52u as=0.26p ps=1.52u w=1u l=0.5u
X19 a_2160_170# a_40_175# a_1336_126# VNW pfet_05v0 ad=0.26p pd=1.52u as=0.26p ps=1.52u w=1u l=0.5u
X20 VDD a_2160_170# a_2488_126# VNW pfet_05v0 ad=0.4312p pd=2.84u as=0.2548p ps=1.5u w=0.98u l=0.5u
X21 VSS RN a_1456_170# VPW nfet_05v0 ad=0.182p pd=1.22u as=0.238p ps=1.38u w=0.7u l=0.6u
X22 VDD a_1336_126# a_1232_593# VNW pfet_05v0 ad=0.26p pd=1.52u as=0.26p ps=1.52u w=1u l=0.5u
X23 a_1288_170# a_432_573# a_1028_593# VPW nfet_05v0 ad=83.99999f pd=0.94u as=0.182p ps=1.22u w=0.7u l=0.6u
X24 a_2384_170# a_432_573# a_2160_170# VNW pfet_05v0 ad=0.26p pd=1.52u as=0.26p ps=1.52u w=1u l=0.5u
X25 a_2488_126# a_2160_170# a_2832_170# VPW nfet_05v0 ad=0.3476p pd=2.46u as=0.263p ps=1.49u w=0.79u l=0.6u
X26 a_1232_593# RN VDD VNW pfet_05v0 ad=0.44p pd=2.88u as=0.26p ps=1.52u w=1u l=0.5u
X27 a_1336_126# a_1028_593# VDD VNW pfet_05v0 ad=0.26p pd=1.52u as=0.44p ps=2.88u w=1u l=0.5u
.ends
